** sch_path: /home/veswaranandam/SKY130-AY38910/DAC/AND_4.sch
.subckt AND_4 A B C D Y VP VN
*.PININFO A:I B:I Y:O VP:B VN:B C:I D:I
x0 B A net1 VP VN AND
x1 net2 net1 Y VP VN AND
x3 C D net2 VP VN AND
.ends

* expanding   symbol:  AND.sym # of pins=5
** sym_path: /home/veswaranandam/SKY130-AY38910/DAC/AND.sym
** sch_path: /home/veswaranandam/SKY130-AY38910/DAC/AND.sch
.subckt AND A B Y VP VN
*.PININFO A:I B:I Y:O VP:B VN:B
x1 A B net1 VP VN NAND
X2 net1 Y VP VN inverter
.ends

* expanding   symbol:  NAND.sym # of pins=5
** sym_path: /home/veswaranandam/SKY130-AY38910/DAC/NAND.sym
** sch_path: /home/veswaranandam/SKY130-AY38910/DAC/NAND.sch
.subckt NAND A B Y VP VN
*.PININFO A:I B:I Y:O VP:B VN:B
XM2 Y A net1 VN sky130_fd_pr__nfet_01v8 L=0.15 W=1 nf=1 ad=0.29 as=0.29 pd=2.58 ps=2.58 nrd=0.29 nrs=0.29 sa=0 sb=0 sd=0 mult=1
+ m=1
XM11 Y A VP VP sky130_fd_pr__pfet_01v8 L=0.15 W=1 nf=1 ad=0.29 as=0.29 pd=2.58 ps=2.58 nrd=0.29 nrs=0.29 sa=0 sb=0 sd=0 mult=1 m=1
XM1 Y B VP VP sky130_fd_pr__pfet_01v8 L=0.15 W=1 nf=1 ad=0.29 as=0.29 pd=2.58 ps=2.58 nrd=0.29 nrs=0.29 sa=0 sb=0 sd=0 mult=1 m=1
XM3 net1 B VN VN sky130_fd_pr__nfet_01v8 L=0.15 W=1 nf=1 ad=0.29 as=0.29 pd=2.58 ps=2.58 nrd=0.29 nrs=0.29 sa=0 sb=0 sd=0 mult=1
+ m=1
.ends

* expanding   symbol:  inverter.sym # of pins=4
** sym_path: /home/veswaranandam/SKY130-AY38910/DAC/inverter.sym
** sch_path: /home/veswaranandam/SKY130-AY38910/DAC/inverter.sch
.subckt inverter A Y VP VN
*.PININFO A:I Y:O VN:B VP:B
XM2 Y A VN VN sky130_fd_pr__nfet_01v8 L=0.15 W=1 nf=1 ad='int((nf+1)/2) * W/nf * 0.29' as='int((nf+2)/2) * W/nf * 0.29' pd='2*int((nf+1)/2) * (W/nf + 0.29)'
+ ps='2*int((nf+2)/2) * (W/nf + 0.29)' nrd='0.29 / W' nrs='0.29 / W' sa=0 sb=0 sd=0 mult=1 m=1
XM1 Y A VP VP sky130_fd_pr__pfet_01v8 L=0.15 W=1 nf=1 ad='int((nf+1)/2) * W/nf * 0.29' as='int((nf+2)/2) * W/nf * 0.29' pd='2*int((nf+1)/2) * (W/nf + 0.29)'
+ ps='2*int((nf+2)/2) * (W/nf + 0.29)' nrd='0.29 / W' nrs='0.29 / W' sa=0 sb=0 sd=0 mult=1 m=1
.ends

.GLOBAL GND
