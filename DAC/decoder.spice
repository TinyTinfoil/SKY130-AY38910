* NGSPICE file created from decoder.ext - technology: sky130A

.subckt inverter A Y VP VN
X0 Y A VP VP sky130_fd_pr__pfet_01v8 ad=0.5 pd=3 as=0.5 ps=3 w=1 l=0.15
X1 Y A VN VN sky130_fd_pr__nfet_01v8 ad=0.5 pd=3 as=0.5 ps=3 w=1 l=0.15
.ends

.subckt NAND A B Y VP VN
X0 Y A a_n120_30# VN sky130_fd_pr__nfet_01v8 ad=0.5 pd=3 as=0.15 ps=1.3 w=1 l=0.15
X1 a_n120_30# B VN VN sky130_fd_pr__nfet_01v8 ad=0.15 pd=1.3 as=0.5 ps=3 w=1 l=0.15
X2 VP A Y VP sky130_fd_pr__pfet_01v8 ad=0.5 pd=3 as=0.25 ps=1.5 w=1 l=0.15
X3 Y B VP VP sky130_fd_pr__pfet_01v8 ad=0.25 pd=1.5 as=0.5 ps=3 w=1 l=0.15
.ends

.subckt AND A B Y VP VN
Xinverter_0 NAND_0/Y Y VP VN inverter
XNAND_0 A B NAND_0/Y VP VN NAND
.ends

.subckt AND_4 A B C D Y VN VP
XAND_0 B A AND_1/B VP VN AND
XAND_1 AND_2/Y AND_1/B Y VP VN AND
XAND_2 C D AND_2/Y VP VN AND
.ends

.subckt decoder A0 A2 A3 MUX2 MUX5 MUX6 MUX12 MUX13 A1 VN VP MUX3 MUX4 MUX7 MUX8 MUX9
+ MUX10 MUX11 MUX14 MUX15 MUX1 MUX0
Xinverter_0 A3 AND_4_1/A VP VN inverter
Xinverter_1 A2 AND_4_9/B VP VN inverter
Xinverter_2 A0 AND_4_9/D VP VN inverter
Xinverter_3 A1 AND_4_9/C VP VN inverter
XAND_4_0 AND_4_1/A AND_4_9/B AND_4_9/C AND_4_9/D MUX0 VN VP AND_4
XAND_4_1 AND_4_1/A AND_4_9/B AND_4_9/C A0 MUX1 VN VP AND_4
XAND_4_2 A3 A2 A1 A0 MUX15 VN VP AND_4
XAND_4_3 A3 A2 A1 AND_4_9/D MUX14 VN VP AND_4
XAND_4_4 A3 A2 AND_4_9/C A0 MUX13 VN VP AND_4
XAND_4_5 A3 A2 AND_4_9/C AND_4_9/D MUX12 VN VP AND_4
XAND_4_6 A3 AND_4_9/B A1 A0 MUX11 VN VP AND_4
XAND_4_10 AND_4_1/A A2 A1 A0 MUX7 VN VP AND_4
XAND_4_7 A3 AND_4_9/B A1 AND_4_9/D MUX10 VN VP AND_4
XAND_4_11 AND_4_1/A A2 A1 AND_4_9/D MUX6 VN VP AND_4
XAND_4_8 A3 AND_4_9/B AND_4_9/C A0 MUX9 VN VP AND_4
XAND_4_12 AND_4_1/A A2 AND_4_9/C A0 MUX5 VN VP AND_4
XAND_4_9 A3 AND_4_9/B AND_4_9/C AND_4_9/D MUX8 VN VP AND_4
XAND_4_13 AND_4_1/A A2 AND_4_9/C AND_4_9/D MUX4 VN VP AND_4
XAND_4_14 AND_4_1/A AND_4_9/B A1 A0 MUX3 VN VP AND_4
XAND_4_15 AND_4_1/A AND_4_9/B A1 AND_4_9/D MUX2 VN VP AND_4
.ends
