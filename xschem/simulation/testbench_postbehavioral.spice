** sch_path: /home/veswaranandam/SKY130-AY38910/xschem/testbench_postbehavioral.sch
**.subckt testbench_postbehavioral
X1 VP A0 A1 A2 A3 A4 B0 B1 B2 B3 B4 C0 C1 C2 C3 C4 net39 net34 net29 net24 net19 net14 net9 net2 net6 net42 net37 net32 net27
+ net22 net17 net12 net5 net38 net33 net28 net23 net18 net13 net8 net1 net7 net41 net36 net31 net26 net21 net16 net11 net4 0 VP bc1 bc2
+ bdir CLK cen din_out0 din_out1 din_out2 din_out3 din_out4 din_out5 din_out6 din_out7 net40 net35 net30 net25 net20 net15 net10 net3 0
+ VRST 0 VP digital_core
Vdd VP 0 1.8
X2 CLK cen VRST bdir bc1 bc2 din_out7 din_out6 din_out5 din_out4 din_out3 din_out2 din_out1 din_out0 test_core
R1 net40 0 1M
R2 net35 0 1M
R3 net30 0 1M
R4 net25 0 1M
R5 net20 0 1M
R6 net15 0 1M
R7 net10 0 1M
R8 net3 0 1M
R9 net1 0 1M
R10 net8 0 1M
R11 net13 0 1M
R12 net18 0 1M
R13 net23 0 1M
R14 net28 0 1M
R15 net33 0 1M
R16 net38 0 1M
R17 net4 0 1M
R18 net11 0 1M
R19 net16 0 1M
R20 net21 0 1M
R21 net26 0 1M
R22 net31 0 1M
R23 net36 0 1M
R24 net41 0 1M
R25 net2 0 1M
R26 net9 0 1M
R27 net14 0 1M
R28 net19 0 1M
R29 net24 0 1M
R30 net29 0 1M
R31 net34 0 1M
R32 net39 0 1M
R33 net5 0 1M
R34 net12 0 1M
R35 net17 0 1M
R36 net22 0 1M
R37 net27 0 1M
R38 net32 0 1M
R39 net37 0 1M
R40 net42 0 1M
R56 net7 0 1M
R57 net6 0 1M
R41 A0 0 1G
R42 A1 0 1G
R43 A2 0 1G
R44 A3 0 1G
R45 A4 0 1G
R46 B0 0 1G
R47 B1 0 1G
R48 B2 0 1G
R49 B3 0 1G
R50 B4 0 1G
R51 C0 0 1G
R52 C1 0 1G
R53 C2 0 1G
R54 C3 0 1G
R55 C4 0 1G
**** begin user architecture code

.param VDD=1.8
.include ext/digital_core.spice
.include ext/test_core.spice
.PREPROCESS REPLACEGROUND TRUE
.OPTIONS DIST STRATEGY=2
.OPTIONS RESTART JOB=checkpt_b INITIAL_INTERVAL=3us
.OPTIONS LINSOL type=KLU
*.OPTIONS LINSOL TR_AMD=0 TR_SINGLETON_FILTER=1
.OPTIONS TIMEINT BREAKPOINTS=49ns,50ns,99ns,100ns,149ns,150ns,199ns,200ns,249ns,250ns,299ns,300ns,349ns,350ns,399ns,400ns,449ns,450ns,499ns,500ns,549ns,550ns,599ns,600ns,649ns,650ns,699ns,700ns,749ns,750ns,799ns,800ns,849ns,850ns,899ns,900ns,949ns,950ns,999ns,1us,1.049us,1.05us,1.099us,1.1us,1.149us,1.15us,1.199us,1.2us,1.249us,1.25us,1.299us,1.3us,1.349us,1.35us,1.399us,1.4us,1.449us,1.45us,1.499us,1.5us,1.549us,1.55us,1.599us,1.6us,1.649us,1.65us,1.699us,1.7us,1.749us,1.75us,1.799us,1.8us,1.849us,1.85us,1.899us,1.9us,1.949us,1.95us,1.999us,2us,2.049us,2.05us,2.099us,2.1us,2.149us,2.15us,2.199us,2.2us,2.249us,2.25us,2.299us,2.3us,2.349us,2.35us,2.399us,2.4us,2.449us,2.45us,2.499us,2.5us,2.549us,2.55us,2.599us,2.6us,2.649us,2.65us,2.699us,2.7us,2.749us,2.75us,2.799us,2.8us,2.849us,2.85us,2.899us,2.9us,2.949us,2.95us,2.999us,3us,3.049us,3.05us,3.099us,3.1us,3.149us,3.15us,3.199us,3.2us,3.249us,3.25us,3.299us,3.3us,3.349us,3.35us,3.399us,3.4us,3.449us,3.45us,3.499us,3.5us,3.549us,3.55us,3.599us,3.6us,3.649us,3.65us,3.699us,3.7us,3.749us,3.75us,3.799us,3.8us,3.849us,3.85us,3.899us,3.9us,3.949us,3.95us,3.999us,4us,4.049us,4.05us,4.099us,4.1us,4.149us,4.15us,4.199us,4.2us,4.249us,4.25us,4.299us,4.3us,4.349us,4.35us,4.399us,4.4us,4.449us,4.45us,4.499us,4.5us,4.549us,4.55us,4.599us,4.6us,4.649us,4.65us,4.699us,4.7us,4.749us,4.75us,4.799us,4.8us,4.849us,4.85us,4.899us,4.9us,4.949us,4.95us,4.999us,5us,5.049us,5.05us,5.099us,5.1us,5.149us,5.15us,5.199us,5.2us,5.249us,5.25us,5.299us,5.3us,5.349us,5.35us,5.399us,5.4us,5.449us,5.45us,5.499us,5.5us,5.549us,5.55us,5.599us,5.6us,5.649us,5.65us,5.699us,5.7us,5.749us,5.75us,5.799us,5.8us,5.849us,5.85us,5.899us,5.9us,5.949us,5.95us,5.999us,6us,6.049us,6.05us,6.099us,6.1us,6.149us,6.15us,6.199us,6.2us,6.249us,6.25us,6.299us,6.3us,6.349us,6.35us,6.399us,6.4us,6.449us,6.45us,6.499us,6.5us,6.549us,6.55us,6.599us,6.6us,6.649us,6.65us,6.699us,6.7us,6.749us,6.75us,6.799us,6.8us,6.849us,6.85us,6.899us,6.9us,6.949us,6.95us,6.999us,7us,7.049us,7.05us,7.099us,7.1us,7.149us,7.15us,7.199us,7.2us,7.249us,7.25us,7.299us,7.3us,7.349us,7.35us,7.399us,7.4us,7.449us,7.45us,7.499us,7.5us,7.549us,7.55us,7.599us,7.6us,7.649us,7.65us,7.699us,7.7us,7.749us,7.75us,7.799us,7.8us,7.849us,7.85us,7.899us,7.9us,7.949us,7.95us,7.999us,8us,8.049us,8.05us,8.099us,8.1us,8.149us,8.15us,8.199us,8.2us,8.249us,8.25us,8.299us,8.3us,8.349us,8.35us,8.399us,8.4us,8.449us,8.45us,8.499us,8.5us,8.549us,8.55us,8.599us,8.6us,8.649us,8.65us,8.699us,8.7us,8.749us,8.75us,8.799us,8.8us,8.849us,8.85us,8.899us,8.9us,8.949us,8.95us,8.999us,9us,9.049us,9.05us,9.099us,9.1us,9.149us,9.15us,9.199us,9.2us,9.249us,9.25us,9.299us,9.3us,9.349us,9.35us,9.399us,9.4us,9.449us,9.45us,9.499us,9.5us,9.549us,9.55us,9.599us,9.6us,9.649us,9.65us,9.699us,9.7us,9.749us,9.75us,9.799us,9.8us,9.849us,9.85us,9.899us,9.9us,9.949us,9.95us,9.999us,10us,10.049us,10.05us,10.099us,10.1us,10.149us,10.15us,10.199us,10.2us,10.249us,10.25us,10.299us,10.3us,10.349us,10.35us,10.399us,10.4us,10.449us,10.45us,10.499us,10.5us,10.549us,10.55us,10.599us,10.6us,10.649us,10.65us,10.699us,10.7us,10.749us,10.75us,10.799us,10.8us,10.849us,10.85us,10.899us,10.9us,10.949us,10.95us,10.999us,11us,11.049us,11.05us,11.099us,11.1us,11.149us,11.15us,11.199us,11.2us,11.249us,11.25us,11.299us,11.3us,11.349us,11.35us,11.399us,11.4us,11.449us,11.45us,11.499us,11.5us,11.549us,11.55us,11.599us,11.6us,11.649us,11.65us,11.699us,11.7us,11.749us,11.75us,11.799us,11.8us,11.849us,11.85us,11.899us,11.9us,11.949us,11.95us,11.999us,12us,12.049us,12.05us,12.099us,12.1us,12.149us,12.15us,12.199us,12.2us,12.249us,12.25us,12.299us,12.3us,12.349us,12.35us,12.399us,12.4us,12.449us,12.45us,12.499us,12.5us,12.549us,12.55us,12.599us,12.6us,12.649us,12.65us,12.699us,12.7us,12.749us,12.75us,12.799us,12.8us,12.849us,12.85us,12.899us,12.9us,12.949us,12.95us,12.999us,13us,13.049us,13.05us,13.099us,13.1us,13.149us,13.15us,13.199us,13.2us,13.249us,13.25us,13.299us,13.3us,13.349us,13.35us,13.399us,13.4us,13.449us,13.45us,13.499us,13.5us,13.549us,13.55us,13.599us,13.6us,13.649us,13.65us,13.699us,13.7us,13.749us,13.75us,13.799us,13.8us,13.849us,13.85us,13.899us,13.9us,13.949us,13.95us,13.999us,14us,14.049us,14.05us,14.099us,14.1us,14.149us,14.15us,14.199us,14.2us,14.249us,14.25us,14.299us,14.3us,14.349us,14.35us,14.399us,14.4us,14.449us,14.45us,14.499us,14.5us,14.549us,14.55us,14.599us,14.6us,14.649us,14.65us,14.699us,14.7us,14.749us,14.75us,14.799us,14.8us,14.849us,14.85us,14.899us,14.9us,14.949us,14.95us,14.999us,15us,15.049us,15.05us,15.099us,15.1us,15.149us,15.15us,15.199us,15.2us,15.249us,15.25us,15.299us,15.3us,15.349us,15.35us,15.399us,15.4us,15.449us,15.45us,15.499us,15.5us,15.549us,15.55us,15.599us,15.6us,15.649us,15.65us,15.699us,15.7us,15.749us,15.75us,15.799us,15.8us,15.849us,15.85us,15.899us,15.9us,15.949us,15.95us,15.999us,16us,16.049us,16.05us,16.099us,16.1us,16.149us,16.15us,16.199us,16.2us,16.249us,16.25us,16.299us,16.3us,16.349us,16.35us,16.399us,16.4us,16.449us,16.45us,16.499us,16.5us,16.549us,16.55us,16.599us,16.6us,16.649us,16.65us,16.699us,16.7us,16.749us,16.75us,16.799us,16.8us,16.849us,16.85us,16.899us,16.9us,16.949us,16.95us,16.999us,17us,17.049us,17.05us,17.099us,17.1us,17.149us,17.15us,17.199us,17.2us,17.249us,17.25us,17.299us,17.3us,17.349us,17.35us,17.399us,17.4us,17.449us,17.45us,17.499us,17.5us,17.549us,17.55us,17.599us,17.6us,17.649us,17.65us,17.699us,17.7us,17.749us,17.75us,17.799us,17.8us,17.849us,17.85us,17.899us,17.9us,17.949us,17.95us,17.999us,18us,18.049us,18.05us,18.099us,18.1us,18.149us,18.15us,18.199us,18.2us,18.249us,18.25us,18.299us,18.3us,18.349us,18.35us,18.399us,18.4us,18.449us,18.45us,18.499us,18.5us,18.549us,18.55us,18.599us,18.6us,18.649us,18.65us,18.699us,18.7us,18.749us,18.75us,18.799us,18.8us,18.849us,18.85us,18.899us,18.9us,18.949us,18.95us,18.999us,19us,19.049us,19.05us,19.099us,19.1us,19.149us,19.15us,19.199us,19.2us,19.249us,19.25us,19.299us,19.3us,19.349us,19.35us,19.399us,19.4us,19.449us,19.45us,19.499us,19.5us,19.549us,19.55us,19.599us,19.6us,19.649us,19.65us,19.699us,19.7us,19.749us,19.75us,19.799us,19.8us,19.849us,19.85us,19.899us,19.9us,19.949us,19.95us,19.999us,20us,20.049us,20.05us,20.099us,20.1us,20.149us,20.15us,20.199us,20.2us,20.249us,20.25us,20.299us,20.3us,20.349us,20.35us,20.399us,20.4us,20.449us,20.45us,20.499us,20.5us,20.549us,20.55us,20.599us,20.6us,20.649us,20.65us,20.699us,20.7us,20.749us,20.75us,20.799us,20.8us,20.849us,20.85us,20.899us,20.9us,20.949us,20.95us,20.999us,21us,21.049us,21.05us,21.099us,21.1us,21.149us,21.15us,21.199us,21.2us,21.249us,21.25us,21.299us,21.3us,21.349us,21.35us,21.399us,21.4us,21.449us,21.45us,21.499us,21.5us,21.549us,21.55us,21.599us,21.6us,21.649us,21.65us,21.699us,21.7us,21.749us,21.75us,21.799us,21.8us,21.849us,21.85us,21.899us,21.9us,21.949us,21.95us,21.999us,22us,22.049us,22.05us,22.099us,22.1us,22.149us,22.15us,22.199us,22.2us,22.249us,22.25us,22.299us,22.3us,22.349us,22.35us,22.399us,22.4us,22.449us,22.45us,22.499us,22.5us,22.549us,22.55us,22.599us,22.6us,22.649us,22.65us,22.699us,22.7us,22.749us,22.75us,22.799us,22.8us,22.849us,22.85us,22.899us,22.9us,22.949us,22.95us,22.999us,23us,23.049us,23.05us,23.099us,23.1us,23.149us,23.15us,23.199us,23.2us,23.249us,23.25us,23.299us,23.3us,23.349us,23.35us,23.399us,23.4us,23.449us,23.45us,23.499us,23.5us,23.549us,23.55us,23.599us,23.6us,23.649us,23.65us,23.699us,23.7us,23.749us,23.75us,23.799us,23.8us,23.849us,23.85us,23.899us,23.9us,23.949us,23.95us,23.999us,24us,24.049us,24.05us,24.099us,24.1us,24.149us,24.15us,24.199us,24.2us,24.249us,24.25us,24.299us,24.3us,24.349us,24.35us,24.399us,24.4us,24.449us,24.45us,24.499us,24.5us,24.549us,24.55us,24.599us,24.6us,24.649us,24.65us,24.699us,24.7us,24.749us,24.75us,24.799us,24.8us,24.849us,24.85us,24.899us,24.9us,24.949us,24.95us,24.999us,25us,25.049us,25.05us,25.099us,25.1us,25.149us,25.15us,25.199us,25.2us,25.249us,25.25us,25.299us,25.3us,25.349us,25.35us,25.399us,25.4us,25.449us,25.45us,25.499us,25.5us,25.549us,25.55us,25.599us,25.6us,25.649us,25.65us,25.699us,25.7us,25.749us,25.75us,25.799us,25.8us,25.849us,25.85us,25.899us,25.9us,25.949us,25.95us,25.999us,26us,26.049us,26.05us,26.099us,26.1us,26.149us,26.15us,26.199us,26.2us,26.249us,26.25us,26.299us,26.3us,26.349us,26.35us,26.399us,26.4us,26.449us,26.45us,26.499us,26.5us,26.549us,26.55us,26.599us,26.6us,26.649us,26.65us,26.699us,26.7us,26.749us,26.75us,26.799us,26.8us,26.849us,26.85us,26.899us,26.9us,26.949us,26.95us,26.999us,27us,27.049us,27.05us,27.099us,27.1us,27.149us,27.15us,27.199us,27.2us,27.249us,27.25us,27.299us,27.3us,27.349us,27.35us,27.399us,27.4us,27.449us,27.45us,27.499us,27.5us,27.549us,27.55us,27.599us,27.6us,27.649us,27.65us,27.699us,27.7us,27.749us,27.75us,27.799us,27.8us,27.849us,27.85us,27.899us,27.9us,27.949us,27.95us,27.999us,28us,28.049us,28.05us,28.099us,28.1us,28.149us,28.15us,28.199us,28.2us,28.249us,28.25us,28.299us,28.3us,28.349us,28.35us,28.399us,28.4us,28.449us,28.45us,28.499us,28.5us,28.549us,28.55us,28.599us,28.6us,28.649us,28.65us,28.699us,28.7us,28.749us,28.75us,28.799us,28.8us,28.849us,28.85us,28.899us,28.9us,28.949us,28.95us,28.999us,29us,29.049us,29.05us,29.099us,29.1us,29.149us,29.15us,29.199us,29.2us,29.249us,29.25us,29.299us,29.3us,29.349us,29.35us,29.399us,29.4us,29.449us,29.45us,29.499us,29.5us,29.549us,29.55us,29.599us,29.6us,29.649us,29.65us,29.699us,29.7us,29.749us,29.75us,29.799us,29.8us,29.849us,29.85us,29.899us,29.9us,29.949us,29.95us,29.999us,30us,30.049us,30.05us,30.099us,30.1us,30.149us,30.15us,30.199us,30.2us,30.249us,30.25us,30.299us,30.3us,30.349us,30.35us,30.399us,30.4us,30.449us,30.45us,30.499us,30.5us,30.549us,30.55us,30.599us,30.6us,30.649us,30.65us,30.699us,30.7us,30.749us,30.75us,30.799us,30.8us,30.849us,30.85us,30.899us,30.9us,30.949us,30.95us,30.999us,31us,31.049us,31.05us,31.099us,31.1us,31.149us,31.15us,31.199us,31.2us,31.249us,31.25us,31.299us,31.3us,31.349us,31.35us,31.399us,31.4us,31.449us,31.45us,31.499us,31.5us,31.549us,31.55us,31.599us,31.6us,31.649us,31.65us,31.699us,31.7us,31.749us,31.75us,31.799us,31.8us,31.849us,31.85us,31.899us,31.9us,31.949us,31.95us,31.999us,32us,32.049us,32.05us,32.099us,32.1us,32.149us,32.15us,32.199us,32.2us,32.249us,32.25us,32.299us,32.3us,32.349us,32.35us,32.399us,32.4us,32.449us,32.45us,32.499us,32.5us,32.549us,32.55us,32.599us,32.6us,32.649us,32.65us,32.699us,32.7us,32.749us,32.75us,32.799us,32.8us,32.849us,32.85us,32.899us,32.9us,32.949us,32.95us,32.999us,33us,33.049us,33.05us,33.099us,33.1us,33.149us,33.15us,33.199us,33.2us,33.249us,33.25us,33.299us,33.3us,33.349us,33.35us,33.399us,33.4us,33.449us,33.45us,33.499us,33.5us,33.549us,33.55us,33.599us,33.6us,33.649us,33.65us,33.699us,33.7us,33.749us,33.75us,33.799us,33.8us,33.849us,33.85us,33.899us,33.9us,33.949us,33.95us,33.999us,34us,34.049us,34.05us,34.099us,34.1us,34.149us,34.15us,34.199us,34.2us,34.249us,34.25us,34.299us,34.3us,34.349us,34.35us,34.399us,34.4us,34.449us,34.45us,34.499us,34.5us,34.549us,34.55us,34.599us,34.6us,34.649us,34.65us,34.699us,34.7us,34.749us,34.75us,34.799us,34.8us,34.849us,34.85us,34.899us,34.9us,34.949us,34.95us,34.999us,35us,35.049us,35.05us,35.099us,35.1us,35.149us,35.15us,35.199us,35.2us,35.249us,35.25us,35.299us,35.3us,35.349us,35.35us,35.399us,35.4us,35.449us,35.45us,35.499us,35.5us,35.549us,35.55us,35.599us,35.6us,35.649us,35.65us,35.699us,35.7us,35.749us,35.75us,35.799us,35.8us,35.849us,35.85us,35.899us,35.9us,35.949us,35.95us,35.999us,36us,36.049us,36.05us,36.099us,36.1us,36.149us,36.15us,36.199us,36.2us,36.249us,36.25us,36.299us,36.3us,36.349us,36.35us,36.399us,36.4us,36.449us,36.45us,36.499us,36.5us,36.549us,36.55us,36.599us,36.6us,36.649us,36.65us,36.699us,36.7us,36.749us,36.75us,36.799us,36.8us,36.849us,36.85us,36.899us,36.9us,36.949us,36.95us,36.999us,37us,37.049us,37.05us,37.099us,37.1us,37.149us,37.15us,37.199us,37.2us,37.249us,37.25us,37.299us,37.3us,37.349us,37.35us,37.399us,37.4us,37.449us,37.45us,37.499us,37.5us,37.549us,37.55us,37.599us,37.6us,37.649us,37.65us,37.699us,37.7us,37.749us,37.75us,37.799us,37.8us,37.849us,37.85us,37.899us,37.9us,37.949us,37.95us,37.999us,38us,38.049us,38.05us,38.099us,38.1us,38.149us,38.15us,38.199us,38.2us,38.249us,38.25us,38.299us,38.3us,38.349us,38.35us,38.399us,38.4us,38.449us,38.45us,38.499us,38.5us,38.549us,38.55us,38.599us,38.6us,38.649us,38.65us,38.699us,38.7us,38.749us,38.75us,38.799us,38.8us,38.849us,38.85us,38.899us,38.9us,38.949us,38.95us,38.999us,39us,39.049us,39.05us,39.099us,39.1us,39.149us,39.15us,39.199us,39.2us,39.249us,39.25us,39.299us,39.3us,39.349us,39.35us,39.399us,39.4us,39.449us,39.45us,39.499us,39.5us,39.549us,39.55us,39.599us,39.6us,39.649us,39.65us,39.699us,39.7us,39.749us,39.75us,39.799us,39.8us,39.849us,39.85us,39.899us,39.9us,39.949us,39.95us,39.999us,40us,40.049us,40.05us,40.099us,40.1us,40.149us,40.15us,40.199us,40.2us,40.249us,40.25us,40.299us,40.3us,40.349us,40.35us,40.399us,40.4us,40.449us,40.45us,40.499us,40.5us,40.549us,40.55us,40.599us,40.6us,40.649us,40.65us,40.699us,40.7us,40.749us,40.75us,40.799us,40.8us,40.849us,40.85us,40.899us,40.9us,40.949us,40.95us,40.999us,41us,41.049us,41.05us,41.099us,41.1us,41.149us,41.15us,41.199us,41.2us,41.249us,41.25us,41.299us,41.3us,41.349us,41.35us,41.399us,41.4us,41.449us,41.45us,41.499us,41.5us,41.549us,41.55us,41.599us,41.6us,41.649us,41.65us,41.699us,41.7us,41.749us,41.75us,41.799us,41.8us,41.849us,41.85us,41.899us,41.9us,41.949us,41.95us,41.999us,42us,42.049us,42.05us,42.099us,42.1us,42.149us,42.15us,42.199us,42.2us,42.249us,42.25us,42.299us,42.3us,42.349us,42.35us,42.399us,42.4us,42.449us,42.45us,42.499us,42.5us,42.549us,42.55us,42.599us,42.6us,42.649us,42.65us,42.699us,42.7us,42.749us,42.75us,42.799us,42.8us,42.849us,42.85us,42.899us,42.9us,42.949us,42.95us,42.999us,43us,43.049us,43.05us,43.099us,43.1us,43.149us,43.15us,43.199us,43.2us,43.249us,43.25us,43.299us,43.3us,43.349us,43.35us,43.399us,43.4us,43.449us,43.45us,43.499us,43.5us,43.549us,43.55us,43.599us,43.6us,43.649us,43.65us,43.699us,43.7us,43.749us,43.75us,43.799us,43.8us,43.849us,43.85us,43.899us,43.9us,43.949us,43.95us,43.999us,44us,44.049us,44.05us,44.099us,44.1us,44.149us,44.15us,44.199us,44.2us,44.249us,44.25us,44.299us,44.3us,44.349us,44.35us,44.399us,44.4us,44.449us,44.45us,44.499us,44.5us,44.549us,44.55us,44.599us,44.6us,44.649us,44.65us,44.699us,44.7us,44.749us,44.75us,44.799us,44.8us,44.849us,44.85us,44.899us,44.9us,44.949us,44.95us,44.999us,45us,45.049us,45.05us,45.099us,45.1us,45.149us,45.15us,45.199us,45.2us,45.249us,45.25us,45.299us,45.3us,45.349us,45.35us,45.399us,45.4us,45.449us,45.45us,45.499us,45.5us,45.549us,45.55us,45.599us,45.6us,45.649us,45.65us,45.699us,45.7us,45.749us,45.75us,45.799us,45.8us,45.849us,45.85us,45.899us,45.9us,45.949us,45.95us,45.999us,46us,46.049us,46.05us,46.099us,46.1us,46.149us,46.15us,46.199us,46.2us,46.249us,46.25us,46.299us,46.3us,46.349us,46.35us,46.399us,46.4us,46.449us,46.45us,46.499us,46.5us,46.549us,46.55us,46.599us,46.6us,46.649us,46.65us,46.699us,46.7us,46.749us,46.75us,46.799us,46.8us,46.849us,46.85us,46.899us,46.9us,46.949us,46.95us,46.999us,47us,47.049us,47.05us,47.099us,47.1us,47.149us,47.15us,47.199us,47.2us,47.249us,47.25us,47.299us,47.3us,47.349us,47.35us,47.399us,47.4us,47.449us,47.45us,47.499us,47.5us,47.549us,47.55us,47.599us,47.6us,47.649us,47.65us,47.699us,47.7us,47.749us,47.75us,47.799us,47.8us,47.849us,47.85us,47.899us,47.9us,47.949us,47.95us,47.999us,48us,48.049us,48.05us,48.099us,48.1us,48.149us,48.15us,48.199us,48.2us,48.249us,48.25us,48.299us,48.3us,48.349us,48.35us,48.399us,48.4us,48.449us,48.45us,48.499us,48.5us,48.549us,48.55us,48.599us,48.6us,48.649us,48.65us,48.699us,48.7us,48.749us,48.75us,48.799us,48.8us,48.849us,48.85us,48.899us,48.9us,48.949us,48.95us,48.999us,49us,49.049us,49.05us,49.099us,49.1us,49.149us,49.15us,49.199us,49.2us,49.249us,49.25us,49.299us,49.3us,49.349us,49.35us,49.399us,49.4us,49.449us,49.45us,49.499us,49.5us,49.549us,49.55us,49.599us,49.6us,49.649us,49.65us,49.699us,49.7us,49.749us,49.75us,49.799us,49.8us,49.849us,49.85us,49.899us,49.9us,49.949us,49.95us,49.999us,50us,50.049us,50.05us,50.099us,50.1us,50.149us,50.15us,50.199us,50.2us,50.249us,50.25us,50.299us,50.3us,50.349us,50.35us,50.399us,50.4us,50.449us,50.45us,50.499us,50.5us,50.549us,50.55us,50.599us,50.6us,50.649us,50.65us,50.699us,50.7us,50.749us,50.75us,50.799us,50.8us,50.849us,50.85us,50.899us,50.9us,50.949us,50.95us,50.999us,51us,51.049us,51.05us,51.099us,51.1us,51.149us,51.15us,51.199us,51.2us,51.249us,51.25us,51.299us,51.3us,51.349us,51.35us,51.399us,51.4us,51.449us,51.45us,51.499us,51.5us,51.549us,51.55us,51.599us,51.6us,51.649us,51.65us,51.699us,51.7us,51.749us,51.75us,51.799us,51.8us,51.849us,51.85us,51.899us,51.9us,51.949us,51.95us,51.999us,52us,52.049us,52.05us,52.099us,52.1us,52.149us,52.15us,52.199us,52.2us,52.249us,52.25us,52.299us,52.3us,52.349us,52.35us,52.399us,52.4us,52.449us,52.45us,52.499us,52.5us,52.549us,52.55us,52.599us,52.6us,52.649us,52.65us,52.699us,52.7us,52.749us,52.75us,52.799us,52.8us,52.849us,52.85us,52.899us,52.9us,52.949us,52.95us,52.999us,53us,53.049us,53.05us,53.099us,53.1us,53.149us,53.15us,53.199us,53.2us,53.249us,53.25us,53.299us,53.3us,53.349us,53.35us,53.399us,53.4us,53.449us,53.45us,53.499us,53.5us,53.549us,53.55us,53.599us,53.6us,53.649us,53.65us,53.699us,53.7us,53.749us,53.75us,53.799us,53.8us,53.849us,53.85us,53.899us,53.9us,53.949us,53.95us,53.999us,54us,54.049us,54.05us,54.099us,54.1us,54.149us,54.15us,54.199us,54.2us,54.249us,54.25us,54.299us,54.3us,54.349us,54.35us,54.399us,54.4us,54.449us,54.45us,54.499us,54.5us,54.549us,54.55us,54.599us,54.6us,54.649us,54.65us,54.699us,54.7us,54.749us,54.75us,54.799us,54.8us,54.849us,54.85us,54.899us,54.9us,54.949us,54.95us,54.999us,55us,55.049us,55.05us,55.099us,55.1us,55.149us,55.15us,55.199us,55.2us,55.249us,55.25us,55.299us,55.3us,55.349us,55.35us,55.399us,55.4us,55.449us,55.45us,55.499us,55.5us,55.549us,55.55us,55.599us,55.6us,55.649us,55.65us,55.699us,55.7us,55.749us,55.75us,55.799us,55.8us,55.849us,55.85us,55.899us,55.9us,55.949us,55.95us,55.999us,56us,56.049us,56.05us,56.099us,56.1us,56.149us,56.15us,56.199us,56.2us,56.249us,56.25us,56.299us,56.3us,56.349us,56.35us,56.399us,56.4us,56.449us,56.45us,56.499us,56.5us,56.549us,56.55us,56.599us,56.6us,56.649us,56.65us,56.699us,56.7us,56.749us,56.75us,56.799us,56.8us,56.849us,56.85us,56.899us,56.9us,56.949us,56.95us,56.999us,57us,57.049us,57.05us,57.099us,57.1us,57.149us,57.15us,57.199us,57.2us,57.249us,57.25us,57.299us,57.3us,57.349us,57.35us,57.399us,57.4us,57.449us,57.45us,57.499us,57.5us,57.549us,57.55us,57.599us,57.6us,57.649us,57.65us,57.699us,57.7us,57.749us,57.75us,57.799us,57.8us,57.849us,57.85us,57.899us,57.9us,57.949us,57.95us,57.999us,58us,58.049us,58.05us,58.099us,58.1us,58.149us,58.15us,58.199us,58.2us,58.249us,58.25us,58.299us,58.3us,58.349us,58.35us,58.399us,58.4us,58.449us,58.45us,58.499us,58.5us,58.549us,58.55us,58.599us,58.6us,58.649us,58.65us,58.699us,58.7us,58.749us,58.75us,58.799us,58.8us,58.849us,58.85us,58.899us,58.9us,58.949us,58.95us,58.999us,59us,59.049us,59.05us,59.099us,59.1us,59.149us,59.15us,59.199us,59.2us,59.249us,59.25us,59.299us,59.3us,59.349us,59.35us,59.399us,59.4us,59.449us,59.45us,59.499us,59.5us,59.549us,59.55us,59.599us,59.6us,59.649us,59.65us,59.699us,59.7us,59.749us,59.75us,59.799us,59.8us,59.849us,59.85us,59.899us,59.9us,59.949us,59.95us,59.999us,60us,60.049us,60.05us,60.099us,60.1us,60.149us,60.15us,60.199us,60.2us,60.249us,60.25us,60.299us,60.3us,60.349us,60.35us,60.399us,60.4us,60.449us,60.45us,60.499us,60.5us,60.549us,60.55us,60.599us,60.6us,60.649us,60.65us,60.699us,60.7us,60.749us,60.75us,60.799us,60.8us,60.849us,60.85us,60.899us,60.9us,60.949us,60.95us,60.999us,61us,61.049us,61.05us,61.099us,61.1us,61.149us,61.15us,61.199us,61.2us,61.249us,61.25us,61.299us,61.3us,61.349us,61.35us,61.399us,61.4us,61.449us,61.45us,61.499us,61.5us,61.549us,61.55us,61.599us,61.6us,61.649us,61.65us,61.699us,61.7us,61.749us,61.75us,61.799us,61.8us,61.849us,61.85us,61.899us,61.9us,61.949us,61.95us,61.999us,62us,62.049us,62.05us,62.099us,62.1us,62.149us,62.15us,62.199us,62.2us,62.249us,62.25us,62.299us,62.3us,62.349us,62.35us,62.399us,62.4us,62.449us,62.45us,62.499us,62.5us,62.549us,62.55us,62.599us,62.6us,62.649us,62.65us,62.699us,62.7us,62.749us,62.75us,62.799us,62.8us,62.849us,62.85us,62.899us,62.9us,62.949us,62.95us,62.999us,63us,63.049us,63.05us,63.099us,63.1us,63.149us,63.15us,63.199us,63.2us,63.249us,63.25us,63.299us,63.3us,63.349us,63.35us,63.399us,63.4us,63.449us,63.45us,63.499us,63.5us,63.549us,63.55us,63.599us,63.6us,63.649us,63.65us,63.699us,63.7us,63.749us,63.75us,63.799us,63.8us,63.849us,63.85us,63.899us,63.9us,63.949us,63.95us,63.999us,64us,64.049us,64.05us,64.099us,64.1us,64.149us,64.15us,64.199us,64.2us,64.249us,64.25us,64.299us,64.3us,64.349us,64.35us,64.399us,64.4us,64.449us,64.45us,64.499us,64.5us,64.549us,64.55us,64.599us,64.6us,64.649us,64.65us,64.699us,64.7us,64.749us,64.75us,64.799us,64.8us,64.849us,64.85us,64.899us,64.9us,64.949us,64.95us,64.999us,65us,65.049us,65.05us,65.099us,65.1us,65.149us,65.15us,65.199us,65.2us,65.249us,65.25us,65.299us,65.3us,65.349us,65.35us,65.399us,65.4us,65.449us,65.45us,65.499us,65.5us,65.549us,65.55us,65.599us,65.6us,65.649us,65.65us,65.699us,65.7us,65.749us,65.75us,65.799us,65.8us,65.849us,65.85us,65.899us,65.9us,65.949us,65.95us,65.999us,66us,66.049us,66.05us,66.099us,66.1us,66.149us,66.15us,66.199us,66.2us,66.249us,66.25us,66.299us,66.3us,66.349us,66.35us,66.399us,66.4us,66.449us,66.45us,66.499us,66.5us,66.549us,66.55us,66.599us,66.6us,66.649us,66.65us,66.699us,66.7us,66.749us,66.75us,66.799us,66.8us,66.849us,66.85us,66.899us,66.9us,66.949us,66.95us,66.999us,67us,67.049us,67.05us,67.099us,67.1us,67.149us,67.15us,67.199us,67.2us,67.249us,67.25us,67.299us,67.3us,67.349us,67.35us,67.399us,67.4us,67.449us,67.45us,67.499us,67.5us,67.549us,67.55us,67.599us,67.6us,67.649us,67.65us,67.699us,67.7us,67.749us,67.75us,67.799us,67.8us,67.849us,67.85us,67.899us,67.9us,67.949us,67.95us,67.999us,68us,68.049us,68.05us,68.099us,68.1us,68.149us,68.15us,68.199us,68.2us,68.249us,68.25us,68.299us,68.3us,68.349us,68.35us,68.399us,68.4us,68.449us,68.45us,68.499us,68.5us,68.549us,68.55us,68.599us,68.6us,68.649us,68.65us,68.699us,68.7us,68.749us,68.75us,68.799us,68.8us,68.849us,68.85us,68.899us,68.9us,68.949us,68.95us,68.999us,69us,69.049us,69.05us,69.099us,69.1us,69.149us,69.15us,69.199us,69.2us,69.249us,69.25us,69.299us,69.3us,69.349us,69.35us,69.399us,69.4us,69.449us,69.45us,69.499us,69.5us,69.549us,69.55us,69.599us,69.6us,69.649us,69.65us,69.699us,69.7us,69.749us,69.75us,69.799us,69.8us,69.849us,69.85us,69.899us,69.9us,69.949us,69.95us,69.999us,70us,70.049us,70.05us,70.099us,70.1us,70.149us,70.15us,70.199us,70.2us,70.249us,70.25us,70.299us,70.3us,70.349us,70.35us,70.399us,70.4us,70.449us,70.45us,70.499us,70.5us,70.549us,70.55us,70.599us,70.6us,70.649us,70.65us,70.699us,70.7us,70.749us,70.75us,70.799us,70.8us,70.849us,70.85us,70.899us,70.9us,70.949us,70.95us,70.999us,71us,71.049us,71.05us,71.099us,71.1us,71.149us,71.15us,71.199us,71.2us,71.249us,71.25us,71.299us,71.3us,71.349us,71.35us,71.399us,71.4us,71.449us,71.45us,71.499us,71.5us,71.549us,71.55us,71.599us,71.6us,71.649us,71.65us,71.699us,71.7us,71.749us,71.75us,71.799us,71.8us,71.849us,71.85us,71.899us,71.9us,71.949us,71.95us,71.999us,72us,72.049us,72.05us,72.099us,72.1us,72.149us,72.15us,72.199us,72.2us,72.249us,72.25us,72.299us,72.3us,72.349us,72.35us,72.399us,72.4us,72.449us,72.45us,72.499us,72.5us,72.549us,72.55us,72.599us,72.6us,72.649us,72.65us,72.699us,72.7us,72.749us,72.75us,72.799us,72.8us,72.849us,72.85us,72.899us,72.9us,72.949us,72.95us,72.999us,73us,73.049us,73.05us,73.099us,73.1us,73.149us,73.15us,73.199us,73.2us,73.249us,73.25us,73.299us,73.3us,73.349us,73.35us,73.399us,73.4us,73.449us,73.45us,73.499us,73.5us,73.549us,73.55us,73.599us,73.6us,73.649us,73.65us,73.699us,73.7us,73.749us,73.75us,73.799us,73.8us,73.849us,73.85us,73.899us,73.9us,73.949us,73.95us,73.999us,74us,74.049us,74.05us,74.099us,74.1us,74.149us,74.15us,74.199us,74.2us,74.249us,74.25us,74.299us,74.3us,74.349us,74.35us,74.399us,74.4us,74.449us,74.45us,74.499us,74.5us,74.549us,74.55us,74.599us,74.6us,74.649us,74.65us,74.699us,74.7us,74.749us,74.75us,74.799us,74.8us,74.849us,74.85us,74.899us,74.9us,74.949us,74.95us,74.999us,75us,75.049us,75.05us,75.099us,75.1us,75.149us,75.15us,75.199us,75.2us,75.249us,75.25us,75.299us,75.3us,75.349us,75.35us,75.399us,75.4us,75.449us,75.45us,75.499us,75.5us,75.549us,75.55us,75.599us,75.6us,75.649us,75.65us,75.699us,75.7us,75.749us,75.75us,75.799us,75.8us,75.849us,75.85us,75.899us,75.9us,75.949us,75.95us,75.999us,76us,76.049us,76.05us,76.099us,76.1us,76.149us,76.15us,76.199us,76.2us,76.249us,76.25us,76.299us,76.3us,76.349us,76.35us,76.399us,76.4us,76.449us,76.45us,76.499us,76.5us,76.549us,76.55us,76.599us,76.6us,76.649us,76.65us,76.699us,76.7us,76.749us,76.75us,76.799us,76.8us,76.849us,76.85us,76.899us,76.9us,76.949us,76.95us,76.999us,77us,77.049us,77.05us,77.099us,77.1us,77.149us,77.15us,77.199us,77.2us,77.249us,77.25us,77.299us,77.3us,77.349us,77.35us,77.399us,77.4us,77.449us,77.45us,77.499us,77.5us,77.549us,77.55us,77.599us,77.6us,77.649us,77.65us,77.699us,77.7us,77.749us,77.75us,77.799us,77.8us,77.849us,77.85us,77.899us,77.9us,77.949us,77.95us,77.999us,78us,78.049us,78.05us,78.099us,78.1us,78.149us,78.15us,78.199us,78.2us,78.249us,78.25us,78.299us,78.3us,78.349us,78.35us,78.399us,78.4us,78.449us,78.45us,78.499us,78.5us,78.549us,78.55us,78.599us,78.6us,78.649us,78.65us,78.699us,78.7us,78.749us,78.75us,78.799us,78.8us,78.849us,78.85us,78.899us,78.9us,78.949us,78.95us,78.999us,79us,79.049us,79.05us,79.099us,79.1us,79.149us,79.15us,79.199us,79.2us,79.249us,79.25us,79.299us,79.3us,79.349us,79.35us,79.399us,79.4us,79.449us,79.45us,79.499us,79.5us,79.549us,79.55us,79.599us,79.6us,79.649us,79.65us,79.699us,79.7us,79.749us,79.75us,79.799us,79.8us,79.849us,79.85us,79.899us,79.9us,79.949us,79.95us,79.999us,80us,80.049us,80.05us,80.099us,80.1us,80.149us,80.15us,80.199us,80.2us,80.249us,80.25us,80.299us,80.3us,80.349us,80.35us,80.399us,80.4us,80.449us,80.45us,80.499us,80.5us,80.549us,80.55us,80.599us,80.6us,80.649us,80.65us,80.699us,80.7us,80.749us,80.75us,80.799us,80.8us,80.849us,80.85us,80.899us,80.9us,80.949us,80.95us,80.999us,81us,81.049us,81.05us,81.099us,81.1us,81.149us,81.15us,81.199us,81.2us,81.249us,81.25us,81.299us,81.3us,81.349us,81.35us,81.399us,81.4us,81.449us,81.45us,81.499us,81.5us,81.549us,81.55us,81.599us,81.6us,81.649us,81.65us,81.699us,81.7us,81.749us,81.75us,81.799us,81.8us,81.849us,81.85us,81.899us,81.9us,81.949us,81.95us,81.999us,82us,82.049us,82.05us,82.099us,82.1us,82.149us,82.15us,82.199us,82.2us,82.249us,82.25us,82.299us,82.3us,82.349us,82.35us,82.399us,82.4us,82.449us,82.45us,82.499us,82.5us,82.549us,82.55us,82.599us,82.6us,82.649us,82.65us,82.699us,82.7us,82.749us,82.75us,82.799us,82.8us,82.849us,82.85us,82.899us,82.9us,82.949us,82.95us,82.999us,83us,83.049us,83.05us,83.099us,83.1us,83.149us,83.15us,83.199us,83.2us,83.249us,83.25us,83.299us,83.3us,83.349us,83.35us,83.399us,83.4us,83.449us,83.45us,83.499us,83.5us,83.549us,83.55us,83.599us,83.6us,83.649us,83.65us,83.699us,83.7us,83.749us,83.75us,83.799us,83.8us,83.849us,83.85us,83.899us,83.9us,83.949us,83.95us,83.999us,84us,84.049us,84.05us,84.099us,84.1us,84.149us,84.15us,84.199us,84.2us,84.249us,84.25us,84.299us,84.3us,84.349us,84.35us,84.399us,84.4us,84.449us,84.45us,84.499us,84.5us,84.549us,84.55us,84.599us,84.6us,84.649us,84.65us,84.699us,84.7us,84.749us,84.75us,84.799us,84.8us,84.849us,84.85us,84.899us,84.9us,84.949us,84.95us,84.999us,85us,85.049us,85.05us,85.099us,85.1us,85.149us,85.15us,85.199us,85.2us,85.249us,85.25us,85.299us,85.3us,85.349us,85.35us,85.399us,85.4us,85.449us,85.45us,85.499us,85.5us,85.549us,85.55us,85.599us,85.6us,85.649us,85.65us,85.699us,85.7us,85.749us,85.75us,85.799us,85.8us,85.849us,85.85us,85.899us,85.9us,85.949us,85.95us,85.999us,86us,86.049us,86.05us,86.099us,86.1us,86.149us,86.15us,86.199us,86.2us,86.249us,86.25us,86.299us,86.3us,86.349us,86.35us,86.399us,86.4us,86.449us,86.45us,86.499us,86.5us,86.549us,86.55us,86.599us,86.6us,86.649us,86.65us,86.699us,86.7us,86.749us,86.75us,86.799us,86.8us,86.849us,86.85us,86.899us,86.9us,86.949us,86.95us,86.999us,87us,87.049us,87.05us,87.099us,87.1us,87.149us,87.15us,87.199us,87.2us,87.249us,87.25us,87.299us,87.3us,87.349us,87.35us,87.399us,87.4us,87.449us,87.45us,87.499us,87.5us,87.549us,87.55us,87.599us,87.6us,87.649us,87.65us,87.699us,87.7us,87.749us,87.75us,87.799us,87.8us,87.849us,87.85us,87.899us,87.9us,87.949us,87.95us,87.999us,88us,88.049us,88.05us,88.099us,88.1us,88.149us,88.15us,88.199us,88.2us,88.249us,88.25us,88.299us,88.3us,88.349us,88.35us,88.399us,88.4us,88.449us,88.45us,88.499us,88.5us,88.549us,88.55us,88.599us,88.6us,88.649us,88.65us,88.699us,88.7us,88.749us,88.75us,88.799us,88.8us,88.849us,88.85us,88.899us,88.9us,88.949us,88.95us,88.999us,89us,89.049us,89.05us,89.099us,89.1us,89.149us,89.15us,89.199us,89.2us,89.249us,89.25us,89.299us,89.3us,89.349us,89.35us,89.399us,89.4us,89.449us,89.45us,89.499us,89.5us,89.549us,89.55us,89.599us,89.6us,89.649us,89.65us,89.699us,89.7us,89.749us,89.75us,89.799us,89.8us,89.849us,89.85us,89.899us,89.9us,89.949us,89.95us,89.999us,90us,90.049us,90.05us,90.099us,90.1us,90.149us,90.15us,90.199us,90.2us,90.249us,90.25us,90.299us,90.3us,90.349us,90.35us,90.399us,90.4us,90.449us,90.45us,90.499us,90.5us,90.549us,90.55us,90.599us,90.6us,90.649us,90.65us,90.699us,90.7us,90.749us,90.75us,90.799us,90.8us,90.849us,90.85us,90.899us,90.9us,90.949us,90.95us,90.999us,91us,91.049us,91.05us,91.099us,91.1us,91.149us,91.15us,91.199us,91.2us,91.249us,91.25us,91.299us,91.3us,91.349us,91.35us,91.399us,91.4us,91.449us,91.45us,91.499us,91.5us,91.549us,91.55us,91.599us,91.6us,91.649us,91.65us,91.699us,91.7us,91.749us,91.75us,91.799us,91.8us,91.849us,91.85us,91.899us,91.9us,91.949us,91.95us,91.999us,92us,92.049us,92.05us,92.099us,92.1us,92.149us,92.15us,92.199us,92.2us,92.249us,92.25us,92.299us,92.3us,92.349us,92.35us,92.399us,92.4us,92.449us,92.45us,92.499us,92.5us,92.549us,92.55us,92.599us,92.6us,92.649us,92.65us,92.699us,92.7us,92.749us,92.75us,92.799us,92.8us,92.849us,92.85us,92.899us,92.9us,92.949us,92.95us,92.999us,93us,93.049us,93.05us,93.099us,93.1us,93.149us,93.15us,93.199us,93.2us,93.249us,93.25us,93.299us,93.3us,93.349us,93.35us,93.399us,93.4us,93.449us,93.45us,93.499us,93.5us,93.549us,93.55us,93.599us,93.6us,93.649us,93.65us,93.699us,93.7us,93.749us,93.75us,93.799us,93.8us,93.849us,93.85us,93.899us,93.9us,93.949us,93.95us,93.999us,94us,94.049us,94.05us,94.099us,94.1us,94.149us,94.15us,94.199us,94.2us,94.249us,94.25us,94.299us,94.3us,94.349us,94.35us,94.399us,94.4us,94.449us,94.45us,94.499us,94.5us,94.549us,94.55us,94.599us,94.6us,94.649us,94.65us,94.699us,94.7us,94.749us,94.75us,94.799us,94.8us,94.849us,94.85us,94.899us,94.9us,94.949us,94.95us,94.999us,95us,95.049us,95.05us,95.099us,95.1us,95.149us,95.15us,95.199us,95.2us,95.249us,95.25us,95.299us,95.3us,95.349us,95.35us,95.399us,95.4us,95.449us,95.45us,95.499us,95.5us,95.549us,95.55us,95.599us,95.6us,95.649us,95.65us,95.699us,95.7us,95.749us,95.75us,95.799us,95.8us,95.849us,95.85us,95.899us,95.9us,95.949us,95.95us,95.999us,96us,96.049us,96.05us,96.099us,96.1us,96.149us,96.15us,96.199us,96.2us,96.249us,96.25us,96.299us,96.3us,96.349us,96.35us,96.399us,96.4us,96.449us,96.45us,96.499us,96.5us,96.549us,96.55us,96.599us,96.6us,96.649us,96.65us,96.699us,96.7us,96.749us,96.75us,96.799us,96.8us,96.849us,96.85us,96.899us,96.9us,96.949us,96.95us,96.999us,97us,97.049us,97.05us,97.099us,97.1us,97.149us,97.15us,97.199us,97.2us,97.249us,97.25us,97.299us,97.3us,97.349us,97.35us,97.399us,97.4us,97.449us,97.45us,97.499us,97.5us,97.549us,97.55us,97.599us,97.6us,97.649us,97.65us,97.699us,97.7us,97.749us,97.75us,97.799us,97.8us,97.849us,97.85us,97.899us,97.9us,97.949us,97.95us,97.999us,98us,98.049us,98.05us,98.099us,98.1us,98.149us,98.15us,98.199us,98.2us,98.249us,98.25us,98.299us,98.3us,98.349us,98.35us,98.399us,98.4us,98.449us,98.45us,98.499us,98.5us,98.549us,98.55us,98.599us,98.6us,98.649us,98.65us,98.699us,98.7us,98.749us,98.75us,98.799us,98.8us,98.849us,98.85us,98.899us,98.9us,98.949us,98.95us,98.999us,99us,99.049us,99.05us,99.099us,99.1us,99.149us,99.15us,99.199us,99.2us,99.249us,99.25us,99.299us,99.3us,99.349us,99.35us,99.399us,99.4us,99.449us,99.45us,99.499us,99.5us,99.549us,99.55us,99.599us,99.6us,99.649us,99.65us,99.699us,99.7us,99.749us,99.75us,99.799us,99.8us,99.849us,99.85us,99.899us,99.9us,99.949us,99.95us,99.999us,100us,100.049us,100.05us,100.099us,100.1us,100.149us,100.15us,100.199us,100.2us,100.249us,100.25us,100.299us,100.3us,100.349us,100.35us,100.399us,100.4us,100.449us,100.45us,100.499us,100.5us,100.549us,100.55us,100.599us,100.6us,100.649us,100.65us,100.699us,100.7us,100.749us,100.75us,100.799us,100.8us,100.849us,100.85us,100.899us,100.9us,100.949us,100.95us,100.999us,101us,101.049us,101.05us,101.099us,101.1us,101.149us,101.15us,101.199us,101.2us,101.249us,101.25us,101.299us,101.3us,101.349us,101.35us,101.399us,101.4us,101.449us,101.45us,101.499us,101.5us,101.549us,101.55us,101.599us,101.6us,101.649us,101.65us,101.699us,101.7us,101.749us,101.75us,101.799us,101.8us,101.849us,101.85us,101.899us,101.9us,101.949us,101.95us,101.999us,102us,102.049us,102.05us,102.099us,102.1us,102.149us,102.15us,102.199us,102.2us,102.249us,102.25us,102.299us,102.3us,102.349us,102.35us,102.399us,102.4us,102.449us,102.45us,102.499us,102.5us,102.549us,102.55us,102.599us,102.6us,102.649us,102.65us,102.699us,102.7us,102.749us,102.75us,102.799us,102.8us,102.849us,102.85us,102.899us,102.9us,102.949us,102.95us,102.999us,103us,103.049us,103.05us,103.099us,103.1us,103.149us,103.15us,103.199us,103.2us,103.249us,103.25us,103.299us,103.3us,103.349us,103.35us,103.399us,103.4us,103.449us,103.45us,103.499us,103.5us,103.549us,103.55us,103.599us,103.6us,103.649us,103.65us,103.699us,103.7us,103.749us,103.75us,103.799us,103.8us,103.849us,103.85us,103.899us,103.9us,103.949us,103.95us,103.999us,104us,104.049us,104.05us,104.099us,104.1us,104.149us,104.15us,104.199us,104.2us,104.249us,104.25us,104.299us,104.3us,104.349us,104.35us,104.399us,104.4us,104.449us,104.45us,104.499us,104.5us,104.549us,104.55us,104.599us,104.6us,104.649us,104.65us,104.699us,104.7us,104.749us,104.75us,104.799us,104.8us,104.849us,104.85us,104.899us,104.9us,104.949us,104.95us,104.999us,105us,105.049us,105.05us,105.099us,105.1us,105.149us,105.15us,105.199us,105.2us,105.249us,105.25us,105.299us,105.3us,105.349us,105.35us,105.399us,105.4us,105.449us,105.45us,105.499us,105.5us,105.549us,105.55us,105.599us,105.6us,105.649us,105.65us,105.699us,105.7us,105.749us,105.75us,105.799us,105.8us,105.849us,105.85us,105.899us,105.9us,105.949us,105.95us,105.999us,106us,106.049us,106.05us,106.099us,106.1us,106.149us,106.15us,106.199us,106.2us,106.249us,106.25us,106.299us,106.3us,106.349us,106.35us,106.399us,106.4us,106.449us,106.45us,106.499us,106.5us,106.549us,106.55us,106.599us,106.6us,106.649us,106.65us,106.699us,106.7us,106.749us,106.75us,106.799us,106.8us,106.849us,106.85us,106.899us,106.9us,106.949us,106.95us,106.999us,107us,107.049us,107.05us,107.099us,107.1us,107.149us,107.15us,107.199us,107.2us,107.249us,107.25us,107.299us,107.3us,107.349us,107.35us,107.399us,107.4us,107.449us,107.45us,107.499us,107.5us,107.549us,107.55us,107.599us,107.6us,107.649us,107.65us,107.699us,107.7us,107.749us,107.75us,107.799us,107.8us,107.849us,107.85us,107.899us,107.9us,107.949us,107.95us,107.999us,108us,108.049us,108.05us,108.099us,108.1us,108.149us,108.15us,108.199us,108.2us,108.249us,108.25us,108.299us,108.3us,108.349us,108.35us,108.399us,108.4us,108.449us,108.45us,108.499us,108.5us,108.549us,108.55us,108.599us,108.6us,108.649us,108.65us,108.699us,108.7us,108.749us,108.75us,108.799us,108.8us,108.849us,108.85us,108.899us,108.9us,108.949us,108.95us,108.999us,109us,109.049us,109.05us,109.099us,109.1us,109.149us,109.15us,109.199us,109.2us,109.249us,109.25us,109.299us,109.3us,109.349us,109.35us,109.399us,109.4us,109.449us,109.45us,109.499us,109.5us,109.549us,109.55us,109.599us,109.6us,109.649us,109.65us,109.699us,109.7us,109.749us,109.75us,109.799us,109.8us,109.849us,109.85us,109.899us,109.9us,109.949us,109.95us,109.999us,110us,110.049us,110.05us,110.099us,110.1us,110.149us,110.15us,110.199us,110.2us,110.249us,110.25us,110.299us,110.3us,110.349us,110.35us,110.399us,110.4us,110.449us,110.45us,110.499us,110.5us,110.549us,110.55us,110.599us,110.6us,110.649us,110.65us,110.699us,110.7us,110.749us,110.75us,110.799us,110.8us,110.849us,110.85us,110.899us,110.9us,110.949us,110.95us,110.999us,111us,111.049us,111.05us,111.099us,111.1us,111.149us,111.15us,111.199us,111.2us,111.249us,111.25us,111.299us,111.3us,111.349us,111.35us,111.399us,111.4us,111.449us,111.45us,111.499us,111.5us,111.549us,111.55us,111.599us,111.6us,111.649us,111.65us,111.699us,111.7us,111.749us,111.75us,111.799us,111.8us,111.849us,111.85us,111.899us,111.9us,111.949us,111.95us,111.999us,112us,112.049us,112.05us,112.099us,112.1us,112.149us,112.15us,112.199us,112.2us,112.249us,112.25us,112.299us,112.3us,112.349us,112.35us,112.399us,112.4us,112.449us,112.45us,112.499us,112.5us,112.549us,112.55us,112.599us,112.6us,112.649us,112.65us,112.699us,112.7us,112.749us,112.75us,112.799us,112.8us,112.849us,112.85us,112.899us,112.9us,112.949us,112.95us,112.999us,113us,113.049us,113.05us,113.099us,113.1us,113.149us,113.15us,113.199us,113.2us,113.249us,113.25us,113.299us,113.3us,113.349us,113.35us,113.399us,113.4us,113.449us,113.45us,113.499us,113.5us,113.549us,113.55us,113.599us,113.6us,113.649us,113.65us,113.699us,113.7us,113.749us,113.75us,113.799us,113.8us,113.849us,113.85us,113.899us,113.9us,113.949us,113.95us,113.999us,114us,114.049us,114.05us,114.099us,114.1us,114.149us,114.15us,114.199us,114.2us,114.249us,114.25us,114.299us,114.3us,114.349us,114.35us,114.399us,114.4us,114.449us,114.45us,114.499us,114.5us,114.549us,114.55us,114.599us,114.6us,114.649us,114.65us,114.699us,114.7us,114.749us,114.75us,114.799us,114.8us,114.849us,114.85us,114.899us,114.9us,114.949us,114.95us,114.999us,115us,115.049us,115.05us,115.099us,115.1us,115.149us,115.15us,115.199us,115.2us,115.249us,115.25us,115.299us,115.3us,115.349us,115.35us,115.399us,115.4us,115.449us,115.45us,115.499us,115.5us,115.549us,115.55us,115.599us,115.6us,115.649us,115.65us,115.699us,115.7us,115.749us,115.75us,115.799us,115.8us,115.849us,115.85us,115.899us,115.9us,115.949us,115.95us,115.999us,116us,116.049us,116.05us,116.099us,116.1us,116.149us,116.15us,116.199us,116.2us,116.249us,116.25us,116.299us,116.3us,116.349us,116.35us,116.399us,116.4us,116.449us,116.45us,116.499us,116.5us,116.549us,116.55us,116.599us,116.6us,116.649us,116.65us,116.699us,116.7us,116.749us,116.75us,116.799us,116.8us,116.849us,116.85us,116.899us,116.9us,116.949us,116.95us,116.999us,117us,117.049us,117.05us,117.099us,117.1us,117.149us,117.15us,117.199us,117.2us,117.249us,117.25us,117.299us,117.3us,117.349us,117.35us,117.399us,117.4us,117.449us,117.45us,117.499us,117.5us,117.549us,117.55us,117.599us,117.6us,117.649us,117.65us,117.699us,117.7us,117.749us,117.75us,117.799us,117.8us,117.849us,117.85us,117.899us,117.9us,117.949us,117.95us,117.999us,118us,118.049us,118.05us,118.099us,118.1us,118.149us,118.15us,118.199us,118.2us,118.249us,118.25us,118.299us,118.3us,118.349us,118.35us,118.399us,118.4us,118.449us,118.45us,118.499us,118.5us,118.549us,118.55us,118.599us,118.6us,118.649us,118.65us,118.699us,118.7us,118.749us,118.75us,118.799us,118.8us,118.849us,118.85us,118.899us,118.9us,118.949us,118.95us,118.999us,119us,119.049us,119.05us,119.099us,119.1us,119.149us,119.15us,119.199us,119.2us,119.249us,119.25us,119.299us,119.3us,119.349us,119.35us,119.399us,119.4us,119.449us,119.45us,119.499us,119.5us,119.549us,119.55us,119.599us,119.6us,119.649us,119.65us,119.699us,119.7us,119.749us,119.75us,119.799us,119.8us,119.849us,119.85us,119.899us,119.9us,119.949us,119.95us,119.999us,120us,120.049us,120.05us,120.099us,120.1us,120.149us,120.15us,120.199us,120.2us,120.249us,120.25us,120.299us,120.3us,120.349us,120.35us,120.399us,120.4us,120.449us,120.45us,120.499us,120.5us,120.549us,120.55us,120.599us,120.6us,120.649us,120.65us,120.699us,120.7us,120.749us,120.75us,120.799us,120.8us,120.849us,120.85us,120.899us,120.9us,120.949us,120.95us,120.999us,121us,121.049us,121.05us,121.099us,121.1us,121.149us,121.15us,121.199us,121.2us,121.249us,121.25us,121.299us,121.3us,121.349us,121.35us,121.399us,121.4us,121.449us,121.45us,121.499us,121.5us,121.549us,121.55us,121.599us,121.6us,121.649us,121.65us,121.699us,121.7us,121.749us,121.75us,121.799us,121.8us,121.849us,121.85us,121.899us,121.9us,121.949us,121.95us,121.999us,122us,122.049us,122.05us,122.099us,122.1us,122.149us,122.15us,122.199us,122.2us,122.249us,122.25us,122.299us,122.3us,122.349us,122.35us,122.399us,122.4us,122.449us,122.45us,122.499us,122.5us,122.549us,122.55us,122.599us,122.6us,122.649us,122.65us,122.699us,122.7us,122.749us,122.75us,122.799us,122.8us,122.849us,122.85us,122.899us,122.9us,122.949us,122.95us,122.999us,123us,123.049us,123.05us,123.099us,123.1us,123.149us,123.15us,123.199us,123.2us,123.249us,123.25us,123.299us,123.3us,123.349us,123.35us,123.399us,123.4us,123.449us,123.45us,123.499us,123.5us,123.549us,123.55us,123.599us,123.6us,123.649us,123.65us,123.699us,123.7us,123.749us,123.75us,123.799us,123.8us,123.849us,123.85us,123.899us,123.9us,123.949us,123.95us,123.999us,124us,124.049us,124.05us,124.099us,124.1us,124.149us,124.15us,124.199us,124.2us,124.249us,124.25us,124.299us,124.3us,124.349us,124.35us,124.399us,124.4us,124.449us,124.45us,124.499us,124.5us,124.549us,124.55us,124.599us,124.6us,124.649us,124.65us,124.699us,124.7us,124.749us,124.75us,124.799us,124.8us,124.849us,124.85us,124.899us,124.9us,124.949us,124.95us,124.999us,125us,125.049us,125.05us,125.099us,125.1us,125.149us,125.15us,125.199us,125.2us,125.249us,125.25us,125.299us,125.3us,125.349us,125.35us,125.399us,125.4us,125.449us,125.45us,125.499us,125.5us,125.549us,125.55us,125.599us,125.6us,125.649us,125.65us,125.699us,125.7us,125.749us,125.75us,125.799us,125.8us,125.849us,125.85us,125.899us,125.9us,125.949us,125.95us,125.999us,126us,126.049us,126.05us,126.099us,126.1us,126.149us,126.15us,126.199us,126.2us,126.249us,126.25us,126.299us,126.3us,126.349us,126.35us,126.399us,126.4us,126.449us,126.45us,126.499us,126.5us,126.549us,126.55us,126.599us,126.6us,126.649us,126.65us,126.699us,126.7us,126.749us,126.75us,126.799us,126.8us,126.849us,126.85us,126.899us,126.9us,126.949us,126.95us,126.999us,127us,127.049us,127.05us,127.099us,127.1us,127.149us,127.15us,127.199us,127.2us,127.249us,127.25us,127.299us,127.3us,127.349us,127.35us,127.399us,127.4us,127.449us,127.45us,127.499us,127.5us,127.549us,127.55us,127.599us,127.6us,127.649us,127.65us,127.699us,127.7us,127.749us,127.75us,127.799us,127.8us,127.849us,127.85us,127.899us,127.9us,127.949us,127.95us,127.999us,128us,128.049us,128.05us,128.099us,128.1us,128.149us,128.15us,128.199us,128.2us,128.249us,128.25us,128.299us,128.3us,128.349us,128.35us,128.399us,128.4us,128.449us,128.45us,128.499us,128.5us,128.549us,128.55us,128.599us,128.6us,128.649us,128.65us,128.699us,128.7us,128.749us,128.75us,128.799us,128.8us,128.849us,128.85us,128.899us,128.9us,128.949us,128.95us,128.999us,129us,129.049us,129.05us,129.099us,129.1us,129.149us,129.15us,129.199us,129.2us,129.249us,129.25us,129.299us,129.3us,129.349us,129.35us,129.399us,129.4us,129.449us,129.45us,129.499us,129.5us,129.549us,129.55us,129.599us,129.6us,129.649us,129.65us,129.699us,129.7us,129.749us,129.75us,129.799us,129.8us,129.849us,129.85us,129.899us,129.9us,129.949us,129.95us,129.999us,130us,130.049us,130.05us,130.099us,130.1us,130.149us,130.15us,130.199us,130.2us,130.249us,130.25us,130.299us,130.3us,130.349us,130.35us,130.399us,130.4us,130.449us,130.45us,130.499us,130.5us,130.549us,130.55us,130.599us,130.6us,130.649us,130.65us,130.699us,130.7us,130.749us,130.75us,130.799us,130.8us,130.849us,130.85us,130.899us,130.9us,130.949us,130.95us,130.999us,131us,131.049us,131.05us,131.099us,131.1us,131.149us,131.15us,131.199us,131.2us,131.249us,131.25us,131.299us,131.3us,131.349us,131.35us,131.399us,131.4us,131.449us,131.45us,131.499us,131.5us,131.549us,131.55us,131.599us,131.6us,131.649us,131.65us,131.699us,131.7us,131.749us,131.75us,131.799us,131.8us,131.849us,131.85us,131.899us,131.9us,131.949us,131.95us,131.999us,132us,132.049us,132.05us,132.099us,132.1us,132.149us,132.15us,132.199us,132.2us,132.249us,132.25us,132.299us,132.3us,132.349us,132.35us,132.399us,132.4us,132.449us,132.45us,132.499us,132.5us,132.549us,132.55us,132.599us,132.6us,132.649us,132.65us,132.699us,132.7us,132.749us,132.75us,132.799us,132.8us,132.849us,132.85us,132.899us,132.9us,132.949us,132.95us,132.999us,133us,133.049us,133.05us,133.099us,133.1us,133.149us,133.15us,133.199us,133.2us,133.249us,133.25us,133.299us,133.3us,133.349us,133.35us,133.399us,133.4us,133.449us,133.45us,133.499us,133.5us,133.549us,133.55us,133.599us,133.6us,133.649us,133.65us,133.699us,133.7us,133.749us,133.75us,133.799us,133.8us,133.849us,133.85us,133.899us,133.9us,133.949us,133.95us,133.999us,134us,134.049us,134.05us,134.099us,134.1us,134.149us,134.15us,134.199us,134.2us,134.249us,134.25us,134.299us,134.3us,134.349us,134.35us,134.399us,134.4us,134.449us,134.45us,134.499us,134.5us,134.549us,134.55us,134.599us,134.6us,134.649us,134.65us,134.699us,134.7us,134.749us,134.75us,134.799us,134.8us,134.849us,134.85us,134.899us,134.9us,134.949us,134.95us,134.999us,135us,135.049us,135.05us,135.099us,135.1us,135.149us,135.15us,135.199us,135.2us,135.249us,135.25us,135.299us,135.3us,135.349us,135.35us,135.399us,135.4us,135.449us,135.45us,135.499us,135.5us,135.549us,135.55us,135.599us,135.6us,135.649us,135.65us,135.699us,135.7us,135.749us,135.75us,135.799us,135.8us,135.849us,135.85us,135.899us,135.9us,135.949us,135.95us,135.999us,136us,136.049us,136.05us,136.099us,136.1us,136.149us,136.15us,136.199us,136.2us,136.249us,136.25us,136.299us,136.3us,136.349us,136.35us,136.399us,136.4us,136.449us,136.45us,136.499us,136.5us,136.549us,136.55us,136.599us,136.6us,136.649us,136.65us,136.699us,136.7us,136.749us,136.75us,136.799us,136.8us,136.849us,136.85us,136.899us,136.9us,136.949us,136.95us,136.999us,137us,137.049us,137.05us,137.099us,137.1us,137.149us,137.15us,137.199us,137.2us,137.249us,137.25us,137.299us,137.3us,137.349us,137.35us,137.399us,137.4us,137.449us,137.45us,137.499us,137.5us,137.549us,137.55us,137.599us,137.6us,137.649us,137.65us,137.699us,137.7us,137.749us,137.75us,137.799us,137.8us,137.849us,137.85us,137.899us,137.9us,137.949us,137.95us,137.999us,138us,138.049us,138.05us,138.099us,138.1us,138.149us,138.15us,138.199us,138.2us,138.249us,138.25us,138.299us,138.3us,138.349us,138.35us,138.399us,138.4us,138.449us,138.45us,138.499us,138.5us,138.549us,138.55us,138.599us,138.6us,138.649us,138.65us,138.699us,138.7us,138.749us,138.75us,138.799us,138.8us,138.849us,138.85us,138.899us,138.9us,138.949us,138.95us,138.999us,139us,139.049us,139.05us,139.099us,139.1us,139.149us,139.15us,139.199us,139.2us,139.249us,139.25us,139.299us,139.3us,139.349us,139.35us,139.399us,139.4us,139.449us,139.45us,139.499us,139.5us,139.549us,139.55us,139.599us,139.6us,139.649us,139.65us,139.699us,139.7us,139.749us,139.75us,139.799us,139.8us,139.849us,139.85us,139.899us,139.9us,139.949us,139.95us,139.999us,140us,140.049us,140.05us,140.099us,140.1us,140.149us,140.15us,140.199us,140.2us,140.249us,140.25us,140.299us,140.3us,140.349us,140.35us,140.399us,140.4us,140.449us,140.45us,140.499us,140.5us,140.549us,140.55us,140.599us,140.6us,140.649us,140.65us,140.699us,140.7us,140.749us,140.75us,140.799us,140.8us,140.849us,140.85us,140.899us,140.9us,140.949us,140.95us,140.999us,141us,141.049us,141.05us,141.099us,141.1us,141.149us,141.15us,141.199us,141.2us,141.249us,141.25us,141.299us,141.3us,141.349us,141.35us,141.399us,141.4us,141.449us,141.45us,141.499us,141.5us,141.549us,141.55us,141.599us,141.6us,141.649us,141.65us,141.699us,141.7us,141.749us,141.75us,141.799us,141.8us,141.849us,141.85us,141.899us,141.9us,141.949us,141.95us,141.999us,142us,142.049us,142.05us,142.099us,142.1us,142.149us,142.15us,142.199us,142.2us,142.249us,142.25us,142.299us,142.3us,142.349us,142.35us,142.399us,142.4us,142.449us,142.45us,142.499us,142.5us,142.549us,142.55us,142.599us,142.6us,142.649us,142.65us,142.699us,142.7us,142.749us,142.75us,142.799us,142.8us,142.849us,142.85us,142.899us,142.9us,142.949us,142.95us,142.999us,143us,143.049us,143.05us,143.099us,143.1us,143.149us,143.15us,143.199us,143.2us,143.249us,143.25us,143.299us,143.3us,143.349us,143.35us,143.399us,143.4us,143.449us,143.45us,143.499us,143.5us,143.549us,143.55us,143.599us,143.6us,143.649us,143.65us,143.699us,143.7us,143.749us,143.75us,143.799us,143.8us,143.849us,143.85us,143.899us,143.9us,143.949us,143.95us,143.999us,144us,144.049us,144.05us,144.099us,144.1us,144.149us,144.15us,144.199us,144.2us,144.249us,144.25us,144.299us,144.3us,144.349us,144.35us,144.399us,144.4us,144.449us,144.45us,144.499us,144.5us,144.549us,144.55us,144.599us,144.6us,144.649us,144.65us,144.699us,144.7us,144.749us,144.75us,144.799us,144.8us,144.849us,144.85us,144.899us,144.9us,144.949us,144.95us,144.999us,145us,145.049us,145.05us,145.099us,145.1us,145.149us,145.15us,145.199us,145.2us,145.249us,145.25us,145.299us,145.3us,145.349us,145.35us,145.399us,145.4us,145.449us,145.45us,145.499us,145.5us,145.549us,145.55us,145.599us,145.6us,145.649us,145.65us,145.699us,145.7us,145.749us,145.75us,145.799us,145.8us,145.849us,145.85us,145.899us,145.9us,145.949us,145.95us,145.999us,146us,146.049us,146.05us,146.099us,146.1us,146.149us,146.15us,146.199us,146.2us,146.249us,146.25us,146.299us,146.3us,146.349us,146.35us,146.399us,146.4us,146.449us,146.45us,146.499us,146.5us,146.549us,146.55us,146.599us,146.6us,146.649us,146.65us,146.699us,146.7us,146.749us,146.75us,146.799us,146.8us,146.849us,146.85us,146.899us,146.9us,146.949us,146.95us,146.999us,147us,147.049us,147.05us,147.099us,147.1us,147.149us,147.15us,147.199us,147.2us,147.249us,147.25us,147.299us,147.3us,147.349us,147.35us,147.399us,147.4us,147.449us,147.45us,147.499us,147.5us,147.549us,147.55us,147.599us,147.6us,147.649us,147.65us,147.699us,147.7us,147.749us,147.75us,147.799us,147.8us,147.849us,147.85us,147.899us,147.9us,147.949us,147.95us,147.999us,148us,148.049us,148.05us,148.099us,148.1us,148.149us,148.15us,148.199us,148.2us,148.249us,148.25us,148.299us,148.3us,148.349us,148.35us,148.399us,148.4us,148.449us,148.45us,148.499us,148.5us,148.549us,148.55us,148.599us,148.6us,148.649us,148.65us,148.699us,148.7us,148.749us,148.75us,148.799us,148.8us,148.849us,148.85us,148.899us,148.9us,148.949us,148.95us,148.999us,149us,149.049us,149.05us,149.099us,149.1us,149.149us,149.15us,149.199us,149.2us,149.249us,149.25us,149.299us,149.3us,149.349us,149.35us,149.399us,149.4us,149.449us,149.45us,149.499us,149.5us,149.549us,149.55us,149.599us,149.6us,149.649us,149.65us,149.699us,149.7us,149.749us,149.75us,149.799us,149.8us,149.849us,149.85us,149.899us,149.9us,149.949us,149.95us,149.999us,150us,150.049us,150.05us,150.099us,150.1us,150.149us,150.15us,150.199us,150.2us,150.249us,150.25us,150.299us,150.3us,150.349us,150.35us,150.399us,150.4us,150.449us,150.45us,150.499us,150.5us,150.549us,150.55us,150.599us,150.6us,150.649us,150.65us,150.699us,150.7us,150.749us,150.75us,150.799us,150.8us,150.849us,150.85us,150.899us,150.9us,150.949us,150.95us,150.999us,151us,151.049us,151.05us,151.099us,151.1us,151.149us,151.15us,151.199us,151.2us,151.249us,151.25us,151.299us,151.3us,151.349us,151.35us,151.399us,151.4us,151.449us,151.45us,151.499us,151.5us,151.549us,151.55us,151.599us,151.6us,151.649us,151.65us,151.699us,151.7us,151.749us,151.75us,151.799us,151.8us,151.849us,151.85us,151.899us,151.9us,151.949us,151.95us,151.999us,152us,152.049us,152.05us,152.099us,152.1us,152.149us,152.15us,152.199us,152.2us,152.249us,152.25us,152.299us,152.3us,152.349us,152.35us,152.399us,152.4us,152.449us,152.45us,152.499us,152.5us,152.549us,152.55us,152.599us,152.6us,152.649us,152.65us,152.699us,152.7us,152.749us,152.75us,152.799us,152.8us,152.849us,152.85us,152.899us,152.9us,152.949us,152.95us,152.999us,153us,153.049us,153.05us,153.099us,153.1us,153.149us,153.15us,153.199us,153.2us,153.249us,153.25us,153.299us,153.3us,153.349us,153.35us,153.399us,153.4us,153.449us,153.45us,153.499us,153.5us,153.549us,153.55us,153.599us,153.6us,153.649us,153.65us,153.699us,153.7us,153.749us,153.75us,153.799us,153.8us,153.849us,153.85us,153.899us,153.9us,153.949us,153.95us,153.999us,154us,154.049us,154.05us,154.099us,154.1us,154.149us,154.15us,154.199us,154.2us,154.249us,154.25us,154.299us,154.3us,154.349us,154.35us,154.399us,154.4us,154.449us,154.45us,154.499us,154.5us,154.549us,154.55us,154.599us,154.6us,154.649us,154.65us,154.699us,154.7us,154.749us,154.75us,154.799us,154.8us,154.849us,154.85us,154.899us,154.9us,154.949us,154.95us,154.999us,155us,155.049us,155.05us,155.099us,155.1us,155.149us,155.15us,155.199us,155.2us,155.249us,155.25us,155.299us,155.3us,155.349us,155.35us,155.399us,155.4us,155.449us,155.45us,155.499us,155.5us,155.549us,155.55us,155.599us,155.6us,155.649us,155.65us,155.699us,155.7us,155.749us,155.75us,155.799us,155.8us,155.849us,155.85us,155.899us,155.9us,155.949us,155.95us,155.999us,156us,156.049us,156.05us,156.099us,156.1us,156.149us,156.15us,156.199us,156.2us,156.249us,156.25us,156.299us,156.3us,156.349us,156.35us,156.399us,156.4us,156.449us,156.45us,156.499us,156.5us,156.549us,156.55us,156.599us,156.6us,156.649us,156.65us,156.699us,156.7us,156.749us,156.75us,156.799us,156.8us,156.849us,156.85us,156.899us,156.9us,156.949us,156.95us,156.999us,157us,157.049us,157.05us,157.099us,157.1us,157.149us,157.15us,157.199us,157.2us,157.249us,157.25us,157.299us,157.3us,157.349us,157.35us,157.399us,157.4us,157.449us,157.45us,157.499us,157.5us,157.549us,157.55us,157.599us,157.6us,157.649us,157.65us,157.699us,157.7us,157.749us,157.75us,157.799us,157.8us,157.849us,157.85us,157.899us,157.9us,157.949us,157.95us,157.999us,158us,158.049us,158.05us,158.099us,158.1us,158.149us,158.15us,158.199us,158.2us,158.249us,158.25us,158.299us,158.3us,158.349us,158.35us,158.399us,158.4us,158.449us,158.45us,158.499us,158.5us,158.549us,158.55us,158.599us,158.6us,158.649us,158.65us,158.699us,158.7us,158.749us,158.75us,158.799us,158.8us,158.849us,158.85us,158.899us,158.9us,158.949us,158.95us,158.999us,159us,159.049us,159.05us,159.099us,159.1us,159.149us,159.15us,159.199us,159.2us,159.249us,159.25us,159.299us,159.3us,159.349us,159.35us,159.399us,159.4us,159.449us,159.45us,159.499us,159.5us,159.549us,159.55us,159.599us,159.6us,159.649us,159.65us,159.699us,159.7us,159.749us,159.75us,159.799us,159.8us,159.849us,159.85us,159.899us,159.9us,159.949us,159.95us,159.999us,160us,160.049us,160.05us,160.099us,160.1us,160.149us,160.15us,160.199us,160.2us,160.249us,160.25us,160.299us,160.3us,160.349us,160.35us,160.399us,160.4us,160.449us,160.45us,160.499us,160.5us,160.549us,160.55us,160.599us,160.6us,160.649us,160.65us,160.699us,160.7us,160.749us,160.75us,160.799us,160.8us,160.849us,160.85us,160.899us,160.9us,160.949us,160.95us,160.999us,161us,161.049us,161.05us,161.099us,161.1us,161.149us,161.15us,161.199us,161.2us,161.249us,161.25us,161.299us,161.3us,161.349us,161.35us,161.399us,161.4us,161.449us,161.45us,161.499us,161.5us,161.549us,161.55us,161.599us,161.6us,161.649us,161.65us,161.699us,161.7us,161.749us,161.75us,161.799us,161.8us,161.849us,161.85us,161.899us,161.9us,161.949us,161.95us,161.999us,162us,162.049us,162.05us,162.099us,162.1us,162.149us,162.15us,162.199us,162.2us,162.249us,162.25us,162.299us,162.3us,162.349us,162.35us,162.399us,162.4us,162.449us,162.45us,162.499us,162.5us,162.549us,162.55us,162.599us,162.6us,162.649us,162.65us,162.699us,162.7us,162.749us,162.75us,162.799us,162.8us,162.849us,162.85us,162.899us,162.9us,162.949us,162.95us,162.999us,163us,163.049us,163.05us,163.099us,163.1us,163.149us,163.15us,163.199us,163.2us,163.249us,163.25us,163.299us,163.3us,163.349us,163.35us,163.399us,163.4us,163.449us,163.45us,163.499us,163.5us,163.549us,163.55us,163.599us,163.6us,163.649us,163.65us,163.699us,163.7us,163.749us,163.75us,163.799us,163.8us,163.849us,163.85us,163.899us,163.9us,163.949us,163.95us,163.999us,164us,164.049us,164.05us,164.099us,164.1us,164.149us,164.15us,164.199us,164.2us,164.249us,164.25us,164.299us,164.3us,164.349us,164.35us,164.399us,164.4us,164.449us,164.45us,164.499us,164.5us,164.549us,164.55us,164.599us,164.6us,164.649us,164.65us,164.699us,164.7us,164.749us,164.75us,164.799us,164.8us,164.849us,164.85us,164.899us,164.9us,164.949us,164.95us,164.999us,165us,165.049us,165.05us,165.099us,165.1us,165.149us,165.15us,165.199us,165.2us,165.249us,165.25us,165.299us,165.3us,165.349us,165.35us,165.399us,165.4us,165.449us,165.45us,165.499us,165.5us,165.549us,165.55us,165.599us,165.6us,165.649us,165.65us,165.699us,165.7us,165.749us,165.75us,165.799us,165.8us,165.849us,165.85us,165.899us,165.9us,165.949us,165.95us,165.999us,166us,166.049us,166.05us,166.099us,166.1us,166.149us,166.15us,166.199us,166.2us,166.249us,166.25us,166.299us,166.3us,166.349us,166.35us,166.399us,166.4us,166.449us,166.45us,166.499us,166.5us,166.549us,166.55us,166.599us,166.6us,166.649us,166.65us,166.699us,166.7us,166.749us,166.75us,166.799us,166.8us,166.849us,166.85us,166.899us,166.9us,166.949us,166.95us,166.999us,167us,167.049us,167.05us,167.099us,167.1us,167.149us,167.15us,167.199us,167.2us,167.249us,167.25us,167.299us,167.3us,167.349us,167.35us,167.399us,167.4us,167.449us,167.45us,167.499us,167.5us,167.549us,167.55us,167.599us,167.6us,167.649us,167.65us,167.699us,167.7us,167.749us,167.75us,167.799us,167.8us,167.849us,167.85us,167.899us,167.9us,167.949us,167.95us,167.999us,168us,168.049us,168.05us,168.099us,168.1us,168.149us,168.15us,168.199us,168.2us,168.249us,168.25us,168.299us,168.3us,168.349us,168.35us,168.399us,168.4us,168.449us,168.45us,168.499us,168.5us,168.549us,168.55us,168.599us,168.6us,168.649us,168.65us,168.699us,168.7us,168.749us,168.75us,168.799us,168.8us,168.849us,168.85us,168.899us,168.9us,168.949us,168.95us,168.999us,169us,169.049us,169.05us,169.099us,169.1us,169.149us,169.15us,169.199us,169.2us,169.249us,169.25us,169.299us,169.3us,169.349us,169.35us,169.399us,169.4us,169.449us,169.45us,169.499us,169.5us,169.549us,169.55us,169.599us,169.6us,169.649us,169.65us,169.699us,169.7us,169.749us,169.75us,169.799us,169.8us,169.849us,169.85us,169.899us,169.9us,169.949us,169.95us,169.999us,170us,170.049us,170.05us,170.099us,170.1us,170.149us,170.15us,170.199us,170.2us,170.249us,170.25us,170.299us,170.3us,170.349us,170.35us,170.399us,170.4us,170.449us,170.45us,170.499us,170.5us,170.549us,170.55us,170.599us,170.6us,170.649us,170.65us,170.699us,170.7us,170.749us,170.75us,170.799us,170.8us,170.849us,170.85us,170.899us,170.9us,170.949us,170.95us,170.999us,171us,171.049us,171.05us,171.099us,171.1us,171.149us,171.15us,171.199us,171.2us,171.249us,171.25us,171.299us,171.3us,171.349us,171.35us,171.399us,171.4us,171.449us,171.45us,171.499us,171.5us,171.549us,171.55us,171.599us,171.6us,171.649us,171.65us,171.699us,171.7us,171.749us,171.75us,171.799us,171.8us,171.849us,171.85us,171.899us,171.9us,171.949us,171.95us,171.999us,172us,172.049us,172.05us,172.099us,172.1us,172.149us,172.15us,172.199us,172.2us,172.249us,172.25us,172.299us,172.3us,172.349us,172.35us,172.399us,172.4us,172.449us,172.45us,172.499us,172.5us,172.549us,172.55us,172.599us,172.6us,172.649us,172.65us,172.699us,172.7us,172.749us,172.75us,172.799us,172.8us,172.849us,172.85us,172.899us,172.9us,172.949us,172.95us,172.999us,173us,173.049us,173.05us,173.099us,173.1us,173.149us,173.15us,173.199us,173.2us,173.249us,173.25us,173.299us,173.3us,173.349us,173.35us,173.399us,173.4us,173.449us,173.45us,173.499us,173.5us,173.549us,173.55us,173.599us,173.6us,173.649us,173.65us,173.699us,173.7us,173.749us,173.75us,173.799us,173.8us,173.849us,173.85us,173.899us,173.9us,173.949us,173.95us,173.999us,174us,174.049us,174.05us,174.099us,174.1us,174.149us,174.15us,174.199us,174.2us,174.249us,174.25us,174.299us,174.3us,174.349us,174.35us,174.399us,174.4us,174.449us,174.45us,174.499us,174.5us,174.549us,174.55us,174.599us,174.6us,174.649us,174.65us,174.699us,174.7us,174.749us,174.75us,174.799us,174.8us,174.849us,174.85us,174.899us,174.9us,174.949us,174.95us,174.999us,175us,175.049us,175.05us,175.099us,175.1us,175.149us,175.15us,175.199us,175.2us,175.249us,175.25us,175.299us,175.3us,175.349us,175.35us,175.399us,175.4us,175.449us,175.45us,175.499us,175.5us,175.549us,175.55us,175.599us,175.6us,175.649us,175.65us,175.699us,175.7us,175.749us,175.75us,175.799us,175.8us,175.849us,175.85us,175.899us,175.9us,175.949us,175.95us,175.999us,176us,176.049us,176.05us,176.099us,176.1us,176.149us,176.15us,176.199us,176.2us,176.249us,176.25us,176.299us,176.3us,176.349us,176.35us,176.399us,176.4us,176.449us,176.45us,176.499us,176.5us,176.549us,176.55us,176.599us,176.6us,176.649us,176.65us,176.699us,176.7us,176.749us,176.75us,176.799us,176.8us,176.849us,176.85us,176.899us,176.9us,176.949us,176.95us,176.999us,177us,177.049us,177.05us,177.099us,177.1us,177.149us,177.15us,177.199us,177.2us,177.249us,177.25us,177.299us,177.3us,177.349us,177.35us,177.399us,177.4us,177.449us,177.45us,177.499us,177.5us,177.549us,177.55us,177.599us,177.6us,177.649us,177.65us,177.699us,177.7us,177.749us,177.75us,177.799us,177.8us,177.849us,177.85us,177.899us,177.9us,177.949us,177.95us,177.999us,178us,178.049us,178.05us,178.099us,178.1us,178.149us,178.15us,178.199us,178.2us,178.249us,178.25us,178.299us,178.3us,178.349us,178.35us,178.399us,178.4us,178.449us,178.45us,178.499us,178.5us,178.549us,178.55us,178.599us,178.6us,178.649us,178.65us,178.699us,178.7us,178.749us,178.75us,178.799us,178.8us,178.849us,178.85us,178.899us,178.9us,178.949us,178.95us,178.999us,179us,179.049us,179.05us,179.099us,179.1us,179.149us,179.15us,179.199us,179.2us,179.249us,179.25us,179.299us,179.3us,179.349us,179.35us,179.399us,179.4us,179.449us,179.45us,179.499us,179.5us,179.549us,179.55us,179.599us,179.6us,179.649us,179.65us,179.699us,179.7us,179.749us,179.75us,179.799us,179.8us,179.849us,179.85us,179.899us,179.9us,179.949us,179.95us,179.999us,180us,180.049us,180.05us,180.099us,180.1us,180.149us,180.15us,180.199us,180.2us,180.249us,180.25us,180.299us,180.3us,180.349us,180.35us,180.399us,180.4us,180.449us,180.45us,180.499us,180.5us,180.549us,180.55us,180.599us,180.6us,180.649us,180.65us,180.699us,180.7us,180.749us,180.75us,180.799us,180.8us,180.849us,180.85us,180.899us,180.9us,180.949us,180.95us,180.999us,181us,181.049us,181.05us,181.099us,181.1us,181.149us,181.15us,181.199us,181.2us,181.249us,181.25us,181.299us,181.3us,181.349us,181.35us,181.399us,181.4us,181.449us,181.45us,181.499us,181.5us,181.549us,181.55us,181.599us,181.6us,181.649us,181.65us,181.699us,181.7us,181.749us,181.75us,181.799us,181.8us,181.849us,181.85us,181.899us,181.9us,181.949us,181.95us,181.999us,182us,182.049us,182.05us,182.099us,182.1us,182.149us,182.15us,182.199us,182.2us,182.249us,182.25us,182.299us,182.3us,182.349us,182.35us,182.399us,182.4us,182.449us,182.45us,182.499us,182.5us,182.549us,182.55us,182.599us,182.6us,182.649us,182.65us,182.699us,182.7us,182.749us,182.75us,182.799us,182.8us,182.849us,182.85us,182.899us,182.9us,182.949us,182.95us,182.999us,183us,183.049us,183.05us,183.099us,183.1us,183.149us,183.15us,183.199us,183.2us,183.249us,183.25us,183.299us,183.3us,183.349us,183.35us,183.399us,183.4us,183.449us,183.45us,183.499us,183.5us,183.549us,183.55us,183.599us,183.6us,183.649us,183.65us,183.699us,183.7us,183.749us,183.75us,183.799us,183.8us,183.849us,183.85us,183.899us,183.9us,183.949us,183.95us,183.999us,184us,184.049us,184.05us,184.099us,184.1us,184.149us,184.15us,184.199us,184.2us,184.249us,184.25us,184.299us,184.3us,184.349us,184.35us,184.399us,184.4us,184.449us,184.45us,184.499us,184.5us,184.549us,184.55us,184.599us,184.6us,184.649us,184.65us,184.699us,184.7us,184.749us,184.75us,184.799us,184.8us,184.849us,184.85us,184.899us,184.9us,184.949us,184.95us,184.999us,185us,185.049us,185.05us,185.099us,185.1us,185.149us,185.15us,185.199us,185.2us,185.249us,185.25us,185.299us,185.3us,185.349us,185.35us,185.399us,185.4us,185.449us,185.45us,185.499us,185.5us,185.549us,185.55us,185.599us,185.6us,185.649us,185.65us,185.699us,185.7us,185.749us,185.75us,185.799us,185.8us,185.849us,185.85us,185.899us,185.9us,185.949us,185.95us,185.999us,186us,186.049us,186.05us,186.099us,186.1us,186.149us,186.15us,186.199us,186.2us,186.249us,186.25us,186.299us,186.3us,186.349us,186.35us,186.399us,186.4us,186.449us,186.45us,186.499us,186.5us,186.549us,186.55us,186.599us,186.6us,186.649us,186.65us,186.699us,186.7us,186.749us,186.75us,186.799us,186.8us,186.849us,186.85us,186.899us,186.9us,186.949us,186.95us,186.999us,187us,187.049us,187.05us,187.099us,187.1us,187.149us,187.15us,187.199us,187.2us,187.249us,187.25us,187.299us,187.3us,187.349us,187.35us,187.399us,187.4us,187.449us,187.45us,187.499us,187.5us,187.549us,187.55us,187.599us,187.6us,187.649us,187.65us,187.699us,187.7us,187.749us,187.75us,187.799us,187.8us,187.849us,187.85us,187.899us,187.9us,187.949us,187.95us,187.999us,188us,188.049us,188.05us,188.099us,188.1us,188.149us,188.15us,188.199us,188.2us,188.249us,188.25us,188.299us,188.3us,188.349us,188.35us,188.399us,188.4us,188.449us,188.45us,188.499us,188.5us,188.549us,188.55us,188.599us,188.6us,188.649us,188.65us,188.699us,188.7us,188.749us,188.75us,188.799us,188.8us,188.849us,188.85us,188.899us,188.9us,188.949us,188.95us,188.999us,189us,189.049us,189.05us,189.099us,189.1us,189.149us,189.15us,189.199us,189.2us,189.249us,189.25us,189.299us,189.3us,189.349us,189.35us,189.399us,189.4us,189.449us,189.45us,189.499us,189.5us,189.549us,189.55us,189.599us,189.6us,189.649us,189.65us,189.699us,189.7us,189.749us,189.75us,189.799us,189.8us,189.849us,189.85us,189.899us,189.9us,189.949us,189.95us,189.999us,190us,190.049us,190.05us,190.099us,190.1us,190.149us,190.15us,190.199us,190.2us,190.249us,190.25us,190.299us,190.3us,190.349us,190.35us,190.399us,190.4us,190.449us,190.45us,190.499us,190.5us,190.549us,190.55us,190.599us,190.6us,190.649us,190.65us,190.699us,190.7us,190.749us,190.75us,190.799us,190.8us,190.849us,190.85us,190.899us,190.9us,190.949us,190.95us,190.999us,191us,191.049us,191.05us,191.099us,191.1us,191.149us,191.15us,191.199us,191.2us,191.249us,191.25us,191.299us,191.3us,191.349us,191.35us,191.399us,191.4us,191.449us,191.45us,191.499us,191.5us,191.549us,191.55us,191.599us,191.6us,191.649us,191.65us,191.699us,191.7us,191.749us,191.75us,191.799us,191.8us,191.849us,191.85us,191.899us,191.9us,191.949us,191.95us,191.999us,192us,192.049us,192.05us,192.099us,192.1us,192.149us,192.15us,192.199us,192.2us,192.249us,192.25us,192.299us,192.3us,192.349us,192.35us,192.399us,192.4us,192.449us,192.45us,192.499us,192.5us,192.549us,192.55us,192.599us,192.6us,192.649us,192.65us,192.699us,192.7us,192.749us,192.75us,192.799us,192.8us,192.849us,192.85us,192.899us,192.9us,192.949us,192.95us,192.999us,193us,193.049us,193.05us,193.099us,193.1us,193.149us,193.15us,193.199us,193.2us,193.249us,193.25us,193.299us,193.3us,193.349us,193.35us,193.399us,193.4us,193.449us,193.45us,193.499us,193.5us,193.549us,193.55us,193.599us,193.6us,193.649us,193.65us,193.699us,193.7us,193.749us,193.75us,193.799us,193.8us,193.849us,193.85us,193.899us,193.9us,193.949us,193.95us,193.999us,194us,194.049us,194.05us,194.099us,194.1us,194.149us,194.15us,194.199us,194.2us,194.249us,194.25us,194.299us,194.3us,194.349us,194.35us,194.399us,194.4us,194.449us,194.45us,194.499us,194.5us,194.549us,194.55us,194.599us,194.6us,194.649us,194.65us,194.699us,194.7us,194.749us,194.75us,194.799us,194.8us,194.849us,194.85us,194.899us,194.9us,194.949us,194.95us,194.999us,195us,195.049us,195.05us,195.099us,195.1us,195.149us,195.15us,195.199us,195.2us,195.249us,195.25us,195.299us,195.3us,195.349us,195.35us,195.399us,195.4us,195.449us,195.45us,195.499us,195.5us,195.549us,195.55us,195.599us,195.6us,195.649us,195.65us,195.699us,195.7us,195.749us,195.75us,195.799us,195.8us,195.849us,195.85us,195.899us,195.9us,195.949us,195.95us,195.999us,196us,196.049us,196.05us,196.099us,196.1us,196.149us,196.15us,196.199us,196.2us,196.249us,196.25us,196.299us,196.3us,196.349us,196.35us,196.399us,196.4us,196.449us,196.45us,196.499us,196.5us,196.549us,196.55us,196.599us,196.6us,196.649us,196.65us,196.699us,196.7us,196.749us,196.75us,196.799us,196.8us,196.849us,196.85us,196.899us,196.9us,196.949us,196.95us,196.999us,197us,197.049us,197.05us,197.099us,197.1us,197.149us,197.15us,197.199us,197.2us,197.249us,197.25us,197.299us,197.3us,197.349us,197.35us,197.399us,197.4us,197.449us,197.45us,197.499us,197.5us,197.549us,197.55us,197.599us,197.6us,197.649us,197.65us,197.699us,197.7us,197.749us,197.75us,197.799us,197.8us,197.849us,197.85us,197.899us,197.9us,197.949us,197.95us,197.999us,198us,198.049us,198.05us,198.099us,198.1us,198.149us,198.15us,198.199us,198.2us,198.249us,198.25us,198.299us,198.3us,198.349us,198.35us,198.399us,198.4us,198.449us,198.45us,198.499us,198.5us,198.549us,198.55us,198.599us,198.6us,198.649us,198.65us,198.699us,198.7us,198.749us,198.75us,198.799us,198.8us,198.849us,198.85us,198.899us,198.9us,198.949us,198.95us,198.999us,199us,199.049us,199.05us,199.099us,199.1us,199.149us,199.15us,199.199us,199.2us,199.249us,199.25us,199.299us,199.3us,199.349us,199.35us,199.399us,199.4us,199.449us,199.45us,199.499us,199.5us,199.549us,199.55us,199.599us,199.6us,199.649us,199.65us,199.699us,199.7us,199.749us,199.75us,199.799us,199.8us,199.849us,199.85us,199.899us,199.9us,199.949us,199.95us,199.999us,200us,200.049us,200.05us,200.099us,200.1us,200.149us,200.15us,200.199us,200.2us,200.249us,200.25us,200.299us,200.3us,200.349us,200.35us,200.399us,200.4us,200.449us,200.45us,200.499us,200.5us,200.549us,200.55us,200.599us,200.6us,200.649us,200.65us,200.699us,200.7us,200.749us,200.75us,200.799us,200.8us,200.849us,200.85us,200.899us,200.9us,200.949us,200.95us,200.999us,201us,201.049us,201.05us,201.099us,201.1us,201.149us,201.15us,201.199us,201.2us,201.249us,201.25us,201.299us,201.3us,201.349us,201.35us,201.399us,201.4us,201.449us,201.45us,201.499us,201.5us,201.549us,201.55us,201.599us,201.6us,201.649us,201.65us,201.699us,201.7us,201.749us,201.75us,201.799us,201.8us,201.849us,201.85us,201.899us,201.9us,201.949us,201.95us,201.999us,202us,202.049us,202.05us,202.099us,202.1us,202.149us,202.15us,202.199us,202.2us,202.249us,202.25us,202.299us,202.3us,202.349us,202.35us,202.399us,202.4us,202.449us,202.45us,202.499us,202.5us,202.549us,202.55us,202.599us,202.6us,202.649us,202.65us,202.699us,202.7us,202.749us,202.75us,202.799us,202.8us,202.849us,202.85us,202.899us,202.9us,202.949us,202.95us,202.999us,203us,203.049us,203.05us,203.099us,203.1us,203.149us,203.15us,203.199us,203.2us,203.249us,203.25us,203.299us,203.3us,203.349us,203.35us,203.399us,203.4us,203.449us,203.45us,203.499us,203.5us,203.549us,203.55us,203.599us,203.6us,203.649us,203.65us,203.699us,203.7us,203.749us,203.75us,203.799us,203.8us,203.849us,203.85us,203.899us,203.9us,203.949us,203.95us,203.999us,204us,204.049us,204.05us,204.099us,204.1us,204.149us,204.15us,204.199us,204.2us,204.249us,204.25us,204.299us,204.3us,204.349us,204.35us,204.399us,204.4us,204.449us,204.45us,204.499us,204.5us,204.549us,204.55us,204.599us,204.6us,204.649us,204.65us,204.699us,204.7us,204.749us,204.75us,204.799us,204.8us,204.849us,204.85us,204.899us,204.9us,204.949us,204.95us,204.999us,205us,205.049us,205.05us,205.099us,205.1us,205.149us,205.15us,205.199us,205.2us,205.249us,205.25us,205.299us,205.3us,205.349us,205.35us,205.399us,205.4us,205.449us,205.45us,205.499us,205.5us,205.549us,205.55us,205.599us,205.6us,205.649us,205.65us,205.699us,205.7us,205.749us,205.75us,205.799us,205.8us,205.849us,205.85us,205.899us,205.9us,205.949us,205.95us,205.999us,206us,206.049us,206.05us,206.099us,206.1us,206.149us,206.15us,206.199us,206.2us,206.249us,206.25us,206.299us,206.3us,206.349us,206.35us,206.399us,206.4us,206.449us,206.45us,206.499us,206.5us,206.549us,206.55us,206.599us,206.6us,206.649us,206.65us,206.699us,206.7us,206.749us,206.75us,206.799us,206.8us,206.849us,206.85us,206.899us,206.9us,206.949us,206.95us,206.999us,207us,207.049us,207.05us,207.099us,207.1us,207.149us,207.15us,207.199us,207.2us,207.249us,207.25us,207.299us,207.3us,207.349us,207.35us,207.399us,207.4us,207.449us,207.45us,207.499us,207.5us,207.549us,207.55us,207.599us,207.6us,207.649us,207.65us,207.699us,207.7us,207.749us,207.75us,207.799us,207.8us,207.849us,207.85us,207.899us,207.9us,207.949us,207.95us,207.999us,208us,208.049us,208.05us,208.099us,208.1us,208.149us,208.15us,208.199us,208.2us,208.249us,208.25us,208.299us,208.3us,208.349us,208.35us,208.399us,208.4us,208.449us,208.45us,208.499us,208.5us,208.549us,208.55us,208.599us,208.6us,208.649us,208.65us,208.699us,208.7us,208.749us,208.75us,208.799us,208.8us,208.849us,208.85us,208.899us,208.9us,208.949us,208.95us,208.999us,209us,209.049us,209.05us,209.099us,209.1us,209.149us,209.15us,209.199us,209.2us,209.249us,209.25us,209.299us,209.3us,209.349us,209.35us,209.399us,209.4us,209.449us,209.45us,209.499us,209.5us,209.549us,209.55us,209.599us,209.6us,209.649us,209.65us,209.699us,209.7us,209.749us,209.75us,209.799us,209.8us,209.849us,209.85us,209.899us,209.9us,209.949us,209.95us,209.999us,210us,210.049us,210.05us,210.099us,210.1us,210.149us,210.15us,210.199us,210.2us,210.249us,210.25us,210.299us,210.3us,210.349us,210.35us,210.399us,210.4us,210.449us,210.45us,210.499us,210.5us,210.549us,210.55us,210.599us,210.6us,210.649us,210.65us,210.699us,210.7us,210.749us,210.75us,210.799us,210.8us,210.849us,210.85us,210.899us,210.9us,210.949us,210.95us,210.999us,211us,211.049us,211.05us,211.099us,211.1us,211.149us,211.15us,211.199us,211.2us,211.249us,211.25us,211.299us,211.3us,211.349us,211.35us,211.399us,211.4us,211.449us,211.45us,211.499us,211.5us,211.549us,211.55us,211.599us,211.6us,211.649us,211.65us,211.699us,211.7us,211.749us,211.75us,211.799us,211.8us,211.849us,211.85us,211.899us,211.9us,211.949us,211.95us,211.999us,212us,212.049us,212.05us,212.099us,212.1us,212.149us,212.15us,212.199us,212.2us,212.249us,212.25us,212.299us,212.3us,212.349us,212.35us,212.399us,212.4us,212.449us,212.45us,212.499us,212.5us,212.549us,212.55us,212.599us,212.6us,212.649us,212.65us,212.699us,212.7us,212.749us,212.75us,212.799us,212.8us,212.849us,212.85us,212.899us,212.9us,212.949us,212.95us,212.999us,213us,213.049us,213.05us,213.099us,213.1us,213.149us,213.15us,213.199us,213.2us,213.249us,213.25us,213.299us,213.3us,213.349us,213.35us,213.399us,213.4us,213.449us,213.45us,213.499us,213.5us,213.549us,213.55us,213.599us,213.6us,213.649us,213.65us,213.699us,213.7us,213.749us,213.75us,213.799us,213.8us,213.849us,213.85us,213.899us,213.9us,213.949us,213.95us,213.999us,214us,214.049us,214.05us,214.099us,214.1us,214.149us,214.15us,214.199us,214.2us,214.249us,214.25us,214.299us,214.3us,214.349us,214.35us,214.399us,214.4us,214.449us,214.45us,214.499us,214.5us,214.549us,214.55us,214.599us,214.6us,214.649us,214.65us,214.699us,214.7us,214.749us,214.75us,214.799us,214.8us,214.849us,214.85us,214.899us,214.9us,214.949us,214.95us,214.999us,215us,215.049us,215.05us,215.099us,215.1us,215.149us,215.15us,215.199us,215.2us,215.249us,215.25us,215.299us,215.3us,215.349us,215.35us,215.399us,215.4us,215.449us,215.45us,215.499us,215.5us,215.549us,215.55us,215.599us,215.6us,215.649us,215.65us,215.699us,215.7us,215.749us,215.75us,215.799us,215.8us,215.849us,215.85us,215.899us,215.9us,215.949us,215.95us,215.999us,216us,216.049us,216.05us,216.099us,216.1us,216.149us,216.15us,216.199us,216.2us,216.249us,216.25us,216.299us,216.3us,216.349us,216.35us,216.399us,216.4us,216.449us,216.45us,216.499us,216.5us,216.549us,216.55us,216.599us,216.6us,216.649us,216.65us,216.699us,216.7us,216.749us,216.75us,216.799us,216.8us,216.849us,216.85us,216.899us,216.9us,216.949us,216.95us,216.999us,217us,217.049us,217.05us,217.099us,217.1us,217.149us,217.15us,217.199us,217.2us,217.249us,217.25us,217.299us,217.3us,217.349us,217.35us,217.399us,217.4us,217.449us,217.45us,217.499us,217.5us,217.549us,217.55us,217.599us,217.6us,217.649us,217.65us,217.699us,217.7us,217.749us,217.75us,217.799us,217.8us,217.849us,217.85us,217.899us,217.9us,217.949us,217.95us,217.999us,218us,218.049us,218.05us,218.099us,218.1us,218.149us,218.15us,218.199us,218.2us,218.249us,218.25us,218.299us,218.3us,218.349us,218.35us,218.399us,218.4us,218.449us,218.45us,218.499us,218.5us,218.549us,218.55us,218.599us,218.6us,218.649us,218.65us,218.699us,218.7us,218.749us,218.75us,218.799us,218.8us,218.849us,218.85us,218.899us,218.9us,218.949us,218.95us,218.999us,219us,219.049us,219.05us,219.099us,219.1us,219.149us,219.15us,219.199us,219.2us,219.249us,219.25us,219.299us,219.3us,219.349us,219.35us,219.399us,219.4us,219.449us,219.45us,219.499us,219.5us,219.549us,219.55us,219.599us,219.6us,219.649us,219.65us,219.699us,219.7us,219.749us,219.75us,219.799us,219.8us,219.849us,219.85us,219.899us,219.9us,219.949us,219.95us,219.999us,220us,220.049us,220.05us,220.099us,220.1us,220.149us,220.15us,220.199us,220.2us,220.249us,220.25us,220.299us,220.3us,220.349us,220.35us,220.399us,220.4us,220.449us,220.45us,220.499us,220.5us,220.549us,220.55us,220.599us,220.6us,220.649us,220.65us,220.699us,220.7us,220.749us,220.75us,220.799us,220.8us,220.849us,220.85us,220.899us,220.9us,220.949us,220.95us,220.999us,221us,221.049us,221.05us,221.099us,221.1us,221.149us,221.15us,221.199us,221.2us,221.249us,221.25us,221.299us,221.3us,221.349us,221.35us,221.399us,221.4us,221.449us,221.45us,221.499us,221.5us,221.549us,221.55us,221.599us,221.6us,221.649us,221.65us,221.699us,221.7us,221.749us,221.75us,221.799us,221.8us,221.849us,221.85us,221.899us,221.9us,221.949us,221.95us,221.999us,222us,222.049us,222.05us,222.099us,222.1us,222.149us,222.15us,222.199us,222.2us,222.249us,222.25us,222.299us,222.3us,222.349us,222.35us,222.399us,222.4us,222.449us,222.45us,222.499us,222.5us,222.549us,222.55us,222.599us,222.6us,222.649us,222.65us,222.699us,222.7us,222.749us,222.75us,222.799us,222.8us,222.849us,222.85us,222.899us,222.9us,222.949us,222.95us,222.999us,223us,223.049us,223.05us,223.099us,223.1us,223.149us,223.15us,223.199us,223.2us,223.249us,223.25us,223.299us,223.3us,223.349us,223.35us,223.399us,223.4us,223.449us,223.45us,223.499us,223.5us,223.549us,223.55us,223.599us,223.6us,223.649us,223.65us,223.699us,223.7us,223.749us,223.75us,223.799us,223.8us,223.849us,223.85us,223.899us,223.9us,223.949us,223.95us,223.999us,224us,224.049us,224.05us,224.099us,224.1us,224.149us,224.15us,224.199us,224.2us,224.249us,224.25us,224.299us,224.3us,224.349us,224.35us,224.399us,224.4us,224.449us,224.45us,224.499us,224.5us,224.549us,224.55us,224.599us,224.6us,224.649us,224.65us,224.699us,224.7us,224.749us,224.75us,224.799us,224.8us,224.849us,224.85us,224.899us,224.9us,224.949us,224.95us,224.999us,225us,225.049us,225.05us,225.099us,225.1us,225.149us,225.15us,225.199us,225.2us,225.249us,225.25us,225.299us,225.3us,225.349us,225.35us,225.399us,225.4us,225.449us,225.45us,225.499us,225.5us,225.549us,225.55us,225.599us,225.6us,225.649us,225.65us,225.699us,225.7us,225.749us,225.75us,225.799us,225.8us,225.849us,225.85us,225.899us,225.9us,225.949us,225.95us,225.999us,226us,226.049us,226.05us,226.099us,226.1us,226.149us,226.15us,226.199us,226.2us,226.249us,226.25us,226.299us,226.3us,226.349us,226.35us,226.399us,226.4us,226.449us,226.45us,226.499us,226.5us,226.549us,226.55us,226.599us,226.6us,226.649us,226.65us,226.699us,226.7us,226.749us,226.75us,226.799us,226.8us,226.849us,226.85us,226.899us,226.9us,226.949us,226.95us,226.999us,227us,227.049us,227.05us,227.099us,227.1us,227.149us,227.15us,227.199us,227.2us,227.249us,227.25us,227.299us,227.3us,227.349us,227.35us,227.399us,227.4us,227.449us,227.45us,227.499us,227.5us,227.549us,227.55us,227.599us,227.6us,227.649us,227.65us,227.699us,227.7us,227.749us,227.75us,227.799us,227.8us,227.849us,227.85us,227.899us,227.9us,227.949us,227.95us,227.999us,228us,228.049us,228.05us,228.099us,228.1us,228.149us,228.15us,228.199us,228.2us,228.249us,228.25us,228.299us,228.3us,228.349us,228.35us,228.399us,228.4us,228.449us,228.45us,228.499us,228.5us,228.549us,228.55us,228.599us,228.6us,228.649us,228.65us,228.699us,228.7us,228.749us,228.75us,228.799us,228.8us,228.849us,228.85us,228.899us,228.9us,228.949us,228.95us,228.999us,229us,229.049us,229.05us,229.099us,229.1us,229.149us,229.15us,229.199us,229.2us,229.249us,229.25us,229.299us,229.3us,229.349us,229.35us,229.399us,229.4us,229.449us,229.45us,229.499us,229.5us,229.549us,229.55us,229.599us,229.6us,229.649us,229.65us,229.699us,229.7us,229.749us,229.75us,229.799us,229.8us,229.849us,229.85us,229.899us,229.9us,229.949us,229.95us,229.999us,230us,230.049us,230.05us,230.099us,230.1us,230.149us,230.15us,230.199us,230.2us,230.249us,230.25us,230.299us,230.3us,230.349us,230.35us,230.399us,230.4us,230.449us,230.45us,230.499us,230.5us,230.549us,230.55us,230.599us,230.6us,230.649us,230.65us,230.699us,230.7us,230.749us,230.75us,230.799us,230.8us,230.849us,230.85us,230.899us,230.9us,230.949us,230.95us,230.999us,231us,231.049us,231.05us,231.099us,231.1us,231.149us,231.15us,231.199us,231.2us,231.249us,231.25us,231.299us,231.3us,231.349us,231.35us,231.399us,231.4us,231.449us,231.45us,231.499us,231.5us,231.549us,231.55us,231.599us,231.6us,231.649us,231.65us,231.699us,231.7us,231.749us,231.75us,231.799us,231.8us,231.849us,231.85us,231.899us,231.9us,231.949us,231.95us,231.999us,232us,232.049us,232.05us,232.099us,232.1us,232.149us,232.15us,232.199us,232.2us,232.249us,232.25us,232.299us,232.3us,232.349us,232.35us,232.399us,232.4us,232.449us,232.45us,232.499us,232.5us,232.549us,232.55us,232.599us,232.6us,232.649us,232.65us,232.699us,232.7us,232.749us,232.75us,232.799us,232.8us,232.849us,232.85us,232.899us,232.9us,232.949us,232.95us,232.999us,233us,233.049us,233.05us,233.099us,233.1us,233.149us,233.15us,233.199us,233.2us,233.249us,233.25us,233.299us,233.3us,233.349us,233.35us,233.399us,233.4us,233.449us,233.45us,233.499us,233.5us,233.549us,233.55us,233.599us,233.6us,233.649us,233.65us,233.699us,233.7us,233.749us,233.75us,233.799us,233.8us,233.849us,233.85us,233.899us,233.9us,233.949us,233.95us,233.999us,234us,234.049us,234.05us,234.099us,234.1us,234.149us,234.15us,234.199us,234.2us,234.249us,234.25us,234.299us,234.3us,234.349us,234.35us,234.399us,234.4us,234.449us,234.45us,234.499us,234.5us,234.549us,234.55us,234.599us,234.6us,234.649us,234.65us,234.699us,234.7us,234.749us,234.75us,234.799us,234.8us,234.849us,234.85us,234.899us,234.9us,234.949us,234.95us,234.999us,235us,235.049us,235.05us,235.099us,235.1us,235.149us,235.15us,235.199us,235.2us,235.249us,235.25us,235.299us,235.3us,235.349us,235.35us,235.399us,235.4us,235.449us,235.45us,235.499us,235.5us,235.549us,235.55us,235.599us,235.6us,235.649us,235.65us,235.699us,235.7us,235.749us,235.75us,235.799us,235.8us,235.849us,235.85us,235.899us,235.9us,235.949us,235.95us,235.999us,236us,236.049us,236.05us,236.099us,236.1us,236.149us,236.15us,236.199us,236.2us,236.249us,236.25us,236.299us,236.3us,236.349us,236.35us,236.399us,236.4us,236.449us,236.45us,236.499us,236.5us,236.549us,236.55us,236.599us,236.6us,236.649us,236.65us,236.699us,236.7us,236.749us,236.75us,236.799us,236.8us,236.849us,236.85us,236.899us,236.9us,236.949us,236.95us,236.999us,237us,237.049us,237.05us,237.099us,237.1us,237.149us,237.15us,237.199us,237.2us,237.249us,237.25us,237.299us,237.3us,237.349us,237.35us,237.399us,237.4us,237.449us,237.45us,237.499us,237.5us,237.549us,237.55us,237.599us,237.6us,237.649us,237.65us,237.699us,237.7us,237.749us,237.75us,237.799us,237.8us,237.849us,237.85us,237.899us,237.9us,237.949us,237.95us,237.999us,238us,238.049us,238.05us,238.099us,238.1us,238.149us,238.15us,238.199us,238.2us,238.249us,238.25us,238.299us,238.3us,238.349us,238.35us,238.399us,238.4us,238.449us,238.45us,238.499us,238.5us,238.549us,238.55us,238.599us,238.6us,238.649us,238.65us,238.699us,238.7us,238.749us,238.75us,238.799us,238.8us,238.849us,238.85us,238.899us,238.9us,238.949us,238.95us,238.999us,239us,239.049us,239.05us,239.099us,239.1us,239.149us,239.15us,239.199us,239.2us,239.249us,239.25us,239.299us,239.3us,239.349us,239.35us,239.399us,239.4us,239.449us,239.45us,239.499us,239.5us,239.549us,239.55us,239.599us,239.6us,239.649us,239.65us,239.699us,239.7us,239.749us,239.75us,239.799us,239.8us,239.849us,239.85us,239.899us,239.9us,239.949us,239.95us,239.999us,240us,240.049us,240.05us,240.099us,240.1us,240.149us,240.15us,240.199us,240.2us,240.249us,240.25us,240.299us,240.3us,240.349us,240.35us,240.399us,240.4us,240.449us,240.45us,240.499us,240.5us,240.549us,240.55us,240.599us,240.6us,240.649us,240.65us,240.699us,240.7us,240.749us,240.75us,240.799us,240.8us,240.849us,240.85us,240.899us,240.9us,240.949us,240.95us,240.999us,241us,241.049us,241.05us,241.099us,241.1us,241.149us,241.15us,241.199us,241.2us,241.249us,241.25us,241.299us,241.3us,241.349us,241.35us,241.399us,241.4us,241.449us,241.45us,241.499us,241.5us,241.549us,241.55us,241.599us,241.6us,241.649us,241.65us,241.699us,241.7us,241.749us,241.75us,241.799us,241.8us,241.849us,241.85us,241.899us,241.9us,241.949us,241.95us,241.999us,242us,242.049us,242.05us,242.099us,242.1us,242.149us,242.15us,242.199us,242.2us,242.249us,242.25us,242.299us,242.3us,242.349us,242.35us,242.399us,242.4us,242.449us,242.45us,242.499us,242.5us,242.549us,242.55us,242.599us,242.6us,242.649us,242.65us,242.699us,242.7us,242.749us,242.75us,242.799us,242.8us,242.849us,242.85us,242.899us,242.9us,242.949us,242.95us,242.999us,243us,243.049us,243.05us,243.099us,243.1us,243.149us,243.15us,243.199us,243.2us,243.249us,243.25us,243.299us,243.3us,243.349us,243.35us,243.399us,243.4us,243.449us,243.45us,243.499us,243.5us,243.549us,243.55us,243.599us,243.6us,243.649us,243.65us,243.699us,243.7us,243.749us,243.75us,243.799us,243.8us,243.849us,243.85us,243.899us,243.9us,243.949us,243.95us,243.999us,244us,244.049us,244.05us,244.099us,244.1us,244.149us,244.15us,244.199us,244.2us,244.249us,244.25us,244.299us,244.3us,244.349us,244.35us,244.399us,244.4us,244.449us,244.45us,244.499us,244.5us,244.549us,244.55us,244.599us,244.6us,244.649us,244.65us,244.699us,244.7us,244.749us,244.75us,244.799us,244.8us,244.849us,244.85us,244.899us,244.9us,244.949us,244.95us,244.999us,245us,245.049us,245.05us,245.099us,245.1us,245.149us,245.15us,245.199us,245.2us,245.249us,245.25us,245.299us,245.3us,245.349us,245.35us,245.399us,245.4us,245.449us,245.45us,245.499us,245.5us,245.549us,245.55us,245.599us,245.6us,245.649us,245.65us,245.699us,245.7us,245.749us,245.75us,245.799us,245.8us,245.849us,245.85us,245.899us,245.9us,245.949us,245.95us,245.999us,246us,246.049us,246.05us,246.099us,246.1us,246.149us,246.15us,246.199us,246.2us,246.249us,246.25us,246.299us,246.3us,246.349us,246.35us,246.399us,246.4us,246.449us,246.45us,246.499us,246.5us,246.549us,246.55us,246.599us,246.6us,246.649us,246.65us,246.699us,246.7us,246.749us,246.75us,246.799us,246.8us,246.849us,246.85us,246.899us,246.9us,246.949us,246.95us,246.999us,247us,247.049us,247.05us,247.099us,247.1us,247.149us,247.15us,247.199us,247.2us,247.249us,247.25us,247.299us,247.3us,247.349us,247.35us,247.399us,247.4us,247.449us,247.45us,247.499us,247.5us,247.549us,247.55us,247.599us,247.6us,247.649us,247.65us,247.699us,247.7us,247.749us,247.75us,247.799us,247.8us,247.849us,247.85us,247.899us,247.9us,247.949us,247.95us,247.999us,248us,248.049us,248.05us,248.099us,248.1us,248.149us,248.15us,248.199us,248.2us,248.249us,248.25us,248.299us,248.3us,248.349us,248.35us,248.399us,248.4us,248.449us,248.45us,248.499us,248.5us,248.549us,248.55us,248.599us,248.6us,248.649us,248.65us,248.699us,248.7us,248.749us,248.75us,248.799us,248.8us,248.849us,248.85us,248.899us,248.9us,248.949us,248.95us,248.999us,249us,249.049us,249.05us,249.099us,249.1us,249.149us,249.15us,249.199us,249.2us,249.249us,249.25us,249.299us,249.3us,249.349us,249.35us,249.399us,249.4us,249.449us,249.45us,249.499us,249.5us,249.549us,249.55us,249.599us,249.6us,249.649us,249.65us,249.699us,249.7us,249.749us,249.75us,249.799us,249.8us,249.849us,249.85us,249.899us,249.9us,249.949us,249.95us,249.999us,250us,250.049us,250.05us,250.099us,250.1us,250.149us,250.15us,250.199us,250.2us,250.249us,250.25us,250.299us,250.3us,250.349us,250.35us,250.399us,250.4us,250.449us,250.45us,250.499us,250.5us,250.549us,250.55us,250.599us,250.6us,250.649us,250.65us,250.699us,250.7us,250.749us,250.75us,250.799us,250.8us,250.849us,250.85us,250.899us,250.9us,250.949us,250.95us,250.999us,251us,251.049us,251.05us,251.099us,251.1us,251.149us,251.15us,251.199us,251.2us,251.249us,251.25us,251.299us,251.3us,251.349us,251.35us,251.399us,251.4us,251.449us,251.45us,251.499us,251.5us,251.549us,251.55us,251.599us,251.6us,251.649us,251.65us,251.699us,251.7us,251.749us,251.75us,251.799us,251.8us,251.849us,251.85us,251.899us,251.9us,251.949us,251.95us,251.999us,252us,252.049us,252.05us,252.099us,252.1us,252.149us,252.15us,252.199us,252.2us,252.249us,252.25us,252.299us,252.3us,252.349us,252.35us,252.399us,252.4us,252.449us,252.45us,252.499us,252.5us,252.549us,252.55us,252.599us,252.6us,252.649us,252.65us,252.699us,252.7us,252.749us,252.75us,252.799us,252.8us,252.849us,252.85us,252.899us,252.9us,252.949us,252.95us,252.999us,253us,253.049us,253.05us,253.099us,253.1us,253.149us,253.15us,253.199us,253.2us,253.249us,253.25us,253.299us,253.3us,253.349us,253.35us,253.399us,253.4us,253.449us,253.45us,253.499us,253.5us,253.549us,253.55us,253.599us,253.6us,253.649us,253.65us,253.699us,253.7us,253.749us,253.75us,253.799us,253.8us,253.849us,253.85us,253.899us,253.9us,253.949us,253.95us,253.999us,254us,254.049us,254.05us,254.099us,254.1us,254.149us,254.15us,254.199us,254.2us,254.249us,254.25us,254.299us,254.3us,254.349us,254.35us,254.399us,254.4us,254.449us,254.45us,254.499us,254.5us,254.549us,254.55us,254.599us,254.6us,254.649us,254.65us,254.699us,254.7us,254.749us,254.75us,254.799us,254.8us,254.849us,254.85us,254.899us,254.9us,254.949us,254.95us,254.999us,255us,255.049us,255.05us,255.099us,255.1us,255.149us,255.15us,255.199us,255.2us,255.249us,255.25us,255.299us,255.3us,255.349us,255.35us,255.399us,255.4us,255.449us,255.45us,255.499us,255.5us,255.549us,255.55us,255.599us,255.6us,255.649us,255.65us,255.699us,255.7us,255.749us,255.75us,255.799us,255.8us,255.849us,255.85us,255.899us,255.9us,255.949us,255.95us,255.999us,256us,256.049us,256.05us,256.099us,256.1us,256.149us,256.15us,256.199us,256.2us,256.249us,256.25us,256.299us,256.3us,256.349us,256.35us,256.399us,256.4us,256.449us,256.45us,256.499us,256.5us,256.549us,256.55us,256.599us,256.6us,256.649us,256.65us,256.699us,256.7us,256.749us,256.75us,256.799us,256.8us,256.849us,256.85us,256.899us,256.9us,256.949us,256.95us,256.999us,257us,257.049us,257.05us,257.099us,257.1us,257.149us,257.15us,257.199us,257.2us,257.249us,257.25us,257.299us,257.3us,257.349us,257.35us,257.399us,257.4us,257.449us,257.45us,257.499us,257.5us,257.549us,257.55us,257.599us,257.6us,257.649us,257.65us,257.699us,257.7us,257.749us,257.75us,257.799us,257.8us,257.849us,257.85us,257.899us,257.9us,257.949us,257.95us,257.999us,258us,258.049us,258.05us,258.099us,258.1us,258.149us,258.15us,258.199us,258.2us,258.249us,258.25us,258.299us,258.3us,258.349us,258.35us,258.399us,258.4us,258.449us,258.45us,258.499us,258.5us,258.549us,258.55us,258.599us,258.6us,258.649us,258.65us,258.699us,258.7us,258.749us,258.75us,258.799us,258.8us,258.849us,258.85us,258.899us,258.9us,258.949us,258.95us,258.999us,259us,259.049us,259.05us,259.099us,259.1us,259.149us,259.15us,259.199us,259.2us,259.249us,259.25us,259.299us,259.3us,259.349us,259.35us,259.399us,259.4us,259.449us,259.45us,259.499us,259.5us,259.549us,259.55us,259.599us,259.6us,259.649us,259.65us,259.699us,259.7us,259.749us,259.75us,259.799us,259.8us,259.849us,259.85us,259.899us,259.9us,259.949us,259.95us,259.999us,260us,260.049us,260.05us,260.099us,260.1us,260.149us,260.15us,260.199us,260.2us,260.249us,260.25us,260.299us,260.3us,260.349us,260.35us,260.399us,260.4us,260.449us,260.45us,260.499us,260.5us,260.549us,260.55us,260.599us,260.6us,260.649us,260.65us,260.699us,260.7us,260.749us,260.75us,260.799us,260.8us,260.849us,260.85us,260.899us,260.9us,260.949us,260.95us,260.999us,261us,261.049us,261.05us,261.099us,261.1us,261.149us,261.15us,261.199us,261.2us,261.249us,261.25us,261.299us,261.3us,261.349us,261.35us,261.399us,261.4us,261.449us,261.45us,261.499us,261.5us,261.549us,261.55us,261.599us,261.6us,261.649us,261.65us,261.699us,261.7us,261.749us,261.75us,261.799us,261.8us,261.849us,261.85us,261.899us,261.9us,261.949us,261.95us,261.999us,262us,262.049us,262.05us,262.099us,262.1us,262.149us,262.15us,262.199us,262.2us,262.249us,262.25us,262.299us,262.3us,262.349us,262.35us,262.399us,262.4us,262.449us,262.45us,262.499us,262.5us,262.549us,262.55us,262.599us,262.6us,262.649us,262.65us,262.699us,262.7us,262.749us,262.75us,262.799us,262.8us,262.849us,262.85us,262.899us,262.9us,262.949us,262.95us,262.999us,263us,263.049us,263.05us,263.099us,263.1us,263.149us,263.15us,263.199us,263.2us,263.249us,263.25us,263.299us,263.3us,263.349us,263.35us,263.399us,263.4us,263.449us,263.45us,263.499us,263.5us,263.549us,263.55us,263.599us,263.6us,263.649us,263.65us,263.699us,263.7us,263.749us,263.75us,263.799us,263.8us,263.849us,263.85us,263.899us,263.9us,263.949us,263.95us,263.999us,264us,264.049us,264.05us,264.099us,264.1us,264.149us,264.15us,264.199us,264.2us,264.249us,264.25us,264.299us,264.3us,264.349us,264.35us,264.399us,264.4us,264.449us,264.45us,264.499us,264.5us,264.549us,264.55us,264.599us,264.6us,264.649us,264.65us,264.699us,264.7us,264.749us,264.75us,264.799us,264.8us,264.849us,264.85us,264.899us,264.9us,264.949us,264.95us,264.999us,265us,265.049us,265.05us,265.099us,265.1us,265.149us,265.15us,265.199us,265.2us,265.249us,265.25us,265.299us,265.3us,265.349us,265.35us,265.399us,265.4us,265.449us,265.45us,265.499us,265.5us,265.549us,265.55us,265.599us,265.6us,265.649us,265.65us,265.699us,265.7us,265.749us,265.75us,265.799us,265.8us,265.849us,265.85us,265.899us,265.9us,265.949us,265.95us,265.999us,266us,266.049us,266.05us,266.099us,266.1us,266.149us,266.15us,266.199us,266.2us,266.249us,266.25us,266.299us,266.3us,266.349us,266.35us,266.399us,266.4us,266.449us,266.45us,266.499us,266.5us,266.549us,266.55us,266.599us,266.6us,266.649us,266.65us,266.699us,266.7us,266.749us,266.75us,266.799us,266.8us,266.849us,266.85us,266.899us,266.9us,266.949us,266.95us,266.999us,267us,267.049us,267.05us,267.099us,267.1us,267.149us,267.15us,267.199us,267.2us,267.249us,267.25us,267.299us,267.3us,267.349us,267.35us,267.399us,267.4us,267.449us,267.45us,267.499us,267.5us,267.549us,267.55us,267.599us,267.6us,267.649us,267.65us,267.699us,267.7us,267.749us,267.75us,267.799us,267.8us,267.849us,267.85us,267.899us,267.9us,267.949us,267.95us,267.999us,268us,268.049us,268.05us,268.099us,268.1us,268.149us,268.15us,268.199us,268.2us,268.249us,268.25us,268.299us,268.3us,268.349us,268.35us,268.399us,268.4us,268.449us,268.45us,268.499us,268.5us,268.549us,268.55us,268.599us,268.6us,268.649us,268.65us,268.699us,268.7us,268.749us,268.75us,268.799us,268.8us,268.849us,268.85us,268.899us,268.9us,268.949us,268.95us,268.999us,269us,269.049us,269.05us,269.099us,269.1us,269.149us,269.15us,269.199us,269.2us,269.249us,269.25us,269.299us,269.3us,269.349us,269.35us,269.399us,269.4us,269.449us,269.45us,269.499us,269.5us,269.549us,269.55us,269.599us,269.6us,269.649us,269.65us,269.699us,269.7us,269.749us,269.75us,269.799us,269.8us,269.849us,269.85us,269.899us,269.9us,269.949us,269.95us,269.999us,270us,270.049us,270.05us,270.099us,270.1us,270.149us,270.15us,270.199us,270.2us,270.249us,270.25us,270.299us,270.3us,270.349us,270.35us,270.399us,270.4us,270.449us,270.45us,270.499us,270.5us,270.549us,270.55us,270.599us,270.6us,270.649us,270.65us,270.699us,270.7us,270.749us,270.75us,270.799us,270.8us,270.849us,270.85us,270.899us,270.9us,270.949us,270.95us,270.999us,271us,271.049us,271.05us,271.099us,271.1us,271.149us,271.15us,271.199us,271.2us,271.249us,271.25us,271.299us,271.3us,271.349us,271.35us,271.399us,271.4us,271.449us,271.45us,271.499us,271.5us,271.549us,271.55us,271.599us,271.6us,271.649us,271.65us,271.699us,271.7us,271.749us,271.75us,271.799us,271.8us,271.849us,271.85us,271.899us,271.9us,271.949us,271.95us,271.999us,272us,272.049us,272.05us,272.099us,272.1us,272.149us,272.15us,272.199us,272.2us,272.249us,272.25us,272.299us,272.3us,272.349us,272.35us,272.399us,272.4us,272.449us,272.45us,272.499us,272.5us,272.549us,272.55us,272.599us,272.6us,272.649us,272.65us,272.699us,272.7us,272.749us,272.75us,272.799us,272.8us,272.849us,272.85us,272.899us,272.9us,272.949us,272.95us,272.999us,273us,273.049us,273.05us,273.099us,273.1us,273.149us,273.15us,273.199us,273.2us,273.249us,273.25us,273.299us,273.3us,273.349us,273.35us,273.399us,273.4us,273.449us,273.45us,273.499us,273.5us,273.549us,273.55us,273.599us,273.6us,273.649us,273.65us,273.699us,273.7us,273.749us,273.75us,273.799us,273.8us,273.849us,273.85us,273.899us,273.9us,273.949us,273.95us,273.999us,274us,274.049us,274.05us,274.099us,274.1us,274.149us,274.15us,274.199us,274.2us,274.249us,274.25us,274.299us,274.3us,274.349us,274.35us,274.399us,274.4us,274.449us,274.45us,274.499us,274.5us,274.549us,274.55us,274.599us,274.6us,274.649us,274.65us,274.699us,274.7us,274.749us,274.75us,274.799us,274.8us,274.849us,274.85us,274.899us,274.9us,274.949us,274.95us,274.999us,275us,275.049us,275.05us,275.099us,275.1us,275.149us,275.15us,275.199us,275.2us,275.249us,275.25us,275.299us,275.3us,275.349us,275.35us,275.399us,275.4us,275.449us,275.45us,275.499us,275.5us,275.549us,275.55us,275.599us,275.6us,275.649us,275.65us,275.699us,275.7us,275.749us,275.75us,275.799us,275.8us,275.849us,275.85us,275.899us,275.9us,275.949us,275.95us,275.999us,276us,276.049us,276.05us,276.099us,276.1us,276.149us,276.15us,276.199us,276.2us,276.249us,276.25us,276.299us,276.3us,276.349us,276.35us,276.399us,276.4us,276.449us,276.45us,276.499us,276.5us,276.549us,276.55us,276.599us,276.6us,276.649us,276.65us,276.699us,276.7us,276.749us,276.75us,276.799us,276.8us,276.849us,276.85us,276.899us,276.9us,276.949us,276.95us,276.999us,277us,277.049us,277.05us,277.099us,277.1us,277.149us,277.15us,277.199us,277.2us,277.249us,277.25us,277.299us,277.3us,277.349us,277.35us,277.399us,277.4us,277.449us,277.45us,277.499us,277.5us,277.549us,277.55us,277.599us,277.6us,277.649us,277.65us,277.699us,277.7us,277.749us,277.75us,277.799us,277.8us,277.849us,277.85us,277.899us,277.9us,277.949us,277.95us,277.999us,278us,278.049us,278.05us,278.099us,278.1us,278.149us,278.15us,278.199us,278.2us,278.249us,278.25us,278.299us,278.3us,278.349us,278.35us,278.399us,278.4us,278.449us,278.45us,278.499us,278.5us,278.549us,278.55us,278.599us,278.6us,278.649us,278.65us,278.699us,278.7us,278.749us,278.75us,278.799us,278.8us,278.849us,278.85us,278.899us,278.9us,278.949us,278.95us,278.999us,279us,279.049us,279.05us,279.099us,279.1us,279.149us,279.15us,279.199us,279.2us,279.249us,279.25us,279.299us,279.3us,279.349us,279.35us,279.399us,279.4us,279.449us,279.45us,279.499us,279.5us,279.549us,279.55us,279.599us,279.6us,279.649us,279.65us,279.699us,279.7us,279.749us,279.75us,279.799us,279.8us,279.849us,279.85us,279.899us,279.9us,279.949us,279.95us,279.999us,280us,280.049us,280.05us,280.099us,280.1us,280.149us,280.15us,280.199us,280.2us,280.249us,280.25us,280.299us,280.3us,280.349us,280.35us,280.399us,280.4us,280.449us,280.45us,280.499us,280.5us,280.549us,280.55us,280.599us,280.6us,280.649us,280.65us,280.699us,280.7us,280.749us,280.75us,280.799us,280.8us,280.849us,280.85us,280.899us,280.9us,280.949us,280.95us,280.999us,281us,281.049us,281.05us,281.099us,281.1us,281.149us,281.15us,281.199us,281.2us,281.249us,281.25us,281.299us,281.3us,281.349us,281.35us,281.399us,281.4us,281.449us,281.45us,281.499us,281.5us,281.549us,281.55us,281.599us,281.6us,281.649us,281.65us,281.699us,281.7us,281.749us,281.75us,281.799us,281.8us,281.849us,281.85us,281.899us,281.9us,281.949us,281.95us,281.999us,282us,282.049us,282.05us,282.099us,282.1us,282.149us,282.15us,282.199us,282.2us,282.249us,282.25us,282.299us,282.3us,282.349us,282.35us,282.399us,282.4us,282.449us,282.45us,282.499us,282.5us,282.549us,282.55us,282.599us,282.6us,282.649us,282.65us,282.699us,282.7us,282.749us,282.75us,282.799us,282.8us,282.849us,282.85us,282.899us,282.9us,282.949us,282.95us,282.999us,283us,283.049us,283.05us,283.099us,283.1us,283.149us,283.15us,283.199us,283.2us,283.249us,283.25us,283.299us,283.3us,283.349us,283.35us,283.399us,283.4us,283.449us,283.45us,283.499us,283.5us,283.549us,283.55us,283.599us,283.6us,283.649us,283.65us,283.699us,283.7us,283.749us,283.75us,283.799us,283.8us,283.849us,283.85us,283.899us,283.9us,283.949us,283.95us,283.999us,284us,284.049us,284.05us,284.099us,284.1us,284.149us,284.15us,284.199us,284.2us,284.249us,284.25us,284.299us,284.3us,284.349us,284.35us,284.399us,284.4us,284.449us,284.45us,284.499us,284.5us,284.549us,284.55us,284.599us,284.6us,284.649us,284.65us,284.699us,284.7us,284.749us,284.75us,284.799us,284.8us,284.849us,284.85us,284.899us,284.9us,284.949us,284.95us,284.999us,285us,285.049us,285.05us,285.099us,285.1us,285.149us,285.15us,285.199us,285.2us,285.249us,285.25us,285.299us,285.3us,285.349us,285.35us,285.399us,285.4us,285.449us,285.45us,285.499us,285.5us,285.549us,285.55us,285.599us,285.6us,285.649us,285.65us,285.699us,285.7us,285.749us,285.75us,285.799us,285.8us,285.849us,285.85us,285.899us,285.9us,285.949us,285.95us,285.999us,286us,286.049us,286.05us,286.099us,286.1us,286.149us,286.15us,286.199us,286.2us,286.249us,286.25us,286.299us,286.3us,286.349us,286.35us,286.399us,286.4us,286.449us,286.45us,286.499us,286.5us,286.549us,286.55us,286.599us,286.6us,286.649us,286.65us,286.699us,286.7us,286.749us,286.75us,286.799us,286.8us,286.849us,286.85us,286.899us,286.9us,286.949us,286.95us,286.999us,287us,287.049us,287.05us,287.099us,287.1us,287.149us,287.15us,287.199us,287.2us,287.249us,287.25us,287.299us,287.3us,287.349us,287.35us,287.399us,287.4us,287.449us,287.45us,287.499us,287.5us,287.549us,287.55us,287.599us,287.6us,287.649us,287.65us,287.699us,287.7us,287.749us,287.75us,287.799us,287.8us,287.849us,287.85us,287.899us,287.9us,287.949us,287.95us,287.999us,288us,288.049us,288.05us,288.099us,288.1us,288.149us,288.15us,288.199us,288.2us,288.249us,288.25us,288.299us,288.3us,288.349us,288.35us,288.399us,288.4us,288.449us,288.45us,288.499us,288.5us,288.549us,288.55us,288.599us,288.6us,288.649us,288.65us,288.699us,288.7us,288.749us,288.75us,288.799us,288.8us,288.849us,288.85us,288.899us,288.9us,288.949us,288.95us,288.999us,289us,289.049us,289.05us,289.099us,289.1us,289.149us,289.15us,289.199us,289.2us,289.249us,289.25us,289.299us,289.3us,289.349us,289.35us,289.399us,289.4us,289.449us,289.45us,289.499us,289.5us,289.549us,289.55us,289.599us,289.6us,289.649us,289.65us,289.699us,289.7us,289.749us,289.75us,289.799us,289.8us,289.849us,289.85us,289.899us,289.9us,289.949us,289.95us,289.999us,290us,290.049us,290.05us,290.099us,290.1us,290.149us,290.15us,290.199us,290.2us,290.249us,290.25us,290.299us,290.3us,290.349us,290.35us,290.399us,290.4us,290.449us,290.45us,290.499us,290.5us,290.549us,290.55us,290.599us,290.6us,290.649us,290.65us,290.699us,290.7us,290.749us,290.75us,290.799us,290.8us,290.849us,290.85us,290.899us,290.9us,290.949us,290.95us,290.999us,291us,291.049us,291.05us,291.099us,291.1us,291.149us,291.15us,291.199us,291.2us,291.249us,291.25us,291.299us,291.3us,291.349us,291.35us,291.399us,291.4us,291.449us,291.45us,291.499us,291.5us,291.549us,291.55us,291.599us,291.6us,291.649us,291.65us,291.699us,291.7us,291.749us,291.75us,291.799us,291.8us,291.849us,291.85us,291.899us,291.9us,291.949us,291.95us,291.999us,292us,292.049us,292.05us,292.099us,292.1us,292.149us,292.15us,292.199us,292.2us,292.249us,292.25us,292.299us,292.3us,292.349us,292.35us,292.399us,292.4us,292.449us,292.45us,292.499us,292.5us,292.549us,292.55us,292.599us,292.6us,292.649us,292.65us,292.699us,292.7us,292.749us,292.75us,292.799us,292.8us,292.849us,292.85us,292.899us,292.9us,292.949us,292.95us,292.999us,293us,293.049us,293.05us,293.099us,293.1us,293.149us,293.15us,293.199us,293.2us,293.249us,293.25us,293.299us,293.3us,293.349us,293.35us,293.399us,293.4us,293.449us,293.45us,293.499us,293.5us,293.549us,293.55us,293.599us,293.6us,293.649us,293.65us,293.699us,293.7us,293.749us,293.75us,293.799us,293.8us,293.849us,293.85us,293.899us,293.9us,293.949us,293.95us,293.999us,294us,294.049us,294.05us,294.099us,294.1us,294.149us,294.15us,294.199us,294.2us,294.249us,294.25us,294.299us,294.3us,294.349us,294.35us,294.399us,294.4us,294.449us,294.45us,294.499us,294.5us,294.549us,294.55us,294.599us,294.6us,294.649us,294.65us,294.699us,294.7us,294.749us,294.75us,294.799us,294.8us,294.849us,294.85us,294.899us,294.9us,294.949us,294.95us,294.999us,295us,295.049us,295.05us,295.099us,295.1us,295.149us,295.15us,295.199us,295.2us,295.249us,295.25us,295.299us,295.3us,295.349us,295.35us,295.399us,295.4us,295.449us,295.45us,295.499us,295.5us,295.549us,295.55us,295.599us,295.6us,295.649us,295.65us,295.699us,295.7us,295.749us,295.75us,295.799us,295.8us,295.849us,295.85us,295.899us,295.9us,295.949us,295.95us,295.999us,296us,296.049us,296.05us,296.099us,296.1us,296.149us,296.15us,296.199us,296.2us,296.249us,296.25us,296.299us,296.3us,296.349us,296.35us,296.399us,296.4us,296.449us,296.45us,296.499us,296.5us,296.549us,296.55us,296.599us,296.6us,296.649us,296.65us,296.699us,296.7us,296.749us,296.75us,296.799us,296.8us,296.849us,296.85us,296.899us,296.9us,296.949us,296.95us,296.999us,297us,297.049us,297.05us,297.099us,297.1us,297.149us,297.15us,297.199us,297.2us,297.249us,297.25us,297.299us,297.3us,297.349us,297.35us,297.399us,297.4us,297.449us,297.45us,297.499us,297.5us,297.549us,297.55us,297.599us,297.6us,297.649us,297.65us,297.699us,297.7us,297.749us,297.75us,297.799us,297.8us,297.849us,297.85us,297.899us,297.9us,297.949us,297.95us,297.999us,298us,298.049us,298.05us,298.099us,298.1us,298.149us,298.15us,298.199us,298.2us,298.249us,298.25us,298.299us,298.3us,298.349us,298.35us,298.399us,298.4us,298.449us,298.45us,298.499us,298.5us,298.549us,298.55us,298.599us,298.6us,298.649us,298.65us,298.699us,298.7us,298.749us,298.75us,298.799us,298.8us,298.849us,298.85us,298.899us,298.9us,298.949us,298.95us,298.999us,299us,299.049us,299.05us,299.099us,299.1us,299.149us,299.15us,299.199us,299.2us,299.249us,299.25us,299.299us,299.3us,299.349us,299.35us,299.399us,299.4us,299.449us,299.45us,299.499us,299.5us,299.549us,299.55us,299.599us,299.6us,299.649us,299.65us,299.699us,299.7us,299.749us,299.75us,299.799us,299.8us,299.849us,299.85us,299.899us,299.9us,299.949us,299.95us,299.999us,300us,300.049us,300.05us,300.099us,300.1us,300.149us,300.15us,300.199us,300.2us,300.249us,300.25us,300.299us,300.3us,300.349us,300.35us,300.399us,300.4us,300.449us,300.45us,300.499us,300.5us,300.549us,300.55us,300.599us,300.6us,300.649us,300.65us,300.699us,300.7us,300.749us,300.75us,300.799us,300.8us,300.849us,300.85us,300.899us,300.9us,300.949us,300.95us,300.999us,301us,301.049us,301.05us,301.099us,301.1us,301.149us,301.15us,301.199us,301.2us,301.249us,301.25us,301.299us,301.3us,301.349us,301.35us,301.399us,301.4us,301.449us,301.45us,301.499us,301.5us,301.549us,301.55us,301.599us,301.6us,301.649us,301.65us,301.699us,301.7us,301.749us,301.75us,301.799us,301.8us,301.849us,301.85us,301.899us,301.9us,301.949us,301.95us,301.999us,302us,302.049us,302.05us,302.099us,302.1us,302.149us,302.15us,302.199us,302.2us,302.249us,302.25us,302.299us,302.3us,302.349us,302.35us,302.399us,302.4us,302.449us,302.45us,302.499us,302.5us,302.549us,302.55us,302.599us,302.6us,302.649us,302.65us,302.699us,302.7us,302.749us,302.75us,302.799us,302.8us,302.849us,302.85us,302.899us,302.9us,302.949us,302.95us,302.999us,303us,303.049us,303.05us,303.099us,303.1us,303.149us,303.15us,303.199us,303.2us,303.249us,303.25us,303.299us,303.3us,303.349us,303.35us,303.399us,303.4us,303.449us,303.45us,303.499us,303.5us,303.549us,303.55us,303.599us,303.6us,303.649us,303.65us,303.699us,303.7us,303.749us,303.75us,303.799us,303.8us,303.849us,303.85us,303.899us,303.9us,303.949us,303.95us,303.999us,304us,304.049us,304.05us,304.099us,304.1us,304.149us,304.15us,304.199us,304.2us,304.249us,304.25us,304.299us,304.3us,304.349us,304.35us,304.399us,304.4us,304.449us,304.45us,304.499us,304.5us,304.549us,304.55us,304.599us,304.6us,304.649us,304.65us,304.699us,304.7us,304.749us,304.75us,304.799us,304.8us,304.849us,304.85us,304.899us,304.9us,304.949us,304.95us,304.999us,305us,305.049us,305.05us,305.099us,305.1us,305.149us,305.15us,305.199us,305.2us,305.249us,305.25us,305.299us,305.3us,305.349us,305.35us,305.399us,305.4us,305.449us,305.45us,305.499us,305.5us,305.549us,305.55us,305.599us,305.6us,305.649us,305.65us,305.699us,305.7us,305.749us,305.75us,305.799us,305.8us,305.849us,305.85us,305.899us,305.9us,305.949us,305.95us,305.999us,306us,306.049us,306.05us,306.099us,306.1us,306.149us,306.15us,306.199us,306.2us,306.249us,306.25us,306.299us,306.3us,306.349us,306.35us,306.399us,306.4us,306.449us,306.45us,306.499us,306.5us,306.549us,306.55us,306.599us,306.6us,306.649us,306.65us,306.699us,306.7us,306.749us,306.75us,306.799us,306.8us,306.849us,306.85us,306.899us,306.9us,306.949us,306.95us,306.999us,307us,307.049us,307.05us,307.099us,307.1us,307.149us,307.15us,307.199us,307.2us,307.249us,307.25us,307.299us,307.3us,307.349us,307.35us,307.399us,307.4us,307.449us,307.45us,307.499us,307.5us,307.549us,307.55us,307.599us,307.6us,307.649us,307.65us,307.699us,307.7us,307.749us,307.75us,307.799us,307.8us,307.849us,307.85us,307.899us,307.9us,307.949us,307.95us,307.999us,308us,308.049us,308.05us,308.099us,308.1us,308.149us,308.15us,308.199us,308.2us,308.249us,308.25us,308.299us,308.3us,308.349us,308.35us,308.399us,308.4us,308.449us,308.45us,308.499us,308.5us,308.549us,308.55us,308.599us,308.6us,308.649us,308.65us,308.699us,308.7us,308.749us,308.75us,308.799us,308.8us,308.849us,308.85us,308.899us,308.9us,308.949us,308.95us,308.999us,309us,309.049us,309.05us,309.099us,309.1us,309.149us,309.15us,309.199us,309.2us,309.249us,309.25us,309.299us,309.3us,309.349us,309.35us,309.399us,309.4us,309.449us,309.45us,309.499us,309.5us,309.549us,309.55us,309.599us,309.6us,309.649us,309.65us,309.699us,309.7us,309.749us,309.75us,309.799us,309.8us,309.849us,309.85us,309.899us,309.9us,309.949us,309.95us,309.999us,310us,310.049us,310.05us,310.099us,310.1us,310.149us,310.15us,310.199us,310.2us,310.249us,310.25us,310.299us,310.3us,310.349us,310.35us,310.399us,310.4us,310.449us,310.45us,310.499us,310.5us,310.549us,310.55us,310.599us,310.6us,310.649us,310.65us,310.699us,310.7us,310.749us,310.75us,310.799us,310.8us,310.849us,310.85us,310.899us,310.9us,310.949us,310.95us,310.999us,311us,311.049us,311.05us,311.099us,311.1us,311.149us,311.15us,311.199us,311.2us,311.249us,311.25us,311.299us,311.3us,311.349us,311.35us,311.399us,311.4us,311.449us,311.45us,311.499us,311.5us,311.549us,311.55us,311.599us,311.6us,311.649us,311.65us,311.699us,311.7us,311.749us,311.75us,311.799us,311.8us,311.849us,311.85us,311.899us,311.9us,311.949us,311.95us,311.999us,312us,312.049us,312.05us,312.099us,312.1us,312.149us,312.15us,312.199us,312.2us,312.249us,312.25us,312.299us,312.3us,312.349us,312.35us,312.399us,312.4us,312.449us,312.45us,312.499us,312.5us,312.549us,312.55us,312.599us,312.6us,312.649us,312.65us,312.699us,312.7us,312.749us,312.75us,312.799us,312.8us,312.849us,312.85us,312.899us,312.9us,312.949us,312.95us,312.999us,313us,313.049us,313.05us,313.099us,313.1us,313.149us,313.15us,313.199us,313.2us,313.249us,313.25us,313.299us,313.3us,313.349us,313.35us,313.399us,313.4us,313.449us,313.45us,313.499us,313.5us,313.549us,313.55us,313.599us,313.6us,313.649us,313.65us,313.699us,313.7us,313.749us,313.75us,313.799us,313.8us,313.849us,313.85us,313.899us,313.9us,313.949us,313.95us,313.999us,314us,314.049us,314.05us,314.099us,314.1us,314.149us,314.15us,314.199us,314.2us,314.249us,314.25us,314.299us,314.3us,314.349us,314.35us,314.399us,314.4us,314.449us,314.45us,314.499us,314.5us,314.549us,314.55us,314.599us,314.6us,314.649us,314.65us,314.699us,314.7us,314.749us,314.75us,314.799us,314.8us,314.849us,314.85us,314.899us,314.9us,314.949us,314.95us,314.999us,315us,315.049us,315.05us,315.099us,315.1us,315.149us,315.15us,315.199us,315.2us,315.249us,315.25us,315.299us,315.3us,315.349us,315.35us,315.399us,315.4us,315.449us,315.45us,315.499us,315.5us,315.549us,315.55us,315.599us,315.6us,315.649us,315.65us,315.699us,315.7us,315.749us,315.75us,315.799us,315.8us,315.849us,315.85us,315.899us,315.9us,315.949us,315.95us,315.999us,316us,316.049us,316.05us,316.099us,316.1us,316.149us,316.15us,316.199us,316.2us,316.249us,316.25us,316.299us,316.3us,316.349us,316.35us,316.399us,316.4us,316.449us,316.45us,316.499us,316.5us,316.549us,316.55us,316.599us,316.6us,316.649us,316.65us,316.699us,316.7us,316.749us,316.75us,316.799us,316.8us,316.849us,316.85us,316.899us,316.9us,316.949us,316.95us,316.999us,317us,317.049us,317.05us,317.099us,317.1us,317.149us,317.15us,317.199us,317.2us,317.249us,317.25us,317.299us,317.3us,317.349us,317.35us,317.399us,317.4us,317.449us,317.45us,317.499us,317.5us,317.549us,317.55us,317.599us,317.6us,317.649us,317.65us,317.699us,317.7us,317.749us,317.75us,317.799us,317.8us,317.849us,317.85us,317.899us,317.9us,317.949us,317.95us,317.999us,318us,318.049us,318.05us,318.099us,318.1us,318.149us,318.15us,318.199us,318.2us,318.249us,318.25us,318.299us,318.3us,318.349us,318.35us,318.399us,318.4us,318.449us,318.45us,318.499us,318.5us,318.549us,318.55us,318.599us,318.6us,318.649us,318.65us,318.699us,318.7us,318.749us,318.75us,318.799us,318.8us,318.849us,318.85us,318.899us,318.9us,318.949us,318.95us,318.999us,319us,319.049us,319.05us,319.099us,319.1us,319.149us,319.15us,319.199us,319.2us,319.249us,319.25us,319.299us,319.3us,319.349us,319.35us,319.399us,319.4us,319.449us,319.45us,319.499us,319.5us,319.549us,319.55us,319.599us,319.6us,319.649us,319.65us,319.699us,319.7us,319.749us,319.75us,319.799us,319.8us,319.849us,319.85us,319.899us,319.9us,319.949us,319.95us,319.999us,320us,320.049us,320.05us,320.099us,320.1us,320.149us,320.15us,320.199us,320.2us,320.249us,320.25us,320.299us,320.3us,320.349us,320.35us,320.399us,320.4us,320.449us,320.45us,320.499us,320.5us,320.549us,320.55us,320.599us,320.6us,320.649us,320.65us,320.699us,320.7us,320.749us,320.75us,320.799us,320.8us,320.849us,320.85us,320.899us,320.9us,320.949us,320.95us,320.999us,321us,321.049us,321.05us,321.099us,321.1us,321.149us,321.15us,321.199us,321.2us,321.249us,321.25us,321.299us,321.3us,321.349us,321.35us,321.399us,321.4us,321.449us,321.45us,321.499us,321.5us,321.549us,321.55us,321.599us,321.6us,321.649us,321.65us,321.699us,321.7us,321.749us,321.75us,321.799us,321.8us,321.849us,321.85us,321.899us,321.9us,321.949us,321.95us,321.999us,322us,322.049us,322.05us,322.099us,322.1us,322.149us,322.15us,322.199us,322.2us,322.249us,322.25us,322.299us,322.3us,322.349us,322.35us,322.399us,322.4us,322.449us,322.45us,322.499us,322.5us,322.549us,322.55us,322.599us,322.6us,322.649us,322.65us,322.699us,322.7us,322.749us,322.75us,322.799us,322.8us,322.849us,322.85us,322.899us,322.9us,322.949us,322.95us,322.999us,323us,323.049us,323.05us,323.099us,323.1us,323.149us,323.15us,323.199us,323.2us,323.249us,323.25us,323.299us,323.3us,323.349us,323.35us,323.399us,323.4us,323.449us,323.45us,323.499us,323.5us,323.549us,323.55us,323.599us,323.6us,323.649us,323.65us,323.699us,323.7us,323.749us,323.75us,323.799us,323.8us,323.849us,323.85us,323.899us,323.9us,323.949us,323.95us,323.999us,324us,324.049us,324.05us,324.099us,324.1us,324.149us,324.15us,324.199us,324.2us,324.249us,324.25us,324.299us,324.3us,324.349us,324.35us,324.399us,324.4us,324.449us,324.45us,324.499us,324.5us,324.549us,324.55us,324.599us,324.6us,324.649us,324.65us,324.699us,324.7us,324.749us,324.75us,324.799us,324.8us,324.849us,324.85us,324.899us,324.9us,324.949us,324.95us,324.999us,325us,325.049us,325.05us,325.099us,325.1us,325.149us,325.15us,325.199us,325.2us,325.249us,325.25us,325.299us,325.3us,325.349us,325.35us,325.399us,325.4us,325.449us,325.45us,325.499us,325.5us,325.549us,325.55us,325.599us,325.6us,325.649us,325.65us,325.699us,325.7us,325.749us,325.75us,325.799us,325.8us,325.849us,325.85us,325.899us,325.9us,325.949us,325.95us,325.999us,326us,326.049us,326.05us,326.099us,326.1us,326.149us,326.15us,326.199us,326.2us,326.249us,326.25us,326.299us,326.3us,326.349us,326.35us,326.399us,326.4us,326.449us,326.45us,326.499us,326.5us,326.549us,326.55us,326.599us,326.6us,326.649us,326.65us,326.699us,326.7us,326.749us,326.75us,326.799us,326.8us,326.849us,326.85us,326.899us,326.9us,326.949us,326.95us,326.999us,327us,327.049us,327.05us,327.099us,327.1us,327.149us,327.15us,327.199us,327.2us,327.249us,327.25us,327.299us,327.3us,327.349us,327.35us,327.399us,327.4us,327.449us,327.45us,327.499us,327.5us,327.549us,327.55us,327.599us,327.6us,327.649us,327.65us,327.699us,327.7us,327.749us,327.75us,327.799us,327.8us,327.849us,327.85us,327.899us,327.9us,327.949us,327.95us,327.999us,328us,328.049us,328.05us,328.099us,328.1us,328.149us,328.15us,328.199us,328.2us,328.249us,328.25us,328.299us,328.3us,328.349us,328.35us,328.399us,328.4us,328.449us,328.45us,328.499us,328.5us,328.549us,328.55us,328.599us,328.6us,328.649us,328.65us,328.699us,328.7us,328.749us,328.75us,328.799us,328.8us,328.849us,328.85us,328.899us,328.9us,328.949us,328.95us,328.999us,329us,329.049us,329.05us,329.099us,329.1us,329.149us,329.15us,329.199us,329.2us,329.249us,329.25us,329.299us,329.3us,329.349us,329.35us,329.399us,329.4us,329.449us,329.45us,329.499us,329.5us,329.549us,329.55us,329.599us,329.6us,329.649us,329.65us,329.699us,329.7us,329.749us,329.75us,329.799us,329.8us,329.849us,329.85us,329.899us,329.9us,329.949us,329.95us,329.999us,330us,330.049us,330.05us,330.099us,330.1us,330.149us,330.15us,330.199us,330.2us,330.249us,330.25us,330.299us,330.3us,330.349us,330.35us,330.399us,330.4us,330.449us,330.45us,330.499us,330.5us,330.549us,330.55us,330.599us,330.6us,330.649us,330.65us,330.699us,330.7us,330.749us,330.75us,330.799us,330.8us,330.849us,330.85us,330.899us,330.9us,330.949us,330.95us,330.999us,331us,331.049us,331.05us,331.099us,331.1us,331.149us,331.15us,331.199us,331.2us,331.249us,331.25us,331.299us,331.3us,331.349us,331.35us,331.399us,331.4us,331.449us,331.45us,331.499us,331.5us,331.549us,331.55us,331.599us,331.6us,331.649us,331.65us,331.699us,331.7us,331.749us,331.75us,331.799us,331.8us,331.849us,331.85us,331.899us,331.9us,331.949us,331.95us,331.999us,332us,332.049us,332.05us,332.099us,332.1us,332.149us,332.15us,332.199us,332.2us,332.249us,332.25us,332.299us,332.3us,332.349us,332.35us,332.399us,332.4us,332.449us,332.45us,332.499us,332.5us,332.549us,332.55us,332.599us,332.6us,332.649us,332.65us,332.699us,332.7us,332.749us,332.75us,332.799us,332.8us,332.849us,332.85us,332.899us,332.9us,332.949us,332.95us,332.999us,333us,333.049us,333.05us,333.099us,333.1us,333.149us,333.15us,333.199us,333.2us,333.249us,333.25us,333.299us,333.3us,333.349us,333.35us,333.399us,333.4us,333.449us,333.45us,333.499us,333.5us,333.549us,333.55us,333.599us,333.6us,333.649us,333.65us,333.699us,333.7us,333.749us,333.75us,333.799us,333.8us,333.849us,333.85us,333.899us,333.9us,333.949us,333.95us,333.999us,334us,334.049us,334.05us,334.099us,334.1us,334.149us,334.15us,334.199us,334.2us,334.249us,334.25us,334.299us,334.3us,334.349us,334.35us,334.399us,334.4us,334.449us,334.45us,334.499us,334.5us,334.549us,334.55us,334.599us,334.6us,334.649us,334.65us,334.699us,334.7us,334.749us,334.75us,334.799us,334.8us,334.849us,334.85us,334.899us,334.9us,334.949us,334.95us,334.999us,335us,335.049us,335.05us,335.099us,335.1us,335.149us,335.15us,335.199us,335.2us,335.249us,335.25us,335.299us,335.3us,335.349us,335.35us,335.399us,335.4us,335.449us,335.45us,335.499us,335.5us,335.549us,335.55us,335.599us,335.6us,335.649us,335.65us,335.699us,335.7us,335.749us,335.75us,335.799us,335.8us,335.849us,335.85us,335.899us,335.9us,335.949us,335.95us,335.999us,336us,336.049us,336.05us,336.099us,336.1us,336.149us,336.15us,336.199us,336.2us,336.249us,336.25us,336.299us,336.3us,336.349us,336.35us,336.399us,336.4us,336.449us,336.45us,336.499us,336.5us,336.549us,336.55us,336.599us,336.6us,336.649us,336.65us,336.699us,336.7us,336.749us,336.75us,336.799us,336.8us,336.849us,336.85us,336.899us,336.9us,336.949us,336.95us,336.999us,337us,337.049us,337.05us,337.099us,337.1us,337.149us,337.15us,337.199us,337.2us,337.249us,337.25us,337.299us,337.3us,337.349us,337.35us,337.399us,337.4us,337.449us,337.45us,337.499us,337.5us,337.549us,337.55us,337.599us,337.6us,337.649us,337.65us,337.699us,337.7us,337.749us,337.75us,337.799us,337.8us,337.849us,337.85us,337.899us,337.9us,337.949us,337.95us,337.999us,338us,338.049us,338.05us,338.099us,338.1us,338.149us,338.15us,338.199us,338.2us,338.249us,338.25us,338.299us,338.3us,338.349us,338.35us,338.399us,338.4us,338.449us,338.45us,338.499us,338.5us,338.549us,338.55us,338.599us,338.6us,338.649us,338.65us,338.699us,338.7us,338.749us,338.75us,338.799us,338.8us,338.849us,338.85us,338.899us,338.9us,338.949us,338.95us,338.999us,339us,339.049us,339.05us,339.099us,339.1us,339.149us,339.15us,339.199us,339.2us,339.249us,339.25us,339.299us,339.3us,339.349us,339.35us,339.399us,339.4us,339.449us,339.45us,339.499us,339.5us,339.549us,339.55us,339.599us,339.6us,339.649us,339.65us,339.699us,339.7us,339.749us,339.75us,339.799us,339.8us,339.849us,339.85us,339.899us,339.9us,339.949us,339.95us,339.999us,340us,340.049us,340.05us,340.099us,340.1us,340.149us,340.15us,340.199us,340.2us,340.249us,340.25us,340.299us,340.3us,340.349us,340.35us,340.399us,340.4us,340.449us,340.45us,340.499us,340.5us,340.549us,340.55us,340.599us,340.6us,340.649us,340.65us,340.699us,340.7us,340.749us,340.75us,340.799us,340.8us,340.849us,340.85us,340.899us,340.9us,340.949us,340.95us,340.999us,341us,341.049us,341.05us,341.099us,341.1us,341.149us,341.15us,341.199us,341.2us,341.249us,341.25us,341.299us,341.3us,341.349us,341.35us,341.399us,341.4us,341.449us,341.45us,341.499us,341.5us,341.549us,341.55us,341.599us,341.6us,341.649us,341.65us,341.699us,341.7us,341.749us,341.75us,341.799us,341.8us,341.849us,341.85us,341.899us,341.9us,341.949us,341.95us,341.999us,342us,342.049us,342.05us,342.099us,342.1us,342.149us,342.15us,342.199us,342.2us,342.249us,342.25us,342.299us,342.3us,342.349us,342.35us,342.399us,342.4us,342.449us,342.45us,342.499us,342.5us,342.549us,342.55us,342.599us,342.6us,342.649us,342.65us,342.699us,342.7us,342.749us,342.75us,342.799us,342.8us,342.849us,342.85us,342.899us,342.9us,342.949us,342.95us,342.999us,343us,343.049us,343.05us,343.099us,343.1us,343.149us,343.15us,343.199us,343.2us,343.249us,343.25us,343.299us,343.3us,343.349us,343.35us,343.399us,343.4us,343.449us,343.45us,343.499us,343.5us,343.549us,343.55us,343.599us,343.6us,343.649us,343.65us,343.699us,343.7us,343.749us,343.75us,343.799us,343.8us,343.849us,343.85us,343.899us,343.9us,343.949us,343.95us,343.999us,344us,344.049us,344.05us,344.099us,344.1us,344.149us,344.15us,344.199us,344.2us,344.249us,344.25us,344.299us,344.3us,344.349us,344.35us,344.399us,344.4us,344.449us,344.45us,344.499us,344.5us,344.549us,344.55us,344.599us,344.6us,344.649us,344.65us,344.699us,344.7us,344.749us,344.75us,344.799us,344.8us,344.849us,344.85us,344.899us,344.9us,344.949us,344.95us,344.999us,345us,345.049us,345.05us,345.099us,345.1us,345.149us,345.15us,345.199us,345.2us,345.249us,345.25us,345.299us,345.3us,345.349us,345.35us,345.399us,345.4us,345.449us,345.45us,345.499us,345.5us,345.549us,345.55us,345.599us,345.6us,345.649us,345.65us,345.699us,345.7us,345.749us,345.75us,345.799us,345.8us,345.849us,345.85us,345.899us,345.9us,345.949us,345.95us,345.999us,346us,346.049us,346.05us,346.099us,346.1us,346.149us,346.15us,346.199us,346.2us,346.249us,346.25us,346.299us,346.3us,346.349us,346.35us,346.399us,346.4us,346.449us,346.45us,346.499us,346.5us,346.549us,346.55us,346.599us,346.6us,346.649us,346.65us,346.699us,346.7us,346.749us,346.75us,346.799us,346.8us,346.849us,346.85us,346.899us,346.9us,346.949us,346.95us,346.999us,347us,347.049us,347.05us,347.099us,347.1us,347.149us,347.15us,347.199us,347.2us,347.249us,347.25us,347.299us,347.3us,347.349us,347.35us,347.399us,347.4us,347.449us,347.45us,347.499us,347.5us,347.549us,347.55us,347.599us,347.6us,347.649us,347.65us,347.699us,347.7us,347.749us,347.75us,347.799us,347.8us,347.849us,347.85us,347.899us,347.9us,347.949us,347.95us,347.999us,348us,348.049us,348.05us,348.099us,348.1us,348.149us,348.15us,348.199us,348.2us,348.249us,348.25us,348.299us,348.3us,348.349us,348.35us,348.399us,348.4us,348.449us,348.45us,348.499us,348.5us,348.549us,348.55us,348.599us,348.6us,348.649us,348.65us,348.699us,348.7us,348.749us,348.75us,348.799us,348.8us,348.849us,348.85us,348.899us,348.9us,348.949us,348.95us,348.999us,349us,349.049us,349.05us,349.099us,349.1us,349.149us,349.15us,349.199us,349.2us,349.249us,349.25us,349.299us,349.3us,349.349us,349.35us,349.399us,349.4us,349.449us,349.45us,349.499us,349.5us,349.549us,349.55us,349.599us,349.6us,349.649us,349.65us,349.699us,349.7us,349.749us,349.75us,349.799us,349.8us,349.849us,349.85us,349.899us,349.9us,349.949us,349.95us,349.999us,350us,350.049us,350.05us,350.099us,350.1us,350.149us,350.15us,350.199us,350.2us,350.249us,350.25us,350.299us,350.3us,350.349us,350.35us,350.399us,350.4us,350.449us,350.45us,350.499us,350.5us,350.549us,350.55us,350.599us,350.6us,350.649us,350.65us,350.699us,350.7us,350.749us,350.75us,350.799us,350.8us,350.849us,350.85us,350.899us,350.9us,350.949us,350.95us,350.999us,351us,351.049us,351.05us,351.099us,351.1us,351.149us,351.15us,351.199us,351.2us,351.249us,351.25us,351.299us,351.3us,351.349us,351.35us,351.399us,351.4us,351.449us,351.45us,351.499us,351.5us,351.549us,351.55us,351.599us,351.6us,351.649us,351.65us,351.699us,351.7us,351.749us,351.75us,351.799us,351.8us,351.849us,351.85us,351.899us,351.9us,351.949us,351.95us,351.999us,352us,352.049us,352.05us,352.099us,352.1us,352.149us,352.15us,352.199us,352.2us,352.249us,352.25us,352.299us,352.3us,352.349us,352.35us,352.399us,352.4us,352.449us,352.45us,352.499us,352.5us,352.549us,352.55us,352.599us,352.6us,352.649us,352.65us,352.699us,352.7us,352.749us,352.75us,352.799us,352.8us,352.849us,352.85us,352.899us,352.9us,352.949us,352.95us,352.999us,353us,353.049us,353.05us,353.099us,353.1us,353.149us,353.15us,353.199us,353.2us,353.249us,353.25us,353.299us,353.3us,353.349us,353.35us,353.399us,353.4us,353.449us,353.45us,353.499us,353.5us,353.549us,353.55us,353.599us,353.6us,353.649us,353.65us,353.699us,353.7us,353.749us,353.75us,353.799us,353.8us,353.849us,353.85us,353.899us,353.9us,353.949us,353.95us,353.999us,354us,354.049us,354.05us,354.099us,354.1us,354.149us,354.15us,354.199us,354.2us,354.249us,354.25us,354.299us,354.3us,354.349us,354.35us,354.399us,354.4us,354.449us,354.45us,354.499us,354.5us,354.549us,354.55us,354.599us,354.6us,354.649us,354.65us,354.699us,354.7us,354.749us,354.75us,354.799us,354.8us,354.849us,354.85us,354.899us,354.9us,354.949us,354.95us,354.999us,355us,355.049us,355.05us,355.099us,355.1us,355.149us,355.15us,355.199us,355.2us,355.249us,355.25us,355.299us,355.3us,355.349us,355.35us,355.399us,355.4us,355.449us,355.45us,355.499us,355.5us,355.549us,355.55us,355.599us,355.6us,355.649us,355.65us,355.699us,355.7us,355.749us,355.75us,355.799us,355.8us,355.849us,355.85us,355.899us,355.9us,355.949us,355.95us,355.999us,356us,356.049us,356.05us,356.099us,356.1us,356.149us,356.15us,356.199us,356.2us,356.249us,356.25us,356.299us,356.3us,356.349us,356.35us,356.399us,356.4us,356.449us,356.45us,356.499us,356.5us,356.549us,356.55us,356.599us,356.6us,356.649us,356.65us,356.699us,356.7us,356.749us,356.75us,356.799us,356.8us,356.849us,356.85us,356.899us,356.9us,356.949us,356.95us,356.999us,357us,357.049us,357.05us,357.099us,357.1us,357.149us,357.15us,357.199us,357.2us,357.249us,357.25us,357.299us,357.3us,357.349us,357.35us,357.399us,357.4us,357.449us,357.45us,357.499us,357.5us,357.549us,357.55us,357.599us,357.6us,357.649us,357.65us,357.699us,357.7us,357.749us,357.75us,357.799us,357.8us,357.849us,357.85us,357.899us,357.9us,357.949us,357.95us,357.999us,358us,358.049us,358.05us,358.099us,358.1us,358.149us,358.15us,358.199us,358.2us,358.249us,358.25us,358.299us,358.3us,358.349us,358.35us,358.399us,358.4us,358.449us,358.45us,358.499us,358.5us,358.549us,358.55us,358.599us,358.6us,358.649us,358.65us,358.699us,358.7us,358.749us,358.75us,358.799us,358.8us,358.849us,358.85us,358.899us,358.9us,358.949us,358.95us,358.999us,359us,359.049us,359.05us,359.099us,359.1us,359.149us,359.15us,359.199us,359.2us,359.249us,359.25us,359.299us,359.3us,359.349us,359.35us,359.399us,359.4us,359.449us,359.45us,359.499us,359.5us,359.549us,359.55us,359.599us,359.6us,359.649us,359.65us,359.699us,359.7us,359.749us,359.75us,359.799us,359.8us,359.849us,359.85us,359.899us,359.9us,359.949us,359.95us,359.999us,360us,360.049us,360.05us,360.099us,360.1us,360.149us,360.15us,360.199us,360.2us,360.249us,360.25us,360.299us,360.3us,360.349us,360.35us,360.399us,360.4us,360.449us,360.45us,360.499us,360.5us,360.549us,360.55us,360.599us,360.6us,360.649us,360.65us,360.699us,360.7us,360.749us,360.75us,360.799us,360.8us,360.849us,360.85us,360.899us,360.9us,360.949us,360.95us,360.999us,361us,361.049us,361.05us,361.099us,361.1us,361.149us,361.15us,361.199us,361.2us,361.249us,361.25us,361.299us,361.3us,361.349us,361.35us,361.399us,361.4us,361.449us,361.45us,361.499us,361.5us,361.549us,361.55us,361.599us,361.6us,361.649us,361.65us,361.699us,361.7us,361.749us,361.75us,361.799us,361.8us,361.849us,361.85us,361.899us,361.9us,361.949us,361.95us,361.999us,362us,362.049us,362.05us,362.099us,362.1us,362.149us,362.15us,362.199us,362.2us,362.249us,362.25us,362.299us,362.3us,362.349us,362.35us,362.399us,362.4us,362.449us,362.45us,362.499us,362.5us,362.549us,362.55us,362.599us,362.6us,362.649us,362.65us,362.699us,362.7us,362.749us,362.75us,362.799us,362.8us,362.849us,362.85us,362.899us,362.9us,362.949us,362.95us,362.999us,363us,363.049us,363.05us,363.099us,363.1us,363.149us,363.15us,363.199us,363.2us,363.249us,363.25us,363.299us,363.3us,363.349us,363.35us,363.399us,363.4us,363.449us,363.45us,363.499us,363.5us,363.549us,363.55us,363.599us,363.6us,363.649us,363.65us,363.699us,363.7us,363.749us,363.75us,363.799us,363.8us,363.849us,363.85us,363.899us,363.9us,363.949us,363.95us,363.999us,364us,364.049us,364.05us,364.099us,364.1us,364.149us,364.15us,364.199us,364.2us,364.249us,364.25us,364.299us,364.3us,364.349us,364.35us,364.399us,364.4us,364.449us,364.45us,364.499us,364.5us,364.549us,364.55us,364.599us,364.6us,364.649us,364.65us,364.699us,364.7us,364.749us,364.75us,364.799us,364.8us,364.849us,364.85us,364.899us,364.9us,364.949us,364.95us,364.999us,365us,365.049us,365.05us,365.099us,365.1us,365.149us,365.15us,365.199us,365.2us,365.249us,365.25us,365.299us,365.3us,365.349us,365.35us,365.399us,365.4us,365.449us,365.45us,365.499us,365.5us,365.549us,365.55us,365.599us,365.6us,365.649us,365.65us,365.699us,365.7us,365.749us,365.75us,365.799us,365.8us,365.849us,365.85us,365.899us,365.9us,365.949us,365.95us,365.999us,366us,366.049us,366.05us,366.099us,366.1us,366.149us,366.15us,366.199us,366.2us,366.249us,366.25us,366.299us,366.3us,366.349us,366.35us,366.399us,366.4us,366.449us,366.45us,366.499us,366.5us,366.549us,366.55us,366.599us,366.6us,366.649us,366.65us,366.699us,366.7us,366.749us,366.75us,366.799us,366.8us,366.849us,366.85us,366.899us,366.9us,366.949us,366.95us,366.999us,367us,367.049us,367.05us,367.099us,367.1us,367.149us,367.15us,367.199us,367.2us,367.249us,367.25us,367.299us,367.3us,367.349us,367.35us,367.399us,367.4us,367.449us,367.45us,367.499us,367.5us,367.549us,367.55us,367.599us,367.6us,367.649us,367.65us,367.699us,367.7us,367.749us,367.75us,367.799us,367.8us,367.849us,367.85us,367.899us,367.9us,367.949us,367.95us,367.999us,368us,368.049us,368.05us,368.099us,368.1us,368.149us,368.15us,368.199us,368.2us,368.249us,368.25us,368.299us,368.3us,368.349us,368.35us,368.399us,368.4us,368.449us,368.45us,368.499us,368.5us,368.549us,368.55us,368.599us,368.6us,368.649us,368.65us,368.699us,368.7us,368.749us,368.75us,368.799us,368.8us,368.849us,368.85us,368.899us,368.9us,368.949us,368.95us,368.999us,369us,369.049us,369.05us,369.099us,369.1us,369.149us,369.15us,369.199us,369.2us,369.249us,369.25us,369.299us,369.3us,369.349us,369.35us,369.399us,369.4us,369.449us,369.45us,369.499us,369.5us,369.549us,369.55us,369.599us,369.6us,369.649us,369.65us,369.699us,369.7us,369.749us,369.75us,369.799us,369.8us,369.849us,369.85us,369.899us,369.9us,369.949us,369.95us,369.999us,370us,370.049us,370.05us,370.099us,370.1us,370.149us,370.15us,370.199us,370.2us,370.249us,370.25us,370.299us,370.3us,370.349us,370.35us,370.399us,370.4us,370.449us,370.45us,370.499us,370.5us,370.549us,370.55us,370.599us,370.6us,370.649us,370.65us,370.699us,370.7us,370.749us,370.75us,370.799us,370.8us,370.849us,370.85us,370.899us,370.9us,370.949us,370.95us,370.999us,371us,371.049us,371.05us,371.099us,371.1us,371.149us,371.15us,371.199us,371.2us,371.249us,371.25us,371.299us,371.3us,371.349us,371.35us,371.399us,371.4us,371.449us,371.45us,371.499us,371.5us,371.549us,371.55us,371.599us,371.6us,371.649us,371.65us,371.699us,371.7us,371.749us,371.75us,371.799us,371.8us,371.849us,371.85us,371.899us,371.9us,371.949us,371.95us,371.999us,372us,372.049us,372.05us,372.099us,372.1us,372.149us,372.15us,372.199us,372.2us,372.249us,372.25us,372.299us,372.3us,372.349us,372.35us,372.399us,372.4us,372.449us,372.45us,372.499us,372.5us,372.549us,372.55us,372.599us,372.6us,372.649us,372.65us,372.699us,372.7us,372.749us,372.75us,372.799us,372.8us,372.849us,372.85us,372.899us,372.9us,372.949us,372.95us,372.999us,373us,373.049us,373.05us,373.099us,373.1us,373.149us,373.15us,373.199us,373.2us,373.249us,373.25us,373.299us,373.3us,373.349us,373.35us,373.399us,373.4us,373.449us,373.45us,373.499us,373.5us,373.549us,373.55us,373.599us,373.6us,373.649us,373.65us,373.699us,373.7us,373.749us,373.75us,373.799us,373.8us,373.849us,373.85us,373.899us,373.9us,373.949us,373.95us,373.999us,374us,374.049us,374.05us,374.099us,374.1us,374.149us,374.15us,374.199us,374.2us,374.249us,374.25us,374.299us,374.3us,374.349us,374.35us,374.399us,374.4us,374.449us,374.45us,374.499us,374.5us,374.549us,374.55us,374.599us,374.6us,374.649us,374.65us,374.699us,374.7us,374.749us,374.75us,374.799us,374.8us,374.849us,374.85us,374.899us,374.9us,374.949us,374.95us,374.999us,375us,375.049us,375.05us,375.099us,375.1us,375.149us,375.15us,375.199us,375.2us,375.249us,375.25us,375.299us,375.3us,375.349us,375.35us,375.399us,375.4us,375.449us,375.45us,375.499us,375.5us,375.549us,375.55us,375.599us,375.6us,375.649us,375.65us,375.699us,375.7us,375.749us,375.75us,375.799us,375.8us,375.849us,375.85us,375.899us,375.9us,375.949us,375.95us,375.999us,376us,376.049us,376.05us,376.099us,376.1us,376.149us,376.15us,376.199us,376.2us,376.249us,376.25us,376.299us,376.3us,376.349us,376.35us,376.399us,376.4us,376.449us,376.45us,376.499us,376.5us,376.549us,376.55us,376.599us,376.6us,376.649us,376.65us,376.699us,376.7us,376.749us,376.75us,376.799us,376.8us,376.849us,376.85us,376.899us,376.9us,376.949us,376.95us,376.999us,377us,377.049us,377.05us,377.099us,377.1us,377.149us,377.15us,377.199us,377.2us,377.249us,377.25us,377.299us,377.3us,377.349us,377.35us,377.399us,377.4us,377.449us,377.45us,377.499us,377.5us,377.549us,377.55us,377.599us,377.6us,377.649us,377.65us,377.699us,377.7us,377.749us,377.75us,377.799us,377.8us,377.849us,377.85us,377.899us,377.9us,377.949us,377.95us,377.999us,378us,378.049us,378.05us,378.099us,378.1us,378.149us,378.15us,378.199us,378.2us,378.249us,378.25us,378.299us,378.3us,378.349us,378.35us,378.399us,378.4us,378.449us,378.45us,378.499us,378.5us,378.549us,378.55us,378.599us,378.6us,378.649us,378.65us,378.699us,378.7us,378.749us,378.75us,378.799us,378.8us,378.849us,378.85us,378.899us,378.9us,378.949us,378.95us,378.999us,379us,379.049us,379.05us,379.099us,379.1us,379.149us,379.15us,379.199us,379.2us,379.249us,379.25us,379.299us,379.3us,379.349us,379.35us,379.399us,379.4us,379.449us,379.45us,379.499us,379.5us,379.549us,379.55us,379.599us,379.6us,379.649us,379.65us,379.699us,379.7us,379.749us,379.75us,379.799us,379.8us,379.849us,379.85us,379.899us,379.9us,379.949us,379.95us,379.999us,380us,380.049us,380.05us,380.099us,380.1us,380.149us,380.15us,380.199us,380.2us,380.249us,380.25us,380.299us,380.3us,380.349us,380.35us,380.399us,380.4us,380.449us,380.45us,380.499us,380.5us,380.549us,380.55us,380.599us,380.6us,380.649us,380.65us,380.699us,380.7us,380.749us,380.75us,380.799us,380.8us,380.849us,380.85us,380.899us,380.9us,380.949us,380.95us,380.999us,381us,381.049us,381.05us,381.099us,381.1us,381.149us,381.15us,381.199us,381.2us,381.249us,381.25us,381.299us,381.3us,381.349us,381.35us,381.399us,381.4us,381.449us,381.45us,381.499us,381.5us,381.549us,381.55us,381.599us,381.6us,381.649us,381.65us,381.699us,381.7us,381.749us,381.75us,381.799us,381.8us,381.849us,381.85us,381.899us,381.9us,381.949us,381.95us,381.999us,382us,382.049us,382.05us,382.099us,382.1us,382.149us,382.15us,382.199us,382.2us,382.249us,382.25us,382.299us,382.3us,382.349us,382.35us,382.399us,382.4us,382.449us,382.45us,382.499us,382.5us,382.549us,382.55us,382.599us,382.6us,382.649us,382.65us,382.699us,382.7us,382.749us,382.75us,382.799us,382.8us,382.849us,382.85us,382.899us,382.9us,382.949us,382.95us,382.999us,383us,383.049us,383.05us,383.099us,383.1us,383.149us,383.15us,383.199us,383.2us,383.249us,383.25us,383.299us,383.3us,383.349us,383.35us,383.399us,383.4us,383.449us,383.45us,383.499us,383.5us,383.549us,383.55us,383.599us,383.6us,383.649us,383.65us,383.699us,383.7us,383.749us,383.75us,383.799us,383.8us,383.849us,383.85us,383.899us,383.9us,383.949us,383.95us,383.999us,384us,384.049us,384.05us,384.099us,384.1us,384.149us,384.15us,384.199us,384.2us,384.249us,384.25us,384.299us,384.3us,384.349us,384.35us,384.399us,384.4us,384.449us,384.45us,384.499us,384.5us,384.549us,384.55us,384.599us,384.6us,384.649us,384.65us,384.699us,384.7us,384.749us,384.75us,384.799us,384.8us,384.849us,384.85us,384.899us,384.9us,384.949us,384.95us,384.999us,385us,385.049us,385.05us,385.099us,385.1us,385.149us,385.15us,385.199us,385.2us,385.249us,385.25us,385.299us,385.3us,385.349us,385.35us,385.399us,385.4us,385.449us,385.45us,385.499us,385.5us,385.549us,385.55us,385.599us,385.6us,385.649us,385.65us,385.699us,385.7us,385.749us,385.75us,385.799us,385.8us,385.849us,385.85us,385.899us,385.9us,385.949us,385.95us,385.999us,386us,386.049us,386.05us,386.099us,386.1us,386.149us,386.15us,386.199us,386.2us,386.249us,386.25us,386.299us,386.3us,386.349us,386.35us,386.399us,386.4us,386.449us,386.45us,386.499us,386.5us,386.549us,386.55us,386.599us,386.6us,386.649us,386.65us,386.699us,386.7us,386.749us,386.75us,386.799us,386.8us,386.849us,386.85us,386.899us,386.9us,386.949us,386.95us,386.999us,387us,387.049us,387.05us,387.099us,387.1us,387.149us,387.15us,387.199us,387.2us,387.249us,387.25us,387.299us,387.3us,387.349us,387.35us,387.399us,387.4us,387.449us,387.45us,387.499us,387.5us,387.549us,387.55us,387.599us,387.6us,387.649us,387.65us,387.699us,387.7us,387.749us,387.75us,387.799us,387.8us,387.849us,387.85us,387.899us,387.9us,387.949us,387.95us,387.999us,388us,388.049us,388.05us,388.099us,388.1us,388.149us,388.15us,388.199us,388.2us,388.249us,388.25us,388.299us,388.3us,388.349us,388.35us,388.399us,388.4us,388.449us,388.45us,388.499us,388.5us,388.549us,388.55us,388.599us,388.6us,388.649us,388.65us,388.699us,388.7us,388.749us,388.75us,388.799us,388.8us,388.849us,388.85us,388.899us,388.9us,388.949us,388.95us,388.999us,389us,389.049us,389.05us,389.099us,389.1us,389.149us,389.15us,389.199us,389.2us,389.249us,389.25us,389.299us,389.3us,389.349us,389.35us,389.399us,389.4us,389.449us,389.45us,389.499us,389.5us,389.549us,389.55us,389.599us,389.6us,389.649us,389.65us,389.699us,389.7us,389.749us,389.75us,389.799us,389.8us,389.849us,389.85us,389.899us,389.9us,389.949us,389.95us,389.999us,390us,390.049us,390.05us,390.099us,390.1us,390.149us,390.15us,390.199us,390.2us,390.249us,390.25us,390.299us,390.3us,390.349us,390.35us,390.399us,390.4us,390.449us,390.45us,390.499us,390.5us,390.549us,390.55us,390.599us,390.6us,390.649us,390.65us,390.699us,390.7us,390.749us,390.75us,390.799us,390.8us,390.849us,390.85us,390.899us,390.9us,390.949us,390.95us,390.999us,391us,391.049us,391.05us,391.099us,391.1us,391.149us,391.15us,391.199us,391.2us,391.249us,391.25us,391.299us,391.3us,391.349us,391.35us,391.399us,391.4us,391.449us,391.45us,391.499us,391.5us,391.549us,391.55us,391.599us,391.6us,391.649us,391.65us,391.699us,391.7us,391.749us,391.75us,391.799us,391.8us,391.849us,391.85us,391.899us,391.9us,391.949us,391.95us,391.999us,392us,392.049us,392.05us,392.099us,392.1us,392.149us,392.15us,392.199us,392.2us,392.249us,392.25us,392.299us,392.3us,392.349us,392.35us,392.399us,392.4us,392.449us,392.45us,392.499us,392.5us,392.549us,392.55us,392.599us,392.6us,392.649us,392.65us,392.699us,392.7us,392.749us,392.75us,392.799us,392.8us,392.849us,392.85us,392.899us,392.9us,392.949us,392.95us,392.999us,393us,393.049us,393.05us,393.099us,393.1us,393.149us,393.15us,393.199us,393.2us,393.249us,393.25us,393.299us,393.3us,393.349us,393.35us,393.399us,393.4us,393.449us,393.45us,393.499us,393.5us,393.549us,393.55us,393.599us,393.6us,393.649us,393.65us,393.699us,393.7us,393.749us,393.75us,393.799us,393.8us,393.849us,393.85us,393.899us,393.9us,393.949us,393.95us,393.999us,394us,394.049us,394.05us,394.099us,394.1us,394.149us,394.15us,394.199us,394.2us,394.249us,394.25us,394.299us,394.3us,394.349us,394.35us,394.399us,394.4us,394.449us,394.45us,394.499us,394.5us,394.549us,394.55us,394.599us,394.6us,394.649us,394.65us,394.699us,394.7us,394.749us,394.75us,394.799us,394.8us,394.849us,394.85us,394.899us,394.9us,394.949us,394.95us,394.999us,395us,395.049us,395.05us,395.099us,395.1us,395.149us,395.15us,395.199us,395.2us,395.249us,395.25us,395.299us,395.3us,395.349us,395.35us,395.399us,395.4us,395.449us,395.45us,395.499us,395.5us,395.549us,395.55us,395.599us,395.6us,395.649us,395.65us,395.699us,395.7us,395.749us,395.75us,395.799us,395.8us,395.849us,395.85us,395.899us,395.9us,395.949us,395.95us,395.999us,396us,396.049us,396.05us,396.099us,396.1us,396.149us,396.15us,396.199us,396.2us,396.249us,396.25us,396.299us,396.3us,396.349us,396.35us,396.399us,396.4us,396.449us,396.45us,396.499us,396.5us,396.549us,396.55us,396.599us,396.6us,396.649us,396.65us,396.699us,396.7us,396.749us,396.75us,396.799us,396.8us,396.849us,396.85us,396.899us,396.9us,396.949us,396.95us,396.999us,397us,397.049us,397.05us,397.099us,397.1us,397.149us,397.15us,397.199us,397.2us,397.249us,397.25us,397.299us,397.3us,397.349us,397.35us,397.399us,397.4us,397.449us,397.45us,397.499us,397.5us,397.549us,397.55us,397.599us,397.6us,397.649us,397.65us,397.699us,397.7us,397.749us,397.75us,397.799us,397.8us,397.849us,397.85us,397.899us,397.9us,397.949us,397.95us,397.999us,398us,398.049us,398.05us,398.099us,398.1us,398.149us,398.15us,398.199us,398.2us,398.249us,398.25us,398.299us,398.3us,398.349us,398.35us,398.399us,398.4us,398.449us,398.45us,398.499us,398.5us,398.549us,398.55us,398.599us,398.6us,398.649us,398.65us,398.699us,398.7us,398.749us,398.75us,398.799us,398.8us,398.849us,398.85us,398.899us,398.9us,398.949us,398.95us,398.999us,399us,399.049us,399.05us,399.099us,399.1us,399.149us,399.15us,399.199us,399.2us,399.249us,399.25us,399.299us,399.3us,399.349us,399.35us,399.399us,399.4us,399.449us,399.45us,399.499us,399.5us,399.549us,399.55us,399.599us,399.6us,399.649us,399.65us,399.699us,399.7us,399.749us,399.75us,399.799us,399.8us,399.849us,399.85us,399.899us,399.9us,399.949us,399.95us,399.999us,400us,400.049us,400.05us,400.099us,400.1us,400.149us,400.15us,400.199us,400.2us,400.249us,400.25us,400.299us,400.3us,400.349us,400.35us,400.399us,400.4us,400.449us,400.45us,400.499us,400.5us,400.549us,400.55us,400.599us,400.6us,400.649us,400.65us,400.699us,400.7us,400.749us,400.75us,400.799us,400.8us,400.849us,400.85us,400.899us,400.9us,400.949us,400.95us,400.999us,401us,401.049us,401.05us,401.099us,401.1us,401.149us,401.15us,401.199us,401.2us,401.249us,401.25us,401.299us,401.3us,401.349us,401.35us,401.399us,401.4us,401.449us,401.45us,401.499us,401.5us,401.549us,401.55us,401.599us,401.6us,401.649us,401.65us,401.699us,401.7us,401.749us,401.75us,401.799us,401.8us,401.849us,401.85us,401.899us,401.9us,401.949us,401.95us,401.999us,402us,402.049us,402.05us,402.099us,402.1us,402.149us,402.15us,402.199us,402.2us,402.249us,402.25us,402.299us,402.3us,402.349us,402.35us,402.399us,402.4us,402.449us,402.45us,402.499us,402.5us,402.549us,402.55us,402.599us,402.6us,402.649us,402.65us,402.699us,402.7us,402.749us,402.75us,402.799us,402.8us,402.849us,402.85us,402.899us,402.9us,402.949us,402.95us,402.999us,403us,403.049us,403.05us,403.099us,403.1us,403.149us,403.15us,403.199us,403.2us,403.249us,403.25us,403.299us,403.3us,403.349us,403.35us,403.399us,403.4us,403.449us,403.45us,403.499us,403.5us,403.549us,403.55us,403.599us,403.6us,403.649us,403.65us,403.699us,403.7us,403.749us,403.75us,403.799us,403.8us,403.849us,403.85us,403.899us,403.9us,403.949us,403.95us,403.999us,404us,404.049us,404.05us,404.099us,404.1us,404.149us,404.15us,404.199us,404.2us,404.249us,404.25us,404.299us,404.3us,404.349us,404.35us,404.399us,404.4us,404.449us,404.45us,404.499us,404.5us,404.549us,404.55us,404.599us,404.6us,404.649us,404.65us,404.699us,404.7us,404.749us,404.75us,404.799us,404.8us,404.849us,404.85us,404.899us,404.9us,404.949us,404.95us,404.999us,405us,405.049us,405.05us,405.099us,405.1us,405.149us,405.15us,405.199us,405.2us,405.249us,405.25us,405.299us,405.3us,405.349us,405.35us,405.399us,405.4us,405.449us,405.45us,405.499us,405.5us,405.549us,405.55us,405.599us,405.6us,405.649us,405.65us,405.699us,405.7us,405.749us,405.75us,405.799us,405.8us,405.849us,405.85us,405.899us,405.9us,405.949us,405.95us,405.999us,406us,406.049us,406.05us,406.099us,406.1us,406.149us,406.15us,406.199us,406.2us,406.249us,406.25us,406.299us,406.3us,406.349us,406.35us,406.399us,406.4us,406.449us,406.45us,406.499us,406.5us,406.549us,406.55us,406.599us,406.6us,406.649us,406.65us,406.699us,406.7us,406.749us,406.75us,406.799us,406.8us,406.849us,406.85us,406.899us,406.9us,406.949us,406.95us,406.999us,407us,407.049us,407.05us,407.099us,407.1us,407.149us,407.15us,407.199us,407.2us,407.249us,407.25us,407.299us,407.3us,407.349us,407.35us,407.399us,407.4us,407.449us,407.45us,407.499us,407.5us,407.549us,407.55us,407.599us,407.6us,407.649us,407.65us,407.699us,407.7us,407.749us,407.75us,407.799us,407.8us,407.849us,407.85us,407.899us,407.9us,407.949us,407.95us,407.999us,408us,408.049us,408.05us,408.099us,408.1us,408.149us,408.15us,408.199us,408.2us,408.249us,408.25us,408.299us,408.3us,408.349us,408.35us,408.399us,408.4us,408.449us,408.45us,408.499us,408.5us,408.549us,408.55us,408.599us,408.6us,408.649us,408.65us,408.699us,408.7us,408.749us,408.75us,408.799us,408.8us,408.849us,408.85us,408.899us,408.9us,408.949us,408.95us,408.999us,409us,409.049us,409.05us,409.099us,409.1us,409.149us,409.15us,409.199us,409.2us,409.249us,409.25us,409.299us,409.3us,409.349us,409.35us,409.399us,409.4us,409.449us,409.45us,409.499us,409.5us,409.549us,409.55us,409.599us,409.6us,409.649us,409.65us,409.699us,409.7us,409.749us,409.75us,409.799us,409.8us,409.849us,409.85us,409.899us,409.9us,409.949us,409.95us,409.999us,410us,410.049us,410.05us,410.099us,410.1us,410.149us,410.15us,410.199us,410.2us,410.249us,410.25us,410.299us,410.3us,410.349us,410.35us,410.399us,410.4us,410.449us,410.45us,410.499us,410.5us,410.549us,410.55us,410.599us,410.6us,410.649us,410.65us,410.699us,410.7us,410.749us,410.75us,410.799us,410.8us,410.849us,410.85us,410.899us,410.9us,410.949us,410.95us,410.999us,411us,411.049us,411.05us,411.099us,411.1us,411.149us,411.15us,411.199us,411.2us,411.249us,411.25us,411.299us,411.3us,411.349us,411.35us,411.399us,411.4us,411.449us,411.45us,411.499us,411.5us,411.549us,411.55us,411.599us,411.6us,411.649us,411.65us,411.699us,411.7us,411.749us,411.75us,411.799us,411.8us,411.849us,411.85us,411.899us,411.9us,411.949us,411.95us,411.999us,412us,412.049us,412.05us,412.099us,412.1us,412.149us,412.15us,412.199us,412.2us,412.249us,412.25us,412.299us,412.3us,412.349us,412.35us,412.399us,412.4us,412.449us,412.45us,412.499us,412.5us,412.549us,412.55us,412.599us,412.6us,412.649us,412.65us,412.699us,412.7us,412.749us,412.75us,412.799us,412.8us,412.849us,412.85us,412.899us,412.9us,412.949us,412.95us,412.999us,413us,413.049us,413.05us,413.099us,413.1us,413.149us,413.15us,413.199us,413.2us,413.249us,413.25us,413.299us,413.3us,413.349us,413.35us,413.399us,413.4us,413.449us,413.45us,413.499us,413.5us,413.549us,413.55us,413.599us,413.6us,413.649us,413.65us,413.699us,413.7us,413.749us,413.75us,413.799us,413.8us,413.849us,413.85us,413.899us,413.9us,413.949us,413.95us,413.999us,414us,414.049us,414.05us,414.099us,414.1us,414.149us,414.15us,414.199us,414.2us,414.249us,414.25us,414.299us,414.3us,414.349us,414.35us,414.399us,414.4us,414.449us,414.45us,414.499us,414.5us,414.549us,414.55us,414.599us,414.6us,414.649us,414.65us,414.699us,414.7us,414.749us,414.75us,414.799us,414.8us,414.849us,414.85us,414.899us,414.9us,414.949us,414.95us,414.999us,415us,415.049us,415.05us,415.099us,415.1us,415.149us,415.15us,415.199us,415.2us,415.249us,415.25us,415.299us,415.3us,415.349us,415.35us,415.399us,415.4us,415.449us,415.45us,415.499us,415.5us,415.549us,415.55us,415.599us,415.6us,415.649us,415.65us,415.699us,415.7us,415.749us,415.75us,415.799us,415.8us,415.849us,415.85us,415.899us,415.9us,415.949us,415.95us,415.999us,416us,416.049us,416.05us,416.099us,416.1us,416.149us,416.15us,416.199us,416.2us,416.249us,416.25us,416.299us,416.3us,416.349us,416.35us,416.399us,416.4us,416.449us,416.45us,416.499us,416.5us,416.549us,416.55us,416.599us,416.6us,416.649us,416.65us,416.699us,416.7us,416.749us,416.75us,416.799us,416.8us,416.849us,416.85us,416.899us,416.9us,416.949us,416.95us,416.999us,417us,417.049us,417.05us,417.099us,417.1us,417.149us,417.15us,417.199us,417.2us,417.249us,417.25us,417.299us,417.3us,417.349us,417.35us,417.399us,417.4us,417.449us,417.45us,417.499us,417.5us,417.549us,417.55us,417.599us,417.6us,417.649us,417.65us,417.699us,417.7us,417.749us,417.75us,417.799us,417.8us,417.849us,417.85us,417.899us,417.9us,417.949us,417.95us,417.999us,418us,418.049us,418.05us,418.099us,418.1us,418.149us,418.15us,418.199us,418.2us,418.249us,418.25us,418.299us,418.3us,418.349us,418.35us,418.399us,418.4us,418.449us,418.45us,418.499us,418.5us,418.549us,418.55us,418.599us,418.6us,418.649us,418.65us,418.699us,418.7us,418.749us,418.75us,418.799us,418.8us,418.849us,418.85us,418.899us,418.9us,418.949us,418.95us,418.999us,419us,419.049us,419.05us,419.099us,419.1us,419.149us,419.15us,419.199us,419.2us,419.249us,419.25us,419.299us,419.3us,419.349us,419.35us,419.399us,419.4us,419.449us,419.45us,419.499us,419.5us,419.549us,419.55us,419.599us,419.6us,419.649us,419.65us,419.699us,419.7us,419.749us,419.75us,419.799us,419.8us,419.849us,419.85us,419.899us,419.9us,419.949us,419.95us,419.999us,420us,420.049us,420.05us,420.099us,420.1us,420.149us,420.15us,420.199us,420.2us,420.249us,420.25us,420.299us,420.3us,420.349us,420.35us,420.399us,420.4us,420.449us,420.45us,420.499us,420.5us,420.549us,420.55us,420.599us,420.6us,420.649us,420.65us,420.699us,420.7us,420.749us,420.75us,420.799us,420.8us,420.849us,420.85us,420.899us,420.9us,420.949us,420.95us,420.999us,421us,421.049us,421.05us,421.099us,421.1us,421.149us,421.15us,421.199us,421.2us,421.249us,421.25us,421.299us,421.3us,421.349us,421.35us,421.399us,421.4us,421.449us,421.45us,421.499us,421.5us,421.549us,421.55us,421.599us,421.6us,421.649us,421.65us,421.699us,421.7us,421.749us,421.75us,421.799us,421.8us,421.849us,421.85us,421.899us,421.9us,421.949us,421.95us,421.999us,422us,422.049us,422.05us,422.099us,422.1us,422.149us,422.15us,422.199us,422.2us,422.249us,422.25us,422.299us,422.3us,422.349us,422.35us,422.399us,422.4us,422.449us,422.45us,422.499us,422.5us,422.549us,422.55us,422.599us,422.6us,422.649us,422.65us,422.699us,422.7us,422.749us,422.75us,422.799us,422.8us,422.849us,422.85us,422.899us,422.9us,422.949us,422.95us,422.999us,423us,423.049us,423.05us,423.099us,423.1us,423.149us,423.15us,423.199us,423.2us,423.249us,423.25us,423.299us,423.3us,423.349us,423.35us,423.399us,423.4us,423.449us,423.45us,423.499us,423.5us,423.549us,423.55us,423.599us,423.6us,423.649us,423.65us,423.699us,423.7us,423.749us,423.75us,423.799us,423.8us,423.849us,423.85us,423.899us,423.9us,423.949us,423.95us,423.999us,424us,424.049us,424.05us,424.099us,424.1us,424.149us,424.15us,424.199us,424.2us,424.249us,424.25us,424.299us,424.3us,424.349us,424.35us,424.399us,424.4us,424.449us,424.45us,424.499us,424.5us,424.549us,424.55us,424.599us,424.6us,424.649us,424.65us,424.699us,424.7us,424.749us,424.75us,424.799us,424.8us,424.849us,424.85us,424.899us,424.9us,424.949us,424.95us,424.999us,425us,425.049us,425.05us,425.099us,425.1us,425.149us,425.15us,425.199us,425.2us,425.249us,425.25us,425.299us,425.3us,425.349us,425.35us,425.399us,425.4us,425.449us,425.45us,425.499us,425.5us,425.549us,425.55us,425.599us,425.6us,425.649us,425.65us,425.699us,425.7us,425.749us,425.75us,425.799us,425.8us,425.849us,425.85us,425.899us,425.9us,425.949us,425.95us,425.999us,426us,426.049us,426.05us,426.099us,426.1us,426.149us,426.15us,426.199us,426.2us,426.249us,426.25us,426.299us,426.3us,426.349us,426.35us,426.399us,426.4us,426.449us,426.45us,426.499us,426.5us,426.549us,426.55us,426.599us,426.6us,426.649us,426.65us,426.699us,426.7us,426.749us,426.75us,426.799us,426.8us,426.849us,426.85us,426.899us,426.9us,426.949us,426.95us,426.999us,427us,427.049us,427.05us,427.099us,427.1us,427.149us,427.15us,427.199us,427.2us,427.249us,427.25us,427.299us,427.3us,427.349us,427.35us,427.399us,427.4us,427.449us,427.45us,427.499us,427.5us,427.549us,427.55us,427.599us,427.6us,427.649us,427.65us,427.699us,427.7us,427.749us,427.75us,427.799us,427.8us,427.849us,427.85us,427.899us,427.9us,427.949us,427.95us,427.999us,428us,428.049us,428.05us,428.099us,428.1us,428.149us,428.15us,428.199us,428.2us,428.249us,428.25us,428.299us,428.3us,428.349us,428.35us,428.399us,428.4us,428.449us,428.45us,428.499us,428.5us,428.549us,428.55us,428.599us,428.6us,428.649us,428.65us,428.699us,428.7us,428.749us,428.75us,428.799us,428.8us,428.849us,428.85us,428.899us,428.9us,428.949us,428.95us,428.999us,429us,429.049us,429.05us,429.099us,429.1us,429.149us,429.15us,429.199us,429.2us,429.249us,429.25us,429.299us,429.3us,429.349us,429.35us,429.399us,429.4us,429.449us,429.45us,429.499us,429.5us,429.549us,429.55us,429.599us,429.6us,429.649us,429.65us,429.699us,429.7us,429.749us,429.75us,429.799us,429.8us,429.849us,429.85us,429.899us,429.9us,429.949us,429.95us,429.999us,430us,430.049us,430.05us,430.099us,430.1us,430.149us,430.15us,430.199us,430.2us,430.249us,430.25us,430.299us,430.3us,430.349us,430.35us,430.399us,430.4us,430.449us,430.45us,430.499us,430.5us,430.549us,430.55us,430.599us,430.6us,430.649us,430.65us,430.699us,430.7us,430.749us,430.75us,430.799us,430.8us,430.849us,430.85us,430.899us,430.9us,430.949us,430.95us,430.999us,431us,431.049us,431.05us,431.099us,431.1us,431.149us,431.15us,431.199us,431.2us,431.249us,431.25us,431.299us,431.3us,431.349us,431.35us,431.399us,431.4us,431.449us,431.45us,431.499us,431.5us,431.549us,431.55us,431.599us,431.6us,431.649us,431.65us,431.699us,431.7us,431.749us,431.75us,431.799us,431.8us,431.849us,431.85us,431.899us,431.9us,431.949us,431.95us,431.999us,432us,432.049us,432.05us,432.099us,432.1us,432.149us,432.15us,432.199us,432.2us,432.249us,432.25us,432.299us,432.3us,432.349us,432.35us,432.399us,432.4us,432.449us,432.45us,432.499us,432.5us,432.549us,432.55us,432.599us,432.6us,432.649us,432.65us,432.699us,432.7us,432.749us,432.75us,432.799us,432.8us,432.849us,432.85us,432.899us,432.9us,432.949us,432.95us,432.999us,433us,433.049us,433.05us,433.099us,433.1us,433.149us,433.15us,433.199us,433.2us,433.249us,433.25us,433.299us,433.3us,433.349us,433.35us,433.399us,433.4us,433.449us,433.45us,433.499us,433.5us,433.549us,433.55us,433.599us,433.6us,433.649us,433.65us,433.699us,433.7us,433.749us,433.75us,433.799us,433.8us,433.849us,433.85us,433.899us,433.9us,433.949us,433.95us,433.999us,434us,434.049us,434.05us,434.099us,434.1us,434.149us,434.15us,434.199us,434.2us,434.249us,434.25us,434.299us,434.3us,434.349us,434.35us,434.399us,434.4us,434.449us,434.45us,434.499us,434.5us,434.549us,434.55us,434.599us,434.6us,434.649us,434.65us,434.699us,434.7us,434.749us,434.75us,434.799us,434.8us,434.849us,434.85us,434.899us,434.9us,434.949us,434.95us,434.999us,435us,435.049us,435.05us,435.099us,435.1us,435.149us,435.15us,435.199us,435.2us,435.249us,435.25us,435.299us,435.3us,435.349us,435.35us,435.399us,435.4us,435.449us,435.45us,435.499us,435.5us,435.549us,435.55us,435.599us,435.6us,435.649us,435.65us,435.699us,435.7us,435.749us,435.75us,435.799us,435.8us,435.849us,435.85us,435.899us,435.9us,435.949us,435.95us,435.999us,436us,436.049us,436.05us,436.099us,436.1us,436.149us,436.15us,436.199us,436.2us,436.249us,436.25us,436.299us,436.3us,436.349us,436.35us,436.399us,436.4us,436.449us,436.45us,436.499us,436.5us,436.549us,436.55us,436.599us,436.6us,436.649us,436.65us,436.699us,436.7us,436.749us,436.75us,436.799us,436.8us,436.849us,436.85us,436.899us,436.9us,436.949us,436.95us,436.999us,437us,437.049us,437.05us,437.099us,437.1us,437.149us,437.15us,437.199us,437.2us,437.249us,437.25us,437.299us,437.3us,437.349us,437.35us,437.399us,437.4us,437.449us,437.45us,437.499us,437.5us,437.549us,437.55us,437.599us,437.6us,437.649us,437.65us,437.699us,437.7us,437.749us,437.75us,437.799us,437.8us,437.849us,437.85us,437.899us,437.9us,437.949us,437.95us,437.999us,438us,438.049us,438.05us,438.099us,438.1us,438.149us,438.15us,438.199us,438.2us,438.249us,438.25us,438.299us,438.3us,438.349us,438.35us,438.399us,438.4us,438.449us,438.45us,438.499us,438.5us,438.549us,438.55us,438.599us,438.6us,438.649us,438.65us,438.699us,438.7us,438.749us,438.75us,438.799us,438.8us,438.849us,438.85us,438.899us,438.9us,438.949us,438.95us,438.999us,439us,439.049us,439.05us,439.099us,439.1us,439.149us,439.15us,439.199us,439.2us,439.249us,439.25us,439.299us,439.3us,439.349us,439.35us,439.399us,439.4us,439.449us,439.45us,439.499us,439.5us,439.549us,439.55us,439.599us,439.6us,439.649us,439.65us,439.699us,439.7us,439.749us,439.75us,439.799us,439.8us,439.849us,439.85us,439.899us,439.9us,439.949us,439.95us,439.999us,440us,440.049us,440.05us,440.099us,440.1us,440.149us,440.15us,440.199us,440.2us,440.249us,440.25us,440.299us,440.3us,440.349us,440.35us,440.399us,440.4us,440.449us,440.45us,440.499us,440.5us,440.549us,440.55us,440.599us,440.6us,440.649us,440.65us,440.699us,440.7us,440.749us,440.75us,440.799us,440.8us,440.849us,440.85us,440.899us,440.9us,440.949us,440.95us,440.999us,441us,441.049us,441.05us,441.099us,441.1us,441.149us,441.15us,441.199us,441.2us,441.249us,441.25us,441.299us,441.3us,441.349us,441.35us,441.399us,441.4us,441.449us,441.45us,441.499us,441.5us,441.549us,441.55us,441.599us,441.6us,441.649us,441.65us,441.699us,441.7us,441.749us,441.75us,441.799us,441.8us,441.849us,441.85us,441.899us,441.9us,441.949us,441.95us,441.999us,442us,442.049us,442.05us,442.099us,442.1us,442.149us,442.15us,442.199us,442.2us,442.249us,442.25us,442.299us,442.3us,442.349us,442.35us,442.399us,442.4us,442.449us,442.45us,442.499us,442.5us,442.549us,442.55us,442.599us,442.6us,442.649us,442.65us,442.699us,442.7us,442.749us,442.75us,442.799us,442.8us,442.849us,442.85us,442.899us,442.9us,442.949us,442.95us,442.999us,443us,443.049us,443.05us,443.099us,443.1us,443.149us,443.15us,443.199us,443.2us,443.249us,443.25us,443.299us,443.3us,443.349us,443.35us,443.399us,443.4us,443.449us,443.45us,443.499us,443.5us,443.549us,443.55us,443.599us,443.6us,443.649us,443.65us,443.699us,443.7us,443.749us,443.75us,443.799us,443.8us,443.849us,443.85us,443.899us,443.9us,443.949us,443.95us,443.999us,444us,444.049us,444.05us,444.099us,444.1us,444.149us,444.15us,444.199us,444.2us,444.249us,444.25us,444.299us,444.3us,444.349us,444.35us,444.399us,444.4us,444.449us,444.45us,444.499us,444.5us,444.549us,444.55us,444.599us,444.6us,444.649us,444.65us,444.699us,444.7us,444.749us,444.75us,444.799us,444.8us,444.849us,444.85us,444.899us,444.9us,444.949us,444.95us,444.999us,445us,445.049us,445.05us,445.099us,445.1us,445.149us,445.15us,445.199us,445.2us,445.249us,445.25us,445.299us,445.3us,445.349us,445.35us,445.399us,445.4us,445.449us,445.45us,445.499us,445.5us,445.549us,445.55us,445.599us,445.6us,445.649us,445.65us,445.699us,445.7us,445.749us,445.75us,445.799us,445.8us,445.849us,445.85us,445.899us,445.9us,445.949us,445.95us,445.999us,446us,446.049us,446.05us,446.099us,446.1us,446.149us,446.15us,446.199us,446.2us,446.249us,446.25us,446.299us,446.3us,446.349us,446.35us,446.399us,446.4us,446.449us,446.45us,446.499us,446.5us,446.549us,446.55us,446.599us,446.6us,446.649us,446.65us,446.699us,446.7us,446.749us,446.75us,446.799us,446.8us,446.849us,446.85us,446.899us,446.9us,446.949us,446.95us,446.999us,447us,447.049us,447.05us,447.099us,447.1us,447.149us,447.15us,447.199us,447.2us,447.249us,447.25us,447.299us,447.3us,447.349us,447.35us,447.399us,447.4us,447.449us,447.45us,447.499us,447.5us,447.549us,447.55us,447.599us,447.6us,447.649us,447.65us,447.699us,447.7us,447.749us,447.75us,447.799us,447.8us,447.849us,447.85us,447.899us,447.9us,447.949us,447.95us,447.999us,448us,448.049us,448.05us,448.099us,448.1us,448.149us,448.15us,448.199us,448.2us,448.249us,448.25us,448.299us,448.3us,448.349us,448.35us,448.399us,448.4us,448.449us,448.45us,448.499us,448.5us,448.549us,448.55us,448.599us,448.6us,448.649us,448.65us,448.699us,448.7us,448.749us,448.75us,448.799us,448.8us,448.849us,448.85us,448.899us,448.9us,448.949us,448.95us,448.999us,449us,449.049us,449.05us,449.099us,449.1us,449.149us,449.15us,449.199us,449.2us,449.249us,449.25us,449.299us,449.3us,449.349us,449.35us,449.399us,449.4us,449.449us,449.45us,449.499us,449.5us,449.549us,449.55us,449.599us,449.6us,449.649us,449.65us,449.699us,449.7us,449.749us,449.75us,449.799us,449.8us,449.849us,449.85us,449.899us,449.9us,449.949us,449.95us,449.999us,450us,450.049us,450.05us,450.099us,450.1us,450.149us,450.15us,450.199us,450.2us,450.249us,450.25us,450.299us,450.3us,450.349us,450.35us,450.399us,450.4us,450.449us,450.45us,450.499us,450.5us,450.549us,450.55us,450.599us,450.6us,450.649us,450.65us,450.699us,450.7us,450.749us,450.75us,450.799us,450.8us,450.849us,450.85us,450.899us,450.9us,450.949us,450.95us,450.999us,451us,451.049us,451.05us,451.099us,451.1us,451.149us,451.15us,451.199us,451.2us,451.249us,451.25us,451.299us,451.3us,451.349us,451.35us,451.399us,451.4us,451.449us,451.45us,451.499us,451.5us,451.549us,451.55us,451.599us,451.6us,451.649us,451.65us,451.699us,451.7us,451.749us,451.75us,451.799us,451.8us,451.849us,451.85us,451.899us,451.9us,451.949us,451.95us,451.999us,452us,452.049us,452.05us,452.099us,452.1us,452.149us,452.15us,452.199us,452.2us,452.249us,452.25us,452.299us,452.3us,452.349us,452.35us,452.399us,452.4us,452.449us,452.45us,452.499us,452.5us,452.549us,452.55us,452.599us,452.6us,452.649us,452.65us,452.699us,452.7us,452.749us,452.75us,452.799us,452.8us,452.849us,452.85us,452.899us,452.9us,452.949us,452.95us,452.999us,453us,453.049us,453.05us,453.099us,453.1us,453.149us,453.15us,453.199us,453.2us,453.249us,453.25us,453.299us,453.3us,453.349us,453.35us,453.399us,453.4us,453.449us,453.45us,453.499us,453.5us,453.549us,453.55us,453.599us,453.6us,453.649us,453.65us,453.699us,453.7us,453.749us,453.75us,453.799us,453.8us,453.849us,453.85us,453.899us,453.9us,453.949us,453.95us,453.999us,454us,454.049us,454.05us,454.099us,454.1us,454.149us,454.15us,454.199us,454.2us,454.249us,454.25us,454.299us,454.3us,454.349us,454.35us,454.399us,454.4us,454.449us,454.45us,454.499us,454.5us,454.549us,454.55us,454.599us,454.6us,454.649us,454.65us,454.699us,454.7us,454.749us,454.75us,454.799us,454.8us,454.849us,454.85us,454.899us,454.9us,454.949us,454.95us,454.999us,455us,455.049us,455.05us,455.099us,455.1us,455.149us,455.15us,455.199us,455.2us,455.249us,455.25us,455.299us,455.3us,455.349us,455.35us,455.399us,455.4us,455.449us,455.45us,455.499us,455.5us,455.549us,455.55us,455.599us,455.6us,455.649us,455.65us,455.699us,455.7us,455.749us,455.75us,455.799us,455.8us,455.849us,455.85us,455.899us,455.9us,455.949us,455.95us,455.999us,456us,456.049us,456.05us,456.099us,456.1us,456.149us,456.15us,456.199us,456.2us,456.249us,456.25us,456.299us,456.3us,456.349us,456.35us,456.399us,456.4us,456.449us,456.45us,456.499us,456.5us,456.549us,456.55us,456.599us,456.6us,456.649us,456.65us,456.699us,456.7us,456.749us,456.75us,456.799us,456.8us,456.849us,456.85us,456.899us,456.9us,456.949us,456.95us,456.999us,457us,457.049us,457.05us,457.099us,457.1us,457.149us,457.15us,457.199us,457.2us,457.249us,457.25us,457.299us,457.3us,457.349us,457.35us,457.399us,457.4us,457.449us,457.45us,457.499us,457.5us,457.549us,457.55us,457.599us,457.6us,457.649us,457.65us,457.699us,457.7us,457.749us,457.75us,457.799us,457.8us,457.849us,457.85us,457.899us,457.9us,457.949us,457.95us,457.999us,458us,458.049us,458.05us,458.099us,458.1us,458.149us,458.15us,458.199us,458.2us,458.249us,458.25us,458.299us,458.3us,458.349us,458.35us,458.399us,458.4us,458.449us,458.45us,458.499us,458.5us,458.549us,458.55us,458.599us,458.6us,458.649us,458.65us,458.699us,458.7us,458.749us,458.75us,458.799us,458.8us,458.849us,458.85us,458.899us,458.9us,458.949us,458.95us,458.999us,459us,459.049us,459.05us,459.099us,459.1us,459.149us,459.15us,459.199us,459.2us,459.249us,459.25us,459.299us,459.3us,459.349us,459.35us,459.399us,459.4us,459.449us,459.45us,459.499us,459.5us,459.549us,459.55us,459.599us,459.6us,459.649us,459.65us,459.699us,459.7us,459.749us,459.75us,459.799us,459.8us,459.849us,459.85us,459.899us,459.9us,459.949us,459.95us,459.999us,460us,460.049us,460.05us,460.099us,460.1us,460.149us,460.15us,460.199us,460.2us,460.249us,460.25us,460.299us,460.3us,460.349us,460.35us,460.399us,460.4us,460.449us,460.45us,460.499us,460.5us,460.549us,460.55us,460.599us,460.6us,460.649us,460.65us,460.699us,460.7us,460.749us,460.75us,460.799us,460.8us,460.849us,460.85us,460.899us,460.9us,460.949us,460.95us,460.999us,461us,461.049us,461.05us,461.099us,461.1us,461.149us,461.15us,461.199us,461.2us,461.249us,461.25us,461.299us,461.3us,461.349us,461.35us,461.399us,461.4us,461.449us,461.45us,461.499us,461.5us,461.549us,461.55us,461.599us,461.6us,461.649us,461.65us,461.699us,461.7us,461.749us,461.75us,461.799us,461.8us,461.849us,461.85us,461.899us,461.9us,461.949us,461.95us,461.999us,462us,462.049us,462.05us,462.099us,462.1us,462.149us,462.15us,462.199us,462.2us,462.249us,462.25us,462.299us,462.3us,462.349us,462.35us,462.399us,462.4us,462.449us,462.45us,462.499us,462.5us,462.549us,462.55us,462.599us,462.6us,462.649us,462.65us,462.699us,462.7us,462.749us,462.75us,462.799us,462.8us,462.849us,462.85us,462.899us,462.9us,462.949us,462.95us,462.999us,463us,463.049us,463.05us,463.099us,463.1us,463.149us,463.15us,463.199us,463.2us,463.249us,463.25us,463.299us,463.3us,463.349us,463.35us,463.399us,463.4us,463.449us,463.45us,463.499us,463.5us,463.549us,463.55us,463.599us,463.6us,463.649us,463.65us,463.699us,463.7us,463.749us,463.75us,463.799us,463.8us,463.849us,463.85us,463.899us,463.9us,463.949us,463.95us,463.999us,464us,464.049us,464.05us,464.099us,464.1us,464.149us,464.15us,464.199us,464.2us,464.249us,464.25us,464.299us,464.3us,464.349us,464.35us,464.399us,464.4us,464.449us,464.45us,464.499us,464.5us,464.549us,464.55us,464.599us,464.6us,464.649us,464.65us,464.699us,464.7us,464.749us,464.75us,464.799us,464.8us,464.849us,464.85us,464.899us,464.9us,464.949us,464.95us,464.999us,465us,465.049us,465.05us,465.099us,465.1us,465.149us,465.15us,465.199us,465.2us,465.249us,465.25us,465.299us,465.3us,465.349us,465.35us,465.399us,465.4us,465.449us,465.45us,465.499us,465.5us,465.549us,465.55us,465.599us,465.6us,465.649us,465.65us,465.699us,465.7us,465.749us,465.75us,465.799us,465.8us,465.849us,465.85us,465.899us,465.9us,465.949us,465.95us,465.999us,466us,466.049us,466.05us,466.099us,466.1us,466.149us,466.15us,466.199us,466.2us,466.249us,466.25us,466.299us,466.3us,466.349us,466.35us,466.399us,466.4us,466.449us,466.45us,466.499us,466.5us,466.549us,466.55us,466.599us,466.6us,466.649us,466.65us,466.699us,466.7us,466.749us,466.75us,466.799us,466.8us,466.849us,466.85us,466.899us,466.9us,466.949us,466.95us,466.999us,467us,467.049us,467.05us,467.099us,467.1us,467.149us,467.15us,467.199us,467.2us,467.249us,467.25us,467.299us,467.3us,467.349us,467.35us,467.399us,467.4us,467.449us,467.45us,467.499us,467.5us,467.549us,467.55us,467.599us,467.6us,467.649us,467.65us,467.699us,467.7us,467.749us,467.75us,467.799us,467.8us,467.849us,467.85us,467.899us,467.9us,467.949us,467.95us,467.999us,468us,468.049us,468.05us,468.099us,468.1us,468.149us,468.15us,468.199us,468.2us,468.249us,468.25us,468.299us,468.3us,468.349us,468.35us,468.399us,468.4us,468.449us,468.45us,468.499us,468.5us,468.549us,468.55us,468.599us,468.6us,468.649us,468.65us,468.699us,468.7us,468.749us,468.75us,468.799us,468.8us,468.849us,468.85us,468.899us,468.9us,468.949us,468.95us,468.999us,469us,469.049us,469.05us,469.099us,469.1us,469.149us,469.15us,469.199us,469.2us,469.249us,469.25us,469.299us,469.3us,469.349us,469.35us,469.399us,469.4us,469.449us,469.45us,469.499us,469.5us,469.549us,469.55us,469.599us,469.6us,469.649us,469.65us,469.699us,469.7us,469.749us,469.75us,469.799us,469.8us,469.849us,469.85us,469.899us,469.9us,469.949us,469.95us,469.999us,470us,470.049us,470.05us,470.099us,470.1us,470.149us,470.15us,470.199us,470.2us,470.249us,470.25us,470.299us,470.3us,470.349us,470.35us,470.399us,470.4us,470.449us,470.45us,470.499us,470.5us,470.549us,470.55us,470.599us,470.6us,470.649us,470.65us,470.699us,470.7us,470.749us,470.75us,470.799us,470.8us,470.849us,470.85us,470.899us,470.9us,470.949us,470.95us,470.999us,471us,471.049us,471.05us,471.099us,471.1us,471.149us,471.15us,471.199us,471.2us,471.249us,471.25us,471.299us,471.3us,471.349us,471.35us,471.399us,471.4us,471.449us,471.45us,471.499us,471.5us,471.549us,471.55us,471.599us,471.6us,471.649us,471.65us,471.699us,471.7us,471.749us,471.75us,471.799us,471.8us,471.849us,471.85us,471.899us,471.9us,471.949us,471.95us,471.999us,472us,472.049us,472.05us,472.099us,472.1us,472.149us,472.15us,472.199us,472.2us,472.249us,472.25us,472.299us,472.3us,472.349us,472.35us,472.399us,472.4us,472.449us,472.45us,472.499us,472.5us,472.549us,472.55us,472.599us,472.6us,472.649us,472.65us,472.699us,472.7us,472.749us,472.75us,472.799us,472.8us,472.849us,472.85us,472.899us,472.9us,472.949us,472.95us,472.999us,473us,473.049us,473.05us,473.099us,473.1us,473.149us,473.15us,473.199us,473.2us,473.249us,473.25us,473.299us,473.3us,473.349us,473.35us,473.399us,473.4us,473.449us,473.45us,473.499us,473.5us,473.549us,473.55us,473.599us,473.6us,473.649us,473.65us,473.699us,473.7us,473.749us,473.75us,473.799us,473.8us,473.849us,473.85us,473.899us,473.9us,473.949us,473.95us,473.999us,474us,474.049us,474.05us,474.099us,474.1us,474.149us,474.15us,474.199us,474.2us,474.249us,474.25us,474.299us,474.3us,474.349us,474.35us,474.399us,474.4us,474.449us,474.45us,474.499us,474.5us,474.549us,474.55us,474.599us,474.6us,474.649us,474.65us,474.699us,474.7us,474.749us,474.75us,474.799us,474.8us,474.849us,474.85us,474.899us,474.9us,474.949us,474.95us,474.999us,475us,475.049us,475.05us,475.099us,475.1us,475.149us,475.15us,475.199us,475.2us,475.249us,475.25us,475.299us,475.3us,475.349us,475.35us,475.399us,475.4us,475.449us,475.45us,475.499us,475.5us,475.549us,475.55us,475.599us,475.6us,475.649us,475.65us,475.699us,475.7us,475.749us,475.75us,475.799us,475.8us,475.849us,475.85us,475.899us,475.9us,475.949us,475.95us,475.999us,476us,476.049us,476.05us,476.099us,476.1us,476.149us,476.15us,476.199us,476.2us,476.249us,476.25us,476.299us,476.3us,476.349us,476.35us,476.399us,476.4us,476.449us,476.45us,476.499us,476.5us,476.549us,476.55us,476.599us,476.6us,476.649us,476.65us,476.699us,476.7us,476.749us,476.75us,476.799us,476.8us,476.849us,476.85us,476.899us,476.9us,476.949us,476.95us,476.999us,477us,477.049us,477.05us,477.099us,477.1us,477.149us,477.15us,477.199us,477.2us,477.249us,477.25us,477.299us,477.3us,477.349us,477.35us,477.399us,477.4us,477.449us,477.45us,477.499us,477.5us,477.549us,477.55us,477.599us,477.6us,477.649us,477.65us,477.699us,477.7us,477.749us,477.75us,477.799us,477.8us,477.849us,477.85us,477.899us,477.9us,477.949us,477.95us,477.999us,478us,478.049us,478.05us,478.099us,478.1us,478.149us,478.15us,478.199us,478.2us,478.249us,478.25us,478.299us,478.3us,478.349us,478.35us,478.399us,478.4us,478.449us,478.45us,478.499us,478.5us,478.549us,478.55us,478.599us,478.6us,478.649us,478.65us,478.699us,478.7us,478.749us,478.75us,478.799us,478.8us,478.849us,478.85us,478.899us,478.9us,478.949us,478.95us,478.999us,479us,479.049us,479.05us,479.099us,479.1us,479.149us,479.15us,479.199us,479.2us,479.249us,479.25us,479.299us,479.3us,479.349us,479.35us,479.399us,479.4us,479.449us,479.45us,479.499us,479.5us,479.549us,479.55us,479.599us,479.6us,479.649us,479.65us,479.699us,479.7us,479.749us,479.75us,479.799us,479.8us,479.849us,479.85us,479.899us,479.9us,479.949us,479.95us,479.999us,480us,480.049us,480.05us,480.099us,480.1us,480.149us,480.15us,480.199us,480.2us,480.249us,480.25us,480.299us,480.3us,480.349us,480.35us,480.399us,480.4us,480.449us,480.45us,480.499us,480.5us,480.549us,480.55us,480.599us,480.6us,480.649us,480.65us,480.699us,480.7us,480.749us,480.75us,480.799us,480.8us,480.849us,480.85us,480.899us,480.9us,480.949us,480.95us,480.999us,481us,481.049us,481.05us,481.099us,481.1us,481.149us,481.15us,481.199us,481.2us,481.249us,481.25us,481.299us,481.3us,481.349us,481.35us,481.399us,481.4us,481.449us,481.45us,481.499us,481.5us,481.549us,481.55us,481.599us,481.6us,481.649us,481.65us,481.699us,481.7us,481.749us,481.75us,481.799us,481.8us,481.849us,481.85us,481.899us,481.9us,481.949us,481.95us,481.999us,482us,482.049us,482.05us,482.099us,482.1us,482.149us,482.15us,482.199us,482.2us,482.249us,482.25us,482.299us,482.3us,482.349us,482.35us,482.399us,482.4us,482.449us,482.45us,482.499us,482.5us,482.549us,482.55us,482.599us,482.6us,482.649us,482.65us,482.699us,482.7us,482.749us,482.75us,482.799us,482.8us,482.849us,482.85us,482.899us,482.9us,482.949us,482.95us,482.999us,483us,483.049us,483.05us,483.099us,483.1us,483.149us,483.15us,483.199us,483.2us,483.249us,483.25us,483.299us,483.3us,483.349us,483.35us,483.399us,483.4us,483.449us,483.45us,483.499us,483.5us,483.549us,483.55us,483.599us,483.6us,483.649us,483.65us,483.699us,483.7us,483.749us,483.75us,483.799us,483.8us,483.849us,483.85us,483.899us,483.9us,483.949us,483.95us,483.999us,484us,484.049us,484.05us,484.099us,484.1us,484.149us,484.15us,484.199us,484.2us,484.249us,484.25us,484.299us,484.3us,484.349us,484.35us,484.399us,484.4us,484.449us,484.45us,484.499us,484.5us,484.549us,484.55us,484.599us,484.6us,484.649us,484.65us,484.699us,484.7us,484.749us,484.75us,484.799us,484.8us,484.849us,484.85us,484.899us,484.9us,484.949us,484.95us,484.999us,485us,485.049us,485.05us,485.099us,485.1us,485.149us,485.15us,485.199us,485.2us,485.249us,485.25us,485.299us,485.3us,485.349us,485.35us,485.399us,485.4us,485.449us,485.45us,485.499us,485.5us,485.549us,485.55us,485.599us,485.6us,485.649us,485.65us,485.699us,485.7us,485.749us,485.75us,485.799us,485.8us,485.849us,485.85us,485.899us,485.9us,485.949us,485.95us,485.999us,486us,486.049us,486.05us,486.099us,486.1us,486.149us,486.15us,486.199us,486.2us,486.249us,486.25us,486.299us,486.3us,486.349us,486.35us,486.399us,486.4us,486.449us,486.45us,486.499us,486.5us,486.549us,486.55us,486.599us,486.6us,486.649us,486.65us,486.699us,486.7us,486.749us,486.75us,486.799us,486.8us,486.849us,486.85us,486.899us,486.9us,486.949us,486.95us,486.999us,487us,487.049us,487.05us,487.099us,487.1us,487.149us,487.15us,487.199us,487.2us,487.249us,487.25us,487.299us,487.3us,487.349us,487.35us,487.399us,487.4us,487.449us,487.45us,487.499us,487.5us,487.549us,487.55us,487.599us,487.6us,487.649us,487.65us,487.699us,487.7us,487.749us,487.75us,487.799us,487.8us,487.849us,487.85us,487.899us,487.9us,487.949us,487.95us,487.999us,488us,488.049us,488.05us,488.099us,488.1us,488.149us,488.15us,488.199us,488.2us,488.249us,488.25us,488.299us,488.3us,488.349us,488.35us,488.399us,488.4us,488.449us,488.45us,488.499us,488.5us,488.549us,488.55us,488.599us,488.6us,488.649us,488.65us,488.699us,488.7us,488.749us,488.75us,488.799us,488.8us,488.849us,488.85us,488.899us,488.9us,488.949us,488.95us,488.999us,489us,489.049us,489.05us,489.099us,489.1us,489.149us,489.15us,489.199us,489.2us,489.249us,489.25us,489.299us,489.3us,489.349us,489.35us,489.399us,489.4us,489.449us,489.45us,489.499us,489.5us,489.549us,489.55us,489.599us,489.6us,489.649us,489.65us,489.699us,489.7us,489.749us,489.75us,489.799us,489.8us,489.849us,489.85us,489.899us,489.9us,489.949us,489.95us,489.999us,490us,490.049us,490.05us,490.099us,490.1us,490.149us,490.15us,490.199us,490.2us,490.249us,490.25us,490.299us,490.3us,490.349us,490.35us,490.399us,490.4us,490.449us,490.45us,490.499us,490.5us,490.549us,490.55us,490.599us,490.6us,490.649us,490.65us,490.699us,490.7us,490.749us,490.75us,490.799us,490.8us,490.849us,490.85us,490.899us,490.9us,490.949us,490.95us,490.999us,491us,491.049us,491.05us,491.099us,491.1us,491.149us,491.15us,491.199us,491.2us,491.249us,491.25us,491.299us,491.3us,491.349us,491.35us,491.399us,491.4us,491.449us,491.45us,491.499us,491.5us,491.549us,491.55us,491.599us,491.6us,491.649us,491.65us,491.699us,491.7us,491.749us,491.75us,491.799us,491.8us,491.849us,491.85us,491.899us,491.9us,491.949us,491.95us,491.999us,492us,492.049us,492.05us,492.099us,492.1us,492.149us,492.15us,492.199us,492.2us,492.249us,492.25us,492.299us,492.3us,492.349us,492.35us,492.399us,492.4us,492.449us,492.45us,492.499us,492.5us,492.549us,492.55us,492.599us,492.6us,492.649us,492.65us,492.699us,492.7us,492.749us,492.75us,492.799us,492.8us,492.849us,492.85us,492.899us,492.9us,492.949us,492.95us,492.999us,493us,493.049us,493.05us,493.099us,493.1us,493.149us,493.15us,493.199us,493.2us,493.249us,493.25us,493.299us,493.3us,493.349us,493.35us,493.399us,493.4us,493.449us,493.45us,493.499us,493.5us,493.549us,493.55us,493.599us,493.6us,493.649us,493.65us,493.699us,493.7us,493.749us,493.75us,493.799us,493.8us,493.849us,493.85us,493.899us,493.9us,493.949us,493.95us,493.999us,494us,494.049us,494.05us,494.099us,494.1us,494.149us,494.15us,494.199us,494.2us,494.249us,494.25us,494.299us,494.3us,494.349us,494.35us,494.399us,494.4us,494.449us,494.45us,494.499us,494.5us,494.549us,494.55us,494.599us,494.6us,494.649us,494.65us,494.699us,494.7us,494.749us,494.75us,494.799us,494.8us,494.849us,494.85us,494.899us,494.9us,494.949us,494.95us,494.999us,495us,495.049us,495.05us,495.099us,495.1us,495.149us,495.15us,495.199us,495.2us,495.249us,495.25us,495.299us,495.3us,495.349us,495.35us,495.399us,495.4us,495.449us,495.45us,495.499us,495.5us,495.549us,495.55us,495.599us,495.6us,495.649us,495.65us,495.699us,495.7us,495.749us,495.75us,495.799us,495.8us,495.849us,495.85us,495.899us,495.9us,495.949us,495.95us,495.999us,496us,496.049us,496.05us,496.099us,496.1us,496.149us,496.15us,496.199us,496.2us,496.249us,496.25us,496.299us,496.3us,496.349us,496.35us,496.399us,496.4us,496.449us,496.45us,496.499us,496.5us,496.549us,496.55us,496.599us,496.6us,496.649us,496.65us,496.699us,496.7us,496.749us,496.75us,496.799us,496.8us,496.849us,496.85us,496.899us,496.9us,496.949us,496.95us,496.999us,497us,497.049us,497.05us,497.099us,497.1us,497.149us,497.15us,497.199us,497.2us,497.249us,497.25us,497.299us,497.3us,497.349us,497.35us,497.399us,497.4us,497.449us,497.45us,497.499us,497.5us,497.549us,497.55us,497.599us,497.6us,497.649us,497.65us,497.699us,497.7us,497.749us,497.75us,497.799us,497.8us,497.849us,497.85us,497.899us,497.9us,497.949us,497.95us,497.999us,498us,498.049us,498.05us,498.099us,498.1us,498.149us,498.15us,498.199us,498.2us,498.249us,498.25us,498.299us,498.3us,498.349us,498.35us,498.399us,498.4us,498.449us,498.45us,498.499us,498.5us,498.549us,498.55us,498.599us,498.6us,498.649us,498.65us,498.699us,498.7us,498.749us,498.75us,498.799us,498.8us,498.849us,498.85us,498.899us,498.9us,498.949us,498.95us,498.999us,499us,499.049us,499.05us,499.099us,499.1us,499.149us,499.15us,499.199us,499.2us,499.249us,499.25us,499.299us,499.3us,499.349us,499.35us,499.399us,499.4us,499.449us,499.45us,499.499us,499.5us,499.549us,499.55us,499.599us,499.6us,499.649us,499.65us,499.699us,499.7us,499.749us,499.75us,499.799us,499.8us,499.849us,499.85us,499.899us,499.9us,499.949us,499.95us,499.999us,500us,500.049us,500.05us,500.099us,500.1us,500.149us,500.15us,500.199us,500.2us,500.249us,500.25us,500.299us,500.3us,500.349us,500.35us,500.399us,500.4us,500.449us,500.45us,500.499us,500.5us,500.549us,500.55us,500.599us,500.6us,500.649us,500.65us,500.699us,500.7us,500.749us,500.75us,500.799us,500.8us,500.849us,500.85us,500.899us,500.9us,500.949us,500.95us,500.999us,501us,501.049us,501.05us,501.099us,501.1us,501.149us,501.15us,501.199us,501.2us,501.249us,501.25us,501.299us,501.3us,501.349us,501.35us,501.399us,501.4us,501.449us,501.45us,501.499us,501.5us,501.549us,501.55us,501.599us,501.6us,501.649us,501.65us,501.699us,501.7us,501.749us,501.75us,501.799us,501.8us,501.849us,501.85us,501.899us,501.9us,501.949us,501.95us,501.999us,502us,502.049us,502.05us,502.099us,502.1us,502.149us,502.15us,502.199us,502.2us,502.249us,502.25us,502.299us,502.3us,502.349us,502.35us,502.399us,502.4us,502.449us,502.45us,502.499us,502.5us,502.549us,502.55us,502.599us,502.6us,502.649us,502.65us,502.699us,502.7us,502.749us,502.75us,502.799us,502.8us,502.849us,502.85us,502.899us,502.9us,502.949us,502.95us,502.999us,503us,503.049us,503.05us,503.099us,503.1us,503.149us,503.15us,503.199us,503.2us,503.249us,503.25us,503.299us,503.3us,503.349us,503.35us,503.399us,503.4us,503.449us,503.45us,503.499us,503.5us,503.549us,503.55us,503.599us,503.6us,503.649us,503.65us,503.699us,503.7us,503.749us,503.75us,503.799us,503.8us,503.849us,503.85us,503.899us,503.9us,503.949us,503.95us,503.999us,504us,504.049us,504.05us,504.099us,504.1us,504.149us,504.15us,504.199us,504.2us,504.249us,504.25us,504.299us,504.3us,504.349us,504.35us,504.399us,504.4us,504.449us,504.45us,504.499us,504.5us,504.549us,504.55us,504.599us,504.6us,504.649us,504.65us,504.699us,504.7us,504.749us,504.75us,504.799us,504.8us,504.849us,504.85us,504.899us,504.9us,504.949us,504.95us,504.999us,505us,505.049us,505.05us,505.099us,505.1us,505.149us,505.15us,505.199us,505.2us,505.249us,505.25us,505.299us,505.3us,505.349us,505.35us,505.399us,505.4us,505.449us,505.45us,505.499us,505.5us,505.549us,505.55us,505.599us,505.6us,505.649us,505.65us,505.699us,505.7us,505.749us,505.75us,505.799us,505.8us,505.849us,505.85us,505.899us,505.9us,505.949us,505.95us,505.999us,506us,506.049us,506.05us,506.099us,506.1us,506.149us,506.15us,506.199us,506.2us,506.249us,506.25us,506.299us,506.3us,506.349us,506.35us,506.399us,506.4us,506.449us,506.45us,506.499us,506.5us,506.549us,506.55us,506.599us,506.6us,506.649us,506.65us,506.699us,506.7us,506.749us,506.75us,506.799us,506.8us,506.849us,506.85us,506.899us,506.9us,506.949us,506.95us,506.999us,507us,507.049us,507.05us,507.099us,507.1us,507.149us,507.15us,507.199us,507.2us,507.249us,507.25us,507.299us,507.3us,507.349us,507.35us,507.399us,507.4us,507.449us,507.45us,507.499us,507.5us,507.549us,507.55us,507.599us,507.6us,507.649us,507.65us,507.699us,507.7us,507.749us,507.75us,507.799us,507.8us,507.849us,507.85us,507.899us,507.9us,507.949us,507.95us,507.999us,508us,508.049us,508.05us,508.099us,508.1us,508.149us,508.15us,508.199us,508.2us,508.249us,508.25us,508.299us,508.3us,508.349us,508.35us,508.399us,508.4us,508.449us,508.45us,508.499us,508.5us,508.549us,508.55us,508.599us,508.6us,508.649us,508.65us,508.699us,508.7us,508.749us,508.75us,508.799us,508.8us,508.849us,508.85us,508.899us,508.9us,508.949us,508.95us,508.999us,509us,509.049us,509.05us,509.099us,509.1us,509.149us,509.15us,509.199us,509.2us,509.249us,509.25us,509.299us,509.3us,509.349us,509.35us,509.399us,509.4us,509.449us,509.45us,509.499us,509.5us,509.549us,509.55us,509.599us,509.6us,509.649us,509.65us,509.699us,509.7us,509.749us,509.75us,509.799us,509.8us,509.849us,509.85us,509.899us,509.9us,509.949us,509.95us,509.999us,510us,510.049us,510.05us,510.099us,510.1us,510.149us,510.15us,510.199us,510.2us,510.249us,510.25us,510.299us,510.3us,510.349us,510.35us,510.399us,510.4us,510.449us,510.45us,510.499us,510.5us,510.549us,510.55us,510.599us,510.6us,510.649us,510.65us,510.699us,510.7us,510.749us,510.75us,510.799us,510.8us,510.849us,510.85us,510.899us,510.9us,510.949us,510.95us,510.999us,511us,511.049us,511.05us,511.099us,511.1us,511.149us,511.15us,511.199us,511.2us,511.249us,511.25us,511.299us,511.3us,511.349us,511.35us,511.399us,511.4us,511.449us,511.45us,511.499us,511.5us,511.549us,511.55us,511.599us,511.6us,511.649us,511.65us,511.699us,511.7us,511.749us,511.75us,511.799us,511.8us,511.849us,511.85us,511.899us,511.9us,511.949us,511.95us,511.999us,512us,512.049us,512.05us,512.099us,512.1us,512.149us,512.15us,512.199us,512.2us,512.249us,512.25us,512.299us,512.3us,512.349us,512.35us,512.399us,512.4us,512.449us,512.45us,512.499us,512.5us,512.549us,512.55us,512.599us,512.6us,512.649us,512.65us,512.699us,512.7us,512.749us,512.75us,512.799us,512.8us,512.849us,512.85us,512.899us,512.9us,512.949us,512.95us,512.999us,513us,513.049us,513.05us,513.099us,513.1us,513.149us,513.15us,513.199us,513.2us,513.249us,513.25us,513.299us,513.3us,513.349us,513.35us,513.399us,513.4us,513.449us,513.45us,513.499us,513.5us,513.549us,513.55us,513.599us,513.6us,513.649us,513.65us,513.699us,513.7us,513.749us,513.75us,513.799us,513.8us,513.849us,513.85us,513.899us,513.9us,513.949us,513.95us,513.999us,514us,514.049us,514.05us,514.099us,514.1us,514.149us,514.15us,514.199us,514.2us,514.249us,514.25us,514.299us,514.3us,514.349us,514.35us,514.399us,514.4us,514.449us,514.45us,514.499us,514.5us,514.549us,514.55us,514.599us,514.6us,514.649us,514.65us,514.699us,514.7us,514.749us,514.75us,514.799us,514.8us,514.849us,514.85us,514.899us,514.9us,514.949us,514.95us,514.999us,515us,515.049us,515.05us,515.099us,515.1us,515.149us,515.15us,515.199us,515.2us,515.249us,515.25us,515.299us,515.3us,515.349us,515.35us,515.399us,515.4us,515.449us,515.45us,515.499us,515.5us,515.549us,515.55us,515.599us,515.6us,515.649us,515.65us,515.699us,515.7us,515.749us,515.75us,515.799us,515.8us,515.849us,515.85us,515.899us,515.9us,515.949us,515.95us,515.999us,516us,516.049us,516.05us,516.099us,516.1us,516.149us,516.15us,516.199us,516.2us,516.249us,516.25us,516.299us,516.3us,516.349us,516.35us,516.399us,516.4us,516.449us,516.45us,516.499us,516.5us,516.549us,516.55us,516.599us,516.6us,516.649us,516.65us,516.699us,516.7us,516.749us,516.75us,516.799us,516.8us,516.849us,516.85us,516.899us,516.9us,516.949us,516.95us,516.999us,517us,517.049us,517.05us,517.099us,517.1us,517.149us,517.15us,517.199us,517.2us,517.249us,517.25us,517.299us,517.3us,517.349us,517.35us,517.399us,517.4us,517.449us,517.45us,517.499us,517.5us,517.549us,517.55us,517.599us,517.6us,517.649us,517.65us,517.699us,517.7us,517.749us,517.75us,517.799us,517.8us,517.849us,517.85us,517.899us,517.9us,517.949us,517.95us,517.999us,518us,518.049us,518.05us,518.099us,518.1us,518.149us,518.15us,518.199us,518.2us,518.249us,518.25us,518.299us,518.3us,518.349us,518.35us,518.399us,518.4us,518.449us,518.45us,518.499us,518.5us,518.549us,518.55us,518.599us,518.6us,518.649us,518.65us,518.699us,518.7us,518.749us,518.75us,518.799us,518.8us,518.849us,518.85us,518.899us,518.9us,518.949us,518.95us,518.999us,519us,519.049us,519.05us,519.099us,519.1us,519.149us,519.15us,519.199us,519.2us,519.249us,519.25us,519.299us,519.3us,519.349us,519.35us,519.399us,519.4us,519.449us,519.45us,519.499us,519.5us,519.549us,519.55us,519.599us,519.6us,519.649us,519.65us,519.699us,519.7us,519.749us,519.75us,519.799us,519.8us,519.849us,519.85us,519.899us,519.9us,519.949us,519.95us,519.999us,520us,520.049us,520.05us,520.099us,520.1us,520.149us,520.15us,520.199us,520.2us,520.249us,520.25us,520.299us,520.3us,520.349us,520.35us,520.399us,520.4us,520.449us,520.45us,520.499us,520.5us,520.549us,520.55us,520.599us,520.6us,520.649us,520.65us,520.699us,520.7us,520.749us,520.75us,520.799us,520.8us,520.849us,520.85us,520.899us,520.9us,520.949us,520.95us,520.999us,521us,521.049us,521.05us,521.099us,521.1us,521.149us,521.15us,521.199us,521.2us,521.249us,521.25us,521.299us,521.3us,521.349us,521.35us,521.399us,521.4us,521.449us,521.45us,521.499us,521.5us,521.549us,521.55us,521.599us,521.6us,521.649us,521.65us,521.699us,521.7us,521.749us,521.75us,521.799us,521.8us,521.849us,521.85us,521.899us,521.9us,521.949us,521.95us,521.999us,522us,522.049us,522.05us,522.099us,522.1us,522.149us,522.15us,522.199us,522.2us,522.249us,522.25us,522.299us,522.3us,522.349us,522.35us,522.399us,522.4us,522.449us,522.45us,522.499us,522.5us,522.549us,522.55us,522.599us,522.6us,522.649us,522.65us,522.699us,522.7us,522.749us,522.75us,522.799us,522.8us,522.849us,522.85us,522.899us,522.9us,522.949us,522.95us,522.999us,523us,523.049us,523.05us,523.099us,523.1us,523.149us,523.15us,523.199us,523.2us,523.249us,523.25us,523.299us,523.3us,523.349us,523.35us,523.399us,523.4us,523.449us,523.45us,523.499us,523.5us,523.549us,523.55us,523.599us,523.6us,523.649us,523.65us,523.699us,523.7us,523.749us,523.75us,523.799us,523.8us,523.849us,523.85us,523.899us,523.9us,523.949us,523.95us,523.999us,524us,524.049us,524.05us,524.099us,524.1us,524.149us,524.15us,524.199us,524.2us,524.249us,524.25us,524.299us,524.3us,524.349us,524.35us,524.399us,524.4us,524.449us,524.45us,524.499us,524.5us,524.549us,524.55us,524.599us,524.6us,524.649us,524.65us,524.699us,524.7us,524.749us,524.75us,524.799us,524.8us,524.849us,524.85us,524.899us,524.9us,524.949us,524.95us,524.999us,525us,525.049us,525.05us,525.099us,525.1us,525.149us,525.15us,525.199us,525.2us,525.249us,525.25us,525.299us,525.3us,525.349us,525.35us,525.399us,525.4us,525.449us,525.45us,525.499us,525.5us,525.549us,525.55us,525.599us,525.6us,525.649us,525.65us,525.699us,525.7us,525.749us,525.75us,525.799us,525.8us,525.849us,525.85us,525.899us,525.9us,525.949us,525.95us,525.999us,526us,526.049us,526.05us,526.099us,526.1us,526.149us,526.15us,526.199us,526.2us,526.249us,526.25us,526.299us,526.3us,526.349us,526.35us,526.399us,526.4us,526.449us,526.45us,526.499us,526.5us,526.549us,526.55us,526.599us,526.6us,526.649us,526.65us,526.699us,526.7us,526.749us,526.75us,526.799us,526.8us,526.849us,526.85us,526.899us,526.9us,526.949us,526.95us,526.999us,527us,527.049us,527.05us,527.099us,527.1us,527.149us,527.15us,527.199us,527.2us,527.249us,527.25us,527.299us,527.3us,527.349us,527.35us,527.399us,527.4us,527.449us,527.45us,527.499us,527.5us,527.549us,527.55us,527.599us,527.6us,527.649us,527.65us,527.699us,527.7us,527.749us,527.75us,527.799us,527.8us,527.849us,527.85us,527.899us,527.9us,527.949us,527.95us,527.999us,528us,528.049us,528.05us,528.099us,528.1us,528.149us,528.15us,528.199us,528.2us,528.249us,528.25us,528.299us,528.3us,528.349us,528.35us,528.399us,528.4us,528.449us,528.45us,528.499us,528.5us,528.549us,528.55us,528.599us,528.6us,528.649us,528.65us,528.699us,528.7us,528.749us,528.75us,528.799us,528.8us,528.849us,528.85us,528.899us,528.9us,528.949us,528.95us,528.999us,529us,529.049us,529.05us,529.099us,529.1us,529.149us,529.15us,529.199us,529.2us,529.249us,529.25us,529.299us,529.3us,529.349us,529.35us,529.399us,529.4us,529.449us,529.45us,529.499us,529.5us,529.549us,529.55us,529.599us,529.6us,529.649us,529.65us,529.699us,529.7us,529.749us,529.75us,529.799us,529.8us,529.849us,529.85us,529.899us,529.9us,529.949us,529.95us,529.999us,530us,530.049us,530.05us,530.099us,530.1us,530.149us,530.15us,530.199us,530.2us,530.249us,530.25us,530.299us,530.3us,530.349us,530.35us,530.399us,530.4us,530.449us,530.45us,530.499us,530.5us,530.549us,530.55us,530.599us,530.6us,530.649us,530.65us,530.699us,530.7us,530.749us,530.75us,530.799us,530.8us,530.849us,530.85us,530.899us,530.9us,530.949us,530.95us,530.999us,531us,531.049us,531.05us,531.099us,531.1us,531.149us,531.15us,531.199us,531.2us,531.249us,531.25us,531.299us,531.3us,531.349us,531.35us,531.399us,531.4us,531.449us,531.45us,531.499us,531.5us,531.549us,531.55us,531.599us,531.6us,531.649us,531.65us,531.699us,531.7us,531.749us,531.75us,531.799us,531.8us,531.849us,531.85us,531.899us,531.9us,531.949us,531.95us,531.999us,532us,532.049us,532.05us,532.099us,532.1us,532.149us,532.15us,532.199us,532.2us,532.249us,532.25us,532.299us,532.3us,532.349us,532.35us,532.399us,532.4us,532.449us,532.45us,532.499us,532.5us,532.549us,532.55us,532.599us,532.6us,532.649us,532.65us,532.699us,532.7us,532.749us,532.75us,532.799us,532.8us,532.849us,532.85us,532.899us,532.9us,532.949us,532.95us,532.999us,533us,533.049us,533.05us,533.099us,533.1us,533.149us,533.15us,533.199us,533.2us,533.249us,533.25us,533.299us,533.3us,533.349us,533.35us,533.399us,533.4us,533.449us,533.45us,533.499us,533.5us,533.549us,533.55us,533.599us,533.6us,533.649us,533.65us,533.699us,533.7us,533.749us,533.75us,533.799us,533.8us,533.849us,533.85us,533.899us,533.9us,533.949us,533.95us,533.999us,534us,534.049us,534.05us,534.099us,534.1us,534.149us,534.15us,534.199us,534.2us,534.249us,534.25us,534.299us,534.3us,534.349us,534.35us,534.399us,534.4us,534.449us,534.45us,534.499us,534.5us,534.549us,534.55us,534.599us,534.6us,534.649us,534.65us,534.699us,534.7us,534.749us,534.75us,534.799us,534.8us,534.849us,534.85us,534.899us,534.9us,534.949us,534.95us,534.999us,535us,535.049us,535.05us,535.099us,535.1us,535.149us,535.15us,535.199us,535.2us,535.249us,535.25us,535.299us,535.3us,535.349us,535.35us,535.399us,535.4us,535.449us,535.45us,535.499us,535.5us,535.549us,535.55us,535.599us,535.6us,535.649us,535.65us,535.699us,535.7us,535.749us,535.75us,535.799us,535.8us,535.849us,535.85us,535.899us,535.9us,535.949us,535.95us,535.999us,536us,536.049us,536.05us,536.099us,536.1us,536.149us,536.15us,536.199us,536.2us,536.249us,536.25us,536.299us,536.3us,536.349us,536.35us,536.399us,536.4us,536.449us,536.45us,536.499us,536.5us,536.549us,536.55us,536.599us,536.6us,536.649us,536.65us,536.699us,536.7us,536.749us,536.75us,536.799us,536.8us,536.849us,536.85us,536.899us,536.9us,536.949us,536.95us,536.999us,537us,537.049us,537.05us,537.099us,537.1us,537.149us,537.15us,537.199us,537.2us,537.249us,537.25us,537.299us,537.3us,537.349us,537.35us,537.399us,537.4us,537.449us,537.45us,537.499us,537.5us,537.549us,537.55us,537.599us,537.6us,537.649us,537.65us,537.699us,537.7us,537.749us,537.75us,537.799us,537.8us,537.849us,537.85us,537.899us,537.9us,537.949us,537.95us,537.999us,538us,538.049us,538.05us,538.099us,538.1us,538.149us,538.15us,538.199us,538.2us,538.249us,538.25us,538.299us,538.3us,538.349us,538.35us,538.399us,538.4us,538.449us,538.45us,538.499us,538.5us,538.549us,538.55us,538.599us,538.6us,538.649us,538.65us,538.699us,538.7us,538.749us,538.75us,538.799us,538.8us,538.849us,538.85us,538.899us,538.9us,538.949us,538.95us,538.999us,539us,539.049us,539.05us,539.099us,539.1us,539.149us,539.15us,539.199us,539.2us,539.249us,539.25us,539.299us,539.3us,539.349us,539.35us,539.399us,539.4us,539.449us,539.45us,539.499us,539.5us,539.549us,539.55us,539.599us,539.6us,539.649us,539.65us,539.699us,539.7us,539.749us,539.75us,539.799us,539.8us,539.849us,539.85us,539.899us,539.9us,539.949us,539.95us,539.999us,540us,540.049us,540.05us,540.099us,540.1us,540.149us,540.15us,540.199us,540.2us,540.249us,540.25us,540.299us,540.3us,540.349us,540.35us,540.399us,540.4us,540.449us,540.45us,540.499us,540.5us,540.549us,540.55us,540.599us,540.6us,540.649us,540.65us,540.699us,540.7us,540.749us,540.75us,540.799us,540.8us,540.849us,540.85us,540.899us,540.9us,540.949us,540.95us,540.999us,541us,541.049us,541.05us,541.099us,541.1us,541.149us,541.15us,541.199us,541.2us,541.249us,541.25us,541.299us,541.3us,541.349us,541.35us,541.399us,541.4us,541.449us,541.45us,541.499us,541.5us,541.549us,541.55us,541.599us,541.6us,541.649us,541.65us,541.699us,541.7us,541.749us,541.75us,541.799us,541.8us,541.849us,541.85us,541.899us,541.9us,541.949us,541.95us,541.999us,542us,542.049us,542.05us,542.099us,542.1us,542.149us,542.15us,542.199us,542.2us,542.249us,542.25us,542.299us,542.3us,542.349us,542.35us,542.399us,542.4us,542.449us,542.45us,542.499us,542.5us,542.549us,542.55us,542.599us,542.6us,542.649us,542.65us,542.699us,542.7us,542.749us,542.75us,542.799us,542.8us,542.849us,542.85us,542.899us,542.9us,542.949us,542.95us,542.999us,543us,543.049us,543.05us,543.099us,543.1us,543.149us,543.15us,543.199us,543.2us,543.249us,543.25us,543.299us,543.3us,543.349us,543.35us,543.399us,543.4us,543.449us,543.45us,543.499us,543.5us,543.549us,543.55us,543.599us,543.6us,543.649us,543.65us,543.699us,543.7us,543.749us,543.75us,543.799us,543.8us,543.849us,543.85us,543.899us,543.9us,543.949us,543.95us,543.999us,544us,544.049us,544.05us,544.099us,544.1us,544.149us,544.15us,544.199us,544.2us,544.249us,544.25us,544.299us,544.3us,544.349us,544.35us,544.399us,544.4us,544.449us,544.45us,544.499us,544.5us,544.549us,544.55us,544.599us,544.6us,544.649us,544.65us,544.699us,544.7us,544.749us,544.75us,544.799us,544.8us,544.849us,544.85us,544.899us,544.9us,544.949us,544.95us,544.999us,545us,545.049us,545.05us,545.099us,545.1us,545.149us,545.15us,545.199us,545.2us,545.249us,545.25us,545.299us,545.3us,545.349us,545.35us,545.399us,545.4us,545.449us,545.45us,545.499us,545.5us,545.549us,545.55us,545.599us,545.6us,545.649us,545.65us,545.699us,545.7us,545.749us,545.75us,545.799us,545.8us,545.849us,545.85us,545.899us,545.9us,545.949us,545.95us,545.999us,546us,546.049us,546.05us,546.099us,546.1us,546.149us,546.15us,546.199us,546.2us,546.249us,546.25us,546.299us,546.3us,546.349us,546.35us,546.399us,546.4us,546.449us,546.45us,546.499us,546.5us,546.549us,546.55us,546.599us,546.6us,546.649us,546.65us,546.699us,546.7us,546.749us,546.75us,546.799us,546.8us,546.849us,546.85us,546.899us,546.9us,546.949us,546.95us,546.999us,547us,547.049us,547.05us,547.099us,547.1us,547.149us,547.15us,547.199us,547.2us,547.249us,547.25us,547.299us,547.3us,547.349us,547.35us,547.399us,547.4us,547.449us,547.45us,547.499us,547.5us,547.549us,547.55us,547.599us,547.6us,547.649us,547.65us,547.699us,547.7us,547.749us,547.75us,547.799us,547.8us,547.849us,547.85us,547.899us,547.9us,547.949us,547.95us,547.999us,548us,548.049us,548.05us,548.099us,548.1us,548.149us,548.15us,548.199us,548.2us,548.249us,548.25us,548.299us,548.3us,548.349us,548.35us,548.399us,548.4us,548.449us,548.45us,548.499us,548.5us,548.549us,548.55us,548.599us,548.6us,548.649us,548.65us,548.699us,548.7us,548.749us,548.75us,548.799us,548.8us,548.849us,548.85us,548.899us,548.9us,548.949us,548.95us,548.999us,549us,549.049us,549.05us,549.099us,549.1us,549.149us,549.15us,549.199us,549.2us,549.249us,549.25us,549.299us,549.3us,549.349us,549.35us,549.399us,549.4us,549.449us,549.45us,549.499us,549.5us,549.549us,549.55us,549.599us,549.6us,549.649us,549.65us,549.699us,549.7us,549.749us,549.75us,549.799us,549.8us,549.849us,549.85us,549.899us,549.9us,549.949us,549.95us,549.999us,550us,550.049us,550.05us,550.099us,550.1us,550.149us,550.15us,550.199us,550.2us,550.249us,550.25us,550.299us,550.3us,550.349us,550.35us,550.399us,550.4us,550.449us,550.45us,550.499us,550.5us,550.549us,550.55us,550.599us,550.6us,550.649us,550.65us,550.699us,550.7us,550.749us,550.75us,550.799us,550.8us,550.849us,550.85us,550.899us,550.9us,550.949us,550.95us,550.999us,551us,551.049us,551.05us,551.099us,551.1us,551.149us,551.15us,551.199us,551.2us,551.249us,551.25us,551.299us,551.3us,551.349us,551.35us,551.399us,551.4us,551.449us,551.45us,551.499us,551.5us,551.549us,551.55us,551.599us,551.6us,551.649us,551.65us,551.699us,551.7us,551.749us,551.75us,551.799us,551.8us,551.849us,551.85us,551.899us,551.9us,551.949us,551.95us,551.999us,552us,552.049us,552.05us,552.099us,552.1us,552.149us,552.15us,552.199us,552.2us,552.249us,552.25us,552.299us,552.3us,552.349us,552.35us,552.399us,552.4us,552.449us,552.45us,552.499us,552.5us,552.549us,552.55us,552.599us,552.6us,552.649us,552.65us,552.699us,552.7us,552.749us,552.75us,552.799us,552.8us,552.849us,552.85us,552.899us,552.9us,552.949us,552.95us,552.999us,553us,553.049us,553.05us,553.099us,553.1us,553.149us,553.15us,553.199us,553.2us,553.249us,553.25us,553.299us,553.3us,553.349us,553.35us,553.399us,553.4us,553.449us,553.45us,553.499us,553.5us,553.549us,553.55us,553.599us,553.6us,553.649us,553.65us,553.699us,553.7us,553.749us,553.75us,553.799us,553.8us,553.849us,553.85us,553.899us,553.9us,553.949us,553.95us,553.999us,554us,554.049us,554.05us,554.099us,554.1us,554.149us,554.15us,554.199us,554.2us,554.249us,554.25us,554.299us,554.3us,554.349us,554.35us,554.399us,554.4us,554.449us,554.45us,554.499us,554.5us,554.549us,554.55us,554.599us,554.6us,554.649us,554.65us,554.699us,554.7us,554.749us,554.75us,554.799us,554.8us,554.849us,554.85us,554.899us,554.9us,554.949us,554.95us,554.999us,555us,555.049us,555.05us,555.099us,555.1us,555.149us,555.15us,555.199us,555.2us,555.249us,555.25us,555.299us,555.3us,555.349us,555.35us,555.399us,555.4us,555.449us,555.45us,555.499us,555.5us,555.549us,555.55us,555.599us,555.6us,555.649us,555.65us,555.699us,555.7us,555.749us,555.75us,555.799us,555.8us,555.849us,555.85us,555.899us,555.9us,555.949us,555.95us,555.999us,556us,556.049us,556.05us,556.099us,556.1us,556.149us,556.15us,556.199us,556.2us,556.249us,556.25us,556.299us,556.3us,556.349us,556.35us,556.399us,556.4us,556.449us,556.45us,556.499us,556.5us,556.549us,556.55us,556.599us,556.6us,556.649us,556.65us,556.699us,556.7us,556.749us,556.75us,556.799us,556.8us,556.849us,556.85us,556.899us,556.9us,556.949us,556.95us,556.999us,557us,557.049us,557.05us,557.099us,557.1us,557.149us,557.15us,557.199us,557.2us,557.249us,557.25us,557.299us,557.3us,557.349us,557.35us,557.399us,557.4us,557.449us,557.45us,557.499us,557.5us,557.549us,557.55us,557.599us,557.6us,557.649us,557.65us,557.699us,557.7us,557.749us,557.75us,557.799us,557.8us,557.849us,557.85us,557.899us,557.9us,557.949us,557.95us,557.999us,558us,558.049us,558.05us,558.099us,558.1us,558.149us,558.15us,558.199us,558.2us,558.249us,558.25us,558.299us,558.3us,558.349us,558.35us,558.399us,558.4us,558.449us,558.45us,558.499us,558.5us,558.549us,558.55us,558.599us,558.6us,558.649us,558.65us,558.699us,558.7us,558.749us,558.75us,558.799us,558.8us,558.849us,558.85us,558.899us,558.9us,558.949us,558.95us,558.999us,559us,559.049us,559.05us,559.099us,559.1us,559.149us,559.15us,559.199us,559.2us,559.249us,559.25us,559.299us,559.3us,559.349us,559.35us,559.399us,559.4us,559.449us,559.45us,559.499us,559.5us,559.549us,559.55us,559.599us,559.6us,559.649us,559.65us,559.699us,559.7us,559.749us,559.75us,559.799us,559.8us,559.849us,559.85us,559.899us,559.9us,559.949us,559.95us,559.999us,560us,560.049us,560.05us,560.099us,560.1us,560.149us,560.15us,560.199us,560.2us,560.249us,560.25us,560.299us,560.3us,560.349us,560.35us,560.399us,560.4us,560.449us,560.45us,560.499us,560.5us,560.549us,560.55us,560.599us,560.6us,560.649us,560.65us,560.699us,560.7us,560.749us,560.75us,560.799us,560.8us,560.849us,560.85us,560.899us,560.9us,560.949us,560.95us,560.999us,561us,561.049us,561.05us,561.099us,561.1us,561.149us,561.15us,561.199us,561.2us,561.249us,561.25us,561.299us,561.3us,561.349us,561.35us,561.399us,561.4us,561.449us,561.45us,561.499us,561.5us,561.549us,561.55us,561.599us,561.6us,561.649us,561.65us,561.699us,561.7us,561.749us,561.75us,561.799us,561.8us,561.849us,561.85us,561.899us,561.9us,561.949us,561.95us,561.999us,562us,562.049us,562.05us,562.099us,562.1us,562.149us,562.15us,562.199us,562.2us,562.249us,562.25us,562.299us,562.3us,562.349us,562.35us,562.399us,562.4us,562.449us,562.45us,562.499us,562.5us,562.549us,562.55us,562.599us,562.6us,562.649us,562.65us,562.699us,562.7us,562.749us,562.75us,562.799us,562.8us,562.849us,562.85us,562.899us,562.9us,562.949us,562.95us,562.999us,563us,563.049us,563.05us,563.099us,563.1us,563.149us,563.15us,563.199us,563.2us,563.249us,563.25us,563.299us,563.3us,563.349us,563.35us,563.399us,563.4us,563.449us,563.45us,563.499us,563.5us,563.549us,563.55us,563.599us,563.6us,563.649us,563.65us,563.699us,563.7us,563.749us,563.75us,563.799us,563.8us,563.849us,563.85us,563.899us,563.9us,563.949us,563.95us,563.999us,564us,564.049us,564.05us,564.099us,564.1us,564.149us,564.15us,564.199us,564.2us,564.249us,564.25us,564.299us,564.3us,564.349us,564.35us,564.399us,564.4us,564.449us,564.45us,564.499us,564.5us,564.549us,564.55us,564.599us,564.6us,564.649us,564.65us,564.699us,564.7us,564.749us,564.75us,564.799us,564.8us,564.849us,564.85us,564.899us,564.9us,564.949us,564.95us,564.999us,565us,565.049us,565.05us,565.099us,565.1us,565.149us,565.15us,565.199us,565.2us,565.249us,565.25us,565.299us,565.3us,565.349us,565.35us,565.399us,565.4us,565.449us,565.45us,565.499us,565.5us,565.549us,565.55us,565.599us,565.6us,565.649us,565.65us,565.699us,565.7us,565.749us,565.75us,565.799us,565.8us,565.849us,565.85us,565.899us,565.9us,565.949us,565.95us,565.999us,566us,566.049us,566.05us,566.099us,566.1us,566.149us,566.15us,566.199us,566.2us,566.249us,566.25us,566.299us,566.3us,566.349us,566.35us,566.399us,566.4us,566.449us,566.45us,566.499us,566.5us,566.549us,566.55us,566.599us,566.6us,566.649us,566.65us,566.699us,566.7us,566.749us,566.75us,566.799us,566.8us,566.849us,566.85us,566.899us,566.9us,566.949us,566.95us,566.999us,567us,567.049us,567.05us,567.099us,567.1us,567.149us,567.15us,567.199us,567.2us,567.249us,567.25us,567.299us,567.3us,567.349us,567.35us,567.399us,567.4us,567.449us,567.45us,567.499us,567.5us,567.549us,567.55us,567.599us,567.6us,567.649us,567.65us,567.699us,567.7us,567.749us,567.75us,567.799us,567.8us,567.849us,567.85us,567.899us,567.9us,567.949us,567.95us,567.999us,568us,568.049us,568.05us,568.099us,568.1us,568.149us,568.15us,568.199us,568.2us,568.249us,568.25us,568.299us,568.3us,568.349us,568.35us,568.399us,568.4us,568.449us,568.45us,568.499us,568.5us,568.549us,568.55us,568.599us,568.6us,568.649us,568.65us,568.699us,568.7us,568.749us,568.75us,568.799us,568.8us,568.849us,568.85us,568.899us,568.9us,568.949us,568.95us,568.999us,569us,569.049us,569.05us,569.099us,569.1us,569.149us,569.15us,569.199us,569.2us,569.249us,569.25us,569.299us,569.3us,569.349us,569.35us,569.399us,569.4us,569.449us,569.45us,569.499us,569.5us,569.549us,569.55us,569.599us,569.6us,569.649us,569.65us,569.699us,569.7us,569.749us,569.75us,569.799us,569.8us,569.849us,569.85us,569.899us,569.9us,569.949us,569.95us,569.999us,570us,570.049us,570.05us,570.099us,570.1us,570.149us,570.15us,570.199us,570.2us,570.249us,570.25us,570.299us,570.3us,570.349us,570.35us,570.399us,570.4us,570.449us,570.45us,570.499us,570.5us,570.549us,570.55us,570.599us,570.6us,570.649us,570.65us,570.699us,570.7us,570.749us,570.75us,570.799us,570.8us,570.849us,570.85us,570.899us,570.9us,570.949us,570.95us,570.999us,571us,571.049us,571.05us,571.099us,571.1us,571.149us,571.15us,571.199us,571.2us,571.249us,571.25us,571.299us,571.3us,571.349us,571.35us,571.399us,571.4us,571.449us,571.45us,571.499us,571.5us,571.549us,571.55us,571.599us,571.6us,571.649us,571.65us,571.699us,571.7us,571.749us,571.75us,571.799us,571.8us,571.849us,571.85us,571.899us,571.9us,571.949us,571.95us,571.999us,572us,572.049us,572.05us,572.099us,572.1us,572.149us,572.15us,572.199us,572.2us,572.249us,572.25us,572.299us,572.3us,572.349us,572.35us,572.399us,572.4us,572.449us,572.45us,572.499us,572.5us,572.549us,572.55us,572.599us,572.6us,572.649us,572.65us,572.699us,572.7us,572.749us,572.75us,572.799us,572.8us,572.849us,572.85us,572.899us,572.9us,572.949us,572.95us,572.999us,573us,573.049us,573.05us,573.099us,573.1us,573.149us,573.15us,573.199us,573.2us,573.249us,573.25us,573.299us,573.3us,573.349us,573.35us,573.399us,573.4us,573.449us,573.45us,573.499us,573.5us,573.549us,573.55us,573.599us,573.6us,573.649us,573.65us,573.699us,573.7us,573.749us,573.75us,573.799us,573.8us,573.849us,573.85us,573.899us,573.9us,573.949us,573.95us,573.999us,574us,574.049us,574.05us,574.099us,574.1us,574.149us,574.15us,574.199us,574.2us,574.249us,574.25us,574.299us,574.3us,574.349us,574.35us,574.399us,574.4us,574.449us,574.45us,574.499us,574.5us,574.549us,574.55us,574.599us,574.6us,574.649us,574.65us,574.699us,574.7us,574.749us,574.75us,574.799us,574.8us,574.849us,574.85us,574.899us,574.9us,574.949us,574.95us,574.999us,575us,575.049us,575.05us,575.099us,575.1us,575.149us,575.15us,575.199us,575.2us,575.249us,575.25us,575.299us,575.3us,575.349us,575.35us,575.399us,575.4us,575.449us,575.45us,575.499us,575.5us,575.549us,575.55us,575.599us,575.6us,575.649us,575.65us,575.699us,575.7us,575.749us,575.75us,575.799us,575.8us,575.849us,575.85us,575.899us,575.9us,575.949us,575.95us,575.999us,576us,576.049us,576.05us,576.099us,576.1us,576.149us,576.15us,576.199us,576.2us,576.249us,576.25us,576.299us,576.3us,576.349us,576.35us,576.399us,576.4us,576.449us,576.45us,576.499us,576.5us,576.549us,576.55us,576.599us,576.6us,576.649us,576.65us,576.699us,576.7us,576.749us,576.75us,576.799us,576.8us,576.849us,576.85us,576.899us,576.9us,576.949us,576.95us,576.999us,577us,577.049us,577.05us,577.099us,577.1us,577.149us,577.15us,577.199us,577.2us,577.249us,577.25us,577.299us,577.3us,577.349us,577.35us,577.399us,577.4us,577.449us,577.45us,577.499us,577.5us,577.549us,577.55us,577.599us,577.6us,577.649us,577.65us,577.699us,577.7us,577.749us,577.75us,577.799us,577.8us,577.849us,577.85us,577.899us,577.9us,577.949us,577.95us,577.999us,578us,578.049us,578.05us,578.099us,578.1us,578.149us,578.15us,578.199us,578.2us,578.249us,578.25us,578.299us,578.3us,578.349us,578.35us,578.399us,578.4us,578.449us,578.45us,578.499us,578.5us,578.549us,578.55us,578.599us,578.6us,578.649us,578.65us,578.699us,578.7us,578.749us,578.75us,578.799us,578.8us,578.849us,578.85us,578.899us,578.9us,578.949us,578.95us,578.999us,579us,579.049us,579.05us,579.099us,579.1us,579.149us,579.15us,579.199us,579.2us,579.249us,579.25us,579.299us,579.3us,579.349us,579.35us,579.399us,579.4us,579.449us,579.45us,579.499us,579.5us,579.549us,579.55us,579.599us,579.6us,579.649us,579.65us,579.699us,579.7us,579.749us,579.75us,579.799us,579.8us,579.849us,579.85us,579.899us,579.9us,579.949us,579.95us,579.999us,580us,580.049us,580.05us,580.099us,580.1us,580.149us,580.15us,580.199us,580.2us,580.249us,580.25us,580.299us,580.3us,580.349us,580.35us,580.399us,580.4us,580.449us,580.45us,580.499us,580.5us,580.549us,580.55us,580.599us,580.6us,580.649us,580.65us,580.699us,580.7us,580.749us,580.75us,580.799us,580.8us,580.849us,580.85us,580.899us,580.9us,580.949us,580.95us,580.999us,581us,581.049us,581.05us,581.099us,581.1us,581.149us,581.15us,581.199us,581.2us,581.249us,581.25us,581.299us,581.3us,581.349us,581.35us,581.399us,581.4us,581.449us,581.45us,581.499us,581.5us,581.549us,581.55us,581.599us,581.6us,581.649us,581.65us,581.699us,581.7us,581.749us,581.75us,581.799us,581.8us,581.849us,581.85us,581.899us,581.9us,581.949us,581.95us,581.999us,582us,582.049us,582.05us,582.099us,582.1us,582.149us,582.15us,582.199us,582.2us,582.249us,582.25us,582.299us,582.3us,582.349us,582.35us,582.399us,582.4us,582.449us,582.45us,582.499us,582.5us,582.549us,582.55us,582.599us,582.6us,582.649us,582.65us,582.699us,582.7us,582.749us,582.75us,582.799us,582.8us,582.849us,582.85us,582.899us,582.9us,582.949us,582.95us,582.999us,583us,583.049us,583.05us,583.099us,583.1us,583.149us,583.15us,583.199us,583.2us,583.249us,583.25us,583.299us,583.3us,583.349us,583.35us,583.399us,583.4us,583.449us,583.45us,583.499us,583.5us,583.549us,583.55us,583.599us,583.6us,583.649us,583.65us,583.699us,583.7us,583.749us,583.75us,583.799us,583.8us,583.849us,583.85us,583.899us,583.9us,583.949us,583.95us,583.999us,584us,584.049us,584.05us,584.099us,584.1us,584.149us,584.15us,584.199us,584.2us,584.249us,584.25us,584.299us,584.3us,584.349us,584.35us,584.399us,584.4us,584.449us,584.45us,584.499us,584.5us,584.549us,584.55us,584.599us,584.6us,584.649us,584.65us,584.699us,584.7us,584.749us,584.75us,584.799us,584.8us,584.849us,584.85us,584.899us,584.9us,584.949us,584.95us,584.999us,585us,585.049us,585.05us,585.099us,585.1us,585.149us,585.15us,585.199us,585.2us,585.249us,585.25us,585.299us,585.3us,585.349us,585.35us,585.399us,585.4us,585.449us,585.45us,585.499us,585.5us,585.549us,585.55us,585.599us,585.6us,585.649us,585.65us,585.699us,585.7us,585.749us,585.75us,585.799us,585.8us,585.849us,585.85us,585.899us,585.9us,585.949us,585.95us,585.999us,586us,586.049us,586.05us,586.099us,586.1us,586.149us,586.15us,586.199us,586.2us,586.249us,586.25us,586.299us,586.3us,586.349us,586.35us,586.399us,586.4us,586.449us,586.45us,586.499us,586.5us,586.549us,586.55us,586.599us,586.6us,586.649us,586.65us,586.699us,586.7us,586.749us,586.75us,586.799us,586.8us,586.849us,586.85us,586.899us,586.9us,586.949us,586.95us,586.999us,587us,587.049us,587.05us,587.099us,587.1us,587.149us,587.15us,587.199us,587.2us,587.249us,587.25us,587.299us,587.3us,587.349us,587.35us,587.399us,587.4us,587.449us,587.45us,587.499us,587.5us,587.549us,587.55us,587.599us,587.6us,587.649us,587.65us,587.699us,587.7us,587.749us,587.75us,587.799us,587.8us,587.849us,587.85us,587.899us,587.9us,587.949us,587.95us,587.999us,588us,588.049us,588.05us,588.099us,588.1us,588.149us,588.15us,588.199us,588.2us,588.249us,588.25us,588.299us,588.3us,588.349us,588.35us,588.399us,588.4us,588.449us,588.45us,588.499us,588.5us,588.549us,588.55us,588.599us,588.6us,588.649us,588.65us,588.699us,588.7us,588.749us,588.75us,588.799us,588.8us,588.849us,588.85us,588.899us,588.9us,588.949us,588.95us,588.999us,589us,589.049us,589.05us,589.099us,589.1us,589.149us,589.15us,589.199us,589.2us,589.249us,589.25us,589.299us,589.3us,589.349us,589.35us,589.399us,589.4us,589.449us,589.45us,589.499us,589.5us,589.549us,589.55us,589.599us,589.6us,589.649us,589.65us,589.699us,589.7us,589.749us,589.75us,589.799us,589.8us,589.849us,589.85us,589.899us,589.9us,589.949us,589.95us,589.999us,590us,590.049us,590.05us,590.099us,590.1us,590.149us,590.15us,590.199us,590.2us,590.249us,590.25us,590.299us,590.3us,590.349us,590.35us,590.399us,590.4us,590.449us,590.45us,590.499us,590.5us,590.549us,590.55us,590.599us,590.6us,590.649us,590.65us,590.699us,590.7us,590.749us,590.75us,590.799us,590.8us,590.849us,590.85us,590.899us,590.9us,590.949us,590.95us,590.999us,591us,591.049us,591.05us,591.099us,591.1us,591.149us,591.15us,591.199us,591.2us,591.249us,591.25us,591.299us,591.3us,591.349us,591.35us,591.399us,591.4us,591.449us,591.45us,591.499us,591.5us,591.549us,591.55us,591.599us,591.6us,591.649us,591.65us,591.699us,591.7us,591.749us,591.75us,591.799us,591.8us,591.849us,591.85us,591.899us,591.9us,591.949us,591.95us,591.999us,592us,592.049us,592.05us,592.099us,592.1us,592.149us,592.15us,592.199us,592.2us,592.249us,592.25us,592.299us,592.3us,592.349us,592.35us,592.399us,592.4us,592.449us,592.45us,592.499us,592.5us,592.549us,592.55us,592.599us,592.6us,592.649us,592.65us,592.699us,592.7us,592.749us,592.75us,592.799us,592.8us,592.849us,592.85us,592.899us,592.9us,592.949us,592.95us,592.999us,593us,593.049us,593.05us,593.099us,593.1us,593.149us,593.15us,593.199us,593.2us,593.249us,593.25us,593.299us,593.3us,593.349us,593.35us,593.399us,593.4us,593.449us,593.45us,593.499us,593.5us,593.549us,593.55us,593.599us,593.6us,593.649us,593.65us,593.699us,593.7us,593.749us,593.75us,593.799us,593.8us,593.849us,593.85us,593.899us,593.9us,593.949us,593.95us,593.999us,594us,594.049us,594.05us,594.099us,594.1us,594.149us,594.15us,594.199us,594.2us,594.249us,594.25us,594.299us,594.3us,594.349us,594.35us,594.399us,594.4us,594.449us,594.45us,594.499us,594.5us,594.549us,594.55us,594.599us,594.6us,594.649us,594.65us,594.699us,594.7us,594.749us,594.75us,594.799us,594.8us,594.849us,594.85us,594.899us,594.9us,594.949us,594.95us,594.999us,595us,595.049us,595.05us,595.099us,595.1us,595.149us,595.15us,595.199us,595.2us,595.249us,595.25us,595.299us,595.3us,595.349us,595.35us,595.399us,595.4us,595.449us,595.45us,595.499us,595.5us,595.549us,595.55us,595.599us,595.6us,595.649us,595.65us,595.699us,595.7us,595.749us,595.75us,595.799us,595.8us,595.849us,595.85us,595.899us,595.9us,595.949us,595.95us,595.999us,596us,596.049us,596.05us,596.099us,596.1us,596.149us,596.15us,596.199us,596.2us,596.249us,596.25us,596.299us,596.3us,596.349us,596.35us,596.399us,596.4us,596.449us,596.45us,596.499us,596.5us,596.549us,596.55us,596.599us,596.6us,596.649us,596.65us,596.699us,596.7us,596.749us,596.75us,596.799us,596.8us,596.849us,596.85us,596.899us,596.9us,596.949us,596.95us,596.999us,597us,597.049us,597.05us,597.099us,597.1us,597.149us,597.15us,597.199us,597.2us,597.249us,597.25us,597.299us,597.3us,597.349us,597.35us,597.399us,597.4us,597.449us,597.45us,597.499us,597.5us,597.549us,597.55us,597.599us,597.6us,597.649us,597.65us,597.699us,597.7us,597.749us,597.75us,597.799us,597.8us,597.849us,597.85us,597.899us,597.9us,597.949us,597.95us,597.999us,598us,598.049us,598.05us,598.099us,598.1us,598.149us,598.15us,598.199us,598.2us,598.249us,598.25us,598.299us,598.3us,598.349us,598.35us,598.399us,598.4us,598.449us,598.45us,598.499us,598.5us,598.549us,598.55us,598.599us,598.6us,598.649us,598.65us,598.699us,598.7us,598.749us,598.75us,598.799us,598.8us,598.849us,598.85us,598.899us,598.9us,598.949us,598.95us,598.999us,599us,599.049us,599.05us,599.099us,599.1us,599.149us,599.15us,599.199us,599.2us,599.249us,599.25us,599.299us,599.3us,599.349us,599.35us,599.399us,599.4us,599.449us,599.45us,599.499us,599.5us,599.549us,599.55us,599.599us,599.6us,599.649us,599.65us,599.699us,599.7us,599.749us,599.75us,599.799us,599.8us,599.849us,599.85us,599.899us,599.9us,599.949us,599.95us,599.999us,600us,600.049us,600.05us,600.099us,600.1us,600.149us,600.15us,600.199us,600.2us,600.249us,600.25us,600.299us,600.3us,600.349us,600.35us,600.399us,600.4us,600.449us,600.45us,600.499us,600.5us,600.549us,600.55us,600.599us,600.6us,600.649us,600.65us,600.699us,600.7us,600.749us,600.75us,600.799us,600.8us,600.849us,600.85us,600.899us,600.9us,600.949us,600.95us,600.999us,601us,601.049us,601.05us,601.099us,601.1us,601.149us,601.15us,601.199us,601.2us,601.249us,601.25us,601.299us,601.3us,601.349us,601.35us,601.399us,601.4us,601.449us,601.45us,601.499us,601.5us,601.549us,601.55us,601.599us,601.6us,601.649us,601.65us,601.699us,601.7us,601.749us,601.75us,601.799us,601.8us,601.849us,601.85us,601.899us,601.9us,601.949us,601.95us,601.999us,602us,602.049us,602.05us,602.099us,602.1us,602.149us,602.15us,602.199us,602.2us,602.249us,602.25us,602.299us,602.3us,602.349us,602.35us,602.399us,602.4us,602.449us,602.45us,602.499us,602.5us,602.549us,602.55us,602.599us,602.6us,602.649us,602.65us,602.699us,602.7us,602.749us,602.75us,602.799us,602.8us,602.849us,602.85us,602.899us,602.9us,602.949us,602.95us,602.999us,603us,603.049us,603.05us,603.099us,603.1us,603.149us,603.15us,603.199us,603.2us,603.249us,603.25us,603.299us,603.3us,603.349us,603.35us,603.399us,603.4us,603.449us,603.45us,603.499us,603.5us,603.549us,603.55us,603.599us,603.6us,603.649us,603.65us,603.699us,603.7us,603.749us,603.75us,603.799us,603.8us,603.849us,603.85us,603.899us,603.9us,603.949us,603.95us,603.999us,604us,604.049us,604.05us,604.099us,604.1us,604.149us,604.15us,604.199us,604.2us,604.249us,604.25us,604.299us,604.3us,604.349us,604.35us,604.399us,604.4us,604.449us,604.45us,604.499us,604.5us,604.549us,604.55us,604.599us,604.6us,604.649us,604.65us,604.699us,604.7us,604.749us,604.75us,604.799us,604.8us,604.849us,604.85us,604.899us,604.9us,604.949us,604.95us,604.999us,605us,605.049us,605.05us,605.099us,605.1us,605.149us,605.15us,605.199us,605.2us,605.249us,605.25us,605.299us,605.3us,605.349us,605.35us,605.399us,605.4us,605.449us,605.45us,605.499us,605.5us,605.549us,605.55us,605.599us,605.6us,605.649us,605.65us,605.699us,605.7us,605.749us,605.75us,605.799us,605.8us,605.849us,605.85us,605.899us,605.9us,605.949us,605.95us,605.999us,606us,606.049us,606.05us,606.099us,606.1us,606.149us,606.15us,606.199us,606.2us,606.249us,606.25us,606.299us,606.3us,606.349us,606.35us,606.399us,606.4us,606.449us,606.45us,606.499us,606.5us,606.549us,606.55us,606.599us,606.6us,606.649us,606.65us,606.699us,606.7us,606.749us,606.75us,606.799us,606.8us,606.849us,606.85us,606.899us,606.9us,606.949us,606.95us,606.999us,607us,607.049us,607.05us,607.099us,607.1us,607.149us,607.15us,607.199us,607.2us,607.249us,607.25us,607.299us,607.3us,607.349us,607.35us,607.399us,607.4us,607.449us,607.45us,607.499us,607.5us,607.549us,607.55us,607.599us,607.6us,607.649us,607.65us,607.699us,607.7us,607.749us,607.75us,607.799us,607.8us,607.849us,607.85us,607.899us,607.9us,607.949us,607.95us,607.999us,608us,608.049us,608.05us,608.099us,608.1us,608.149us,608.15us,608.199us,608.2us,608.249us,608.25us,608.299us,608.3us,608.349us,608.35us,608.399us,608.4us,608.449us,608.45us,608.499us,608.5us,608.549us,608.55us,608.599us,608.6us,608.649us,608.65us,608.699us,608.7us,608.749us,608.75us,608.799us,608.8us,608.849us,608.85us,608.899us,608.9us,608.949us,608.95us,608.999us,609us,609.049us,609.05us,609.099us,609.1us,609.149us,609.15us,609.199us,609.2us,609.249us,609.25us,609.299us,609.3us,609.349us,609.35us,609.399us,609.4us,609.449us,609.45us,609.499us,609.5us,609.549us,609.55us,609.599us,609.6us,609.649us,609.65us,609.699us,609.7us,609.749us,609.75us,609.799us,609.8us,609.849us,609.85us,609.899us,609.9us,609.949us,609.95us,609.999us,610us,610.049us,610.05us,610.099us,610.1us,610.149us,610.15us,610.199us,610.2us,610.249us,610.25us,610.299us,610.3us,610.349us,610.35us,610.399us,610.4us,610.449us,610.45us,610.499us,610.5us,610.549us,610.55us,610.599us,610.6us,610.649us,610.65us,610.699us,610.7us,610.749us,610.75us,610.799us,610.8us,610.849us,610.85us,610.899us,610.9us,610.949us,610.95us,610.999us,611us,611.049us,611.05us,611.099us,611.1us,611.149us,611.15us,611.199us,611.2us,611.249us,611.25us,611.299us,611.3us,611.349us,611.35us,611.399us,611.4us,611.449us,611.45us,611.499us,611.5us,611.549us,611.55us,611.599us,611.6us,611.649us,611.65us,611.699us,611.7us,611.749us,611.75us,611.799us,611.8us,611.849us,611.85us,611.899us,611.9us,611.949us,611.95us,611.999us,612us,612.049us,612.05us,612.099us,612.1us,612.149us,612.15us,612.199us,612.2us,612.249us,612.25us,612.299us,612.3us,612.349us,612.35us,612.399us,612.4us,612.449us,612.45us,612.499us,612.5us,612.549us,612.55us,612.599us,612.6us,612.649us,612.65us,612.699us,612.7us,612.749us,612.75us,612.799us,612.8us,612.849us,612.85us,612.899us,612.9us,612.949us,612.95us,612.999us,613us,613.049us,613.05us,613.099us,613.1us,613.149us,613.15us,613.199us,613.2us,613.249us,613.25us,613.299us,613.3us,613.349us,613.35us,613.399us,613.4us,613.449us,613.45us,613.499us,613.5us,613.549us,613.55us,613.599us,613.6us,613.649us,613.65us,613.699us,613.7us,613.749us,613.75us,613.799us,613.8us,613.849us,613.85us,613.899us,613.9us,613.949us,613.95us,613.999us,614us,614.049us,614.05us,614.099us,614.1us,614.149us,614.15us,614.199us,614.2us,614.249us,614.25us,614.299us,614.3us,614.349us,614.35us,614.399us,614.4us,614.449us,614.45us,614.499us,614.5us,614.549us,614.55us,614.599us,614.6us,614.649us,614.65us,614.699us,614.7us,614.749us,614.75us,614.799us,614.8us,614.849us,614.85us,614.899us,614.9us,614.949us,614.95us,614.999us,615us,615.049us,615.05us,615.099us,615.1us,615.149us,615.15us,615.199us,615.2us,615.249us,615.25us,615.299us,615.3us,615.349us,615.35us,615.399us,615.4us,615.449us,615.45us,615.499us,615.5us,615.549us,615.55us,615.599us,615.6us,615.649us,615.65us,615.699us,615.7us,615.749us,615.75us,615.799us,615.8us,615.849us,615.85us,615.899us,615.9us,615.949us,615.95us,615.999us,616us,616.049us,616.05us,616.099us,616.1us,616.149us,616.15us,616.199us,616.2us,616.249us,616.25us,616.299us,616.3us,616.349us,616.35us,616.399us,616.4us,616.449us,616.45us,616.499us,616.5us,616.549us,616.55us,616.599us,616.6us,616.649us,616.65us,616.699us,616.7us,616.749us,616.75us,616.799us,616.8us,616.849us,616.85us,616.899us,616.9us,616.949us,616.95us,616.999us,617us,617.049us,617.05us,617.099us,617.1us,617.149us,617.15us,617.199us,617.2us,617.249us,617.25us,617.299us,617.3us,617.349us,617.35us,617.399us,617.4us,617.449us,617.45us,617.499us,617.5us,617.549us,617.55us,617.599us,617.6us,617.649us,617.65us,617.699us,617.7us,617.749us,617.75us,617.799us,617.8us,617.849us,617.85us,617.899us,617.9us,617.949us,617.95us,617.999us,618us,618.049us,618.05us,618.099us,618.1us,618.149us,618.15us,618.199us,618.2us,618.249us,618.25us,618.299us,618.3us,618.349us,618.35us,618.399us,618.4us,618.449us,618.45us,618.499us,618.5us,618.549us,618.55us,618.599us,618.6us,618.649us,618.65us,618.699us,618.7us,618.749us,618.75us,618.799us,618.8us,618.849us,618.85us,618.899us,618.9us,618.949us,618.95us,618.999us,619us,619.049us,619.05us,619.099us,619.1us,619.149us,619.15us,619.199us,619.2us,619.249us,619.25us,619.299us,619.3us,619.349us,619.35us,619.399us,619.4us,619.449us,619.45us,619.499us,619.5us,619.549us,619.55us,619.599us,619.6us,619.649us,619.65us,619.699us,619.7us,619.749us,619.75us,619.799us,619.8us,619.849us,619.85us,619.899us,619.9us,619.949us,619.95us,619.999us,620us,620.049us,620.05us,620.099us,620.1us,620.149us,620.15us,620.199us,620.2us,620.249us,620.25us,620.299us,620.3us,620.349us,620.35us,620.399us,620.4us,620.449us,620.45us,620.499us,620.5us,620.549us,620.55us,620.599us,620.6us,620.649us,620.65us,620.699us,620.7us,620.749us,620.75us,620.799us,620.8us,620.849us,620.85us,620.899us,620.9us,620.949us,620.95us,620.999us,621us,621.049us,621.05us,621.099us,621.1us,621.149us,621.15us,621.199us,621.2us,621.249us,621.25us,621.299us,621.3us,621.349us,621.35us,621.399us,621.4us,621.449us,621.45us,621.499us,621.5us,621.549us,621.55us,621.599us,621.6us,621.649us,621.65us,621.699us,621.7us,621.749us,621.75us,621.799us,621.8us,621.849us,621.85us,621.899us,621.9us,621.949us,621.95us,621.999us,622us,622.049us,622.05us,622.099us,622.1us,622.149us,622.15us,622.199us,622.2us,622.249us,622.25us,622.299us,622.3us,622.349us,622.35us,622.399us,622.4us,622.449us,622.45us,622.499us,622.5us,622.549us,622.55us,622.599us,622.6us,622.649us,622.65us,622.699us,622.7us,622.749us,622.75us,622.799us,622.8us,622.849us,622.85us,622.899us,622.9us,622.949us,622.95us,622.999us,623us,623.049us,623.05us,623.099us,623.1us,623.149us,623.15us,623.199us,623.2us,623.249us,623.25us,623.299us,623.3us,623.349us,623.35us,623.399us,623.4us,623.449us,623.45us,623.499us,623.5us,623.549us,623.55us,623.599us,623.6us,623.649us,623.65us,623.699us,623.7us,623.749us,623.75us,623.799us,623.8us,623.849us,623.85us,623.899us,623.9us,623.949us,623.95us,623.999us,624us,624.049us,624.05us,624.099us,624.1us,624.149us,624.15us,624.199us,624.2us,624.249us,624.25us,624.299us,624.3us,624.349us,624.35us,624.399us,624.4us,624.449us,624.45us,624.499us,624.5us,624.549us,624.55us,624.599us,624.6us,624.649us,624.65us,624.699us,624.7us,624.749us,624.75us,624.799us,624.8us,624.849us,624.85us,624.899us,624.9us,624.949us,624.95us,624.999us,625us,625.049us,625.05us,625.099us,625.1us,625.149us,625.15us,625.199us,625.2us,625.249us,625.25us,625.299us,625.3us,625.349us,625.35us,625.399us,625.4us,625.449us,625.45us,625.499us,625.5us,625.549us,625.55us,625.599us,625.6us,625.649us,625.65us,625.699us,625.7us,625.749us,625.75us,625.799us,625.8us,625.849us,625.85us,625.899us,625.9us,625.949us,625.95us,625.999us,626us,626.049us,626.05us,626.099us,626.1us,626.149us,626.15us,626.199us,626.2us,626.249us,626.25us,626.299us,626.3us,626.349us,626.35us,626.399us,626.4us,626.449us,626.45us,626.499us,626.5us,626.549us,626.55us,626.599us,626.6us,626.649us,626.65us,626.699us,626.7us,626.749us,626.75us,626.799us,626.8us,626.849us,626.85us,626.899us,626.9us,626.949us,626.95us,626.999us,627us,627.049us,627.05us,627.099us,627.1us,627.149us,627.15us,627.199us,627.2us,627.249us,627.25us,627.299us,627.3us,627.349us,627.35us,627.399us,627.4us,627.449us,627.45us,627.499us,627.5us,627.549us,627.55us,627.599us,627.6us,627.649us,627.65us,627.699us,627.7us,627.749us,627.75us,627.799us,627.8us,627.849us,627.85us,627.899us,627.9us,627.949us,627.95us,627.999us,628us,628.049us,628.05us,628.099us,628.1us,628.149us,628.15us,628.199us,628.2us,628.249us,628.25us,628.299us,628.3us,628.349us,628.35us,628.399us,628.4us,628.449us,628.45us,628.499us,628.5us,628.549us,628.55us,628.599us,628.6us,628.649us,628.65us,628.699us,628.7us,628.749us,628.75us,628.799us,628.8us,628.849us,628.85us,628.899us,628.9us,628.949us,628.95us,628.999us,629us,629.049us,629.05us,629.099us,629.1us,629.149us,629.15us,629.199us,629.2us,629.249us,629.25us,629.299us,629.3us,629.349us,629.35us,629.399us,629.4us,629.449us,629.45us,629.499us,629.5us,629.549us,629.55us,629.599us,629.6us,629.649us,629.65us,629.699us,629.7us,629.749us,629.75us,629.799us,629.8us,629.849us,629.85us,629.899us,629.9us,629.949us,629.95us,629.999us,630us,630.049us,630.05us,630.099us,630.1us,630.149us,630.15us,630.199us,630.2us,630.249us,630.25us,630.299us,630.3us,630.349us,630.35us,630.399us,630.4us,630.449us,630.45us,630.499us,630.5us,630.549us,630.55us,630.599us,630.6us,630.649us,630.65us,630.699us,630.7us,630.749us,630.75us,630.799us,630.8us,630.849us,630.85us,630.899us,630.9us,630.949us,630.95us,630.999us,631us,631.049us,631.05us,631.099us,631.1us,631.149us,631.15us,631.199us,631.2us,631.249us,631.25us,631.299us,631.3us,631.349us,631.35us,631.399us,631.4us,631.449us,631.45us,631.499us,631.5us,631.549us,631.55us,631.599us,631.6us,631.649us,631.65us,631.699us,631.7us,631.749us,631.75us,631.799us,631.8us,631.849us,631.85us,631.899us,631.9us,631.949us,631.95us,631.999us,632us,632.049us,632.05us,632.099us,632.1us,632.149us,632.15us,632.199us,632.2us,632.249us,632.25us,632.299us,632.3us,632.349us,632.35us,632.399us,632.4us,632.449us,632.45us,632.499us,632.5us,632.549us,632.55us,632.599us,632.6us,632.649us,632.65us,632.699us,632.7us,632.749us,632.75us,632.799us,632.8us,632.849us,632.85us,632.899us,632.9us,632.949us,632.95us,632.999us,633us,633.049us,633.05us,633.099us,633.1us,633.149us,633.15us,633.199us,633.2us,633.249us,633.25us,633.299us,633.3us,633.349us,633.35us,633.399us,633.4us,633.449us,633.45us,633.499us,633.5us,633.549us,633.55us,633.599us,633.6us,633.649us,633.65us,633.699us,633.7us,633.749us,633.75us,633.799us,633.8us,633.849us,633.85us,633.899us,633.9us,633.949us,633.95us,633.999us,634us,634.049us,634.05us,634.099us,634.1us,634.149us,634.15us,634.199us,634.2us,634.249us,634.25us,634.299us,634.3us,634.349us,634.35us,634.399us,634.4us,634.449us,634.45us,634.499us,634.5us,634.549us,634.55us,634.599us,634.6us,634.649us,634.65us,634.699us,634.7us,634.749us,634.75us,634.799us,634.8us,634.849us,634.85us,634.899us,634.9us,634.949us,634.95us,634.999us,635us,635.049us,635.05us,635.099us,635.1us,635.149us,635.15us,635.199us,635.2us,635.249us,635.25us,635.299us,635.3us,635.349us,635.35us,635.399us,635.4us,635.449us,635.45us,635.499us,635.5us,635.549us,635.55us,635.599us,635.6us,635.649us,635.65us,635.699us,635.7us,635.749us,635.75us,635.799us,635.8us,635.849us,635.85us,635.899us,635.9us,635.949us,635.95us,635.999us,636us,636.049us,636.05us,636.099us,636.1us,636.149us,636.15us,636.199us,636.2us,636.249us,636.25us,636.299us,636.3us,636.349us,636.35us,636.399us,636.4us,636.449us,636.45us,636.499us,636.5us,636.549us,636.55us,636.599us,636.6us,636.649us,636.65us,636.699us,636.7us,636.749us,636.75us,636.799us,636.8us,636.849us,636.85us,636.899us,636.9us,636.949us,636.95us,636.999us,637us,637.049us,637.05us,637.099us,637.1us,637.149us,637.15us,637.199us,637.2us,637.249us,637.25us,637.299us,637.3us,637.349us,637.35us,637.399us,637.4us,637.449us,637.45us,637.499us,637.5us,637.549us,637.55us,637.599us,637.6us,637.649us,637.65us,637.699us,637.7us,637.749us,637.75us,637.799us,637.8us,637.849us,637.85us,637.899us,637.9us,637.949us,637.95us,637.999us,638us,638.049us,638.05us,638.099us,638.1us,638.149us,638.15us,638.199us,638.2us,638.249us,638.25us,638.299us,638.3us,638.349us,638.35us,638.399us,638.4us,638.449us,638.45us,638.499us,638.5us,638.549us,638.55us,638.599us,638.6us,638.649us,638.65us,638.699us,638.7us,638.749us,638.75us,638.799us,638.8us,638.849us,638.85us,638.899us,638.9us,638.949us,638.95us,638.999us,639us,639.049us,639.05us,639.099us,639.1us,639.149us,639.15us,639.199us,639.2us,639.249us,639.25us,639.299us,639.3us,639.349us,639.35us,639.399us,639.4us,639.449us,639.45us,639.499us,639.5us,639.549us,639.55us,639.599us,639.6us,639.649us,639.65us,639.699us,639.7us,639.749us,639.75us,639.799us,639.8us,639.849us,639.85us,639.899us,639.9us,639.949us,639.95us,639.999us,640us,640.049us,640.05us,640.099us,640.1us,640.149us,640.15us,640.199us,640.2us,640.249us,640.25us,640.299us,640.3us,640.349us,640.35us,640.399us,640.4us,640.449us,640.45us,640.499us,640.5us,640.549us,640.55us,640.599us,640.6us,640.649us,640.65us,640.699us,640.7us,640.749us,640.75us,640.799us,640.8us,640.849us,640.85us,640.899us,640.9us,640.949us,640.95us,640.999us,641us,641.049us,641.05us,641.099us,641.1us,641.149us,641.15us,641.199us,641.2us,641.249us,641.25us,641.299us,641.3us,641.349us,641.35us,641.399us,641.4us,641.449us,641.45us,641.499us,641.5us,641.549us,641.55us,641.599us,641.6us,641.649us,641.65us,641.699us,641.7us,641.749us,641.75us,641.799us,641.8us,641.849us,641.85us,641.899us,641.9us,641.949us,641.95us,641.999us,642us,642.049us,642.05us,642.099us,642.1us,642.149us,642.15us,642.199us,642.2us,642.249us,642.25us,642.299us,642.3us,642.349us,642.35us,642.399us,642.4us,642.449us,642.45us,642.499us,642.5us,642.549us,642.55us,642.599us,642.6us,642.649us,642.65us,642.699us,642.7us,642.749us,642.75us,642.799us,642.8us,642.849us,642.85us,642.899us,642.9us,642.949us,642.95us,642.999us,643us,643.049us,643.05us,643.099us,643.1us,643.149us,643.15us,643.199us,643.2us,643.249us,643.25us,643.299us,643.3us,643.349us,643.35us,643.399us,643.4us,643.449us,643.45us,643.499us,643.5us,643.549us,643.55us,643.599us,643.6us,643.649us,643.65us,643.699us,643.7us,643.749us,643.75us,643.799us,643.8us,643.849us,643.85us,643.899us,643.9us,643.949us,643.95us,643.999us,644us,644.049us,644.05us,644.099us,644.1us,644.149us,644.15us,644.199us,644.2us,644.249us,644.25us,644.299us,644.3us,644.349us,644.35us,644.399us,644.4us,644.449us,644.45us,644.499us,644.5us,644.549us,644.55us,644.599us,644.6us,644.649us,644.65us,644.699us,644.7us,644.749us,644.75us,644.799us,644.8us,644.849us,644.85us,644.899us,644.9us,644.949us,644.95us,644.999us,645us,645.049us,645.05us,645.099us,645.1us,645.149us,645.15us,645.199us,645.2us,645.249us,645.25us,645.299us,645.3us,645.349us,645.35us,645.399us,645.4us,645.449us,645.45us,645.499us,645.5us,645.549us,645.55us,645.599us,645.6us,645.649us,645.65us,645.699us,645.7us,645.749us,645.75us,645.799us,645.8us,645.849us,645.85us,645.899us,645.9us,645.949us,645.95us,645.999us,646us,646.049us,646.05us,646.099us,646.1us,646.149us,646.15us,646.199us,646.2us,646.249us,646.25us,646.299us,646.3us,646.349us,646.35us,646.399us,646.4us,646.449us,646.45us,646.499us,646.5us,646.549us,646.55us,646.599us,646.6us,646.649us,646.65us,646.699us,646.7us,646.749us,646.75us,646.799us,646.8us,646.849us,646.85us,646.899us,646.9us,646.949us,646.95us,646.999us,647us,647.049us,647.05us,647.099us,647.1us,647.149us,647.15us,647.199us,647.2us,647.249us,647.25us,647.299us,647.3us,647.349us,647.35us,647.399us,647.4us,647.449us,647.45us,647.499us,647.5us,647.549us,647.55us,647.599us,647.6us,647.649us,647.65us,647.699us,647.7us,647.749us,647.75us,647.799us,647.8us,647.849us,647.85us,647.899us,647.9us,647.949us,647.95us,647.999us,648us,648.049us,648.05us,648.099us,648.1us,648.149us,648.15us,648.199us,648.2us,648.249us,648.25us,648.299us,648.3us,648.349us,648.35us,648.399us,648.4us,648.449us,648.45us,648.499us,648.5us,648.549us,648.55us,648.599us,648.6us,648.649us,648.65us,648.699us,648.7us,648.749us,648.75us,648.799us,648.8us,648.849us,648.85us,648.899us,648.9us,648.949us,648.95us,648.999us,649us,649.049us,649.05us,649.099us,649.1us,649.149us,649.15us,649.199us,649.2us,649.249us,649.25us,649.299us,649.3us,649.349us,649.35us,649.399us,649.4us,649.449us,649.45us,649.499us,649.5us,649.549us,649.55us,649.599us,649.6us,649.649us,649.65us,649.699us,649.7us,649.749us,649.75us,649.799us,649.8us,649.849us,649.85us,649.899us,649.9us,649.949us,649.95us,649.999us,650us,650.049us,650.05us,650.099us,650.1us,650.149us,650.15us,650.199us,650.2us,650.249us,650.25us,650.299us,650.3us,650.349us,650.35us,650.399us,650.4us,650.449us,650.45us,650.499us,650.5us,650.549us,650.55us,650.599us,650.6us,650.649us,650.65us,650.699us,650.7us,650.749us,650.75us,650.799us,650.8us,650.849us,650.85us,650.899us,650.9us,650.949us,650.95us,650.999us,651us,651.049us,651.05us,651.099us,651.1us,651.149us,651.15us,651.199us,651.2us,651.249us,651.25us,651.299us,651.3us,651.349us,651.35us,651.399us,651.4us,651.449us,651.45us,651.499us,651.5us,651.549us,651.55us,651.599us,651.6us,651.649us,651.65us,651.699us,651.7us,651.749us,651.75us,651.799us,651.8us,651.849us,651.85us,651.899us,651.9us,651.949us,651.95us,651.999us,652us,652.049us,652.05us,652.099us,652.1us,652.149us,652.15us,652.199us,652.2us,652.249us,652.25us,652.299us,652.3us,652.349us,652.35us,652.399us,652.4us,652.449us,652.45us,652.499us,652.5us,652.549us,652.55us,652.599us,652.6us,652.649us,652.65us,652.699us,652.7us,652.749us,652.75us,652.799us,652.8us,652.849us,652.85us,652.899us,652.9us,652.949us,652.95us,652.999us,653us,653.049us,653.05us,653.099us,653.1us,653.149us,653.15us,653.199us,653.2us,653.249us,653.25us,653.299us,653.3us,653.349us,653.35us,653.399us,653.4us,653.449us,653.45us,653.499us,653.5us,653.549us,653.55us,653.599us,653.6us,653.649us,653.65us,653.699us,653.7us,653.749us,653.75us,653.799us,653.8us,653.849us,653.85us,653.899us,653.9us,653.949us,653.95us,653.999us,654us,654.049us,654.05us,654.099us,654.1us,654.149us,654.15us,654.199us,654.2us,654.249us,654.25us,654.299us,654.3us,654.349us,654.35us,654.399us,654.4us,654.449us,654.45us,654.499us,654.5us,654.549us,654.55us,654.599us,654.6us,654.649us,654.65us,654.699us,654.7us,654.749us,654.75us,654.799us,654.8us,654.849us,654.85us,654.899us,654.9us,654.949us,654.95us,654.999us,655us,655.049us,655.05us,655.099us,655.1us,655.149us,655.15us,655.199us,655.2us,655.249us,655.25us,655.299us,655.3us,655.349us,655.35us,655.399us,655.4us,655.449us,655.45us,655.499us,655.5us,655.549us,655.55us,655.599us,655.6us,655.649us,655.65us,655.699us,655.7us,655.749us,655.75us,655.799us,655.8us,655.849us,655.85us,655.899us,655.9us,655.949us,655.95us,655.999us,656us,656.049us,656.05us,656.099us,656.1us,656.149us,656.15us,656.199us,656.2us,656.249us,656.25us,656.299us,656.3us,656.349us,656.35us,656.399us,656.4us,656.449us,656.45us,656.499us,656.5us,656.549us,656.55us,656.599us,656.6us,656.649us,656.65us,656.699us,656.7us,656.749us,656.75us,656.799us,656.8us,656.849us,656.85us,656.899us,656.9us,656.949us,656.95us,656.999us,657us,657.049us,657.05us,657.099us,657.1us,657.149us,657.15us,657.199us,657.2us,657.249us,657.25us,657.299us,657.3us,657.349us,657.35us,657.399us,657.4us,657.449us,657.45us,657.499us,657.5us,657.549us,657.55us,657.599us,657.6us,657.649us,657.65us,657.699us,657.7us,657.749us,657.75us,657.799us,657.8us,657.849us,657.85us,657.899us,657.9us,657.949us,657.95us,657.999us,658us,658.049us,658.05us,658.099us,658.1us,658.149us,658.15us,658.199us,658.2us,658.249us,658.25us,658.299us,658.3us,658.349us,658.35us,658.399us,658.4us,658.449us,658.45us,658.499us,658.5us,658.549us,658.55us,658.599us,658.6us,658.649us,658.65us,658.699us,658.7us,658.749us,658.75us,658.799us,658.8us,658.849us,658.85us,658.899us,658.9us,658.949us,658.95us,658.999us,659us,659.049us,659.05us,659.099us,659.1us,659.149us,659.15us,659.199us,659.2us,659.249us,659.25us,659.299us,659.3us,659.349us,659.35us,659.399us,659.4us,659.449us,659.45us,659.499us,659.5us,659.549us,659.55us,659.599us,659.6us,659.649us,659.65us,659.699us,659.7us,659.749us,659.75us,659.799us,659.8us,659.849us,659.85us,659.899us,659.9us,659.949us,659.95us,659.999us,660us,660.049us,660.05us,660.099us,660.1us,660.149us,660.15us,660.199us,660.2us,660.249us,660.25us,660.299us,660.3us,660.349us,660.35us,660.399us,660.4us,660.449us,660.45us,660.499us,660.5us,660.549us,660.55us,660.599us,660.6us,660.649us,660.65us,660.699us,660.7us,660.749us,660.75us,660.799us,660.8us,660.849us,660.85us,660.899us,660.9us,660.949us,660.95us,660.999us,661us,661.049us,661.05us,661.099us,661.1us,661.149us,661.15us,661.199us,661.2us,661.249us,661.25us,661.299us,661.3us,661.349us,661.35us,661.399us,661.4us,661.449us,661.45us,661.499us,661.5us,661.549us,661.55us,661.599us,661.6us,661.649us,661.65us,661.699us,661.7us,661.749us,661.75us,661.799us,661.8us,661.849us,661.85us,661.899us,661.9us,661.949us,661.95us,661.999us,662us,662.049us,662.05us,662.099us,662.1us,662.149us,662.15us,662.199us,662.2us,662.249us,662.25us,662.299us,662.3us,662.349us,662.35us,662.399us,662.4us,662.449us,662.45us,662.499us,662.5us,662.549us,662.55us,662.599us,662.6us,662.649us,662.65us,662.699us,662.7us,662.749us,662.75us,662.799us,662.8us,662.849us,662.85us,662.899us,662.9us,662.949us,662.95us,662.999us,663us,663.049us,663.05us,663.099us,663.1us,663.149us,663.15us,663.199us,663.2us,663.249us,663.25us,663.299us,663.3us,663.349us,663.35us,663.399us,663.4us,663.449us,663.45us,663.499us,663.5us,663.549us,663.55us,663.599us,663.6us,663.649us,663.65us,663.699us,663.7us,663.749us,663.75us,663.799us,663.8us,663.849us,663.85us,663.899us,663.9us,663.949us,663.95us,663.999us,664us,664.049us,664.05us,664.099us,664.1us,664.149us,664.15us,664.199us,664.2us,664.249us,664.25us,664.299us,664.3us,664.349us,664.35us,664.399us,664.4us,664.449us,664.45us,664.499us,664.5us,664.549us,664.55us,664.599us,664.6us,664.649us,664.65us,664.699us,664.7us,664.749us,664.75us,664.799us,664.8us,664.849us,664.85us,664.899us,664.9us,664.949us,664.95us,664.999us,665us,665.049us,665.05us,665.099us,665.1us,665.149us,665.15us,665.199us,665.2us,665.249us,665.25us,665.299us,665.3us,665.349us,665.35us,665.399us,665.4us,665.449us,665.45us,665.499us,665.5us,665.549us,665.55us,665.599us,665.6us,665.649us,665.65us,665.699us,665.7us,665.749us,665.75us,665.799us,665.8us,665.849us,665.85us,665.899us,665.9us,665.949us,665.95us,665.999us,666us,666.049us,666.05us,666.099us,666.1us,666.149us,666.15us,666.199us,666.2us,666.249us,666.25us,666.299us,666.3us,666.349us,666.35us,666.399us,666.4us,666.449us,666.45us,666.499us,666.5us,666.549us,666.55us,666.599us,666.6us,666.649us,666.65us,666.699us,666.7us,666.749us,666.75us,666.799us,666.8us,666.849us,666.85us,666.899us,666.9us,666.949us,666.95us,666.999us,667us,667.049us,667.05us,667.099us,667.1us,667.149us,667.15us,667.199us,667.2us,667.249us,667.25us,667.299us,667.3us,667.349us,667.35us,667.399us,667.4us,667.449us,667.45us,667.499us,667.5us,667.549us,667.55us,667.599us,667.6us,667.649us,667.65us,667.699us,667.7us,667.749us,667.75us,667.799us,667.8us,667.849us,667.85us,667.899us,667.9us,667.949us,667.95us,667.999us,668us,668.049us,668.05us,668.099us,668.1us,668.149us,668.15us,668.199us,668.2us,668.249us,668.25us,668.299us,668.3us,668.349us,668.35us,668.399us,668.4us,668.449us,668.45us,668.499us,668.5us,668.549us,668.55us,668.599us,668.6us,668.649us,668.65us,668.699us,668.7us,668.749us,668.75us,668.799us,668.8us,668.849us,668.85us,668.899us,668.9us,668.949us,668.95us,668.999us,669us,669.049us,669.05us,669.099us,669.1us,669.149us,669.15us,669.199us,669.2us,669.249us,669.25us,669.299us,669.3us,669.349us,669.35us,669.399us,669.4us,669.449us,669.45us,669.499us,669.5us,669.549us,669.55us,669.599us,669.6us,669.649us,669.65us,669.699us,669.7us,669.749us,669.75us,669.799us,669.8us,669.849us,669.85us,669.899us,669.9us,669.949us,669.95us,669.999us,670us,670.049us,670.05us,670.099us,670.1us,670.149us,670.15us,670.199us,670.2us,670.249us,670.25us,670.299us,670.3us,670.349us,670.35us,670.399us,670.4us,670.449us,670.45us,670.499us,670.5us,670.549us,670.55us,670.599us,670.6us,670.649us,670.65us,670.699us,670.7us,670.749us,670.75us,670.799us,670.8us,670.849us,670.85us,670.899us,670.9us,670.949us,670.95us,670.999us,671us,671.049us,671.05us,671.099us,671.1us,671.149us,671.15us,671.199us,671.2us,671.249us,671.25us,671.299us,671.3us,671.349us,671.35us,671.399us,671.4us,671.449us,671.45us,671.499us,671.5us,671.549us,671.55us,671.599us,671.6us,671.649us,671.65us,671.699us,671.7us,671.749us,671.75us,671.799us,671.8us,671.849us,671.85us,671.899us,671.9us,671.949us,671.95us,671.999us,672us,672.049us,672.05us,672.099us,672.1us,672.149us,672.15us,672.199us,672.2us,672.249us,672.25us,672.299us,672.3us,672.349us,672.35us,672.399us,672.4us,672.449us,672.45us,672.499us,672.5us,672.549us,672.55us,672.599us,672.6us,672.649us,672.65us,672.699us,672.7us,672.749us,672.75us,672.799us,672.8us,672.849us,672.85us,672.899us,672.9us,672.949us,672.95us,672.999us,673us,673.049us,673.05us,673.099us,673.1us,673.149us,673.15us,673.199us,673.2us,673.249us,673.25us,673.299us,673.3us,673.349us,673.35us,673.399us,673.4us,673.449us,673.45us,673.499us,673.5us,673.549us,673.55us,673.599us,673.6us,673.649us,673.65us,673.699us,673.7us,673.749us,673.75us,673.799us,673.8us,673.849us,673.85us,673.899us,673.9us,673.949us,673.95us,673.999us,674us,674.049us,674.05us,674.099us,674.1us,674.149us,674.15us,674.199us,674.2us,674.249us,674.25us,674.299us,674.3us,674.349us,674.35us,674.399us,674.4us,674.449us,674.45us,674.499us,674.5us,674.549us,674.55us,674.599us,674.6us,674.649us,674.65us,674.699us,674.7us,674.749us,674.75us,674.799us,674.8us,674.849us,674.85us,674.899us,674.9us,674.949us,674.95us,674.999us,675us,675.049us,675.05us,675.099us,675.1us,675.149us,675.15us,675.199us,675.2us,675.249us,675.25us,675.299us,675.3us,675.349us,675.35us,675.399us,675.4us,675.449us,675.45us,675.499us,675.5us,675.549us,675.55us,675.599us,675.6us,675.649us,675.65us,675.699us,675.7us,675.749us,675.75us,675.799us,675.8us,675.849us,675.85us,675.899us,675.9us,675.949us,675.95us,675.999us,676us,676.049us,676.05us,676.099us,676.1us,676.149us,676.15us,676.199us,676.2us,676.249us,676.25us,676.299us,676.3us,676.349us,676.35us,676.399us,676.4us,676.449us,676.45us,676.499us,676.5us,676.549us,676.55us,676.599us,676.6us,676.649us,676.65us,676.699us,676.7us,676.749us,676.75us,676.799us,676.8us,676.849us,676.85us,676.899us,676.9us,676.949us,676.95us,676.999us,677us,677.049us,677.05us,677.099us,677.1us,677.149us,677.15us,677.199us,677.2us,677.249us,677.25us,677.299us,677.3us,677.349us,677.35us,677.399us,677.4us,677.449us,677.45us,677.499us,677.5us,677.549us,677.55us,677.599us,677.6us,677.649us,677.65us,677.699us,677.7us,677.749us,677.75us,677.799us,677.8us,677.849us,677.85us,677.899us,677.9us,677.949us,677.95us,677.999us,678us,678.049us,678.05us,678.099us,678.1us,678.149us,678.15us,678.199us,678.2us,678.249us,678.25us,678.299us,678.3us,678.349us,678.35us,678.399us,678.4us,678.449us,678.45us,678.499us,678.5us,678.549us,678.55us,678.599us,678.6us,678.649us,678.65us,678.699us,678.7us,678.749us,678.75us,678.799us,678.8us,678.849us,678.85us,678.899us,678.9us,678.949us,678.95us,678.999us,679us,679.049us,679.05us,679.099us,679.1us,679.149us,679.15us,679.199us,679.2us,679.249us,679.25us,679.299us,679.3us,679.349us,679.35us,679.399us,679.4us,679.449us,679.45us,679.499us,679.5us,679.549us,679.55us,679.599us,679.6us,679.649us,679.65us,679.699us,679.7us,679.749us,679.75us,679.799us,679.8us,679.849us,679.85us,679.899us,679.9us,679.949us,679.95us,679.999us,680us,680.049us,680.05us,680.099us,680.1us,680.149us,680.15us,680.199us,680.2us,680.249us,680.25us,680.299us,680.3us,680.349us,680.35us,680.399us,680.4us,680.449us,680.45us,680.499us,680.5us,680.549us,680.55us,680.599us,680.6us,680.649us,680.65us,680.699us,680.7us,680.749us,680.75us,680.799us,680.8us,680.849us,680.85us,680.899us,680.9us,680.949us,680.95us,680.999us,681us,681.049us,681.05us,681.099us,681.1us,681.149us,681.15us,681.199us,681.2us,681.249us,681.25us,681.299us,681.3us,681.349us,681.35us,681.399us,681.4us,681.449us,681.45us,681.499us,681.5us,681.549us,681.55us,681.599us,681.6us,681.649us,681.65us,681.699us,681.7us,681.749us,681.75us,681.799us,681.8us,681.849us,681.85us,681.899us,681.9us,681.949us,681.95us,681.999us,682us,682.049us,682.05us,682.099us,682.1us,682.149us,682.15us,682.199us,682.2us,682.249us,682.25us,682.299us,682.3us,682.349us,682.35us,682.399us,682.4us,682.449us,682.45us,682.499us,682.5us,682.549us,682.55us,682.599us,682.6us,682.649us,682.65us,682.699us,682.7us,682.749us,682.75us,682.799us,682.8us,682.849us,682.85us,682.899us,682.9us,682.949us,682.95us,682.999us,683us,683.049us,683.05us,683.099us,683.1us,683.149us,683.15us,683.199us,683.2us,683.249us,683.25us,683.299us,683.3us,683.349us,683.35us,683.399us,683.4us,683.449us,683.45us,683.499us,683.5us,683.549us,683.55us,683.599us,683.6us,683.649us,683.65us,683.699us,683.7us,683.749us,683.75us,683.799us,683.8us,683.849us,683.85us,683.899us,683.9us,683.949us,683.95us,683.999us,684us,684.049us,684.05us,684.099us,684.1us,684.149us,684.15us,684.199us,684.2us,684.249us,684.25us,684.299us,684.3us,684.349us,684.35us,684.399us,684.4us,684.449us,684.45us,684.499us,684.5us,684.549us,684.55us,684.599us,684.6us,684.649us,684.65us,684.699us,684.7us,684.749us,684.75us,684.799us,684.8us,684.849us,684.85us,684.899us,684.9us,684.949us,684.95us,684.999us,685us,685.049us,685.05us,685.099us,685.1us,685.149us,685.15us,685.199us,685.2us,685.249us,685.25us,685.299us,685.3us,685.349us,685.35us,685.399us,685.4us,685.449us,685.45us,685.499us,685.5us,685.549us,685.55us,685.599us,685.6us,685.649us,685.65us,685.699us,685.7us,685.749us,685.75us,685.799us,685.8us,685.849us,685.85us,685.899us,685.9us,685.949us,685.95us,685.999us,686us,686.049us,686.05us,686.099us,686.1us,686.149us,686.15us,686.199us,686.2us,686.249us,686.25us,686.299us,686.3us,686.349us,686.35us,686.399us,686.4us,686.449us,686.45us,686.499us,686.5us,686.549us,686.55us,686.599us,686.6us,686.649us,686.65us,686.699us,686.7us,686.749us,686.75us,686.799us,686.8us,686.849us,686.85us,686.899us,686.9us,686.949us,686.95us,686.999us,687us,687.049us,687.05us,687.099us,687.1us,687.149us,687.15us,687.199us,687.2us,687.249us,687.25us,687.299us,687.3us,687.349us,687.35us,687.399us,687.4us,687.449us,687.45us,687.499us,687.5us,687.549us,687.55us,687.599us,687.6us,687.649us,687.65us,687.699us,687.7us,687.749us,687.75us,687.799us,687.8us,687.849us,687.85us,687.899us,687.9us,687.949us,687.95us,687.999us,688us,688.049us,688.05us,688.099us,688.1us,688.149us,688.15us,688.199us,688.2us,688.249us,688.25us,688.299us,688.3us,688.349us,688.35us,688.399us,688.4us,688.449us,688.45us,688.499us,688.5us,688.549us,688.55us,688.599us,688.6us,688.649us,688.65us,688.699us,688.7us,688.749us,688.75us,688.799us,688.8us,688.849us,688.85us,688.899us,688.9us,688.949us,688.95us,688.999us,689us,689.049us,689.05us,689.099us,689.1us,689.149us,689.15us,689.199us,689.2us,689.249us,689.25us,689.299us,689.3us,689.349us,689.35us,689.399us,689.4us,689.449us,689.45us,689.499us,689.5us,689.549us,689.55us,689.599us,689.6us,689.649us,689.65us,689.699us,689.7us,689.749us,689.75us,689.799us,689.8us,689.849us,689.85us,689.899us,689.9us,689.949us,689.95us,689.999us,690us,690.049us,690.05us,690.099us,690.1us,690.149us,690.15us,690.199us,690.2us,690.249us,690.25us,690.299us,690.3us,690.349us,690.35us,690.399us,690.4us,690.449us,690.45us,690.499us,690.5us,690.549us,690.55us,690.599us,690.6us,690.649us,690.65us,690.699us,690.7us,690.749us,690.75us,690.799us,690.8us,690.849us,690.85us,690.899us,690.9us,690.949us,690.95us,690.999us,691us,691.049us,691.05us,691.099us,691.1us,691.149us,691.15us,691.199us,691.2us,691.249us,691.25us,691.299us,691.3us,691.349us,691.35us,691.399us,691.4us,691.449us,691.45us,691.499us,691.5us,691.549us,691.55us,691.599us,691.6us,691.649us,691.65us,691.699us,691.7us,691.749us,691.75us,691.799us,691.8us,691.849us,691.85us,691.899us,691.9us,691.949us,691.95us,691.999us,692us,692.049us,692.05us,692.099us,692.1us,692.149us,692.15us,692.199us,692.2us,692.249us,692.25us,692.299us,692.3us,692.349us,692.35us,692.399us,692.4us,692.449us,692.45us,692.499us,692.5us,692.549us,692.55us,692.599us,692.6us,692.649us,692.65us,692.699us,692.7us,692.749us,692.75us,692.799us,692.8us,692.849us,692.85us,692.899us,692.9us,692.949us,692.95us,692.999us,693us,693.049us,693.05us,693.099us,693.1us,693.149us,693.15us,693.199us,693.2us,693.249us,693.25us,693.299us,693.3us,693.349us,693.35us,693.399us,693.4us,693.449us,693.45us,693.499us,693.5us,693.549us,693.55us,693.599us,693.6us,693.649us,693.65us,693.699us,693.7us,693.749us,693.75us,693.799us,693.8us,693.849us,693.85us,693.899us,693.9us,693.949us,693.95us,693.999us,694us,694.049us,694.05us,694.099us,694.1us,694.149us,694.15us,694.199us,694.2us,694.249us,694.25us,694.299us,694.3us,694.349us,694.35us,694.399us,694.4us,694.449us,694.45us,694.499us,694.5us,694.549us,694.55us,694.599us,694.6us,694.649us,694.65us,694.699us,694.7us,694.749us,694.75us,694.799us,694.8us,694.849us,694.85us,694.899us,694.9us,694.949us,694.95us,694.999us,695us,695.049us,695.05us,695.099us,695.1us,695.149us,695.15us,695.199us,695.2us,695.249us,695.25us,695.299us,695.3us,695.349us,695.35us,695.399us,695.4us,695.449us,695.45us,695.499us,695.5us,695.549us,695.55us,695.599us,695.6us,695.649us,695.65us,695.699us,695.7us,695.749us,695.75us,695.799us,695.8us,695.849us,695.85us,695.899us,695.9us,695.949us,695.95us,695.999us,696us,696.049us,696.05us,696.099us,696.1us,696.149us,696.15us,696.199us,696.2us,696.249us,696.25us,696.299us,696.3us,696.349us,696.35us,696.399us,696.4us,696.449us,696.45us,696.499us,696.5us,696.549us,696.55us,696.599us,696.6us,696.649us,696.65us,696.699us,696.7us,696.749us,696.75us,696.799us,696.8us,696.849us,696.85us,696.899us,696.9us,696.949us,696.95us,696.999us,697us,697.049us,697.05us,697.099us,697.1us,697.149us,697.15us,697.199us,697.2us,697.249us,697.25us,697.299us,697.3us,697.349us,697.35us,697.399us,697.4us,697.449us,697.45us,697.499us,697.5us,697.549us,697.55us,697.599us,697.6us,697.649us,697.65us,697.699us,697.7us,697.749us,697.75us,697.799us,697.8us,697.849us,697.85us,697.899us,697.9us,697.949us,697.95us,697.999us,698us,698.049us,698.05us,698.099us,698.1us,698.149us,698.15us,698.199us,698.2us,698.249us,698.25us,698.299us,698.3us,698.349us,698.35us,698.399us,698.4us,698.449us,698.45us,698.499us,698.5us,698.549us,698.55us,698.599us,698.6us,698.649us,698.65us,698.699us,698.7us,698.749us,698.75us,698.799us,698.8us,698.849us,698.85us,698.899us,698.9us,698.949us,698.95us,698.999us,699us,699.049us,699.05us,699.099us,699.1us,699.149us,699.15us,699.199us,699.2us,699.249us,699.25us,699.299us,699.3us,699.349us,699.35us,699.399us,699.4us,699.449us,699.45us,699.499us,699.5us,699.549us,699.55us,699.599us,699.6us,699.649us,699.65us,699.699us,699.7us,699.749us,699.75us,699.799us,699.8us,699.849us,699.85us,699.899us,699.9us,699.949us,699.95us,699.999us,700us,700.049us,700.05us,700.099us,700.1us,700.149us,700.15us,700.199us,700.2us,700.249us,700.25us,700.299us,700.3us,700.349us,700.35us,700.399us,700.4us,700.449us,700.45us,700.499us,700.5us,700.549us,700.55us,700.599us,700.6us,700.649us,700.65us,700.699us,700.7us,700.749us,700.75us,700.799us,700.8us,700.849us,700.85us,700.899us,700.9us,700.949us,700.95us,700.999us,701us,701.049us,701.05us,701.099us,701.1us,701.149us,701.15us,701.199us,701.2us,701.249us,701.25us,701.299us,701.3us,701.349us,701.35us,701.399us,701.4us,701.449us,701.45us,701.499us,701.5us,701.549us,701.55us,701.599us,701.6us,701.649us,701.65us,701.699us,701.7us,701.749us,701.75us,701.799us,701.8us,701.849us,701.85us,701.899us,701.9us,701.949us,701.95us,701.999us,702us,702.049us,702.05us,702.099us,702.1us,702.149us,702.15us,702.199us,702.2us,702.249us,702.25us,702.299us,702.3us,702.349us,702.35us,702.399us,702.4us,702.449us,702.45us,702.499us,702.5us,702.549us,702.55us,702.599us,702.6us,702.649us,702.65us,702.699us,702.7us,702.749us,702.75us,702.799us,702.8us,702.849us,702.85us,702.899us,702.9us,702.949us,702.95us,702.999us,703us,703.049us,703.05us,703.099us,703.1us,703.149us,703.15us,703.199us,703.2us,703.249us,703.25us,703.299us,703.3us,703.349us,703.35us,703.399us,703.4us,703.449us,703.45us,703.499us,703.5us,703.549us,703.55us,703.599us,703.6us,703.649us,703.65us,703.699us,703.7us,703.749us,703.75us,703.799us,703.8us,703.849us,703.85us,703.899us,703.9us,703.949us,703.95us,703.999us,704us,704.049us,704.05us,704.099us,704.1us,704.149us,704.15us,704.199us,704.2us,704.249us,704.25us,704.299us,704.3us,704.349us,704.35us,704.399us,704.4us,704.449us,704.45us,704.499us,704.5us,704.549us,704.55us,704.599us,704.6us,704.649us,704.65us,704.699us,704.7us,704.749us,704.75us,704.799us,704.8us,704.849us,704.85us,704.899us,704.9us,704.949us,704.95us,704.999us,705us,705.049us,705.05us,705.099us,705.1us,705.149us,705.15us,705.199us,705.2us,705.249us,705.25us,705.299us,705.3us,705.349us,705.35us,705.399us,705.4us,705.449us,705.45us,705.499us,705.5us,705.549us,705.55us,705.599us,705.6us,705.649us,705.65us,705.699us,705.7us,705.749us,705.75us,705.799us,705.8us,705.849us,705.85us,705.899us,705.9us,705.949us,705.95us,705.999us,706us,706.049us,706.05us,706.099us,706.1us,706.149us,706.15us,706.199us,706.2us,706.249us,706.25us,706.299us,706.3us,706.349us,706.35us,706.399us,706.4us,706.449us,706.45us,706.499us,706.5us,706.549us,706.55us,706.599us,706.6us,706.649us,706.65us,706.699us,706.7us,706.749us,706.75us,706.799us,706.8us,706.849us,706.85us,706.899us,706.9us,706.949us,706.95us,706.999us,707us,707.049us,707.05us,707.099us,707.1us,707.149us,707.15us,707.199us,707.2us,707.249us,707.25us,707.299us,707.3us,707.349us,707.35us,707.399us,707.4us,707.449us,707.45us,707.499us,707.5us,707.549us,707.55us,707.599us,707.6us,707.649us,707.65us,707.699us,707.7us,707.749us,707.75us,707.799us,707.8us,707.849us,707.85us,707.899us,707.9us,707.949us,707.95us,707.999us,708us,708.049us,708.05us,708.099us,708.1us,708.149us,708.15us,708.199us,708.2us,708.249us,708.25us,708.299us,708.3us,708.349us,708.35us,708.399us,708.4us,708.449us,708.45us,708.499us,708.5us,708.549us,708.55us,708.599us,708.6us,708.649us,708.65us,708.699us,708.7us,708.749us,708.75us,708.799us,708.8us,708.849us,708.85us,708.899us,708.9us,708.949us,708.95us,708.999us,709us,709.049us,709.05us,709.099us,709.1us,709.149us,709.15us,709.199us,709.2us,709.249us,709.25us,709.299us,709.3us,709.349us,709.35us,709.399us,709.4us,709.449us,709.45us,709.499us,709.5us,709.549us,709.55us,709.599us,709.6us,709.649us,709.65us,709.699us,709.7us,709.749us,709.75us,709.799us,709.8us,709.849us,709.85us,709.899us,709.9us,709.949us,709.95us,709.999us,710us,710.049us,710.05us,710.099us,710.1us,710.149us,710.15us,710.199us,710.2us,710.249us,710.25us,710.299us,710.3us,710.349us,710.35us,710.399us,710.4us,710.449us,710.45us,710.499us,710.5us,710.549us,710.55us,710.599us,710.6us,710.649us,710.65us,710.699us,710.7us,710.749us,710.75us,710.799us,710.8us,710.849us,710.85us,710.899us,710.9us,710.949us,710.95us,710.999us,711us,711.049us,711.05us,711.099us,711.1us,711.149us,711.15us,711.199us,711.2us,711.249us,711.25us,711.299us,711.3us,711.349us,711.35us,711.399us,711.4us,711.449us,711.45us,711.499us,711.5us,711.549us,711.55us,711.599us,711.6us,711.649us,711.65us,711.699us,711.7us,711.749us,711.75us,711.799us,711.8us,711.849us,711.85us,711.899us,711.9us,711.949us,711.95us,711.999us,712us,712.049us,712.05us,712.099us,712.1us,712.149us,712.15us,712.199us,712.2us,712.249us,712.25us,712.299us,712.3us,712.349us,712.35us,712.399us,712.4us,712.449us,712.45us,712.499us,712.5us,712.549us,712.55us,712.599us,712.6us,712.649us,712.65us,712.699us,712.7us,712.749us,712.75us,712.799us,712.8us,712.849us,712.85us,712.899us,712.9us,712.949us,712.95us,712.999us,713us,713.049us,713.05us,713.099us,713.1us,713.149us,713.15us,713.199us,713.2us,713.249us,713.25us,713.299us,713.3us,713.349us,713.35us,713.399us,713.4us,713.449us,713.45us,713.499us,713.5us,713.549us,713.55us,713.599us,713.6us,713.649us,713.65us,713.699us,713.7us,713.749us,713.75us,713.799us,713.8us,713.849us,713.85us,713.899us,713.9us,713.949us,713.95us,713.999us,714us,714.049us,714.05us,714.099us,714.1us,714.149us,714.15us,714.199us,714.2us,714.249us,714.25us,714.299us,714.3us,714.349us,714.35us,714.399us,714.4us,714.449us,714.45us,714.499us,714.5us,714.549us,714.55us,714.599us,714.6us,714.649us,714.65us,714.699us,714.7us,714.749us,714.75us,714.799us,714.8us,714.849us,714.85us,714.899us,714.9us,714.949us,714.95us,714.999us,715us,715.049us,715.05us,715.099us,715.1us,715.149us,715.15us,715.199us,715.2us,715.249us,715.25us,715.299us,715.3us,715.349us,715.35us,715.399us,715.4us,715.449us,715.45us,715.499us,715.5us,715.549us,715.55us,715.599us,715.6us,715.649us,715.65us,715.699us,715.7us,715.749us,715.75us,715.799us,715.8us,715.849us,715.85us,715.899us,715.9us,715.949us,715.95us,715.999us,716us,716.049us,716.05us,716.099us,716.1us,716.149us,716.15us,716.199us,716.2us,716.249us,716.25us,716.299us,716.3us,716.349us,716.35us,716.399us,716.4us,716.449us,716.45us,716.499us,716.5us,716.549us,716.55us,716.599us,716.6us,716.649us,716.65us,716.699us,716.7us,716.749us,716.75us,716.799us,716.8us,716.849us,716.85us,716.899us,716.9us,716.949us,716.95us,716.999us,717us,717.049us,717.05us,717.099us,717.1us,717.149us,717.15us,717.199us,717.2us,717.249us,717.25us,717.299us,717.3us,717.349us,717.35us,717.399us,717.4us,717.449us,717.45us,717.499us,717.5us,717.549us,717.55us,717.599us,717.6us,717.649us,717.65us,717.699us,717.7us,717.749us,717.75us,717.799us,717.8us,717.849us,717.85us,717.899us,717.9us,717.949us,717.95us,717.999us,718us,718.049us,718.05us,718.099us,718.1us,718.149us,718.15us,718.199us,718.2us,718.249us,718.25us,718.299us,718.3us,718.349us,718.35us,718.399us,718.4us,718.449us,718.45us,718.499us,718.5us,718.549us,718.55us,718.599us,718.6us,718.649us,718.65us,718.699us,718.7us,718.749us,718.75us,718.799us,718.8us,718.849us,718.85us,718.899us,718.9us,718.949us,718.95us,718.999us,719us,719.049us,719.05us,719.099us,719.1us,719.149us,719.15us,719.199us,719.2us,719.249us,719.25us,719.299us,719.3us,719.349us,719.35us,719.399us,719.4us,719.449us,719.45us,719.499us,719.5us,719.549us,719.55us,719.599us,719.6us,719.649us,719.65us,719.699us,719.7us,719.749us,719.75us,719.799us,719.8us,719.849us,719.85us,719.899us,719.9us,719.949us,719.95us,719.999us,720us,720.049us,720.05us,720.099us,720.1us,720.149us,720.15us,720.199us,720.2us,720.249us,720.25us,720.299us,720.3us,720.349us,720.35us,720.399us,720.4us,720.449us,720.45us,720.499us,720.5us,720.549us,720.55us,720.599us,720.6us,720.649us,720.65us,720.699us,720.7us,720.749us,720.75us,720.799us,720.8us,720.849us,720.85us,720.899us,720.9us,720.949us,720.95us,720.999us,721us,721.049us,721.05us,721.099us,721.1us,721.149us,721.15us,721.199us,721.2us,721.249us,721.25us,721.299us,721.3us,721.349us,721.35us,721.399us,721.4us,721.449us,721.45us,721.499us,721.5us,721.549us,721.55us,721.599us,721.6us,721.649us,721.65us,721.699us,721.7us,721.749us,721.75us,721.799us,721.8us,721.849us,721.85us,721.899us,721.9us,721.949us,721.95us,721.999us,722us,722.049us,722.05us,722.099us,722.1us,722.149us,722.15us,722.199us,722.2us,722.249us,722.25us,722.299us,722.3us,722.349us,722.35us,722.399us,722.4us,722.449us,722.45us,722.499us,722.5us,722.549us,722.55us,722.599us,722.6us,722.649us,722.65us,722.699us,722.7us,722.749us,722.75us,722.799us,722.8us,722.849us,722.85us,722.899us,722.9us,722.949us,722.95us,722.999us,723us,723.049us,723.05us,723.099us,723.1us,723.149us,723.15us,723.199us,723.2us,723.249us,723.25us,723.299us,723.3us,723.349us,723.35us,723.399us,723.4us,723.449us,723.45us,723.499us,723.5us,723.549us,723.55us,723.599us,723.6us,723.649us,723.65us,723.699us,723.7us,723.749us,723.75us,723.799us,723.8us,723.849us,723.85us,723.899us,723.9us,723.949us,723.95us,723.999us,724us,724.049us,724.05us,724.099us,724.1us,724.149us,724.15us,724.199us,724.2us,724.249us,724.25us,724.299us,724.3us,724.349us,724.35us,724.399us,724.4us,724.449us,724.45us,724.499us,724.5us,724.549us,724.55us,724.599us,724.6us,724.649us,724.65us,724.699us,724.7us,724.749us,724.75us,724.799us,724.8us,724.849us,724.85us,724.899us,724.9us,724.949us,724.95us,724.999us,725us,725.049us,725.05us,725.099us,725.1us,725.149us,725.15us,725.199us,725.2us,725.249us,725.25us,725.299us,725.3us,725.349us,725.35us,725.399us,725.4us,725.449us,725.45us,725.499us,725.5us,725.549us,725.55us,725.599us,725.6us,725.649us,725.65us,725.699us,725.7us,725.749us,725.75us,725.799us,725.8us,725.849us,725.85us,725.899us,725.9us,725.949us,725.95us,725.999us,726us,726.049us,726.05us,726.099us,726.1us,726.149us,726.15us,726.199us,726.2us,726.249us,726.25us,726.299us,726.3us,726.349us,726.35us,726.399us,726.4us,726.449us,726.45us,726.499us,726.5us,726.549us,726.55us,726.599us,726.6us,726.649us,726.65us,726.699us,726.7us,726.749us,726.75us,726.799us,726.8us,726.849us,726.85us,726.899us,726.9us,726.949us,726.95us,726.999us,727us,727.049us,727.05us,727.099us,727.1us,727.149us,727.15us,727.199us,727.2us,727.249us,727.25us,727.299us,727.3us,727.349us,727.35us,727.399us,727.4us,727.449us,727.45us,727.499us,727.5us,727.549us,727.55us,727.599us,727.6us,727.649us,727.65us,727.699us,727.7us,727.749us,727.75us,727.799us,727.8us,727.849us,727.85us,727.899us,727.9us,727.949us,727.95us,727.999us,728us,728.049us,728.05us,728.099us,728.1us,728.149us,728.15us,728.199us,728.2us,728.249us,728.25us,728.299us,728.3us,728.349us,728.35us,728.399us,728.4us,728.449us,728.45us,728.499us,728.5us,728.549us,728.55us,728.599us,728.6us,728.649us,728.65us,728.699us,728.7us,728.749us,728.75us,728.799us,728.8us,728.849us,728.85us,728.899us,728.9us,728.949us,728.95us,728.999us,729us,729.049us,729.05us,729.099us,729.1us,729.149us,729.15us,729.199us,729.2us,729.249us,729.25us,729.299us,729.3us,729.349us,729.35us,729.399us,729.4us,729.449us,729.45us,729.499us,729.5us,729.549us,729.55us,729.599us,729.6us,729.649us,729.65us,729.699us,729.7us,729.749us,729.75us,729.799us,729.8us,729.849us,729.85us,729.899us,729.9us,729.949us,729.95us,729.999us,730us,730.049us,730.05us,730.099us,730.1us,730.149us,730.15us,730.199us,730.2us,730.249us,730.25us,730.299us,730.3us,730.349us,730.35us,730.399us,730.4us,730.449us,730.45us,730.499us,730.5us,730.549us,730.55us,730.599us,730.6us,730.649us,730.65us,730.699us,730.7us,730.749us,730.75us,730.799us,730.8us,730.849us,730.85us,730.899us,730.9us,730.949us,730.95us,730.999us,731us,731.049us,731.05us,731.099us,731.1us,731.149us,731.15us,731.199us,731.2us,731.249us,731.25us,731.299us,731.3us,731.349us,731.35us,731.399us,731.4us,731.449us,731.45us,731.499us,731.5us,731.549us,731.55us,731.599us,731.6us,731.649us,731.65us,731.699us,731.7us,731.749us,731.75us,731.799us,731.8us,731.849us,731.85us,731.899us,731.9us,731.949us,731.95us,731.999us,732us,732.049us,732.05us,732.099us,732.1us,732.149us,732.15us,732.199us,732.2us,732.249us,732.25us,732.299us,732.3us,732.349us,732.35us,732.399us,732.4us,732.449us,732.45us,732.499us,732.5us,732.549us,732.55us,732.599us,732.6us,732.649us,732.65us,732.699us,732.7us,732.749us,732.75us,732.799us,732.8us,732.849us,732.85us,732.899us,732.9us,732.949us,732.95us,732.999us,733us,733.049us,733.05us,733.099us,733.1us,733.149us,733.15us,733.199us,733.2us,733.249us,733.25us,733.299us,733.3us,733.349us,733.35us,733.399us,733.4us,733.449us,733.45us,733.499us,733.5us,733.549us,733.55us,733.599us,733.6us,733.649us,733.65us,733.699us,733.7us,733.749us,733.75us,733.799us,733.8us,733.849us,733.85us,733.899us,733.9us,733.949us,733.95us,733.999us,734us,734.049us,734.05us,734.099us,734.1us,734.149us,734.15us,734.199us,734.2us,734.249us,734.25us,734.299us,734.3us,734.349us,734.35us,734.399us,734.4us,734.449us,734.45us,734.499us,734.5us,734.549us,734.55us,734.599us,734.6us,734.649us,734.65us,734.699us,734.7us,734.749us,734.75us,734.799us,734.8us,734.849us,734.85us,734.899us,734.9us,734.949us,734.95us,734.999us,735us,735.049us,735.05us,735.099us,735.1us,735.149us,735.15us,735.199us,735.2us,735.249us,735.25us,735.299us,735.3us,735.349us,735.35us,735.399us,735.4us,735.449us,735.45us,735.499us,735.5us,735.549us,735.55us,735.599us,735.6us,735.649us,735.65us,735.699us,735.7us,735.749us,735.75us,735.799us,735.8us,735.849us,735.85us,735.899us,735.9us,735.949us,735.95us,735.999us,736us,736.049us,736.05us,736.099us,736.1us,736.149us,736.15us,736.199us,736.2us,736.249us,736.25us,736.299us,736.3us,736.349us,736.35us,736.399us,736.4us,736.449us,736.45us,736.499us,736.5us,736.549us,736.55us,736.599us,736.6us,736.649us,736.65us,736.699us,736.7us,736.749us,736.75us,736.799us,736.8us,736.849us,736.85us,736.899us,736.9us,736.949us,736.95us,736.999us,737us,737.049us,737.05us,737.099us,737.1us,737.149us,737.15us,737.199us,737.2us,737.249us,737.25us,737.299us,737.3us,737.349us,737.35us,737.399us,737.4us,737.449us,737.45us,737.499us,737.5us,737.549us,737.55us,737.599us,737.6us,737.649us,737.65us,737.699us,737.7us,737.749us,737.75us,737.799us,737.8us,737.849us,737.85us,737.899us,737.9us,737.949us,737.95us,737.999us,738us,738.049us,738.05us,738.099us,738.1us,738.149us,738.15us,738.199us,738.2us,738.249us,738.25us,738.299us,738.3us,738.349us,738.35us,738.399us,738.4us,738.449us,738.45us,738.499us,738.5us,738.549us,738.55us,738.599us,738.6us,738.649us,738.65us,738.699us,738.7us,738.749us,738.75us,738.799us,738.8us,738.849us,738.85us,738.899us,738.9us,738.949us,738.95us,738.999us,739us,739.049us,739.05us,739.099us,739.1us,739.149us,739.15us,739.199us,739.2us,739.249us,739.25us,739.299us,739.3us,739.349us,739.35us,739.399us,739.4us,739.449us,739.45us,739.499us,739.5us,739.549us,739.55us,739.599us,739.6us,739.649us,739.65us,739.699us,739.7us,739.749us,739.75us,739.799us,739.8us,739.849us,739.85us,739.899us,739.9us,739.949us,739.95us,739.999us,740us,740.049us,740.05us,740.099us,740.1us,740.149us,740.15us,740.199us,740.2us,740.249us,740.25us,740.299us,740.3us,740.349us,740.35us,740.399us,740.4us,740.449us,740.45us,740.499us,740.5us,740.549us,740.55us,740.599us,740.6us,740.649us,740.65us,740.699us,740.7us,740.749us,740.75us,740.799us,740.8us,740.849us,740.85us,740.899us,740.9us,740.949us,740.95us,740.999us,741us,741.049us,741.05us,741.099us,741.1us,741.149us,741.15us,741.199us,741.2us,741.249us,741.25us,741.299us,741.3us,741.349us,741.35us,741.399us,741.4us,741.449us,741.45us,741.499us,741.5us,741.549us,741.55us,741.599us,741.6us,741.649us,741.65us,741.699us,741.7us,741.749us,741.75us,741.799us,741.8us,741.849us,741.85us,741.899us,741.9us,741.949us,741.95us,741.999us,742us,742.049us,742.05us,742.099us,742.1us,742.149us,742.15us,742.199us,742.2us,742.249us,742.25us,742.299us,742.3us,742.349us,742.35us,742.399us,742.4us,742.449us,742.45us,742.499us,742.5us,742.549us,742.55us,742.599us,742.6us,742.649us,742.65us,742.699us,742.7us,742.749us,742.75us,742.799us,742.8us,742.849us,742.85us,742.899us,742.9us,742.949us,742.95us,742.999us,743us,743.049us,743.05us,743.099us,743.1us,743.149us,743.15us,743.199us,743.2us,743.249us,743.25us,743.299us,743.3us,743.349us,743.35us,743.399us,743.4us,743.449us,743.45us,743.499us,743.5us,743.549us,743.55us,743.599us,743.6us,743.649us,743.65us,743.699us,743.7us,743.749us,743.75us,743.799us,743.8us,743.849us,743.85us,743.899us,743.9us,743.949us,743.95us,743.999us,744us,744.049us,744.05us,744.099us,744.1us,744.149us,744.15us,744.199us,744.2us,744.249us,744.25us,744.299us,744.3us,744.349us,744.35us,744.399us,744.4us,744.449us,744.45us,744.499us,744.5us,744.549us,744.55us,744.599us,744.6us,744.649us,744.65us,744.699us,744.7us,744.749us,744.75us,744.799us,744.8us,744.849us,744.85us,744.899us,744.9us,744.949us,744.95us,744.999us,745us,745.049us,745.05us,745.099us,745.1us,745.149us,745.15us,745.199us,745.2us,745.249us,745.25us,745.299us,745.3us,745.349us,745.35us,745.399us,745.4us,745.449us,745.45us,745.499us,745.5us,745.549us,745.55us,745.599us,745.6us,745.649us,745.65us,745.699us,745.7us,745.749us,745.75us,745.799us,745.8us,745.849us,745.85us,745.899us,745.9us,745.949us,745.95us,745.999us,746us,746.049us,746.05us,746.099us,746.1us,746.149us,746.15us,746.199us,746.2us,746.249us,746.25us,746.299us,746.3us,746.349us,746.35us,746.399us,746.4us,746.449us,746.45us,746.499us,746.5us,746.549us,746.55us,746.599us,746.6us,746.649us,746.65us,746.699us,746.7us,746.749us,746.75us,746.799us,746.8us,746.849us,746.85us,746.899us,746.9us,746.949us,746.95us,746.999us,747us,747.049us,747.05us,747.099us,747.1us,747.149us,747.15us,747.199us,747.2us,747.249us,747.25us,747.299us,747.3us,747.349us,747.35us,747.399us,747.4us,747.449us,747.45us,747.499us,747.5us,747.549us,747.55us,747.599us,747.6us,747.649us,747.65us,747.699us,747.7us,747.749us,747.75us,747.799us,747.8us,747.849us,747.85us,747.899us,747.9us,747.949us,747.95us,747.999us,748us,748.049us,748.05us,748.099us,748.1us,748.149us,748.15us,748.199us,748.2us,748.249us,748.25us,748.299us,748.3us,748.349us,748.35us,748.399us,748.4us,748.449us,748.45us,748.499us,748.5us,748.549us,748.55us,748.599us,748.6us,748.649us,748.65us,748.699us,748.7us,748.749us,748.75us,748.799us,748.8us,748.849us,748.85us,748.899us,748.9us,748.949us,748.95us,748.999us,749us,749.049us,749.05us,749.099us,749.1us,749.149us,749.15us,749.199us,749.2us,749.249us,749.25us,749.299us,749.3us,749.349us,749.35us,749.399us,749.4us,749.449us,749.45us,749.499us,749.5us,749.549us,749.55us,749.599us,749.6us,749.649us,749.65us,749.699us,749.7us,749.749us,749.75us,749.799us,749.8us,749.849us,749.85us,749.899us,749.9us,749.949us,749.95us,749.999us,750us,750.049us,750.05us,750.099us,750.1us,750.149us,750.15us,750.199us,750.2us,750.249us,750.25us,750.299us,750.3us,750.349us,750.35us,750.399us,750.4us,750.449us,750.45us,750.499us,750.5us,750.549us,750.55us,750.599us,750.6us,750.649us,750.65us,750.699us,750.7us,750.749us,750.75us,750.799us,750.8us,750.849us,750.85us,750.899us,750.9us,750.949us,750.95us,750.999us,751us,751.049us,751.05us,751.099us,751.1us,751.149us,751.15us,751.199us,751.2us,751.249us,751.25us,751.299us,751.3us,751.349us,751.35us,751.399us,751.4us,751.449us,751.45us,751.499us,751.5us,751.549us,751.55us,751.599us,751.6us,751.649us,751.65us,751.699us,751.7us,751.749us,751.75us,751.799us,751.8us,751.849us,751.85us,751.899us,751.9us,751.949us,751.95us,751.999us,752us,752.049us,752.05us,752.099us,752.1us,752.149us,752.15us,752.199us,752.2us,752.249us,752.25us,752.299us,752.3us,752.349us,752.35us,752.399us,752.4us,752.449us,752.45us,752.499us,752.5us,752.549us,752.55us,752.599us,752.6us,752.649us,752.65us,752.699us,752.7us,752.749us,752.75us,752.799us,752.8us,752.849us,752.85us,752.899us,752.9us,752.949us,752.95us,752.999us,753us,753.049us,753.05us,753.099us,753.1us,753.149us,753.15us,753.199us,753.2us,753.249us,753.25us,753.299us,753.3us,753.349us,753.35us,753.399us,753.4us,753.449us,753.45us,753.499us,753.5us,753.549us,753.55us,753.599us,753.6us,753.649us,753.65us,753.699us,753.7us,753.749us,753.75us,753.799us,753.8us,753.849us,753.85us,753.899us,753.9us,753.949us,753.95us,753.999us,754us,754.049us,754.05us,754.099us,754.1us,754.149us,754.15us,754.199us,754.2us,754.249us,754.25us,754.299us,754.3us,754.349us,754.35us,754.399us,754.4us,754.449us,754.45us,754.499us,754.5us,754.549us,754.55us,754.599us,754.6us,754.649us,754.65us,754.699us,754.7us,754.749us,754.75us,754.799us,754.8us,754.849us,754.85us,754.899us,754.9us,754.949us,754.95us,754.999us,755us,755.049us,755.05us,755.099us,755.1us,755.149us,755.15us,755.199us,755.2us,755.249us,755.25us,755.299us,755.3us,755.349us,755.35us,755.399us,755.4us,755.449us,755.45us,755.499us,755.5us,755.549us,755.55us,755.599us,755.6us,755.649us,755.65us,755.699us,755.7us,755.749us,755.75us,755.799us,755.8us,755.849us,755.85us,755.899us,755.9us,755.949us,755.95us,755.999us,756us,756.049us,756.05us,756.099us,756.1us,756.149us,756.15us,756.199us,756.2us,756.249us,756.25us,756.299us,756.3us,756.349us,756.35us,756.399us,756.4us,756.449us,756.45us,756.499us,756.5us,756.549us,756.55us,756.599us,756.6us,756.649us,756.65us,756.699us,756.7us,756.749us,756.75us,756.799us,756.8us,756.849us,756.85us,756.899us,756.9us,756.949us,756.95us,756.999us,757us,757.049us,757.05us,757.099us,757.1us,757.149us,757.15us,757.199us,757.2us,757.249us,757.25us,757.299us,757.3us,757.349us,757.35us,757.399us,757.4us,757.449us,757.45us,757.499us,757.5us,757.549us,757.55us,757.599us,757.6us,757.649us,757.65us,757.699us,757.7us,757.749us,757.75us,757.799us,757.8us,757.849us,757.85us,757.899us,757.9us,757.949us,757.95us,757.999us,758us,758.049us,758.05us,758.099us,758.1us,758.149us,758.15us,758.199us,758.2us,758.249us,758.25us,758.299us,758.3us,758.349us,758.35us,758.399us,758.4us,758.449us,758.45us,758.499us,758.5us,758.549us,758.55us,758.599us,758.6us,758.649us,758.65us,758.699us,758.7us,758.749us,758.75us,758.799us,758.8us,758.849us,758.85us,758.899us,758.9us,758.949us,758.95us,758.999us,759us,759.049us,759.05us,759.099us,759.1us,759.149us,759.15us,759.199us,759.2us,759.249us,759.25us,759.299us,759.3us,759.349us,759.35us,759.399us,759.4us,759.449us,759.45us,759.499us,759.5us,759.549us,759.55us,759.599us,759.6us,759.649us,759.65us,759.699us,759.7us,759.749us,759.75us,759.799us,759.8us,759.849us,759.85us,759.899us,759.9us,759.949us,759.95us,759.999us,760us,760.049us,760.05us,760.099us,760.1us,760.149us,760.15us,760.199us,760.2us,760.249us,760.25us,760.299us,760.3us,760.349us,760.35us,760.399us,760.4us,760.449us,760.45us,760.499us,760.5us,760.549us,760.55us,760.599us,760.6us,760.649us,760.65us,760.699us,760.7us,760.749us,760.75us,760.799us,760.8us,760.849us,760.85us,760.899us,760.9us,760.949us,760.95us,760.999us,761us,761.049us,761.05us,761.099us,761.1us,761.149us,761.15us,761.199us,761.2us,761.249us,761.25us,761.299us,761.3us,761.349us,761.35us,761.399us,761.4us,761.449us,761.45us,761.499us,761.5us,761.549us,761.55us,761.599us,761.6us,761.649us,761.65us,761.699us,761.7us,761.749us,761.75us,761.799us,761.8us,761.849us,761.85us,761.899us,761.9us,761.949us,761.95us,761.999us,762us,762.049us,762.05us,762.099us,762.1us,762.149us,762.15us,762.199us,762.2us,762.249us,762.25us,762.299us,762.3us,762.349us,762.35us,762.399us,762.4us,762.449us,762.45us,762.499us,762.5us,762.549us,762.55us,762.599us,762.6us,762.649us,762.65us,762.699us,762.7us,762.749us,762.75us,762.799us,762.8us,762.849us,762.85us,762.899us,762.9us,762.949us,762.95us,762.999us,763us,763.049us,763.05us,763.099us,763.1us,763.149us,763.15us,763.199us,763.2us,763.249us,763.25us,763.299us,763.3us,763.349us,763.35us,763.399us,763.4us,763.449us,763.45us,763.499us,763.5us,763.549us,763.55us,763.599us,763.6us,763.649us,763.65us,763.699us,763.7us,763.749us,763.75us,763.799us,763.8us,763.849us,763.85us,763.899us,763.9us,763.949us,763.95us,763.999us,764us,764.049us,764.05us,764.099us,764.1us,764.149us,764.15us,764.199us,764.2us,764.249us,764.25us,764.299us,764.3us,764.349us,764.35us,764.399us,764.4us,764.449us,764.45us,764.499us,764.5us,764.549us,764.55us,764.599us,764.6us,764.649us,764.65us,764.699us,764.7us,764.749us,764.75us,764.799us,764.8us,764.849us,764.85us,764.899us,764.9us,764.949us,764.95us,764.999us,765us,765.049us,765.05us,765.099us,765.1us,765.149us,765.15us,765.199us,765.2us,765.249us,765.25us,765.299us,765.3us,765.349us,765.35us,765.399us,765.4us,765.449us,765.45us,765.499us,765.5us,765.549us,765.55us,765.599us,765.6us,765.649us,765.65us,765.699us,765.7us,765.749us,765.75us,765.799us,765.8us,765.849us,765.85us,765.899us,765.9us,765.949us,765.95us,765.999us,766us,766.049us,766.05us,766.099us,766.1us,766.149us,766.15us,766.199us,766.2us,766.249us,766.25us,766.299us,766.3us,766.349us,766.35us,766.399us,766.4us,766.449us,766.45us,766.499us,766.5us,766.549us,766.55us,766.599us,766.6us,766.649us,766.65us,766.699us,766.7us,766.749us,766.75us,766.799us,766.8us,766.849us,766.85us,766.899us,766.9us,766.949us,766.95us,766.999us,767us,767.049us,767.05us,767.099us,767.1us,767.149us,767.15us,767.199us,767.2us,767.249us,767.25us,767.299us,767.3us,767.349us,767.35us,767.399us,767.4us,767.449us,767.45us,767.499us,767.5us,767.549us,767.55us,767.599us,767.6us,767.649us,767.65us,767.699us,767.7us,767.749us,767.75us,767.799us,767.8us,767.849us,767.85us,767.899us,767.9us,767.949us,767.95us,767.999us,768us,768.049us,768.05us,768.099us,768.1us,768.149us,768.15us,768.199us,768.2us,768.249us,768.25us,768.299us,768.3us,768.349us,768.35us,768.399us,768.4us,768.449us,768.45us,768.499us,768.5us,768.549us,768.55us,768.599us,768.6us,768.649us,768.65us,768.699us,768.7us,768.749us,768.75us,768.799us,768.8us,768.849us,768.85us,768.899us,768.9us,768.949us,768.95us,768.999us,769us,769.049us,769.05us,769.099us,769.1us,769.149us,769.15us,769.199us,769.2us,769.249us,769.25us,769.299us,769.3us,769.349us,769.35us,769.399us,769.4us,769.449us,769.45us,769.499us,769.5us,769.549us,769.55us,769.599us,769.6us,769.649us,769.65us,769.699us,769.7us,769.749us,769.75us,769.799us,769.8us,769.849us,769.85us,769.899us,769.9us,769.949us,769.95us,769.999us,770us,770.049us,770.05us,770.099us,770.1us,770.149us,770.15us,770.199us,770.2us,770.249us,770.25us,770.299us,770.3us,770.349us,770.35us,770.399us,770.4us,770.449us,770.45us,770.499us,770.5us,770.549us,770.55us,770.599us,770.6us,770.649us,770.65us,770.699us,770.7us,770.749us,770.75us,770.799us,770.8us,770.849us,770.85us,770.899us,770.9us,770.949us,770.95us,770.999us,771us,771.049us,771.05us,771.099us,771.1us,771.149us,771.15us,771.199us,771.2us,771.249us,771.25us,771.299us,771.3us,771.349us,771.35us,771.399us,771.4us,771.449us,771.45us,771.499us,771.5us,771.549us,771.55us,771.599us,771.6us,771.649us,771.65us,771.699us,771.7us,771.749us,771.75us,771.799us,771.8us,771.849us,771.85us,771.899us,771.9us,771.949us,771.95us,771.999us,772us,772.049us,772.05us,772.099us,772.1us,772.149us,772.15us,772.199us,772.2us,772.249us,772.25us,772.299us,772.3us,772.349us,772.35us,772.399us,772.4us,772.449us,772.45us,772.499us,772.5us,772.549us,772.55us,772.599us,772.6us,772.649us,772.65us,772.699us,772.7us,772.749us,772.75us,772.799us,772.8us,772.849us,772.85us,772.899us,772.9us,772.949us,772.95us,772.999us,773us,773.049us,773.05us,773.099us,773.1us,773.149us,773.15us,773.199us,773.2us,773.249us,773.25us,773.299us,773.3us,773.349us,773.35us,773.399us,773.4us,773.449us,773.45us,773.499us,773.5us,773.549us,773.55us,773.599us,773.6us,773.649us,773.65us,773.699us,773.7us,773.749us,773.75us,773.799us,773.8us,773.849us,773.85us,773.899us,773.9us,773.949us,773.95us,773.999us,774us,774.049us,774.05us,774.099us,774.1us,774.149us,774.15us,774.199us,774.2us,774.249us,774.25us,774.299us,774.3us,774.349us,774.35us,774.399us,774.4us,774.449us,774.45us,774.499us,774.5us,774.549us,774.55us,774.599us,774.6us,774.649us,774.65us,774.699us,774.7us,774.749us,774.75us,774.799us,774.8us,774.849us,774.85us,774.899us,774.9us,774.949us,774.95us,774.999us,775us,775.049us,775.05us,775.099us,775.1us,775.149us,775.15us,775.199us,775.2us,775.249us,775.25us,775.299us,775.3us,775.349us,775.35us,775.399us,775.4us,775.449us,775.45us,775.499us,775.5us,775.549us,775.55us,775.599us,775.6us,775.649us,775.65us,775.699us,775.7us,775.749us,775.75us,775.799us,775.8us,775.849us,775.85us,775.899us,775.9us,775.949us,775.95us,775.999us,776us,776.049us,776.05us,776.099us,776.1us,776.149us,776.15us,776.199us,776.2us,776.249us,776.25us,776.299us,776.3us,776.349us,776.35us,776.399us,776.4us,776.449us,776.45us,776.499us,776.5us,776.549us,776.55us,776.599us,776.6us,776.649us,776.65us,776.699us,776.7us,776.749us,776.75us,776.799us,776.8us,776.849us,776.85us,776.899us,776.9us,776.949us,776.95us,776.999us,777us,777.049us,777.05us,777.099us,777.1us,777.149us,777.15us,777.199us,777.2us,777.249us,777.25us,777.299us,777.3us,777.349us,777.35us,777.399us,777.4us,777.449us,777.45us,777.499us,777.5us,777.549us,777.55us,777.599us,777.6us,777.649us,777.65us,777.699us,777.7us,777.749us,777.75us,777.799us,777.8us,777.849us,777.85us,777.899us,777.9us,777.949us,777.95us,777.999us,778us,778.049us,778.05us,778.099us,778.1us,778.149us,778.15us,778.199us,778.2us,778.249us,778.25us,778.299us,778.3us,778.349us,778.35us,778.399us,778.4us,778.449us,778.45us,778.499us,778.5us,778.549us,778.55us,778.599us,778.6us,778.649us,778.65us,778.699us,778.7us,778.749us,778.75us,778.799us,778.8us,778.849us,778.85us,778.899us,778.9us,778.949us,778.95us,778.999us,779us,779.049us,779.05us,779.099us,779.1us,779.149us,779.15us,779.199us,779.2us,779.249us,779.25us,779.299us,779.3us,779.349us,779.35us,779.399us,779.4us,779.449us,779.45us,779.499us,779.5us,779.549us,779.55us,779.599us,779.6us,779.649us,779.65us,779.699us,779.7us,779.749us,779.75us,779.799us,779.8us,779.849us,779.85us,779.899us,779.9us,779.949us,779.95us,779.999us,780us,780.049us,780.05us,780.099us,780.1us,780.149us,780.15us,780.199us,780.2us,780.249us,780.25us,780.299us,780.3us,780.349us,780.35us,780.399us,780.4us,780.449us,780.45us,780.499us,780.5us,780.549us,780.55us,780.599us,780.6us,780.649us,780.65us,780.699us,780.7us,780.749us,780.75us,780.799us,780.8us,780.849us,780.85us,780.899us,780.9us,780.949us,780.95us,780.999us,781us,781.049us,781.05us,781.099us,781.1us,781.149us,781.15us,781.199us,781.2us,781.249us,781.25us,781.299us,781.3us,781.349us,781.35us,781.399us,781.4us,781.449us,781.45us,781.499us,781.5us,781.549us,781.55us,781.599us,781.6us,781.649us,781.65us,781.699us,781.7us,781.749us,781.75us,781.799us,781.8us,781.849us,781.85us,781.899us,781.9us,781.949us,781.95us,781.999us,782us,782.049us,782.05us,782.099us,782.1us,782.149us,782.15us,782.199us,782.2us,782.249us,782.25us,782.299us,782.3us,782.349us,782.35us,782.399us,782.4us,782.449us,782.45us,782.499us,782.5us,782.549us,782.55us,782.599us,782.6us,782.649us,782.65us,782.699us,782.7us,782.749us,782.75us,782.799us,782.8us,782.849us,782.85us,782.899us,782.9us,782.949us,782.95us,782.999us,783us,783.049us,783.05us,783.099us,783.1us,783.149us,783.15us,783.199us,783.2us,783.249us,783.25us,783.299us,783.3us,783.349us,783.35us,783.399us,783.4us,783.449us,783.45us,783.499us,783.5us,783.549us,783.55us,783.599us,783.6us,783.649us,783.65us,783.699us,783.7us,783.749us,783.75us,783.799us,783.8us,783.849us,783.85us,783.899us,783.9us,783.949us,783.95us,783.999us,784us,784.049us,784.05us,784.099us,784.1us,784.149us,784.15us,784.199us,784.2us,784.249us,784.25us,784.299us,784.3us,784.349us,784.35us,784.399us,784.4us,784.449us,784.45us,784.499us,784.5us,784.549us,784.55us,784.599us,784.6us,784.649us,784.65us,784.699us,784.7us,784.749us,784.75us,784.799us,784.8us,784.849us,784.85us,784.899us,784.9us,784.949us,784.95us,784.999us,785us,785.049us,785.05us,785.099us,785.1us,785.149us,785.15us,785.199us,785.2us,785.249us,785.25us,785.299us,785.3us,785.349us,785.35us,785.399us,785.4us,785.449us,785.45us,785.499us,785.5us,785.549us,785.55us,785.599us,785.6us,785.649us,785.65us,785.699us,785.7us,785.749us,785.75us,785.799us,785.8us,785.849us,785.85us,785.899us,785.9us,785.949us,785.95us,785.999us,786us,786.049us,786.05us,786.099us,786.1us,786.149us,786.15us,786.199us,786.2us,786.249us,786.25us,786.299us,786.3us,786.349us,786.35us,786.399us,786.4us,786.449us,786.45us,786.499us,786.5us,786.549us,786.55us,786.599us,786.6us,786.649us,786.65us,786.699us,786.7us,786.749us,786.75us,786.799us,786.8us,786.849us,786.85us,786.899us,786.9us,786.949us,786.95us,786.999us,787us,787.049us,787.05us,787.099us,787.1us,787.149us,787.15us,787.199us,787.2us,787.249us,787.25us,787.299us,787.3us,787.349us,787.35us,787.399us,787.4us,787.449us,787.45us,787.499us,787.5us,787.549us,787.55us,787.599us,787.6us,787.649us,787.65us,787.699us,787.7us,787.749us,787.75us,787.799us,787.8us,787.849us,787.85us,787.899us,787.9us,787.949us,787.95us,787.999us,788us,788.049us,788.05us,788.099us,788.1us,788.149us,788.15us,788.199us,788.2us,788.249us,788.25us,788.299us,788.3us,788.349us,788.35us,788.399us,788.4us,788.449us,788.45us,788.499us,788.5us,788.549us,788.55us,788.599us,788.6us,788.649us,788.65us,788.699us,788.7us,788.749us,788.75us,788.799us,788.8us,788.849us,788.85us,788.899us,788.9us,788.949us,788.95us,788.999us,789us,789.049us,789.05us,789.099us,789.1us,789.149us,789.15us,789.199us,789.2us,789.249us,789.25us,789.299us,789.3us,789.349us,789.35us,789.399us,789.4us,789.449us,789.45us,789.499us,789.5us,789.549us,789.55us,789.599us,789.6us,789.649us,789.65us,789.699us,789.7us,789.749us,789.75us,789.799us,789.8us,789.849us,789.85us,789.899us,789.9us,789.949us,789.95us,789.999us,790us,790.049us,790.05us,790.099us,790.1us,790.149us,790.15us,790.199us,790.2us,790.249us,790.25us,790.299us,790.3us,790.349us,790.35us,790.399us,790.4us,790.449us,790.45us,790.499us,790.5us,790.549us,790.55us,790.599us,790.6us,790.649us,790.65us,790.699us,790.7us,790.749us,790.75us,790.799us,790.8us,790.849us,790.85us,790.899us,790.9us,790.949us,790.95us,790.999us,791us,791.049us,791.05us,791.099us,791.1us,791.149us,791.15us,791.199us,791.2us,791.249us,791.25us,791.299us,791.3us,791.349us,791.35us,791.399us,791.4us,791.449us,791.45us,791.499us,791.5us,791.549us,791.55us,791.599us,791.6us,791.649us,791.65us,791.699us,791.7us,791.749us,791.75us,791.799us,791.8us,791.849us,791.85us,791.899us,791.9us,791.949us,791.95us,791.999us,792us,792.049us,792.05us,792.099us,792.1us,792.149us,792.15us,792.199us,792.2us,792.249us,792.25us,792.299us,792.3us,792.349us,792.35us,792.399us,792.4us,792.449us,792.45us,792.499us,792.5us,792.549us,792.55us,792.599us,792.6us,792.649us,792.65us,792.699us,792.7us,792.749us,792.75us,792.799us,792.8us,792.849us,792.85us,792.899us,792.9us,792.949us,792.95us,792.999us,793us,793.049us,793.05us,793.099us,793.1us,793.149us,793.15us,793.199us,793.2us,793.249us,793.25us,793.299us,793.3us,793.349us,793.35us,793.399us,793.4us,793.449us,793.45us,793.499us,793.5us,793.549us,793.55us,793.599us,793.6us,793.649us,793.65us,793.699us,793.7us,793.749us,793.75us,793.799us,793.8us,793.849us,793.85us,793.899us,793.9us,793.949us,793.95us,793.999us,794us,794.049us,794.05us,794.099us,794.1us,794.149us,794.15us,794.199us,794.2us,794.249us,794.25us,794.299us,794.3us,794.349us,794.35us,794.399us,794.4us,794.449us,794.45us,794.499us,794.5us,794.549us,794.55us,794.599us,794.6us,794.649us,794.65us,794.699us,794.7us,794.749us,794.75us,794.799us,794.8us,794.849us,794.85us,794.899us,794.9us,794.949us,794.95us,794.999us,795us,795.049us,795.05us,795.099us,795.1us,795.149us,795.15us,795.199us,795.2us,795.249us,795.25us,795.299us,795.3us,795.349us,795.35us,795.399us,795.4us,795.449us,795.45us,795.499us,795.5us,795.549us,795.55us,795.599us,795.6us,795.649us,795.65us,795.699us,795.7us,795.749us,795.75us,795.799us,795.8us,795.849us,795.85us,795.899us,795.9us,795.949us,795.95us,795.999us,796us,796.049us,796.05us,796.099us,796.1us,796.149us,796.15us,796.199us,796.2us,796.249us,796.25us,796.299us,796.3us,796.349us,796.35us,796.399us,796.4us,796.449us,796.45us,796.499us,796.5us,796.549us,796.55us,796.599us,796.6us,796.649us,796.65us,796.699us,796.7us,796.749us,796.75us,796.799us,796.8us,796.849us,796.85us,796.899us,796.9us,796.949us,796.95us,796.999us,797us,797.049us,797.05us,797.099us,797.1us,797.149us,797.15us,797.199us,797.2us,797.249us,797.25us,797.299us,797.3us,797.349us,797.35us,797.399us,797.4us,797.449us,797.45us,797.499us,797.5us,797.549us,797.55us,797.599us,797.6us,797.649us,797.65us,797.699us,797.7us,797.749us,797.75us,797.799us,797.8us,797.849us,797.85us,797.899us,797.9us,797.949us,797.95us,797.999us,798us,798.049us,798.05us,798.099us,798.1us,798.149us,798.15us,798.199us,798.2us,798.249us,798.25us,798.299us,798.3us,798.349us,798.35us,798.399us,798.4us,798.449us,798.45us,798.499us,798.5us,798.549us,798.55us,798.599us,798.6us,798.649us,798.65us,798.699us,798.7us,798.749us,798.75us,798.799us,798.8us,798.849us,798.85us,798.899us,798.9us,798.949us,798.95us,798.999us,799us,799.049us,799.05us,799.099us,799.1us,799.149us,799.15us,799.199us,799.2us,799.249us,799.25us,799.299us,799.3us,799.349us,799.35us,799.399us,799.4us,799.449us,799.45us,799.499us,799.5us,799.549us,799.55us,799.599us,799.6us,799.649us,799.65us,799.699us,799.7us,799.749us,799.75us,799.799us,799.8us,799.849us,799.85us,799.899us,799.9us,799.949us,799.95us,799.999us,800us,800.049us,800.05us,800.099us,800.1us,800.149us,800.15us,800.199us,800.2us,800.249us,800.25us,800.299us,800.3us,800.349us,800.35us,800.399us,800.4us,800.449us,800.45us,800.499us,800.5us,800.549us,800.55us,800.599us,800.6us,800.649us,800.65us,800.699us,800.7us,800.749us,800.75us,800.799us,800.8us,800.849us,800.85us,800.899us,800.9us,800.949us,800.95us,800.999us,801us,801.049us,801.05us,801.099us,801.1us,801.149us,801.15us,801.199us,801.2us,801.249us,801.25us,801.299us,801.3us,801.349us,801.35us,801.399us,801.4us,801.449us,801.45us,801.499us,801.5us,801.549us,801.55us,801.599us,801.6us,801.649us,801.65us,801.699us,801.7us,801.749us,801.75us,801.799us,801.8us,801.849us,801.85us,801.899us,801.9us,801.949us,801.95us,801.999us,802us,802.049us,802.05us,802.099us,802.1us,802.149us,802.15us,802.199us,802.2us,802.249us,802.25us,802.299us,802.3us,802.349us,802.35us,802.399us,802.4us,802.449us,802.45us,802.499us,802.5us,802.549us,802.55us,802.599us,802.6us,802.649us,802.65us,802.699us,802.7us,802.749us,802.75us,802.799us,802.8us,802.849us,802.85us,802.899us,802.9us,802.949us,802.95us,802.999us,803us,803.049us,803.05us,803.099us,803.1us,803.149us,803.15us,803.199us,803.2us,803.249us,803.25us,803.299us,803.3us,803.349us,803.35us,803.399us,803.4us,803.449us,803.45us,803.499us,803.5us,803.549us,803.55us,803.599us,803.6us,803.649us,803.65us,803.699us,803.7us,803.749us,803.75us,803.799us,803.8us,803.849us,803.85us,803.899us,803.9us,803.949us,803.95us,803.999us,804us,804.049us,804.05us,804.099us,804.1us,804.149us,804.15us,804.199us,804.2us,804.249us,804.25us,804.299us,804.3us,804.349us,804.35us,804.399us,804.4us,804.449us,804.45us,804.499us,804.5us,804.549us,804.55us,804.599us,804.6us,804.649us,804.65us,804.699us,804.7us,804.749us,804.75us,804.799us,804.8us,804.849us,804.85us,804.899us,804.9us,804.949us,804.95us,804.999us,805us,805.049us,805.05us,805.099us,805.1us,805.149us,805.15us,805.199us,805.2us,805.249us,805.25us,805.299us,805.3us,805.349us,805.35us,805.399us,805.4us,805.449us,805.45us,805.499us,805.5us,805.549us,805.55us,805.599us,805.6us,805.649us,805.65us,805.699us,805.7us,805.749us,805.75us,805.799us,805.8us,805.849us,805.85us,805.899us,805.9us,805.949us,805.95us,805.999us,806us,806.049us,806.05us,806.099us,806.1us,806.149us,806.15us,806.199us,806.2us,806.249us,806.25us,806.299us,806.3us,806.349us,806.35us,806.399us,806.4us,806.449us,806.45us,806.499us,806.5us,806.549us,806.55us,806.599us,806.6us,806.649us,806.65us,806.699us,806.7us,806.749us,806.75us,806.799us,806.8us,806.849us,806.85us,806.899us,806.9us,806.949us,806.95us,806.999us,807us,807.049us,807.05us,807.099us,807.1us,807.149us,807.15us,807.199us,807.2us,807.249us,807.25us,807.299us,807.3us,807.349us,807.35us,807.399us,807.4us,807.449us,807.45us,807.499us,807.5us,807.549us,807.55us,807.599us,807.6us,807.649us,807.65us,807.699us,807.7us,807.749us,807.75us,807.799us,807.8us,807.849us,807.85us,807.899us,807.9us,807.949us,807.95us,807.999us,808us,808.049us,808.05us,808.099us,808.1us,808.149us,808.15us,808.199us,808.2us,808.249us,808.25us,808.299us,808.3us,808.349us,808.35us,808.399us,808.4us,808.449us,808.45us,808.499us,808.5us,808.549us,808.55us,808.599us,808.6us,808.649us,808.65us,808.699us,808.7us,808.749us,808.75us,808.799us,808.8us,808.849us,808.85us,808.899us,808.9us,808.949us,808.95us,808.999us,809us,809.049us,809.05us,809.099us,809.1us,809.149us,809.15us,809.199us,809.2us,809.249us,809.25us,809.299us,809.3us,809.349us,809.35us,809.399us,809.4us,809.449us,809.45us,809.499us,809.5us,809.549us,809.55us,809.599us,809.6us,809.649us,809.65us,809.699us,809.7us,809.749us,809.75us,809.799us,809.8us,809.849us,809.85us,809.899us,809.9us,809.949us,809.95us,809.999us,810us,810.049us,810.05us,810.099us,810.1us,810.149us,810.15us,810.199us,810.2us,810.249us,810.25us,810.299us,810.3us,810.349us,810.35us,810.399us,810.4us,810.449us,810.45us,810.499us,810.5us,810.549us,810.55us,810.599us,810.6us,810.649us,810.65us,810.699us,810.7us,810.749us,810.75us,810.799us,810.8us,810.849us,810.85us,810.899us,810.9us,810.949us,810.95us,810.999us,811us,811.049us,811.05us,811.099us,811.1us,811.149us,811.15us,811.199us,811.2us,811.249us,811.25us,811.299us,811.3us,811.349us,811.35us,811.399us,811.4us,811.449us,811.45us,811.499us,811.5us,811.549us,811.55us,811.599us,811.6us,811.649us,811.65us,811.699us,811.7us,811.749us,811.75us,811.799us,811.8us,811.849us,811.85us,811.899us,811.9us,811.949us,811.95us,811.999us,812us,812.049us,812.05us,812.099us,812.1us,812.149us,812.15us,812.199us,812.2us,812.249us,812.25us,812.299us,812.3us,812.349us,812.35us,812.399us,812.4us,812.449us,812.45us,812.499us,812.5us,812.549us,812.55us,812.599us,812.6us,812.649us,812.65us,812.699us,812.7us,812.749us,812.75us,812.799us,812.8us,812.849us,812.85us,812.899us,812.9us,812.949us,812.95us,812.999us,813us,813.049us,813.05us,813.099us,813.1us,813.149us,813.15us,813.199us,813.2us,813.249us,813.25us,813.299us,813.3us,813.349us,813.35us,813.399us,813.4us,813.449us,813.45us,813.499us,813.5us,813.549us,813.55us,813.599us,813.6us,813.649us,813.65us,813.699us,813.7us,813.749us,813.75us,813.799us,813.8us,813.849us,813.85us,813.899us,813.9us,813.949us,813.95us,813.999us,814us,814.049us,814.05us,814.099us,814.1us,814.149us,814.15us,814.199us,814.2us,814.249us,814.25us,814.299us,814.3us,814.349us,814.35us,814.399us,814.4us,814.449us,814.45us,814.499us,814.5us,814.549us,814.55us,814.599us,814.6us,814.649us,814.65us,814.699us,814.7us,814.749us,814.75us,814.799us,814.8us,814.849us,814.85us,814.899us,814.9us,814.949us,814.95us,814.999us,815us,815.049us,815.05us,815.099us,815.1us,815.149us,815.15us,815.199us,815.2us,815.249us,815.25us,815.299us,815.3us,815.349us,815.35us,815.399us,815.4us,815.449us,815.45us,815.499us,815.5us,815.549us,815.55us,815.599us,815.6us,815.649us,815.65us,815.699us,815.7us,815.749us,815.75us,815.799us,815.8us,815.849us,815.85us,815.899us,815.9us,815.949us,815.95us,815.999us,816us,816.049us,816.05us,816.099us,816.1us,816.149us,816.15us,816.199us,816.2us,816.249us,816.25us,816.299us,816.3us,816.349us,816.35us,816.399us,816.4us,816.449us,816.45us,816.499us,816.5us,816.549us,816.55us,816.599us,816.6us,816.649us,816.65us,816.699us,816.7us,816.749us,816.75us,816.799us,816.8us,816.849us,816.85us,816.899us,816.9us,816.949us,816.95us,816.999us,817us,817.049us,817.05us,817.099us,817.1us,817.149us,817.15us,817.199us,817.2us,817.249us,817.25us,817.299us,817.3us,817.349us,817.35us,817.399us,817.4us,817.449us,817.45us,817.499us,817.5us,817.549us,817.55us,817.599us,817.6us,817.649us,817.65us,817.699us,817.7us,817.749us,817.75us,817.799us,817.8us,817.849us,817.85us,817.899us,817.9us,817.949us,817.95us,817.999us,818us,818.049us,818.05us,818.099us,818.1us,818.149us,818.15us,818.199us,818.2us,818.249us,818.25us,818.299us,818.3us,818.349us,818.35us,818.399us,818.4us,818.449us,818.45us,818.499us,818.5us,818.549us,818.55us,818.599us,818.6us,818.649us,818.65us,818.699us,818.7us,818.749us,818.75us,818.799us,818.8us,818.849us,818.85us,818.899us,818.9us,818.949us,818.95us,818.999us,819us,819.049us,819.05us,819.099us,819.1us,819.149us,819.15us,819.199us,819.2us,819.249us,819.25us,819.299us,819.3us,819.349us,819.35us,819.399us,819.4us,819.449us,819.45us,819.499us,819.5us,819.549us,819.55us,819.599us,819.6us,819.649us,819.65us,819.699us,819.7us,819.749us,819.75us,819.799us,819.8us,819.849us,819.85us,819.899us,819.9us,819.949us,819.95us,819.999us,820us,820.049us,820.05us,820.099us,820.1us,820.149us,820.15us,820.199us,820.2us,820.249us,820.25us,820.299us,820.3us,820.349us,820.35us,820.399us,820.4us,820.449us,820.45us,820.499us,820.5us,820.549us,820.55us,820.599us,820.6us,820.649us,820.65us,820.699us,820.7us,820.749us,820.75us,820.799us,820.8us,820.849us,820.85us,820.899us,820.9us,820.949us,820.95us,820.999us,821us,821.049us,821.05us,821.099us,821.1us,821.149us,821.15us,821.199us,821.2us,821.249us,821.25us,821.299us,821.3us,821.349us,821.35us,821.399us,821.4us,821.449us,821.45us,821.499us,821.5us,821.549us,821.55us,821.599us,821.6us,821.649us,821.65us,821.699us,821.7us,821.749us,821.75us,821.799us,821.8us,821.849us,821.85us,821.899us,821.9us,821.949us,821.95us,821.999us,822us,822.049us,822.05us,822.099us,822.1us,822.149us,822.15us,822.199us,822.2us,822.249us,822.25us,822.299us,822.3us,822.349us,822.35us,822.399us,822.4us,822.449us,822.45us,822.499us,822.5us,822.549us,822.55us,822.599us,822.6us,822.649us,822.65us,822.699us,822.7us,822.749us,822.75us,822.799us,822.8us,822.849us,822.85us,822.899us,822.9us,822.949us,822.95us,822.999us,823us,823.049us,823.05us,823.099us,823.1us,823.149us,823.15us,823.199us,823.2us,823.249us,823.25us,823.299us,823.3us,823.349us,823.35us,823.399us,823.4us,823.449us,823.45us,823.499us,823.5us,823.549us,823.55us,823.599us,823.6us,823.649us,823.65us,823.699us,823.7us,823.749us,823.75us,823.799us,823.8us,823.849us,823.85us,823.899us,823.9us,823.949us,823.95us,823.999us,824us,824.049us,824.05us,824.099us,824.1us,824.149us,824.15us,824.199us,824.2us,824.249us,824.25us,824.299us,824.3us,824.349us,824.35us,824.399us,824.4us,824.449us,824.45us,824.499us,824.5us,824.549us,824.55us,824.599us,824.6us,824.649us,824.65us,824.699us,824.7us,824.749us,824.75us,824.799us,824.8us,824.849us,824.85us,824.899us,824.9us,824.949us,824.95us,824.999us,825us,825.049us,825.05us,825.099us,825.1us,825.149us,825.15us,825.199us,825.2us,825.249us,825.25us,825.299us,825.3us,825.349us,825.35us,825.399us,825.4us,825.449us,825.45us,825.499us,825.5us,825.549us,825.55us,825.599us,825.6us,825.649us,825.65us,825.699us,825.7us,825.749us,825.75us,825.799us,825.8us,825.849us,825.85us,825.899us,825.9us,825.949us,825.95us,825.999us,826us,826.049us,826.05us,826.099us,826.1us,826.149us,826.15us,826.199us,826.2us,826.249us,826.25us,826.299us,826.3us,826.349us,826.35us,826.399us,826.4us,826.449us,826.45us,826.499us,826.5us,826.549us,826.55us,826.599us,826.6us,826.649us,826.65us,826.699us,826.7us,826.749us,826.75us,826.799us,826.8us,826.849us,826.85us,826.899us,826.9us,826.949us,826.95us,826.999us,827us,827.049us,827.05us,827.099us,827.1us,827.149us,827.15us,827.199us,827.2us,827.249us,827.25us,827.299us,827.3us,827.349us,827.35us,827.399us,827.4us,827.449us,827.45us,827.499us,827.5us,827.549us,827.55us,827.599us,827.6us,827.649us,827.65us,827.699us,827.7us,827.749us,827.75us,827.799us,827.8us,827.849us,827.85us,827.899us,827.9us,827.949us,827.95us,827.999us,828us,828.049us,828.05us,828.099us,828.1us,828.149us,828.15us,828.199us,828.2us,828.249us,828.25us,828.299us,828.3us,828.349us,828.35us,828.399us,828.4us,828.449us,828.45us,828.499us,828.5us,828.549us,828.55us,828.599us,828.6us,828.649us,828.65us,828.699us,828.7us,828.749us,828.75us,828.799us,828.8us,828.849us,828.85us,828.899us,828.9us,828.949us,828.95us,828.999us,829us,829.049us,829.05us,829.099us,829.1us,829.149us,829.15us,829.199us,829.2us,829.249us,829.25us,829.299us,829.3us,829.349us,829.35us,829.399us,829.4us,829.449us,829.45us,829.499us,829.5us,829.549us,829.55us,829.599us,829.6us,829.649us,829.65us,829.699us,829.7us,829.749us,829.75us,829.799us,829.8us,829.849us,829.85us,829.899us,829.9us,829.949us,829.95us,829.999us,830us,830.049us,830.05us,830.099us,830.1us,830.149us,830.15us,830.199us,830.2us,830.249us,830.25us,830.299us,830.3us,830.349us,830.35us,830.399us,830.4us,830.449us,830.45us,830.499us,830.5us,830.549us,830.55us,830.599us,830.6us,830.649us,830.65us,830.699us,830.7us,830.749us,830.75us,830.799us,830.8us,830.849us,830.85us,830.899us,830.9us,830.949us,830.95us,830.999us,831us,831.049us,831.05us,831.099us,831.1us,831.149us,831.15us,831.199us,831.2us,831.249us,831.25us,831.299us,831.3us,831.349us,831.35us,831.399us,831.4us,831.449us,831.45us,831.499us,831.5us,831.549us,831.55us,831.599us,831.6us,831.649us,831.65us,831.699us,831.7us,831.749us,831.75us,831.799us,831.8us,831.849us,831.85us,831.899us,831.9us,831.949us,831.95us,831.999us,832us,832.049us,832.05us,832.099us,832.1us,832.149us,832.15us,832.199us,832.2us,832.249us,832.25us,832.299us,832.3us,832.349us,832.35us,832.399us,832.4us,832.449us,832.45us,832.499us,832.5us,832.549us,832.55us,832.599us,832.6us,832.649us,832.65us,832.699us,832.7us,832.749us,832.75us,832.799us,832.8us,832.849us,832.85us,832.899us,832.9us,832.949us,832.95us,832.999us,833us,833.049us,833.05us,833.099us,833.1us,833.149us,833.15us,833.199us,833.2us,833.249us,833.25us,833.299us,833.3us,833.349us,833.35us,833.399us,833.4us,833.449us,833.45us,833.499us,833.5us,833.549us,833.55us,833.599us,833.6us,833.649us,833.65us,833.699us,833.7us,833.749us,833.75us,833.799us,833.8us,833.849us,833.85us,833.899us,833.9us,833.949us,833.95us,833.999us,834us,834.049us,834.05us,834.099us,834.1us,834.149us,834.15us,834.199us,834.2us,834.249us,834.25us,834.299us,834.3us,834.349us,834.35us,834.399us,834.4us,834.449us,834.45us,834.499us,834.5us,834.549us,834.55us,834.599us,834.6us,834.649us,834.65us,834.699us,834.7us,834.749us,834.75us,834.799us,834.8us,834.849us,834.85us,834.899us,834.9us,834.949us,834.95us,834.999us,835us,835.049us,835.05us,835.099us,835.1us,835.149us,835.15us,835.199us,835.2us,835.249us,835.25us,835.299us,835.3us,835.349us,835.35us,835.399us,835.4us,835.449us,835.45us,835.499us,835.5us,835.549us,835.55us,835.599us,835.6us,835.649us,835.65us,835.699us,835.7us,835.749us,835.75us,835.799us,835.8us,835.849us,835.85us,835.899us,835.9us,835.949us,835.95us,835.999us,836us,836.049us,836.05us,836.099us,836.1us,836.149us,836.15us,836.199us,836.2us,836.249us,836.25us,836.299us,836.3us,836.349us,836.35us,836.399us,836.4us,836.449us,836.45us,836.499us,836.5us,836.549us,836.55us,836.599us,836.6us,836.649us,836.65us,836.699us,836.7us,836.749us,836.75us,836.799us,836.8us,836.849us,836.85us,836.899us,836.9us,836.949us,836.95us,836.999us,837us,837.049us,837.05us,837.099us,837.1us,837.149us,837.15us,837.199us,837.2us,837.249us,837.25us,837.299us,837.3us,837.349us,837.35us,837.399us,837.4us,837.449us,837.45us,837.499us,837.5us,837.549us,837.55us,837.599us,837.6us,837.649us,837.65us,837.699us,837.7us,837.749us,837.75us,837.799us,837.8us,837.849us,837.85us,837.899us,837.9us,837.949us,837.95us,837.999us,838us,838.049us,838.05us,838.099us,838.1us,838.149us,838.15us,838.199us,838.2us,838.249us,838.25us,838.299us,838.3us,838.349us,838.35us,838.399us,838.4us,838.449us,838.45us,838.499us,838.5us,838.549us,838.55us,838.599us,838.6us,838.649us,838.65us,838.699us,838.7us,838.749us,838.75us,838.799us,838.8us,838.849us,838.85us,838.899us,838.9us,838.949us,838.95us,838.999us,839us,839.049us,839.05us,839.099us,839.1us,839.149us,839.15us,839.199us,839.2us,839.249us,839.25us,839.299us,839.3us,839.349us,839.35us,839.399us,839.4us,839.449us,839.45us,839.499us,839.5us,839.549us,839.55us,839.599us,839.6us,839.649us,839.65us,839.699us,839.7us,839.749us,839.75us,839.799us,839.8us,839.849us,839.85us,839.899us,839.9us,839.949us,839.95us,839.999us,840us,840.049us,840.05us,840.099us,840.1us,840.149us,840.15us,840.199us,840.2us,840.249us,840.25us,840.299us,840.3us,840.349us,840.35us,840.399us,840.4us,840.449us,840.45us,840.499us,840.5us,840.549us,840.55us,840.599us,840.6us,840.649us,840.65us,840.699us,840.7us,840.749us,840.75us,840.799us,840.8us,840.849us,840.85us,840.899us,840.9us,840.949us,840.95us,840.999us,841us,841.049us,841.05us,841.099us,841.1us,841.149us,841.15us,841.199us,841.2us,841.249us,841.25us,841.299us,841.3us,841.349us,841.35us,841.399us,841.4us,841.449us,841.45us,841.499us,841.5us,841.549us,841.55us,841.599us,841.6us,841.649us,841.65us,841.699us,841.7us,841.749us,841.75us,841.799us,841.8us,841.849us,841.85us,841.899us,841.9us,841.949us,841.95us,841.999us,842us,842.049us,842.05us,842.099us,842.1us,842.149us,842.15us,842.199us,842.2us,842.249us,842.25us,842.299us,842.3us,842.349us,842.35us,842.399us,842.4us,842.449us,842.45us,842.499us,842.5us,842.549us,842.55us,842.599us,842.6us,842.649us,842.65us,842.699us,842.7us,842.749us,842.75us,842.799us,842.8us,842.849us,842.85us,842.899us,842.9us,842.949us,842.95us,842.999us,843us,843.049us,843.05us,843.099us,843.1us,843.149us,843.15us,843.199us,843.2us,843.249us,843.25us,843.299us,843.3us,843.349us,843.35us,843.399us,843.4us,843.449us,843.45us,843.499us,843.5us,843.549us,843.55us,843.599us,843.6us,843.649us,843.65us,843.699us,843.7us,843.749us,843.75us,843.799us,843.8us,843.849us,843.85us,843.899us,843.9us,843.949us,843.95us,843.999us,844us,844.049us,844.05us,844.099us,844.1us,844.149us,844.15us,844.199us,844.2us,844.249us,844.25us,844.299us,844.3us,844.349us,844.35us,844.399us,844.4us,844.449us,844.45us,844.499us,844.5us,844.549us,844.55us,844.599us,844.6us,844.649us,844.65us,844.699us,844.7us,844.749us,844.75us,844.799us,844.8us,844.849us,844.85us,844.899us,844.9us,844.949us,844.95us,844.999us,845us,845.049us,845.05us,845.099us,845.1us,845.149us,845.15us,845.199us,845.2us,845.249us,845.25us,845.299us,845.3us,845.349us,845.35us,845.399us,845.4us,845.449us,845.45us,845.499us,845.5us,845.549us,845.55us,845.599us,845.6us,845.649us,845.65us,845.699us,845.7us,845.749us,845.75us,845.799us,845.8us,845.849us,845.85us,845.899us,845.9us,845.949us,845.95us,845.999us,846us,846.049us,846.05us,846.099us,846.1us,846.149us,846.15us,846.199us,846.2us,846.249us,846.25us,846.299us,846.3us,846.349us,846.35us,846.399us,846.4us,846.449us,846.45us,846.499us,846.5us,846.549us,846.55us,846.599us,846.6us,846.649us,846.65us,846.699us,846.7us,846.749us,846.75us,846.799us,846.8us,846.849us,846.85us,846.899us,846.9us,846.949us,846.95us,846.999us,847us,847.049us,847.05us,847.099us,847.1us,847.149us,847.15us,847.199us,847.2us,847.249us,847.25us,847.299us,847.3us,847.349us,847.35us,847.399us,847.4us,847.449us,847.45us,847.499us,847.5us,847.549us,847.55us,847.599us,847.6us,847.649us,847.65us,847.699us,847.7us,847.749us,847.75us,847.799us,847.8us,847.849us,847.85us,847.899us,847.9us,847.949us,847.95us,847.999us,848us,848.049us,848.05us,848.099us,848.1us,848.149us,848.15us,848.199us,848.2us,848.249us,848.25us,848.299us,848.3us,848.349us,848.35us,848.399us,848.4us,848.449us,848.45us,848.499us,848.5us,848.549us,848.55us,848.599us,848.6us,848.649us,848.65us,848.699us,848.7us,848.749us,848.75us,848.799us,848.8us,848.849us,848.85us,848.899us,848.9us,848.949us,848.95us,848.999us,849us,849.049us,849.05us,849.099us,849.1us,849.149us,849.15us,849.199us,849.2us,849.249us,849.25us,849.299us,849.3us,849.349us,849.35us,849.399us,849.4us,849.449us,849.45us,849.499us,849.5us,849.549us,849.55us,849.599us,849.6us,849.649us,849.65us,849.699us,849.7us,849.749us,849.75us,849.799us,849.8us,849.849us,849.85us,849.899us,849.9us,849.949us,849.95us,849.999us,850us,850.049us,850.05us,850.099us,850.1us,850.149us,850.15us,850.199us,850.2us,850.249us,850.25us,850.299us,850.3us,850.349us,850.35us,850.399us,850.4us,850.449us,850.45us,850.499us,850.5us,850.549us,850.55us,850.599us,850.6us,850.649us,850.65us,850.699us,850.7us,850.749us,850.75us,850.799us,850.8us,850.849us,850.85us,850.899us,850.9us,850.949us,850.95us,850.999us,851us,851.049us,851.05us,851.099us,851.1us,851.149us,851.15us,851.199us,851.2us,851.249us,851.25us,851.299us,851.3us,851.349us,851.35us,851.399us,851.4us,851.449us,851.45us,851.499us,851.5us,851.549us,851.55us,851.599us,851.6us,851.649us,851.65us,851.699us,851.7us,851.749us,851.75us,851.799us,851.8us,851.849us,851.85us,851.899us,851.9us,851.949us,851.95us,851.999us,852us,852.049us,852.05us,852.099us,852.1us,852.149us,852.15us,852.199us,852.2us,852.249us,852.25us,852.299us,852.3us,852.349us,852.35us,852.399us,852.4us,852.449us,852.45us,852.499us,852.5us,852.549us,852.55us,852.599us,852.6us,852.649us,852.65us,852.699us,852.7us,852.749us,852.75us,852.799us,852.8us,852.849us,852.85us,852.899us,852.9us,852.949us,852.95us,852.999us,853us,853.049us,853.05us,853.099us,853.1us,853.149us,853.15us,853.199us,853.2us,853.249us,853.25us,853.299us,853.3us,853.349us,853.35us,853.399us,853.4us,853.449us,853.45us,853.499us,853.5us,853.549us,853.55us,853.599us,853.6us,853.649us,853.65us,853.699us,853.7us,853.749us,853.75us,853.799us,853.8us,853.849us,853.85us,853.899us,853.9us,853.949us,853.95us,853.999us,854us,854.049us,854.05us,854.099us,854.1us,854.149us,854.15us,854.199us,854.2us,854.249us,854.25us,854.299us,854.3us,854.349us,854.35us,854.399us,854.4us,854.449us,854.45us,854.499us,854.5us,854.549us,854.55us,854.599us,854.6us,854.649us,854.65us,854.699us,854.7us,854.749us,854.75us,854.799us,854.8us,854.849us,854.85us,854.899us,854.9us,854.949us,854.95us,854.999us,855us,855.049us,855.05us,855.099us,855.1us,855.149us,855.15us,855.199us,855.2us,855.249us,855.25us,855.299us,855.3us,855.349us,855.35us,855.399us,855.4us,855.449us,855.45us,855.499us,855.5us,855.549us,855.55us,855.599us,855.6us,855.649us,855.65us,855.699us,855.7us,855.749us,855.75us,855.799us,855.8us,855.849us,855.85us,855.899us,855.9us,855.949us,855.95us,855.999us,856us,856.049us,856.05us,856.099us,856.1us,856.149us,856.15us,856.199us,856.2us,856.249us,856.25us,856.299us,856.3us,856.349us,856.35us,856.399us,856.4us,856.449us,856.45us,856.499us,856.5us,856.549us,856.55us,856.599us,856.6us,856.649us,856.65us,856.699us,856.7us,856.749us,856.75us,856.799us,856.8us,856.849us,856.85us,856.899us,856.9us,856.949us,856.95us,856.999us,857us,857.049us,857.05us,857.099us,857.1us,857.149us,857.15us,857.199us,857.2us,857.249us,857.25us,857.299us,857.3us,857.349us,857.35us,857.399us,857.4us,857.449us,857.45us,857.499us,857.5us,857.549us,857.55us,857.599us,857.6us,857.649us,857.65us,857.699us,857.7us,857.749us,857.75us,857.799us,857.8us,857.849us,857.85us,857.899us,857.9us,857.949us,857.95us,857.999us,858us,858.049us,858.05us,858.099us,858.1us,858.149us,858.15us,858.199us,858.2us,858.249us,858.25us,858.299us,858.3us,858.349us,858.35us,858.399us,858.4us,858.449us,858.45us,858.499us,858.5us,858.549us,858.55us,858.599us,858.6us,858.649us,858.65us,858.699us,858.7us,858.749us,858.75us,858.799us,858.8us,858.849us,858.85us,858.899us,858.9us,858.949us,858.95us,858.999us,859us,859.049us,859.05us,859.099us,859.1us,859.149us,859.15us,859.199us,859.2us,859.249us,859.25us,859.299us,859.3us,859.349us,859.35us,859.399us,859.4us,859.449us,859.45us,859.499us,859.5us,859.549us,859.55us,859.599us,859.6us,859.649us,859.65us,859.699us,859.7us,859.749us,859.75us,859.799us,859.8us,859.849us,859.85us,859.899us,859.9us,859.949us,859.95us,859.999us,860us,860.049us,860.05us,860.099us,860.1us,860.149us,860.15us,860.199us,860.2us,860.249us,860.25us,860.299us,860.3us,860.349us,860.35us,860.399us,860.4us,860.449us,860.45us,860.499us,860.5us,860.549us,860.55us,860.599us,860.6us,860.649us,860.65us,860.699us,860.7us,860.749us,860.75us,860.799us,860.8us,860.849us,860.85us,860.899us,860.9us,860.949us,860.95us,860.999us,861us,861.049us,861.05us,861.099us,861.1us,861.149us,861.15us,861.199us,861.2us,861.249us,861.25us,861.299us,861.3us,861.349us,861.35us,861.399us,861.4us,861.449us,861.45us,861.499us,861.5us,861.549us,861.55us,861.599us,861.6us,861.649us,861.65us,861.699us,861.7us,861.749us,861.75us,861.799us,861.8us,861.849us,861.85us,861.899us,861.9us,861.949us,861.95us,861.999us,862us,862.049us,862.05us,862.099us,862.1us,862.149us,862.15us,862.199us,862.2us,862.249us,862.25us,862.299us,862.3us,862.349us,862.35us,862.399us,862.4us,862.449us,862.45us,862.499us,862.5us,862.549us,862.55us,862.599us,862.6us,862.649us,862.65us,862.699us,862.7us,862.749us,862.75us,862.799us,862.8us,862.849us,862.85us,862.899us,862.9us,862.949us,862.95us,862.999us,863us,863.049us,863.05us,863.099us,863.1us,863.149us,863.15us,863.199us,863.2us,863.249us,863.25us,863.299us,863.3us,863.349us,863.35us,863.399us,863.4us,863.449us,863.45us,863.499us,863.5us,863.549us,863.55us,863.599us,863.6us,863.649us,863.65us,863.699us,863.7us,863.749us,863.75us,863.799us,863.8us,863.849us,863.85us,863.899us,863.9us,863.949us,863.95us,863.999us,864us,864.049us,864.05us,864.099us,864.1us,864.149us,864.15us,864.199us,864.2us,864.249us,864.25us,864.299us,864.3us,864.349us,864.35us,864.399us,864.4us,864.449us,864.45us,864.499us,864.5us,864.549us,864.55us,864.599us,864.6us,864.649us,864.65us,864.699us,864.7us,864.749us,864.75us,864.799us,864.8us,864.849us,864.85us,864.899us,864.9us,864.949us,864.95us,864.999us,865us,865.049us,865.05us,865.099us,865.1us,865.149us,865.15us,865.199us,865.2us,865.249us,865.25us,865.299us,865.3us,865.349us,865.35us,865.399us,865.4us,865.449us,865.45us,865.499us,865.5us,865.549us,865.55us,865.599us,865.6us,865.649us,865.65us,865.699us,865.7us,865.749us,865.75us,865.799us,865.8us,865.849us,865.85us,865.899us,865.9us,865.949us,865.95us,865.999us,866us,866.049us,866.05us,866.099us,866.1us,866.149us,866.15us,866.199us,866.2us,866.249us,866.25us,866.299us,866.3us,866.349us,866.35us,866.399us,866.4us,866.449us,866.45us,866.499us,866.5us,866.549us,866.55us,866.599us,866.6us,866.649us,866.65us,866.699us,866.7us,866.749us,866.75us,866.799us,866.8us,866.849us,866.85us,866.899us,866.9us,866.949us,866.95us,866.999us,867us,867.049us,867.05us,867.099us,867.1us,867.149us,867.15us,867.199us,867.2us,867.249us,867.25us,867.299us,867.3us,867.349us,867.35us,867.399us,867.4us,867.449us,867.45us,867.499us,867.5us,867.549us,867.55us,867.599us,867.6us,867.649us,867.65us,867.699us,867.7us,867.749us,867.75us,867.799us,867.8us,867.849us,867.85us,867.899us,867.9us,867.949us,867.95us,867.999us,868us,868.049us,868.05us,868.099us,868.1us,868.149us,868.15us,868.199us,868.2us,868.249us,868.25us,868.299us,868.3us,868.349us,868.35us,868.399us,868.4us,868.449us,868.45us,868.499us,868.5us,868.549us,868.55us,868.599us,868.6us,868.649us,868.65us,868.699us,868.7us,868.749us,868.75us,868.799us,868.8us,868.849us,868.85us,868.899us,868.9us,868.949us,868.95us,868.999us,869us,869.049us,869.05us,869.099us,869.1us,869.149us,869.15us,869.199us,869.2us,869.249us,869.25us,869.299us,869.3us,869.349us,869.35us,869.399us,869.4us,869.449us,869.45us,869.499us,869.5us,869.549us,869.55us,869.599us,869.6us,869.649us,869.65us,869.699us,869.7us,869.749us,869.75us,869.799us,869.8us,869.849us,869.85us,869.899us,869.9us,869.949us,869.95us,869.999us,870us,870.049us,870.05us,870.099us,870.1us,870.149us,870.15us,870.199us,870.2us,870.249us,870.25us,870.299us,870.3us,870.349us,870.35us,870.399us,870.4us,870.449us,870.45us,870.499us,870.5us,870.549us,870.55us,870.599us,870.6us,870.649us,870.65us,870.699us,870.7us,870.749us,870.75us,870.799us,870.8us,870.849us,870.85us,870.899us,870.9us,870.949us,870.95us,870.999us,871us,871.049us,871.05us,871.099us,871.1us,871.149us,871.15us,871.199us,871.2us,871.249us,871.25us,871.299us,871.3us,871.349us,871.35us,871.399us,871.4us,871.449us,871.45us,871.499us,871.5us,871.549us,871.55us,871.599us,871.6us,871.649us,871.65us,871.699us,871.7us,871.749us,871.75us,871.799us,871.8us,871.849us,871.85us,871.899us,871.9us,871.949us,871.95us,871.999us,872us,872.049us,872.05us,872.099us,872.1us,872.149us,872.15us,872.199us,872.2us,872.249us,872.25us,872.299us,872.3us,872.349us,872.35us,872.399us,872.4us,872.449us,872.45us,872.499us,872.5us,872.549us,872.55us,872.599us,872.6us,872.649us,872.65us,872.699us,872.7us,872.749us,872.75us,872.799us,872.8us,872.849us,872.85us,872.899us,872.9us,872.949us,872.95us,872.999us,873us,873.049us,873.05us,873.099us,873.1us,873.149us,873.15us,873.199us,873.2us,873.249us,873.25us,873.299us,873.3us,873.349us,873.35us,873.399us,873.4us,873.449us,873.45us,873.499us,873.5us,873.549us,873.55us,873.599us,873.6us,873.649us,873.65us,873.699us,873.7us,873.749us,873.75us,873.799us,873.8us,873.849us,873.85us,873.899us,873.9us,873.949us,873.95us,873.999us,874us,874.049us,874.05us,874.099us,874.1us,874.149us,874.15us,874.199us,874.2us,874.249us,874.25us,874.299us,874.3us,874.349us,874.35us,874.399us,874.4us,874.449us,874.45us,874.499us,874.5us,874.549us,874.55us,874.599us,874.6us,874.649us,874.65us,874.699us,874.7us,874.749us,874.75us,874.799us,874.8us,874.849us,874.85us,874.899us,874.9us,874.949us,874.95us,874.999us,875us,875.049us,875.05us,875.099us,875.1us,875.149us,875.15us,875.199us,875.2us,875.249us,875.25us,875.299us,875.3us,875.349us,875.35us,875.399us,875.4us,875.449us,875.45us,875.499us,875.5us,875.549us,875.55us,875.599us,875.6us,875.649us,875.65us,875.699us,875.7us,875.749us,875.75us,875.799us,875.8us,875.849us,875.85us,875.899us,875.9us,875.949us,875.95us,875.999us,876us,876.049us,876.05us,876.099us,876.1us,876.149us,876.15us,876.199us,876.2us,876.249us,876.25us,876.299us,876.3us,876.349us,876.35us,876.399us,876.4us,876.449us,876.45us,876.499us,876.5us,876.549us,876.55us,876.599us,876.6us,876.649us,876.65us,876.699us,876.7us,876.749us,876.75us,876.799us,876.8us,876.849us,876.85us,876.899us,876.9us,876.949us,876.95us,876.999us,877us,877.049us,877.05us,877.099us,877.1us,877.149us,877.15us,877.199us,877.2us,877.249us,877.25us,877.299us,877.3us,877.349us,877.35us,877.399us,877.4us,877.449us,877.45us,877.499us,877.5us,877.549us,877.55us,877.599us,877.6us,877.649us,877.65us,877.699us,877.7us,877.749us,877.75us,877.799us,877.8us,877.849us,877.85us,877.899us,877.9us,877.949us,877.95us,877.999us,878us,878.049us,878.05us,878.099us,878.1us,878.149us,878.15us,878.199us,878.2us,878.249us,878.25us,878.299us,878.3us,878.349us,878.35us,878.399us,878.4us,878.449us,878.45us,878.499us,878.5us,878.549us,878.55us,878.599us,878.6us,878.649us,878.65us,878.699us,878.7us,878.749us,878.75us,878.799us,878.8us,878.849us,878.85us,878.899us,878.9us,878.949us,878.95us,878.999us,879us,879.049us,879.05us,879.099us,879.1us,879.149us,879.15us,879.199us,879.2us,879.249us,879.25us,879.299us,879.3us,879.349us,879.35us,879.399us,879.4us,879.449us,879.45us,879.499us,879.5us,879.549us,879.55us,879.599us,879.6us,879.649us,879.65us,879.699us,879.7us,879.749us,879.75us,879.799us,879.8us,879.849us,879.85us,879.899us,879.9us,879.949us,879.95us,879.999us,880us,880.049us,880.05us,880.099us,880.1us,880.149us,880.15us,880.199us,880.2us,880.249us,880.25us,880.299us,880.3us,880.349us,880.35us,880.399us,880.4us,880.449us,880.45us,880.499us,880.5us,880.549us,880.55us,880.599us,880.6us,880.649us,880.65us,880.699us,880.7us,880.749us,880.75us,880.799us,880.8us,880.849us,880.85us,880.899us,880.9us,880.949us,880.95us,880.999us,881us,881.049us,881.05us,881.099us,881.1us,881.149us,881.15us,881.199us,881.2us,881.249us,881.25us,881.299us,881.3us,881.349us,881.35us,881.399us,881.4us,881.449us,881.45us,881.499us,881.5us,881.549us,881.55us,881.599us,881.6us,881.649us,881.65us,881.699us,881.7us,881.749us,881.75us,881.799us,881.8us,881.849us,881.85us,881.899us,881.9us,881.949us,881.95us,881.999us,882us,882.049us,882.05us,882.099us,882.1us,882.149us,882.15us,882.199us,882.2us,882.249us,882.25us,882.299us,882.3us,882.349us,882.35us,882.399us,882.4us,882.449us,882.45us,882.499us,882.5us,882.549us,882.55us,882.599us,882.6us,882.649us,882.65us,882.699us,882.7us,882.749us,882.75us,882.799us,882.8us,882.849us,882.85us,882.899us,882.9us,882.949us,882.95us,882.999us,883us,883.049us,883.05us,883.099us,883.1us,883.149us,883.15us,883.199us,883.2us,883.249us,883.25us,883.299us,883.3us,883.349us,883.35us,883.399us,883.4us,883.449us,883.45us,883.499us,883.5us,883.549us,883.55us,883.599us,883.6us,883.649us,883.65us,883.699us,883.7us,883.749us,883.75us,883.799us,883.8us,883.849us,883.85us,883.899us,883.9us,883.949us,883.95us,883.999us,884us,884.049us,884.05us,884.099us,884.1us,884.149us,884.15us,884.199us,884.2us,884.249us,884.25us,884.299us,884.3us,884.349us,884.35us,884.399us,884.4us,884.449us,884.45us,884.499us,884.5us,884.549us,884.55us,884.599us,884.6us,884.649us,884.65us,884.699us,884.7us,884.749us,884.75us,884.799us,884.8us,884.849us,884.85us,884.899us,884.9us,884.949us,884.95us,884.999us,885us,885.049us,885.05us,885.099us,885.1us,885.149us,885.15us,885.199us,885.2us,885.249us,885.25us,885.299us,885.3us,885.349us,885.35us,885.399us,885.4us,885.449us,885.45us,885.499us,885.5us,885.549us,885.55us,885.599us,885.6us,885.649us,885.65us,885.699us,885.7us,885.749us,885.75us,885.799us,885.8us,885.849us,885.85us,885.899us,885.9us,885.949us,885.95us,885.999us,886us,886.049us,886.05us,886.099us,886.1us,886.149us,886.15us,886.199us,886.2us,886.249us,886.25us,886.299us,886.3us,886.349us,886.35us,886.399us,886.4us,886.449us,886.45us,886.499us,886.5us,886.549us,886.55us,886.599us,886.6us,886.649us,886.65us,886.699us,886.7us,886.749us,886.75us,886.799us,886.8us,886.849us,886.85us,886.899us,886.9us,886.949us,886.95us,886.999us,887us,887.049us,887.05us,887.099us,887.1us,887.149us,887.15us,887.199us,887.2us,887.249us,887.25us,887.299us,887.3us,887.349us,887.35us,887.399us,887.4us,887.449us,887.45us,887.499us,887.5us,887.549us,887.55us,887.599us,887.6us,887.649us,887.65us,887.699us,887.7us,887.749us,887.75us,887.799us,887.8us,887.849us,887.85us,887.899us,887.9us,887.949us,887.95us,887.999us,888us,888.049us,888.05us,888.099us,888.1us,888.149us,888.15us,888.199us,888.2us,888.249us,888.25us,888.299us,888.3us,888.349us,888.35us,888.399us,888.4us,888.449us,888.45us,888.499us,888.5us,888.549us,888.55us,888.599us,888.6us,888.649us,888.65us,888.699us,888.7us,888.749us,888.75us,888.799us,888.8us,888.849us,888.85us,888.899us,888.9us,888.949us,888.95us,888.999us,889us,889.049us,889.05us,889.099us,889.1us,889.149us,889.15us,889.199us,889.2us,889.249us,889.25us,889.299us,889.3us,889.349us,889.35us,889.399us,889.4us,889.449us,889.45us,889.499us,889.5us,889.549us,889.55us,889.599us,889.6us,889.649us,889.65us,889.699us,889.7us,889.749us,889.75us,889.799us,889.8us,889.849us,889.85us,889.899us,889.9us,889.949us,889.95us,889.999us,890us,890.049us,890.05us,890.099us,890.1us,890.149us,890.15us,890.199us,890.2us,890.249us,890.25us,890.299us,890.3us,890.349us,890.35us,890.399us,890.4us,890.449us,890.45us,890.499us,890.5us,890.549us,890.55us,890.599us,890.6us,890.649us,890.65us,890.699us,890.7us,890.749us,890.75us,890.799us,890.8us,890.849us,890.85us,890.899us,890.9us,890.949us,890.95us,890.999us,891us,891.049us,891.05us,891.099us,891.1us,891.149us,891.15us,891.199us,891.2us,891.249us,891.25us,891.299us,891.3us,891.349us,891.35us,891.399us,891.4us,891.449us,891.45us,891.499us,891.5us,891.549us,891.55us,891.599us,891.6us,891.649us,891.65us,891.699us,891.7us,891.749us,891.75us,891.799us,891.8us,891.849us,891.85us,891.899us,891.9us,891.949us,891.95us,891.999us,892us,892.049us,892.05us,892.099us,892.1us,892.149us,892.15us,892.199us,892.2us,892.249us,892.25us,892.299us,892.3us,892.349us,892.35us,892.399us,892.4us,892.449us,892.45us,892.499us,892.5us,892.549us,892.55us,892.599us,892.6us,892.649us,892.65us,892.699us,892.7us,892.749us,892.75us,892.799us,892.8us,892.849us,892.85us,892.899us,892.9us,892.949us,892.95us,892.999us,893us,893.049us,893.05us,893.099us,893.1us,893.149us,893.15us,893.199us,893.2us,893.249us,893.25us,893.299us,893.3us,893.349us,893.35us,893.399us,893.4us,893.449us,893.45us,893.499us,893.5us,893.549us,893.55us,893.599us,893.6us,893.649us,893.65us,893.699us,893.7us,893.749us,893.75us,893.799us,893.8us,893.849us,893.85us,893.899us,893.9us,893.949us,893.95us,893.999us,894us,894.049us,894.05us,894.099us,894.1us,894.149us,894.15us,894.199us,894.2us,894.249us,894.25us,894.299us,894.3us,894.349us,894.35us,894.399us,894.4us,894.449us,894.45us,894.499us,894.5us,894.549us,894.55us,894.599us,894.6us,894.649us,894.65us,894.699us,894.7us,894.749us,894.75us,894.799us,894.8us,894.849us,894.85us,894.899us,894.9us,894.949us,894.95us,894.999us,895us,895.049us,895.05us,895.099us,895.1us,895.149us,895.15us,895.199us,895.2us,895.249us,895.25us,895.299us,895.3us,895.349us,895.35us,895.399us,895.4us,895.449us,895.45us,895.499us,895.5us,895.549us,895.55us,895.599us,895.6us,895.649us,895.65us,895.699us,895.7us,895.749us,895.75us,895.799us,895.8us,895.849us,895.85us,895.899us,895.9us,895.949us,895.95us,895.999us,896us,896.049us,896.05us,896.099us,896.1us,896.149us,896.15us,896.199us,896.2us,896.249us,896.25us,896.299us,896.3us,896.349us,896.35us,896.399us,896.4us,896.449us,896.45us,896.499us,896.5us,896.549us,896.55us,896.599us,896.6us,896.649us,896.65us,896.699us,896.7us,896.749us,896.75us,896.799us,896.8us,896.849us,896.85us,896.899us,896.9us,896.949us,896.95us,896.999us,897us,897.049us,897.05us,897.099us,897.1us,897.149us,897.15us,897.199us,897.2us,897.249us,897.25us,897.299us,897.3us,897.349us,897.35us,897.399us,897.4us,897.449us,897.45us,897.499us,897.5us,897.549us,897.55us,897.599us,897.6us,897.649us,897.65us,897.699us,897.7us,897.749us,897.75us,897.799us,897.8us,897.849us,897.85us,897.899us,897.9us,897.949us,897.95us,897.999us,898us,898.049us,898.05us,898.099us,898.1us,898.149us,898.15us,898.199us,898.2us,898.249us,898.25us,898.299us,898.3us,898.349us,898.35us,898.399us,898.4us,898.449us,898.45us,898.499us,898.5us,898.549us,898.55us,898.599us,898.6us,898.649us,898.65us,898.699us,898.7us,898.749us,898.75us,898.799us,898.8us,898.849us,898.85us,898.899us,898.9us,898.949us,898.95us,898.999us,899us,899.049us,899.05us,899.099us,899.1us,899.149us,899.15us,899.199us,899.2us,899.249us,899.25us,899.299us,899.3us,899.349us,899.35us,899.399us,899.4us,899.449us,899.45us,899.499us,899.5us,899.549us,899.55us,899.599us,899.6us,899.649us,899.65us,899.699us,899.7us,899.749us,899.75us,899.799us,899.8us,899.849us,899.85us,899.899us,899.9us,899.949us,899.95us,899.999us,900us,900.049us,900.05us,900.099us,900.1us,900.149us,900.15us,900.199us,900.2us,900.249us,900.25us,900.299us,900.3us,900.349us,900.35us,900.399us,900.4us,900.449us,900.45us,900.499us,900.5us,900.549us,900.55us,900.599us,900.6us,900.649us,900.65us,900.699us,900.7us,900.749us,900.75us,900.799us,900.8us,900.849us,900.85us,900.899us,900.9us,900.949us,900.95us,900.999us,901us,901.049us,901.05us,901.099us,901.1us,901.149us,901.15us,901.199us,901.2us,901.249us,901.25us,901.299us,901.3us,901.349us,901.35us,901.399us,901.4us,901.449us,901.45us,901.499us,901.5us,901.549us,901.55us,901.599us,901.6us,901.649us,901.65us,901.699us,901.7us,901.749us,901.75us,901.799us,901.8us,901.849us,901.85us,901.899us,901.9us,901.949us,901.95us,901.999us,902us,902.049us,902.05us,902.099us,902.1us,902.149us,902.15us,902.199us,902.2us,902.249us,902.25us,902.299us,902.3us,902.349us,902.35us,902.399us,902.4us,902.449us,902.45us,902.499us,902.5us,902.549us,902.55us,902.599us,902.6us,902.649us,902.65us,902.699us,902.7us,902.749us,902.75us,902.799us,902.8us,902.849us,902.85us,902.899us,902.9us,902.949us,902.95us,902.999us,903us,903.049us,903.05us,903.099us,903.1us,903.149us,903.15us,903.199us,903.2us,903.249us,903.25us,903.299us,903.3us,903.349us,903.35us,903.399us,903.4us,903.449us,903.45us,903.499us,903.5us,903.549us,903.55us,903.599us,903.6us,903.649us,903.65us,903.699us,903.7us,903.749us,903.75us,903.799us,903.8us,903.849us,903.85us,903.899us,903.9us,903.949us,903.95us,903.999us,904us,904.049us,904.05us,904.099us,904.1us,904.149us,904.15us,904.199us,904.2us,904.249us,904.25us,904.299us,904.3us,904.349us,904.35us,904.399us,904.4us,904.449us,904.45us,904.499us,904.5us,904.549us,904.55us,904.599us,904.6us,904.649us,904.65us,904.699us,904.7us,904.749us,904.75us,904.799us,904.8us,904.849us,904.85us,904.899us,904.9us,904.949us,904.95us,904.999us,905us,905.049us,905.05us,905.099us,905.1us,905.149us,905.15us,905.199us,905.2us,905.249us,905.25us,905.299us,905.3us,905.349us,905.35us,905.399us,905.4us,905.449us,905.45us,905.499us,905.5us,905.549us,905.55us,905.599us,905.6us,905.649us,905.65us,905.699us,905.7us,905.749us,905.75us,905.799us,905.8us,905.849us,905.85us,905.899us,905.9us,905.949us,905.95us,905.999us,906us,906.049us,906.05us,906.099us,906.1us,906.149us,906.15us,906.199us,906.2us,906.249us,906.25us,906.299us,906.3us,906.349us,906.35us,906.399us,906.4us,906.449us,906.45us,906.499us,906.5us,906.549us,906.55us,906.599us,906.6us,906.649us,906.65us,906.699us,906.7us,906.749us,906.75us,906.799us,906.8us,906.849us,906.85us,906.899us,906.9us,906.949us,906.95us,906.999us,907us,907.049us,907.05us,907.099us,907.1us,907.149us,907.15us,907.199us,907.2us,907.249us,907.25us,907.299us,907.3us,907.349us,907.35us,907.399us,907.4us,907.449us,907.45us,907.499us,907.5us,907.549us,907.55us,907.599us,907.6us,907.649us,907.65us,907.699us,907.7us,907.749us,907.75us,907.799us,907.8us,907.849us,907.85us,907.899us,907.9us,907.949us,907.95us,907.999us,908us,908.049us,908.05us,908.099us,908.1us,908.149us,908.15us,908.199us,908.2us,908.249us,908.25us,908.299us,908.3us,908.349us,908.35us,908.399us,908.4us,908.449us,908.45us,908.499us,908.5us,908.549us,908.55us,908.599us,908.6us,908.649us,908.65us,908.699us,908.7us,908.749us,908.75us,908.799us,908.8us,908.849us,908.85us,908.899us,908.9us,908.949us,908.95us,908.999us,909us,909.049us,909.05us,909.099us,909.1us,909.149us,909.15us,909.199us,909.2us,909.249us,909.25us,909.299us,909.3us,909.349us,909.35us,909.399us,909.4us,909.449us,909.45us,909.499us,909.5us,909.549us,909.55us,909.599us,909.6us,909.649us,909.65us,909.699us,909.7us,909.749us,909.75us,909.799us,909.8us,909.849us,909.85us,909.899us,909.9us,909.949us,909.95us,909.999us,910us,910.049us,910.05us,910.099us,910.1us,910.149us,910.15us,910.199us,910.2us,910.249us,910.25us,910.299us,910.3us,910.349us,910.35us,910.399us,910.4us,910.449us,910.45us,910.499us,910.5us,910.549us,910.55us,910.599us,910.6us,910.649us,910.65us,910.699us,910.7us,910.749us,910.75us,910.799us,910.8us,910.849us,910.85us,910.899us,910.9us,910.949us,910.95us,910.999us,911us,911.049us,911.05us,911.099us,911.1us,911.149us,911.15us,911.199us,911.2us,911.249us,911.25us,911.299us,911.3us,911.349us,911.35us,911.399us,911.4us,911.449us,911.45us,911.499us,911.5us,911.549us,911.55us,911.599us,911.6us,911.649us,911.65us,911.699us,911.7us,911.749us,911.75us,911.799us,911.8us,911.849us,911.85us,911.899us,911.9us,911.949us,911.95us,911.999us,912us,912.049us,912.05us,912.099us,912.1us,912.149us,912.15us,912.199us,912.2us,912.249us,912.25us,912.299us,912.3us,912.349us,912.35us,912.399us,912.4us,912.449us,912.45us,912.499us,912.5us,912.549us,912.55us,912.599us,912.6us,912.649us,912.65us,912.699us,912.7us,912.749us,912.75us,912.799us,912.8us,912.849us,912.85us,912.899us,912.9us,912.949us,912.95us,912.999us,913us,913.049us,913.05us,913.099us,913.1us,913.149us,913.15us,913.199us,913.2us,913.249us,913.25us,913.299us,913.3us,913.349us,913.35us,913.399us,913.4us,913.449us,913.45us,913.499us,913.5us,913.549us,913.55us,913.599us,913.6us,913.649us,913.65us,913.699us,913.7us,913.749us,913.75us,913.799us,913.8us,913.849us,913.85us,913.899us,913.9us,913.949us,913.95us,913.999us,914us,914.049us,914.05us,914.099us,914.1us,914.149us,914.15us,914.199us,914.2us,914.249us,914.25us,914.299us,914.3us,914.349us,914.35us,914.399us,914.4us,914.449us,914.45us,914.499us,914.5us,914.549us,914.55us,914.599us,914.6us,914.649us,914.65us,914.699us,914.7us,914.749us,914.75us,914.799us,914.8us,914.849us,914.85us,914.899us,914.9us,914.949us,914.95us,914.999us,915us,915.049us,915.05us,915.099us,915.1us,915.149us,915.15us,915.199us,915.2us,915.249us,915.25us,915.299us,915.3us,915.349us,915.35us,915.399us,915.4us,915.449us,915.45us,915.499us,915.5us,915.549us,915.55us,915.599us,915.6us,915.649us,915.65us,915.699us,915.7us,915.749us,915.75us,915.799us,915.8us,915.849us,915.85us,915.899us,915.9us,915.949us,915.95us,915.999us,916us,916.049us,916.05us,916.099us,916.1us,916.149us,916.15us,916.199us,916.2us,916.249us,916.25us,916.299us,916.3us,916.349us,916.35us,916.399us,916.4us,916.449us,916.45us,916.499us,916.5us,916.549us,916.55us,916.599us,916.6us,916.649us,916.65us,916.699us,916.7us,916.749us,916.75us,916.799us,916.8us,916.849us,916.85us,916.899us,916.9us,916.949us,916.95us,916.999us,917us,917.049us,917.05us,917.099us,917.1us,917.149us,917.15us,917.199us,917.2us,917.249us,917.25us,917.299us,917.3us,917.349us,917.35us,917.399us,917.4us,917.449us,917.45us,917.499us,917.5us,917.549us,917.55us,917.599us,917.6us,917.649us,917.65us,917.699us,917.7us,917.749us,917.75us,917.799us,917.8us,917.849us,917.85us,917.899us,917.9us,917.949us,917.95us,917.999us,918us,918.049us,918.05us,918.099us,918.1us,918.149us,918.15us,918.199us,918.2us,918.249us,918.25us,918.299us,918.3us,918.349us,918.35us,918.399us,918.4us,918.449us,918.45us,918.499us,918.5us,918.549us,918.55us,918.599us,918.6us,918.649us,918.65us,918.699us,918.7us,918.749us,918.75us,918.799us,918.8us,918.849us,918.85us,918.899us,918.9us,918.949us,918.95us,918.999us,919us,919.049us,919.05us,919.099us,919.1us,919.149us,919.15us,919.199us,919.2us,919.249us,919.25us,919.299us,919.3us,919.349us,919.35us,919.399us,919.4us,919.449us,919.45us,919.499us,919.5us,919.549us,919.55us,919.599us,919.6us,919.649us,919.65us,919.699us,919.7us,919.749us,919.75us,919.799us,919.8us,919.849us,919.85us,919.899us,919.9us,919.949us,919.95us,919.999us,920us,920.049us,920.05us,920.099us,920.1us,920.149us,920.15us,920.199us,920.2us,920.249us,920.25us,920.299us,920.3us,920.349us,920.35us,920.399us,920.4us,920.449us,920.45us,920.499us,920.5us,920.549us,920.55us,920.599us,920.6us,920.649us,920.65us,920.699us,920.7us,920.749us,920.75us,920.799us,920.8us,920.849us,920.85us,920.899us,920.9us,920.949us,920.95us,920.999us,921us,921.049us,921.05us,921.099us,921.1us,921.149us,921.15us,921.199us,921.2us,921.249us,921.25us,921.299us,921.3us,921.349us,921.35us,921.399us,921.4us,921.449us,921.45us,921.499us,921.5us,921.549us,921.55us,921.599us,921.6us,921.649us,921.65us,921.699us,921.7us,921.749us,921.75us,921.799us,921.8us,921.849us,921.85us,921.899us,921.9us,921.949us,921.95us,921.999us,922us,922.049us,922.05us,922.099us,922.1us,922.149us,922.15us,922.199us,922.2us,922.249us,922.25us,922.299us,922.3us,922.349us,922.35us,922.399us,922.4us,922.449us,922.45us,922.499us,922.5us,922.549us,922.55us,922.599us,922.6us,922.649us,922.65us,922.699us,922.7us,922.749us,922.75us,922.799us,922.8us,922.849us,922.85us,922.899us,922.9us,922.949us,922.95us,922.999us,923us,923.049us,923.05us,923.099us,923.1us,923.149us,923.15us,923.199us,923.2us,923.249us,923.25us,923.299us,923.3us,923.349us,923.35us,923.399us,923.4us,923.449us,923.45us,923.499us,923.5us,923.549us,923.55us,923.599us,923.6us,923.649us,923.65us,923.699us,923.7us,923.749us,923.75us,923.799us,923.8us,923.849us,923.85us,923.899us,923.9us,923.949us,923.95us,923.999us,924us,924.049us,924.05us,924.099us,924.1us,924.149us,924.15us,924.199us,924.2us,924.249us,924.25us,924.299us,924.3us,924.349us,924.35us,924.399us,924.4us,924.449us,924.45us,924.499us,924.5us,924.549us,924.55us,924.599us,924.6us,924.649us,924.65us,924.699us,924.7us,924.749us,924.75us,924.799us,924.8us,924.849us,924.85us,924.899us,924.9us,924.949us,924.95us,924.999us,925us,925.049us,925.05us,925.099us,925.1us,925.149us,925.15us,925.199us,925.2us,925.249us,925.25us,925.299us,925.3us,925.349us,925.35us,925.399us,925.4us,925.449us,925.45us,925.499us,925.5us,925.549us,925.55us,925.599us,925.6us,925.649us,925.65us,925.699us,925.7us,925.749us,925.75us,925.799us,925.8us,925.849us,925.85us,925.899us,925.9us,925.949us,925.95us,925.999us,926us,926.049us,926.05us,926.099us,926.1us,926.149us,926.15us,926.199us,926.2us,926.249us,926.25us,926.299us,926.3us,926.349us,926.35us,926.399us,926.4us,926.449us,926.45us,926.499us,926.5us,926.549us,926.55us,926.599us,926.6us,926.649us,926.65us,926.699us,926.7us,926.749us,926.75us,926.799us,926.8us,926.849us,926.85us,926.899us,926.9us,926.949us,926.95us,926.999us,927us,927.049us,927.05us,927.099us,927.1us,927.149us,927.15us,927.199us,927.2us,927.249us,927.25us,927.299us,927.3us,927.349us,927.35us,927.399us,927.4us,927.449us,927.45us,927.499us,927.5us,927.549us,927.55us,927.599us,927.6us,927.649us,927.65us,927.699us,927.7us,927.749us,927.75us,927.799us,927.8us,927.849us,927.85us,927.899us,927.9us,927.949us,927.95us,927.999us,928us,928.049us,928.05us,928.099us,928.1us,928.149us,928.15us,928.199us,928.2us,928.249us,928.25us,928.299us,928.3us,928.349us,928.35us,928.399us,928.4us,928.449us,928.45us,928.499us,928.5us,928.549us,928.55us,928.599us,928.6us,928.649us,928.65us,928.699us,928.7us,928.749us,928.75us,928.799us,928.8us,928.849us,928.85us,928.899us,928.9us,928.949us,928.95us,928.999us,929us,929.049us,929.05us,929.099us,929.1us,929.149us,929.15us,929.199us,929.2us,929.249us,929.25us,929.299us,929.3us,929.349us,929.35us,929.399us,929.4us,929.449us,929.45us,929.499us,929.5us,929.549us,929.55us,929.599us,929.6us,929.649us,929.65us,929.699us,929.7us,929.749us,929.75us,929.799us,929.8us,929.849us,929.85us,929.899us,929.9us,929.949us,929.95us,929.999us,930us,930.049us,930.05us,930.099us,930.1us,930.149us,930.15us,930.199us,930.2us,930.249us,930.25us,930.299us,930.3us,930.349us,930.35us,930.399us,930.4us,930.449us,930.45us,930.499us,930.5us,930.549us,930.55us,930.599us,930.6us,930.649us,930.65us,930.699us,930.7us,930.749us,930.75us,930.799us,930.8us,930.849us,930.85us,930.899us,930.9us,930.949us,930.95us,930.999us,931us,931.049us,931.05us,931.099us,931.1us,931.149us,931.15us,931.199us,931.2us,931.249us,931.25us,931.299us,931.3us,931.349us,931.35us,931.399us,931.4us,931.449us,931.45us,931.499us,931.5us,931.549us,931.55us,931.599us,931.6us,931.649us,931.65us,931.699us,931.7us,931.749us,931.75us,931.799us,931.8us,931.849us,931.85us,931.899us,931.9us,931.949us,931.95us,931.999us,932us,932.049us,932.05us,932.099us,932.1us,932.149us,932.15us,932.199us,932.2us,932.249us,932.25us,932.299us,932.3us,932.349us,932.35us,932.399us,932.4us,932.449us,932.45us,932.499us,932.5us,932.549us,932.55us,932.599us,932.6us,932.649us,932.65us,932.699us,932.7us,932.749us,932.75us,932.799us,932.8us,932.849us,932.85us,932.899us,932.9us,932.949us,932.95us,932.999us,933us,933.049us,933.05us,933.099us,933.1us,933.149us,933.15us,933.199us,933.2us,933.249us,933.25us,933.299us,933.3us,933.349us,933.35us,933.399us,933.4us,933.449us,933.45us,933.499us,933.5us,933.549us,933.55us,933.599us,933.6us,933.649us,933.65us,933.699us,933.7us,933.749us,933.75us,933.799us,933.8us,933.849us,933.85us,933.899us,933.9us,933.949us,933.95us,933.999us,934us,934.049us,934.05us,934.099us,934.1us,934.149us,934.15us,934.199us,934.2us,934.249us,934.25us,934.299us,934.3us,934.349us,934.35us,934.399us,934.4us,934.449us,934.45us,934.499us,934.5us,934.549us,934.55us,934.599us,934.6us,934.649us,934.65us,934.699us,934.7us,934.749us,934.75us,934.799us,934.8us,934.849us,934.85us,934.899us,934.9us,934.949us,934.95us,934.999us,935us,935.049us,935.05us,935.099us,935.1us,935.149us,935.15us,935.199us,935.2us,935.249us,935.25us,935.299us,935.3us,935.349us,935.35us,935.399us,935.4us,935.449us,935.45us,935.499us,935.5us,935.549us,935.55us,935.599us,935.6us,935.649us,935.65us,935.699us,935.7us,935.749us,935.75us,935.799us,935.8us,935.849us,935.85us,935.899us,935.9us,935.949us,935.95us,935.999us,936us,936.049us,936.05us,936.099us,936.1us,936.149us,936.15us,936.199us,936.2us,936.249us,936.25us,936.299us,936.3us,936.349us,936.35us,936.399us,936.4us,936.449us,936.45us,936.499us,936.5us,936.549us,936.55us,936.599us,936.6us,936.649us,936.65us,936.699us,936.7us,936.749us,936.75us,936.799us,936.8us,936.849us,936.85us,936.899us,936.9us,936.949us,936.95us,936.999us,937us,937.049us,937.05us,937.099us,937.1us,937.149us,937.15us,937.199us,937.2us,937.249us,937.25us,937.299us,937.3us,937.349us,937.35us,937.399us,937.4us,937.449us,937.45us,937.499us,937.5us,937.549us,937.55us,937.599us,937.6us,937.649us,937.65us,937.699us,937.7us,937.749us,937.75us,937.799us,937.8us,937.849us,937.85us,937.899us,937.9us,937.949us,937.95us,937.999us,938us,938.049us,938.05us,938.099us,938.1us,938.149us,938.15us,938.199us,938.2us,938.249us,938.25us,938.299us,938.3us,938.349us,938.35us,938.399us,938.4us,938.449us,938.45us,938.499us,938.5us,938.549us,938.55us,938.599us,938.6us,938.649us,938.65us,938.699us,938.7us,938.749us,938.75us,938.799us,938.8us,938.849us,938.85us,938.899us,938.9us,938.949us,938.95us,938.999us,939us,939.049us,939.05us,939.099us,939.1us,939.149us,939.15us,939.199us,939.2us,939.249us,939.25us,939.299us,939.3us,939.349us,939.35us,939.399us,939.4us,939.449us,939.45us,939.499us,939.5us,939.549us,939.55us,939.599us,939.6us,939.649us,939.65us,939.699us,939.7us,939.749us,939.75us,939.799us,939.8us,939.849us,939.85us,939.899us,939.9us,939.949us,939.95us,939.999us,940us,940.049us,940.05us,940.099us,940.1us,940.149us,940.15us,940.199us,940.2us,940.249us,940.25us,940.299us,940.3us,940.349us,940.35us,940.399us,940.4us,940.449us,940.45us,940.499us,940.5us,940.549us,940.55us,940.599us,940.6us,940.649us,940.65us,940.699us,940.7us,940.749us,940.75us,940.799us,940.8us,940.849us,940.85us,940.899us,940.9us,940.949us,940.95us,940.999us,941us,941.049us,941.05us,941.099us,941.1us,941.149us,941.15us,941.199us,941.2us,941.249us,941.25us,941.299us,941.3us,941.349us,941.35us,941.399us,941.4us,941.449us,941.45us,941.499us,941.5us,941.549us,941.55us,941.599us,941.6us,941.649us,941.65us,941.699us,941.7us,941.749us,941.75us,941.799us,941.8us,941.849us,941.85us,941.899us,941.9us,941.949us,941.95us,941.999us,942us,942.049us,942.05us,942.099us,942.1us,942.149us,942.15us,942.199us,942.2us,942.249us,942.25us,942.299us,942.3us,942.349us,942.35us,942.399us,942.4us,942.449us,942.45us,942.499us,942.5us,942.549us,942.55us,942.599us,942.6us,942.649us,942.65us,942.699us,942.7us,942.749us,942.75us,942.799us,942.8us,942.849us,942.85us,942.899us,942.9us,942.949us,942.95us,942.999us,943us,943.049us,943.05us,943.099us,943.1us,943.149us,943.15us,943.199us,943.2us,943.249us,943.25us,943.299us,943.3us,943.349us,943.35us,943.399us,943.4us,943.449us,943.45us,943.499us,943.5us,943.549us,943.55us,943.599us,943.6us,943.649us,943.65us,943.699us,943.7us,943.749us,943.75us,943.799us,943.8us,943.849us,943.85us,943.899us,943.9us,943.949us,943.95us,943.999us,944us,944.049us,944.05us,944.099us,944.1us,944.149us,944.15us,944.199us,944.2us,944.249us,944.25us,944.299us,944.3us,944.349us,944.35us,944.399us,944.4us,944.449us,944.45us,944.499us,944.5us,944.549us,944.55us,944.599us,944.6us,944.649us,944.65us,944.699us,944.7us,944.749us,944.75us,944.799us,944.8us,944.849us,944.85us,944.899us,944.9us,944.949us,944.95us,944.999us,945us,945.049us,945.05us,945.099us,945.1us,945.149us,945.15us,945.199us,945.2us,945.249us,945.25us,945.299us,945.3us,945.349us,945.35us,945.399us,945.4us,945.449us,945.45us,945.499us,945.5us,945.549us,945.55us,945.599us,945.6us,945.649us,945.65us,945.699us,945.7us,945.749us,945.75us,945.799us,945.8us,945.849us,945.85us,945.899us,945.9us,945.949us,945.95us,945.999us,946us,946.049us,946.05us,946.099us,946.1us,946.149us,946.15us,946.199us,946.2us,946.249us,946.25us,946.299us,946.3us,946.349us,946.35us,946.399us,946.4us,946.449us,946.45us,946.499us,946.5us,946.549us,946.55us,946.599us,946.6us,946.649us,946.65us,946.699us,946.7us,946.749us,946.75us,946.799us,946.8us,946.849us,946.85us,946.899us,946.9us,946.949us,946.95us,946.999us,947us,947.049us,947.05us,947.099us,947.1us,947.149us,947.15us,947.199us,947.2us,947.249us,947.25us,947.299us,947.3us,947.349us,947.35us,947.399us,947.4us,947.449us,947.45us,947.499us,947.5us,947.549us,947.55us,947.599us,947.6us,947.649us,947.65us,947.699us,947.7us,947.749us,947.75us,947.799us,947.8us,947.849us,947.85us,947.899us,947.9us,947.949us,947.95us,947.999us,948us,948.049us,948.05us,948.099us,948.1us,948.149us,948.15us,948.199us,948.2us,948.249us,948.25us,948.299us,948.3us,948.349us,948.35us,948.399us,948.4us,948.449us,948.45us,948.499us,948.5us,948.549us,948.55us,948.599us,948.6us,948.649us,948.65us,948.699us,948.7us,948.749us,948.75us,948.799us,948.8us,948.849us,948.85us,948.899us,948.9us,948.949us,948.95us,948.999us,949us,949.049us,949.05us,949.099us,949.1us,949.149us,949.15us,949.199us,949.2us,949.249us,949.25us,949.299us,949.3us,949.349us,949.35us,949.399us,949.4us,949.449us,949.45us,949.499us,949.5us,949.549us,949.55us,949.599us,949.6us,949.649us,949.65us,949.699us,949.7us,949.749us,949.75us,949.799us,949.8us,949.849us,949.85us,949.899us,949.9us,949.949us,949.95us,949.999us,950us,950.049us,950.05us,950.099us,950.1us,950.149us,950.15us,950.199us,950.2us,950.249us,950.25us,950.299us,950.3us,950.349us,950.35us,950.399us,950.4us,950.449us,950.45us,950.499us,950.5us,950.549us,950.55us,950.599us,950.6us,950.649us,950.65us,950.699us,950.7us,950.749us,950.75us,950.799us,950.8us,950.849us,950.85us,950.899us,950.9us,950.949us,950.95us,950.999us,951us,951.049us,951.05us,951.099us,951.1us,951.149us,951.15us,951.199us,951.2us,951.249us,951.25us,951.299us,951.3us,951.349us,951.35us,951.399us,951.4us,951.449us,951.45us,951.499us,951.5us,951.549us,951.55us,951.599us,951.6us,951.649us,951.65us,951.699us,951.7us,951.749us,951.75us,951.799us,951.8us,951.849us,951.85us,951.899us,951.9us,951.949us,951.95us,951.999us,952us,952.049us,952.05us,952.099us,952.1us,952.149us,952.15us,952.199us,952.2us,952.249us,952.25us,952.299us,952.3us,952.349us,952.35us,952.399us,952.4us,952.449us,952.45us,952.499us,952.5us,952.549us,952.55us,952.599us,952.6us,952.649us,952.65us,952.699us,952.7us,952.749us,952.75us,952.799us,952.8us,952.849us,952.85us,952.899us,952.9us,952.949us,952.95us,952.999us,953us,953.049us,953.05us,953.099us,953.1us,953.149us,953.15us,953.199us,953.2us,953.249us,953.25us,953.299us,953.3us,953.349us,953.35us,953.399us,953.4us,953.449us,953.45us,953.499us,953.5us,953.549us,953.55us,953.599us,953.6us,953.649us,953.65us,953.699us,953.7us,953.749us,953.75us,953.799us,953.8us,953.849us,953.85us,953.899us,953.9us,953.949us,953.95us,953.999us,954us,954.049us,954.05us,954.099us,954.1us,954.149us,954.15us,954.199us,954.2us,954.249us,954.25us,954.299us,954.3us,954.349us,954.35us,954.399us,954.4us,954.449us,954.45us,954.499us,954.5us,954.549us,954.55us,954.599us,954.6us,954.649us,954.65us,954.699us,954.7us,954.749us,954.75us,954.799us,954.8us,954.849us,954.85us,954.899us,954.9us,954.949us,954.95us,954.999us,955us,955.049us,955.05us,955.099us,955.1us,955.149us,955.15us,955.199us,955.2us,955.249us,955.25us,955.299us,955.3us,955.349us,955.35us,955.399us,955.4us,955.449us,955.45us,955.499us,955.5us,955.549us,955.55us,955.599us,955.6us,955.649us,955.65us,955.699us,955.7us,955.749us,955.75us,955.799us,955.8us,955.849us,955.85us,955.899us,955.9us,955.949us,955.95us,955.999us,956us,956.049us,956.05us,956.099us,956.1us,956.149us,956.15us,956.199us,956.2us,956.249us,956.25us,956.299us,956.3us,956.349us,956.35us,956.399us,956.4us,956.449us,956.45us,956.499us,956.5us,956.549us,956.55us,956.599us,956.6us,956.649us,956.65us,956.699us,956.7us,956.749us,956.75us,956.799us,956.8us,956.849us,956.85us,956.899us,956.9us,956.949us,956.95us,956.999us,957us,957.049us,957.05us,957.099us,957.1us,957.149us,957.15us,957.199us,957.2us,957.249us,957.25us,957.299us,957.3us,957.349us,957.35us,957.399us,957.4us,957.449us,957.45us,957.499us,957.5us,957.549us,957.55us,957.599us,957.6us,957.649us,957.65us,957.699us,957.7us,957.749us,957.75us,957.799us,957.8us,957.849us,957.85us,957.899us,957.9us,957.949us,957.95us,957.999us,958us,958.049us,958.05us,958.099us,958.1us,958.149us,958.15us,958.199us,958.2us,958.249us,958.25us,958.299us,958.3us,958.349us,958.35us,958.399us,958.4us,958.449us,958.45us,958.499us,958.5us,958.549us,958.55us,958.599us,958.6us,958.649us,958.65us,958.699us,958.7us,958.749us,958.75us,958.799us,958.8us,958.849us,958.85us,958.899us,958.9us,958.949us,958.95us,958.999us,959us,959.049us,959.05us,959.099us,959.1us,959.149us,959.15us,959.199us,959.2us,959.249us,959.25us,959.299us,959.3us,959.349us,959.35us,959.399us,959.4us,959.449us,959.45us,959.499us,959.5us,959.549us,959.55us,959.599us,959.6us,959.649us,959.65us,959.699us,959.7us,959.749us,959.75us,959.799us,959.8us,959.849us,959.85us,959.899us,959.9us,959.949us,959.95us,959.999us,960us,960.049us,960.05us,960.099us,960.1us,960.149us,960.15us,960.199us,960.2us,960.249us,960.25us,960.299us,960.3us,960.349us,960.35us,960.399us,960.4us,960.449us,960.45us,960.499us,960.5us,960.549us,960.55us,960.599us,960.6us,960.649us,960.65us,960.699us,960.7us,960.749us,960.75us,960.799us,960.8us,960.849us,960.85us,960.899us,960.9us,960.949us,960.95us,960.999us,961us,961.049us,961.05us,961.099us,961.1us,961.149us,961.15us,961.199us,961.2us,961.249us,961.25us,961.299us,961.3us,961.349us,961.35us,961.399us,961.4us,961.449us,961.45us,961.499us,961.5us,961.549us,961.55us,961.599us,961.6us,961.649us,961.65us,961.699us,961.7us,961.749us,961.75us,961.799us,961.8us,961.849us,961.85us,961.899us,961.9us,961.949us,961.95us,961.999us,962us,962.049us,962.05us,962.099us,962.1us,962.149us,962.15us,962.199us,962.2us,962.249us,962.25us,962.299us,962.3us,962.349us,962.35us,962.399us,962.4us,962.449us,962.45us,962.499us,962.5us,962.549us,962.55us,962.599us,962.6us,962.649us,962.65us,962.699us,962.7us,962.749us,962.75us,962.799us,962.8us,962.849us,962.85us,962.899us,962.9us,962.949us,962.95us,962.999us,963us,963.049us,963.05us,963.099us,963.1us,963.149us,963.15us,963.199us,963.2us,963.249us,963.25us,963.299us,963.3us,963.349us,963.35us,963.399us,963.4us,963.449us,963.45us,963.499us,963.5us,963.549us,963.55us,963.599us,963.6us,963.649us,963.65us,963.699us,963.7us,963.749us,963.75us,963.799us,963.8us,963.849us,963.85us,963.899us,963.9us,963.949us,963.95us,963.999us,964us,964.049us,964.05us,964.099us,964.1us,964.149us,964.15us,964.199us,964.2us,964.249us,964.25us,964.299us,964.3us,964.349us,964.35us,964.399us,964.4us,964.449us,964.45us,964.499us,964.5us,964.549us,964.55us,964.599us,964.6us,964.649us,964.65us,964.699us,964.7us,964.749us,964.75us,964.799us,964.8us,964.849us,964.85us,964.899us,964.9us,964.949us,964.95us,964.999us,965us,965.049us,965.05us,965.099us,965.1us,965.149us,965.15us,965.199us,965.2us,965.249us,965.25us,965.299us,965.3us,965.349us,965.35us,965.399us,965.4us,965.449us,965.45us,965.499us,965.5us,965.549us,965.55us,965.599us,965.6us,965.649us,965.65us,965.699us,965.7us,965.749us,965.75us,965.799us,965.8us,965.849us,965.85us,965.899us,965.9us,965.949us,965.95us,965.999us,966us,966.049us,966.05us,966.099us,966.1us,966.149us,966.15us,966.199us,966.2us,966.249us,966.25us,966.299us,966.3us,966.349us,966.35us,966.399us,966.4us,966.449us,966.45us,966.499us,966.5us,966.549us,966.55us,966.599us,966.6us,966.649us,966.65us,966.699us,966.7us,966.749us,966.75us,966.799us,966.8us,966.849us,966.85us,966.899us,966.9us,966.949us,966.95us,966.999us,967us,967.049us,967.05us,967.099us,967.1us,967.149us,967.15us,967.199us,967.2us,967.249us,967.25us,967.299us,967.3us,967.349us,967.35us,967.399us,967.4us,967.449us,967.45us,967.499us,967.5us,967.549us,967.55us,967.599us,967.6us,967.649us,967.65us,967.699us,967.7us,967.749us,967.75us,967.799us,967.8us,967.849us,967.85us,967.899us,967.9us,967.949us,967.95us,967.999us,968us,968.049us,968.05us,968.099us,968.1us,968.149us,968.15us,968.199us,968.2us,968.249us,968.25us,968.299us,968.3us,968.349us,968.35us,968.399us,968.4us,968.449us,968.45us,968.499us,968.5us,968.549us,968.55us,968.599us,968.6us,968.649us,968.65us,968.699us,968.7us,968.749us,968.75us,968.799us,968.8us,968.849us,968.85us,968.899us,968.9us,968.949us,968.95us,968.999us,969us,969.049us,969.05us,969.099us,969.1us,969.149us,969.15us,969.199us,969.2us,969.249us,969.25us,969.299us,969.3us,969.349us,969.35us,969.399us,969.4us,969.449us,969.45us,969.499us,969.5us,969.549us,969.55us,969.599us,969.6us,969.649us,969.65us,969.699us,969.7us,969.749us,969.75us,969.799us,969.8us,969.849us,969.85us,969.899us,969.9us,969.949us,969.95us,969.999us,970us,970.049us,970.05us,970.099us,970.1us,970.149us,970.15us,970.199us,970.2us,970.249us,970.25us,970.299us,970.3us,970.349us,970.35us,970.399us,970.4us,970.449us,970.45us,970.499us,970.5us,970.549us,970.55us,970.599us,970.6us,970.649us,970.65us,970.699us,970.7us,970.749us,970.75us,970.799us,970.8us,970.849us,970.85us,970.899us,970.9us,970.949us,970.95us,970.999us,971us,971.049us,971.05us,971.099us,971.1us,971.149us,971.15us,971.199us,971.2us,971.249us,971.25us,971.299us,971.3us,971.349us,971.35us,971.399us,971.4us,971.449us,971.45us,971.499us,971.5us,971.549us,971.55us,971.599us,971.6us,971.649us,971.65us,971.699us,971.7us,971.749us,971.75us,971.799us,971.8us,971.849us,971.85us,971.899us,971.9us,971.949us,971.95us,971.999us,972us,972.049us,972.05us,972.099us,972.1us,972.149us,972.15us,972.199us,972.2us,972.249us,972.25us,972.299us,972.3us,972.349us,972.35us,972.399us,972.4us,972.449us,972.45us,972.499us,972.5us,972.549us,972.55us,972.599us,972.6us,972.649us,972.65us,972.699us,972.7us,972.749us,972.75us,972.799us,972.8us,972.849us,972.85us,972.899us,972.9us,972.949us,972.95us,972.999us,973us,973.049us,973.05us,973.099us,973.1us,973.149us,973.15us,973.199us,973.2us,973.249us,973.25us,973.299us,973.3us,973.349us,973.35us,973.399us,973.4us,973.449us,973.45us,973.499us,973.5us,973.549us,973.55us,973.599us,973.6us,973.649us,973.65us,973.699us,973.7us,973.749us,973.75us,973.799us,973.8us,973.849us,973.85us,973.899us,973.9us,973.949us,973.95us,973.999us,974us,974.049us,974.05us,974.099us,974.1us,974.149us,974.15us,974.199us,974.2us,974.249us,974.25us,974.299us,974.3us,974.349us,974.35us,974.399us,974.4us,974.449us,974.45us,974.499us,974.5us,974.549us,974.55us,974.599us,974.6us,974.649us,974.65us,974.699us,974.7us,974.749us,974.75us,974.799us,974.8us,974.849us,974.85us,974.899us,974.9us,974.949us,974.95us,974.999us,975us,975.049us,975.05us,975.099us,975.1us,975.149us,975.15us,975.199us,975.2us,975.249us,975.25us,975.299us,975.3us,975.349us,975.35us,975.399us,975.4us,975.449us,975.45us,975.499us,975.5us,975.549us,975.55us,975.599us,975.6us,975.649us,975.65us,975.699us,975.7us,975.749us,975.75us,975.799us,975.8us,975.849us,975.85us,975.899us,975.9us,975.949us,975.95us,975.999us,976us,976.049us,976.05us,976.099us,976.1us,976.149us,976.15us,976.199us,976.2us,976.249us,976.25us,976.299us,976.3us,976.349us,976.35us,976.399us,976.4us,976.449us,976.45us,976.499us,976.5us,976.549us,976.55us,976.599us,976.6us,976.649us,976.65us,976.699us,976.7us,976.749us,976.75us,976.799us,976.8us,976.849us,976.85us,976.899us,976.9us,976.949us,976.95us,976.999us,977us,977.049us,977.05us,977.099us,977.1us,977.149us,977.15us,977.199us,977.2us,977.249us,977.25us,977.299us,977.3us,977.349us,977.35us,977.399us,977.4us,977.449us,977.45us,977.499us,977.5us,977.549us,977.55us,977.599us,977.6us,977.649us,977.65us,977.699us,977.7us,977.749us,977.75us,977.799us,977.8us,977.849us,977.85us,977.899us,977.9us,977.949us,977.95us,977.999us,978us,978.049us,978.05us,978.099us,978.1us,978.149us,978.15us,978.199us,978.2us,978.249us,978.25us,978.299us,978.3us,978.349us,978.35us,978.399us,978.4us,978.449us,978.45us,978.499us,978.5us,978.549us,978.55us,978.599us,978.6us,978.649us,978.65us,978.699us,978.7us,978.749us,978.75us,978.799us,978.8us,978.849us,978.85us,978.899us,978.9us,978.949us,978.95us,978.999us,979us,979.049us,979.05us,979.099us,979.1us,979.149us,979.15us,979.199us,979.2us,979.249us,979.25us,979.299us,979.3us,979.349us,979.35us,979.399us,979.4us,979.449us,979.45us,979.499us,979.5us,979.549us,979.55us,979.599us,979.6us,979.649us,979.65us,979.699us,979.7us,979.749us,979.75us,979.799us,979.8us,979.849us,979.85us,979.899us,979.9us,979.949us,979.95us,979.999us,980us,980.049us,980.05us,980.099us,980.1us,980.149us,980.15us,980.199us,980.2us,980.249us,980.25us,980.299us,980.3us,980.349us,980.35us,980.399us,980.4us,980.449us,980.45us,980.499us,980.5us,980.549us,980.55us,980.599us,980.6us,980.649us,980.65us,980.699us,980.7us,980.749us,980.75us,980.799us,980.8us,980.849us,980.85us,980.899us,980.9us,980.949us,980.95us,980.999us,981us,981.049us,981.05us,981.099us,981.1us,981.149us,981.15us,981.199us,981.2us,981.249us,981.25us,981.299us,981.3us,981.349us,981.35us,981.399us,981.4us,981.449us,981.45us,981.499us,981.5us,981.549us,981.55us,981.599us,981.6us,981.649us,981.65us,981.699us,981.7us,981.749us,981.75us,981.799us,981.8us,981.849us,981.85us,981.899us,981.9us,981.949us,981.95us,981.999us,982us,982.049us,982.05us,982.099us,982.1us,982.149us,982.15us,982.199us,982.2us,982.249us,982.25us,982.299us,982.3us,982.349us,982.35us,982.399us,982.4us,982.449us,982.45us,982.499us,982.5us,982.549us,982.55us,982.599us,982.6us,982.649us,982.65us,982.699us,982.7us,982.749us,982.75us,982.799us,982.8us,982.849us,982.85us,982.899us,982.9us,982.949us,982.95us,982.999us,983us,983.049us,983.05us,983.099us,983.1us,983.149us,983.15us,983.199us,983.2us,983.249us,983.25us,983.299us,983.3us,983.349us,983.35us,983.399us,983.4us,983.449us,983.45us,983.499us,983.5us,983.549us,983.55us,983.599us,983.6us,983.649us,983.65us,983.699us,983.7us,983.749us,983.75us,983.799us,983.8us,983.849us,983.85us,983.899us,983.9us,983.949us,983.95us,983.999us,984us,984.049us,984.05us,984.099us,984.1us,984.149us,984.15us,984.199us,984.2us,984.249us,984.25us,984.299us,984.3us,984.349us,984.35us,984.399us,984.4us,984.449us,984.45us,984.499us,984.5us,984.549us,984.55us,984.599us,984.6us,984.649us,984.65us,984.699us,984.7us,984.749us,984.75us,984.799us,984.8us,984.849us,984.85us,984.899us,984.9us,984.949us,984.95us,984.999us,985us,985.049us,985.05us,985.099us,985.1us,985.149us,985.15us,985.199us,985.2us,985.249us,985.25us,985.299us,985.3us,985.349us,985.35us,985.399us,985.4us,985.449us,985.45us,985.499us,985.5us,985.549us,985.55us,985.599us,985.6us,985.649us,985.65us,985.699us,985.7us,985.749us,985.75us,985.799us,985.8us,985.849us,985.85us,985.899us,985.9us,985.949us,985.95us,985.999us,986us,986.049us,986.05us,986.099us,986.1us,986.149us,986.15us,986.199us,986.2us,986.249us,986.25us,986.299us,986.3us,986.349us,986.35us,986.399us,986.4us,986.449us,986.45us,986.499us,986.5us,986.549us,986.55us,986.599us,986.6us,986.649us,986.65us,986.699us,986.7us,986.749us,986.75us,986.799us,986.8us,986.849us,986.85us,986.899us,986.9us,986.949us,986.95us,986.999us,987us,987.049us,987.05us,987.099us,987.1us,987.149us,987.15us,987.199us,987.2us,987.249us,987.25us,987.299us,987.3us,987.349us,987.35us,987.399us,987.4us,987.449us,987.45us,987.499us,987.5us,987.549us,987.55us,987.599us,987.6us,987.649us,987.65us,987.699us,987.7us,987.749us,987.75us,987.799us,987.8us,987.849us,987.85us,987.899us,987.9us,987.949us,987.95us,987.999us,988us,988.049us,988.05us,988.099us,988.1us,988.149us,988.15us,988.199us,988.2us,988.249us,988.25us,988.299us,988.3us,988.349us,988.35us,988.399us,988.4us,988.449us,988.45us,988.499us,988.5us,988.549us,988.55us,988.599us,988.6us,988.649us,988.65us,988.699us,988.7us,988.749us,988.75us,988.799us,988.8us,988.849us,988.85us,988.899us,988.9us,988.949us,988.95us,988.999us,989us,989.049us,989.05us,989.099us,989.1us,989.149us,989.15us,989.199us,989.2us,989.249us,989.25us,989.299us,989.3us,989.349us,989.35us,989.399us,989.4us,989.449us,989.45us,989.499us,989.5us,989.549us,989.55us,989.599us,989.6us,989.649us,989.65us,989.699us,989.7us,989.749us,989.75us,989.799us,989.8us,989.849us,989.85us,989.899us,989.9us,989.949us,989.95us,989.999us,990us,990.049us,990.05us,990.099us,990.1us,990.149us,990.15us,990.199us,990.2us,990.249us,990.25us,990.299us,990.3us,990.349us,990.35us,990.399us,990.4us,990.449us,990.45us,990.499us,990.5us,990.549us,990.55us,990.599us,990.6us,990.649us,990.65us,990.699us,990.7us,990.749us,990.75us,990.799us,990.8us,990.849us,990.85us,990.899us,990.9us,990.949us,990.95us,990.999us,991us,991.049us,991.05us,991.099us,991.1us,991.149us,991.15us,991.199us,991.2us,991.249us,991.25us,991.299us,991.3us,991.349us,991.35us,991.399us,991.4us,991.449us,991.45us,991.499us,991.5us,991.549us,991.55us,991.599us,991.6us,991.649us,991.65us,991.699us,991.7us,991.749us,991.75us,991.799us,991.8us,991.849us,991.85us,991.899us,991.9us,991.949us,991.95us,991.999us,992us,992.049us,992.05us,992.099us,992.1us,992.149us,992.15us,992.199us,992.2us,992.249us,992.25us,992.299us,992.3us,992.349us,992.35us,992.399us,992.4us,992.449us,992.45us,992.499us,992.5us,992.549us,992.55us,992.599us,992.6us,992.649us,992.65us,992.699us,992.7us,992.749us,992.75us,992.799us,992.8us,992.849us,992.85us,992.899us,992.9us,992.949us,992.95us,992.999us,993us,993.049us,993.05us,993.099us,993.1us,993.149us,993.15us,993.199us,993.2us,993.249us,993.25us,993.299us,993.3us,993.349us,993.35us,993.399us,993.4us,993.449us,993.45us,993.499us,993.5us,993.549us,993.55us,993.599us,993.6us,993.649us,993.65us,993.699us,993.7us,993.749us,993.75us,993.799us,993.8us,993.849us,993.85us,993.899us,993.9us,993.949us,993.95us,993.999us,994us,994.049us,994.05us,994.099us,994.1us,994.149us,994.15us,994.199us,994.2us,994.249us,994.25us,994.299us,994.3us,994.349us,994.35us,994.399us,994.4us,994.449us,994.45us,994.499us,994.5us,994.549us,994.55us,994.599us,994.6us,994.649us,994.65us,994.699us,994.7us,994.749us,994.75us,994.799us,994.8us,994.849us,994.85us,994.899us,994.9us,994.949us,994.95us,994.999us,995us,995.049us,995.05us,995.099us,995.1us,995.149us,995.15us,995.199us,995.2us,995.249us,995.25us,995.299us,995.3us,995.349us,995.35us,995.399us,995.4us,995.449us,995.45us,995.499us,995.5us,995.549us,995.55us,995.599us,995.6us,995.649us,995.65us,995.699us,995.7us,995.749us,995.75us,995.799us,995.8us,995.849us,995.85us,995.899us,995.9us,995.949us,995.95us,995.999us,996us,996.049us,996.05us,996.099us,996.1us,996.149us,996.15us,996.199us,996.2us,996.249us,996.25us,996.299us,996.3us,996.349us,996.35us,996.399us,996.4us,996.449us,996.45us,996.499us,996.5us,996.549us,996.55us,996.599us,996.6us,996.649us,996.65us,996.699us,996.7us,996.749us,996.75us,996.799us,996.8us,996.849us,996.85us,996.899us,996.9us,996.949us,996.95us,996.999us,997us,997.049us,997.05us,997.099us,997.1us,997.149us,997.15us,997.199us,997.2us,997.249us,997.25us,997.299us,997.3us,997.349us,997.35us,997.399us,997.4us,997.449us,997.45us,997.499us,997.5us,997.549us,997.55us,997.599us,997.6us,997.649us,997.65us,997.699us,997.7us,997.749us,997.75us,997.799us,997.8us,997.849us,997.85us,997.899us,997.9us,997.949us,997.95us,997.999us,998us,998.049us,998.05us,998.099us,998.1us,998.149us,998.15us,998.199us,998.2us,998.249us,998.25us,998.299us,998.3us,998.349us,998.35us,998.399us,998.4us,998.449us,998.45us,998.499us,998.5us,998.549us,998.55us,998.599us,998.6us,998.649us,998.65us,998.699us,998.7us,998.749us,998.75us,998.799us,998.8us,998.849us,998.85us,998.899us,998.9us,998.949us,998.95us,998.999us,999us,999.049us,999.05us,999.099us,999.1us,999.149us,999.15us,999.199us,999.2us,999.249us,999.25us,999.299us,999.3us,999.349us,999.35us,999.399us,999.4us,999.449us,999.45us,999.499us,999.5us,999.549us,999.55us,999.599us,999.6us,999.649us,999.65us,999.699us,999.7us,999.749us,999.75us,999.799us,999.8us,999.849us,999.85us,999.899us,999.9us,999.949us,999.95us,999.999us,1ms,1.000049ms,1.00005ms,1.000099ms,1.0001ms,1.000149ms,1.00015ms,1.000199ms,1.0002ms,1.000249ms,1.00025ms,1.000299ms,1.0003ms,1.000349ms,1.00035ms,1.000399ms,1.0004ms,1.000449ms,1.00045ms,1.000499ms,1.0005ms,1.000549ms,1.00055ms,1.000599ms,1.0006ms,1.000649ms,1.00065ms,1.000699ms,1.0007ms,1.000749ms,1.00075ms,1.000799ms,1.0008ms,1.000849ms,1.00085ms,1.000899ms,1.0009ms,1.000949ms,1.00095ms,1.000999ms,1.001ms,1.001049ms,1.00105ms,1.001099ms,1.0011ms,1.001149ms,1.00115ms,1.001199ms,1.0012ms,1.001249ms,1.00125ms,1.001299ms,1.0013ms,1.001349ms,1.00135ms,1.001399ms,1.0014ms,1.001449ms,1.00145ms,1.001499ms,1.0015ms,1.001549ms,1.00155ms,1.001599ms,1.0016ms,1.001649ms,1.00165ms,1.001699ms,1.0017ms,1.001749ms,1.00175ms,1.001799ms,1.0018ms,1.001849ms,1.00185ms,1.001899ms,1.0019ms,1.001949ms,1.00195ms,1.001999ms,1.002ms,1.002049ms,1.00205ms,1.002099ms,1.0021ms,1.002149ms,1.00215ms,1.002199ms,1.0022ms,1.002249ms,1.00225ms,1.002299ms,1.0023ms,1.002349ms,1.00235ms,1.002399ms,1.0024ms,1.002449ms,1.00245ms,1.002499ms,1.0025ms,1.002549ms,1.00255ms,1.002599ms,1.0026ms,1.002649ms,1.00265ms,1.002699ms,1.0027ms,1.002749ms,1.00275ms,1.002799ms,1.0028ms,1.002849ms,1.00285ms,1.002899ms,1.0029ms,1.002949ms,1.00295ms,1.002999ms,1.003ms,1.003049ms,1.00305ms,1.003099ms,1.0031ms,1.003149ms,1.00315ms,1.003199ms,1.0032ms,1.003249ms,1.00325ms,1.003299ms,1.0033ms,1.003349ms,1.00335ms,1.003399ms,1.0034ms,1.003449ms,1.00345ms,1.003499ms,1.0035ms,1.003549ms,1.00355ms,1.003599ms,1.0036ms,1.003649ms,1.00365ms,1.003699ms,1.0037ms,1.003749ms,1.00375ms,1.003799ms,1.0038ms,1.003849ms,1.00385ms,1.003899ms,1.0039ms,1.003949ms,1.00395ms,1.003999ms,1.004ms,1.004049ms,1.00405ms,1.004099ms,1.0041ms,1.004149ms,1.00415ms,1.004199ms,1.0042ms,1.004249ms,1.00425ms,1.004299ms,1.0043ms,1.004349ms,1.00435ms,1.004399ms,1.0044ms,1.004449ms,1.00445ms,1.004499ms,1.0045ms,1.004549ms,1.00455ms,1.004599ms,1.0046ms,1.004649ms,1.00465ms,1.004699ms,1.0047ms,1.004749ms,1.00475ms,1.004799ms,1.0048ms,1.004849ms,1.00485ms,1.004899ms,1.0049ms,1.004949ms,1.00495ms,1.004999ms,1.005ms,1.005049ms,1.00505ms,1.005099ms,1.0051ms,1.005149ms,1.00515ms,1.005199ms,1.0052ms,1.005249ms,1.00525ms,1.005299ms,1.0053ms,1.005349ms,1.00535ms,1.005399ms,1.0054ms,1.005449ms,1.00545ms,1.005499ms,1.0055ms,1.005549ms,1.00555ms,1.005599ms,1.0056ms,1.005649ms,1.00565ms,1.005699ms,1.0057ms,1.005749ms,1.00575ms,1.005799ms,1.0058ms,1.005849ms,1.00585ms,1.005899ms,1.0059ms,1.005949ms,1.00595ms,1.005999ms,1.006ms,1.006049ms,1.00605ms,1.006099ms,1.0061ms,1.006149ms,1.00615ms,1.006199ms,1.0062ms,1.006249ms,1.00625ms,1.006299ms,1.0063ms,1.006349ms,1.00635ms,1.006399ms,1.0064ms,1.006449ms,1.00645ms,1.006499ms,1.0065ms,1.006549ms,1.00655ms,1.006599ms,1.0066ms,1.006649ms,1.00665ms,1.006699ms,1.0067ms,1.006749ms,1.00675ms,1.006799ms,1.0068ms,1.006849ms,1.00685ms,1.006899ms,1.0069ms,1.006949ms,1.00695ms,1.006999ms,1.007ms,1.007049ms,1.00705ms,1.007099ms,1.0071ms,1.007149ms,1.00715ms,1.007199ms,1.0072ms,1.007249ms,1.00725ms,1.007299ms,1.0073ms,1.007349ms,1.00735ms,1.007399ms,1.0074ms,1.007449ms,1.00745ms,1.007499ms,1.0075ms,1.007549ms,1.00755ms,1.007599ms,1.0076ms,1.007649ms,1.00765ms,1.007699ms,1.0077ms,1.007749ms,1.00775ms,1.007799ms,1.0078ms,1.007849ms,1.00785ms,1.007899ms,1.0079ms,1.007949ms,1.00795ms,1.007999ms,1.008ms,1.008049ms,1.00805ms,1.008099ms,1.0081ms,1.008149ms,1.00815ms,1.008199ms,1.0082ms,1.008249ms,1.00825ms,1.008299ms,1.0083ms,1.008349ms,1.00835ms,1.008399ms,1.0084ms,1.008449ms,1.00845ms,1.008499ms,1.0085ms,1.008549ms,1.00855ms,1.008599ms,1.0086ms,1.008649ms,1.00865ms,1.008699ms,1.0087ms,1.008749ms,1.00875ms,1.008799ms,1.0088ms,1.008849ms,1.00885ms,1.008899ms,1.0089ms,1.008949ms,1.00895ms,1.008999ms,1.009ms,1.009049ms,1.00905ms,1.009099ms,1.0091ms,1.009149ms,1.00915ms,1.009199ms,1.0092ms,1.009249ms,1.00925ms,1.009299ms,1.0093ms,1.009349ms,1.00935ms,1.009399ms,1.0094ms,1.009449ms,1.00945ms,1.009499ms,1.0095ms,1.009549ms,1.00955ms,1.009599ms,1.0096ms,1.009649ms,1.00965ms,1.009699ms,1.0097ms,1.009749ms,1.00975ms,1.009799ms,1.0098ms,1.009849ms,1.00985ms,1.009899ms,1.0099ms,1.009949ms,1.00995ms,1.009999ms,1.01ms,1.010049ms,1.01005ms,1.010099ms,1.0101ms,1.010149ms,1.01015ms,1.010199ms,1.0102ms,1.010249ms,1.01025ms,1.010299ms,1.0103ms,1.010349ms,1.01035ms,1.010399ms,1.0104ms,1.010449ms,1.01045ms,1.010499ms,1.0105ms,1.010549ms,1.01055ms,1.010599ms,1.0106ms,1.010649ms,1.01065ms,1.010699ms,1.0107ms,1.010749ms,1.01075ms,1.010799ms,1.0108ms,1.010849ms,1.01085ms,1.010899ms,1.0109ms,1.010949ms,1.01095ms,1.010999ms,1.011ms,1.011049ms,1.01105ms,1.011099ms,1.0111ms,1.011149ms,1.01115ms,1.011199ms,1.0112ms,1.011249ms,1.01125ms,1.011299ms,1.0113ms,1.011349ms,1.01135ms,1.011399ms,1.0114ms,1.011449ms,1.01145ms,1.011499ms,1.0115ms,1.011549ms,1.01155ms,1.011599ms,1.0116ms,1.011649ms,1.01165ms,1.011699ms,1.0117ms,1.011749ms,1.01175ms,1.011799ms,1.0118ms,1.011849ms,1.01185ms,1.011899ms,1.0119ms,1.011949ms,1.01195ms,1.011999ms,1.012ms,1.012049ms,1.01205ms,1.012099ms,1.0121ms,1.012149ms,1.01215ms,1.012199ms,1.0122ms,1.012249ms,1.01225ms,1.012299ms,1.0123ms,1.012349ms,1.01235ms,1.012399ms,1.0124ms,1.012449ms,1.01245ms,1.012499ms,1.0125ms,1.012549ms,1.01255ms,1.012599ms,1.0126ms,1.012649ms,1.01265ms,1.012699ms,1.0127ms,1.012749ms,1.01275ms,1.012799ms,1.0128ms,1.012849ms,1.01285ms,1.012899ms,1.0129ms,1.012949ms,1.01295ms,1.012999ms,1.013ms,1.013049ms,1.01305ms,1.013099ms,1.0131ms,1.013149ms,1.01315ms,1.013199ms,1.0132ms,1.013249ms,1.01325ms,1.013299ms,1.0133ms,1.013349ms,1.01335ms,1.013399ms,1.0134ms,1.013449ms,1.01345ms,1.013499ms,1.0135ms,1.013549ms,1.01355ms,1.013599ms,1.0136ms,1.013649ms,1.01365ms,1.013699ms,1.0137ms,1.013749ms,1.01375ms,1.013799ms,1.0138ms,1.013849ms,1.01385ms,1.013899ms,1.0139ms,1.013949ms,1.01395ms,1.013999ms,1.014ms,1.014049ms,1.01405ms,1.014099ms,1.0141ms,1.014149ms,1.01415ms,1.014199ms,1.0142ms,1.014249ms,1.01425ms,1.014299ms,1.0143ms,1.014349ms,1.01435ms,1.014399ms,1.0144ms,1.014449ms,1.01445ms,1.014499ms,1.0145ms,1.014549ms,1.01455ms,1.014599ms,1.0146ms,1.014649ms,1.01465ms,1.014699ms,1.0147ms,1.014749ms,1.01475ms,1.014799ms,1.0148ms,1.014849ms,1.01485ms,1.014899ms,1.0149ms,1.014949ms,1.01495ms,1.014999ms,1.015ms,1.015049ms,1.01505ms,1.015099ms,1.0151ms,1.015149ms,1.01515ms,1.015199ms,1.0152ms,1.015249ms,1.01525ms,1.015299ms,1.0153ms,1.015349ms,1.01535ms,1.015399ms,1.0154ms,1.015449ms,1.01545ms,1.015499ms,1.0155ms,1.015549ms,1.01555ms,1.015599ms,1.0156ms,1.015649ms,1.01565ms,1.015699ms,1.0157ms,1.015749ms,1.01575ms,1.015799ms,1.0158ms,1.015849ms,1.01585ms,1.015899ms,1.0159ms,1.015949ms,1.01595ms,1.015999ms,1.016ms,1.016049ms,1.01605ms,1.016099ms,1.0161ms,1.016149ms,1.01615ms,1.016199ms,1.0162ms,1.016249ms,1.01625ms,1.016299ms,1.0163ms,1.016349ms,1.01635ms,1.016399ms,1.0164ms,1.016449ms,1.01645ms,1.016499ms,1.0165ms,1.016549ms,1.01655ms,1.016599ms,1.0166ms,1.016649ms,1.01665ms,1.016699ms,1.0167ms,1.016749ms,1.01675ms,1.016799ms,1.0168ms,1.016849ms,1.01685ms,1.016899ms,1.0169ms,1.016949ms,1.01695ms,1.016999ms,1.017ms,1.017049ms,1.01705ms,1.017099ms,1.0171ms,1.017149ms,1.01715ms,1.017199ms,1.0172ms,1.017249ms,1.01725ms,1.017299ms,1.0173ms,1.017349ms,1.01735ms,1.017399ms,1.0174ms,1.017449ms,1.01745ms,1.017499ms,1.0175ms,1.017549ms,1.01755ms,1.017599ms,1.0176ms,1.017649ms,1.01765ms,1.017699ms,1.0177ms,1.017749ms,1.01775ms,1.017799ms,1.0178ms,1.017849ms,1.01785ms,1.017899ms,1.0179ms,1.017949ms,1.01795ms,1.017999ms,1.018ms,1.018049ms,1.01805ms,1.018099ms,1.0181ms,1.018149ms,1.01815ms,1.018199ms,1.0182ms,1.018249ms,1.01825ms,1.018299ms,1.0183ms,1.018349ms,1.01835ms,1.018399ms,1.0184ms,1.018449ms,1.01845ms,1.018499ms,1.0185ms,1.018549ms,1.01855ms,1.018599ms,1.0186ms,1.018649ms,1.01865ms,1.018699ms,1.0187ms,1.018749ms,1.01875ms,1.018799ms,1.0188ms,1.018849ms,1.01885ms,1.018899ms,1.0189ms,1.018949ms,1.01895ms,1.018999ms,1.019ms,1.019049ms,1.01905ms,1.019099ms,1.0191ms,1.019149ms,1.01915ms,1.019199ms,1.0192ms,1.019249ms,1.01925ms,1.019299ms,1.0193ms,1.019349ms,1.01935ms,1.019399ms,1.0194ms,1.019449ms,1.01945ms,1.019499ms,1.0195ms,1.019549ms,1.01955ms,1.019599ms,1.0196ms,1.019649ms,1.01965ms,1.019699ms,1.0197ms,1.019749ms,1.01975ms,1.019799ms,1.0198ms,1.019849ms,1.01985ms,1.019899ms,1.0199ms,1.019949ms,1.01995ms,1.019999ms,1.02ms,1.020049ms,1.02005ms,1.020099ms,1.0201ms,1.020149ms,1.02015ms,1.020199ms,1.0202ms,1.020249ms,1.02025ms,1.020299ms,1.0203ms,1.020349ms,1.02035ms,1.020399ms,1.0204ms,1.020449ms,1.02045ms,1.020499ms,1.0205ms,1.020549ms,1.02055ms,1.020599ms,1.0206ms,1.020649ms,1.02065ms,1.020699ms,1.0207ms,1.020749ms,1.02075ms,1.020799ms,1.0208ms,1.020849ms,1.02085ms,1.020899ms,1.0209ms,1.020949ms,1.02095ms,1.020999ms,1.021ms,1.021049ms,1.02105ms,1.021099ms,1.0211ms,1.021149ms,1.02115ms,1.021199ms,1.0212ms,1.021249ms,1.02125ms,1.021299ms,1.0213ms,1.021349ms,1.02135ms,1.021399ms,1.0214ms,1.021449ms,1.02145ms,1.021499ms,1.0215ms,1.021549ms,1.02155ms,1.021599ms,1.0216ms,1.021649ms,1.02165ms,1.021699ms,1.0217ms,1.021749ms,1.02175ms,1.021799ms,1.0218ms,1.021849ms,1.02185ms,1.021899ms,1.0219ms,1.021949ms,1.02195ms,1.021999ms,1.022ms,1.022049ms,1.02205ms,1.022099ms,1.0221ms,1.022149ms,1.02215ms,1.022199ms,1.0222ms,1.022249ms,1.02225ms,1.022299ms,1.0223ms,1.022349ms,1.02235ms,1.022399ms,1.0224ms,1.022449ms,1.02245ms,1.022499ms,1.0225ms,1.022549ms,1.02255ms,1.022599ms,1.0226ms,1.022649ms,1.02265ms,1.022699ms,1.0227ms,1.022749ms,1.02275ms,1.022799ms,1.0228ms,1.022849ms,1.02285ms,1.022899ms,1.0229ms,1.022949ms,1.02295ms,1.022999ms,1.023ms,1.023049ms,1.02305ms,1.023099ms,1.0231ms,1.023149ms,1.02315ms,1.023199ms,1.0232ms,1.023249ms,1.02325ms,1.023299ms,1.0233ms,1.023349ms,1.02335ms,1.023399ms,1.0234ms,1.023449ms,1.02345ms,1.023499ms,1.0235ms,1.023549ms,1.02355ms,1.023599ms,1.0236ms,1.023649ms,1.02365ms,1.023699ms,1.0237ms,1.023749ms,1.02375ms,1.023799ms,1.0238ms,1.023849ms,1.02385ms,1.023899ms,1.0239ms,1.023949ms,1.02395ms,1.023999ms,1.024ms,1.024049ms,1.02405ms,1.024099ms,1.0241ms,1.024149ms,1.02415ms,1.024199ms,1.0242ms,1.024249ms,1.02425ms,1.024299ms,1.0243ms,1.024349ms,1.02435ms,1.024399ms,1.0244ms,1.024449ms,1.02445ms,1.024499ms,1.0245ms,1.024549ms,1.02455ms,1.024599ms,1.0246ms,1.024649ms,1.02465ms,1.024699ms,1.0247ms,1.024749ms,1.02475ms,1.024799ms,1.0248ms,1.024849ms,1.02485ms,1.024899ms,1.0249ms,1.024949ms,1.02495ms,1.024999ms,1.025ms,1.025049ms,1.02505ms,1.025099ms,1.0251ms,1.025149ms,1.02515ms,1.025199ms,1.0252ms,1.025249ms,1.02525ms,1.025299ms,1.0253ms,1.025349ms,1.02535ms,1.025399ms,1.0254ms,1.025449ms,1.02545ms,1.025499ms,1.0255ms,1.025549ms,1.02555ms,1.025599ms,1.0256ms,1.025649ms,1.02565ms,1.025699ms,1.0257ms,1.025749ms,1.02575ms,1.025799ms,1.0258ms,1.025849ms,1.02585ms,1.025899ms,1.0259ms,1.025949ms,1.02595ms,1.025999ms,1.026ms,1.026049ms,1.02605ms,1.026099ms,1.0261ms,1.026149ms,1.02615ms,1.026199ms,1.0262ms,1.026249ms,1.02625ms,1.026299ms,1.0263ms,1.026349ms,1.02635ms,1.026399ms,1.0264ms,1.026449ms,1.02645ms,1.026499ms,1.0265ms,1.026549ms,1.02655ms,1.026599ms,1.0266ms,1.026649ms,1.02665ms,1.026699ms,1.0267ms,1.026749ms,1.02675ms,1.026799ms,1.0268ms,1.026849ms,1.02685ms,1.026899ms,1.0269ms,1.026949ms,1.02695ms,1.026999ms,1.027ms,1.027049ms,1.02705ms,1.027099ms,1.0271ms,1.027149ms,1.02715ms,1.027199ms,1.0272ms,1.027249ms,1.02725ms,1.027299ms,1.0273ms,1.027349ms,1.02735ms,1.027399ms,1.0274ms,1.027449ms,1.02745ms,1.027499ms,1.0275ms,1.027549ms,1.02755ms,1.027599ms,1.0276ms,1.027649ms,1.02765ms,1.027699ms,1.0277ms,1.027749ms,1.02775ms,1.027799ms,1.0278ms,1.027849ms,1.02785ms,1.027899ms,1.0279ms,1.027949ms,1.02795ms,1.027999ms,1.028ms,1.028049ms,1.02805ms,1.028099ms,1.0281ms,1.028149ms,1.02815ms,1.028199ms,1.0282ms,1.028249ms,1.02825ms,1.028299ms,1.0283ms,1.028349ms,1.02835ms,1.028399ms,1.0284ms,1.028449ms,1.02845ms,1.028499ms,1.0285ms,1.028549ms,1.02855ms,1.028599ms,1.0286ms,1.028649ms,1.02865ms,1.028699ms,1.0287ms,1.028749ms,1.02875ms,1.028799ms,1.0288ms,1.028849ms,1.02885ms,1.028899ms,1.0289ms,1.028949ms,1.02895ms,1.028999ms,1.029ms,1.029049ms,1.02905ms,1.029099ms,1.0291ms,1.029149ms,1.02915ms,1.029199ms,1.0292ms,1.029249ms,1.02925ms,1.029299ms,1.0293ms,1.029349ms,1.02935ms,1.029399ms,1.0294ms,1.029449ms,1.02945ms,1.029499ms,1.0295ms,1.029549ms,1.02955ms,1.029599ms,1.0296ms,1.029649ms,1.02965ms,1.029699ms,1.0297ms,1.029749ms,1.02975ms,1.029799ms,1.0298ms,1.029849ms,1.02985ms,1.029899ms,1.0299ms,1.029949ms,1.02995ms,1.029999ms,1.03ms,1.030049ms,1.03005ms,1.030099ms,1.0301ms,1.030149ms,1.03015ms,1.030199ms,1.0302ms,1.030249ms,1.03025ms,1.030299ms,1.0303ms,1.030349ms,1.03035ms,1.030399ms,1.0304ms,1.030449ms,1.03045ms,1.030499ms,1.0305ms,1.030549ms,1.03055ms,1.030599ms,1.0306ms,1.030649ms,1.03065ms,1.030699ms,1.0307ms,1.030749ms,1.03075ms,1.030799ms,1.0308ms,1.030849ms,1.03085ms,1.030899ms,1.0309ms,1.030949ms,1.03095ms,1.030999ms,1.031ms,1.031049ms,1.03105ms,1.031099ms,1.0311ms,1.031149ms,1.03115ms,1.031199ms,1.0312ms,1.031249ms,1.03125ms,1.031299ms,1.0313ms,1.031349ms,1.03135ms,1.031399ms,1.0314ms,1.031449ms,1.03145ms,1.031499ms,1.0315ms,1.031549ms,1.03155ms,1.031599ms,1.0316ms,1.031649ms,1.03165ms,1.031699ms,1.0317ms,1.031749ms,1.03175ms,1.031799ms,1.0318ms,1.031849ms,1.03185ms,1.031899ms,1.0319ms,1.031949ms,1.03195ms,1.031999ms,1.032ms,1.032049ms,1.03205ms,1.032099ms,1.0321ms,1.032149ms,1.03215ms,1.032199ms,1.0322ms,1.032249ms,1.03225ms,1.032299ms,1.0323ms,1.032349ms,1.03235ms,1.032399ms,1.0324ms,1.032449ms,1.03245ms,1.032499ms,1.0325ms,1.032549ms,1.03255ms,1.032599ms,1.0326ms,1.032649ms,1.03265ms,1.032699ms,1.0327ms,1.032749ms,1.03275ms,1.032799ms,1.0328ms,1.032849ms,1.03285ms,1.032899ms,1.0329ms,1.032949ms,1.03295ms,1.032999ms,1.033ms,1.033049ms,1.03305ms,1.033099ms,1.0331ms,1.033149ms,1.03315ms,1.033199ms,1.0332ms,1.033249ms,1.03325ms,1.033299ms,1.0333ms,1.033349ms,1.03335ms,1.033399ms,1.0334ms,1.033449ms,1.03345ms,1.033499ms,1.0335ms,1.033549ms,1.03355ms,1.033599ms,1.0336ms,1.033649ms,1.03365ms,1.033699ms,1.0337ms,1.033749ms,1.03375ms,1.033799ms,1.0338ms,1.033849ms,1.03385ms,1.033899ms,1.0339ms,1.033949ms,1.03395ms,1.033999ms,1.034ms,1.034049ms,1.03405ms,1.034099ms,1.0341ms,1.034149ms,1.03415ms,1.034199ms,1.0342ms,1.034249ms,1.03425ms,1.034299ms,1.0343ms,1.034349ms,1.03435ms,1.034399ms,1.0344ms,1.034449ms,1.03445ms,1.034499ms,1.0345ms,1.034549ms,1.03455ms,1.034599ms,1.0346ms,1.034649ms,1.03465ms,1.034699ms,1.0347ms,1.034749ms,1.03475ms,1.034799ms,1.0348ms,1.034849ms,1.03485ms,1.034899ms,1.0349ms,1.034949ms,1.03495ms,1.034999ms,1.035ms,1.035049ms,1.03505ms,1.035099ms,1.0351ms,1.035149ms,1.03515ms,1.035199ms,1.0352ms,1.035249ms,1.03525ms,1.035299ms,1.0353ms,1.035349ms,1.03535ms,1.035399ms,1.0354ms,1.035449ms,1.03545ms,1.035499ms,1.0355ms,1.035549ms,1.03555ms,1.035599ms,1.0356ms,1.035649ms,1.03565ms,1.035699ms,1.0357ms,1.035749ms,1.03575ms,1.035799ms,1.0358ms,1.035849ms,1.03585ms,1.035899ms,1.0359ms,1.035949ms,1.03595ms,1.035999ms,1.036ms,1.036049ms,1.03605ms,1.036099ms,1.0361ms,1.036149ms,1.03615ms,1.036199ms,1.0362ms,1.036249ms,1.03625ms,1.036299ms,1.0363ms,1.036349ms,1.03635ms,1.036399ms,1.0364ms,1.036449ms,1.03645ms,1.036499ms,1.0365ms,1.036549ms,1.03655ms,1.036599ms,1.0366ms,1.036649ms,1.03665ms,1.036699ms,1.0367ms,1.036749ms,1.03675ms,1.036799ms,1.0368ms,1.036849ms,1.03685ms,1.036899ms,1.0369ms,1.036949ms,1.03695ms,1.036999ms,1.037ms,1.037049ms,1.03705ms,1.037099ms,1.0371ms,1.037149ms,1.03715ms,1.037199ms,1.0372ms,1.037249ms,1.03725ms,1.037299ms,1.0373ms,1.037349ms,1.03735ms,1.037399ms,1.0374ms,1.037449ms,1.03745ms,1.037499ms,1.0375ms,1.037549ms,1.03755ms,1.037599ms,1.0376ms,1.037649ms,1.03765ms,1.037699ms,1.0377ms,1.037749ms,1.03775ms,1.037799ms,1.0378ms,1.037849ms,1.03785ms,1.037899ms,1.0379ms,1.037949ms,1.03795ms,1.037999ms,1.038ms,1.038049ms,1.03805ms,1.038099ms,1.0381ms,1.038149ms,1.03815ms,1.038199ms,1.0382ms,1.038249ms,1.03825ms,1.038299ms,1.0383ms,1.038349ms,1.03835ms,1.038399ms,1.0384ms,1.038449ms,1.03845ms,1.038499ms,1.0385ms,1.038549ms,1.03855ms,1.038599ms,1.0386ms,1.038649ms,1.03865ms,1.038699ms,1.0387ms,1.038749ms,1.03875ms,1.038799ms,1.0388ms,1.038849ms,1.03885ms,1.038899ms,1.0389ms,1.038949ms,1.03895ms,1.038999ms,1.039ms,1.039049ms,1.03905ms,1.039099ms,1.0391ms,1.039149ms,1.03915ms,1.039199ms,1.0392ms,1.039249ms,1.03925ms,1.039299ms,1.0393ms,1.039349ms,1.03935ms,1.039399ms,1.0394ms,1.039449ms,1.03945ms,1.039499ms,1.0395ms,1.039549ms,1.03955ms,1.039599ms,1.0396ms,1.039649ms,1.03965ms,1.039699ms,1.0397ms,1.039749ms,1.03975ms,1.039799ms,1.0398ms,1.039849ms,1.03985ms,1.039899ms,1.0399ms,1.039949ms,1.03995ms,1.039999ms,1.04ms,1.040049ms,1.04005ms,1.040099ms,1.0401ms,1.040149ms,1.04015ms,1.040199ms,1.0402ms,1.040249ms,1.04025ms,1.040299ms,1.0403ms,1.040349ms,1.04035ms,1.040399ms,1.0404ms,1.040449ms,1.04045ms,1.040499ms,1.0405ms,1.040549ms,1.04055ms,1.040599ms,1.0406ms,1.040649ms,1.04065ms,1.040699ms,1.0407ms,1.040749ms,1.04075ms,1.040799ms,1.0408ms,1.040849ms,1.04085ms,1.040899ms,1.0409ms,1.040949ms,1.04095ms,1.040999ms,1.041ms,1.041049ms,1.04105ms,1.041099ms,1.0411ms,1.041149ms,1.04115ms,1.041199ms,1.0412ms,1.041249ms,1.04125ms,1.041299ms,1.0413ms,1.041349ms,1.04135ms,1.041399ms,1.0414ms,1.041449ms,1.04145ms,1.041499ms,1.0415ms,1.041549ms,1.04155ms,1.041599ms,1.0416ms,1.041649ms,1.04165ms,1.041699ms,1.0417ms,1.041749ms,1.04175ms,1.041799ms,1.0418ms,1.041849ms,1.04185ms,1.041899ms,1.0419ms,1.041949ms,1.04195ms,1.041999ms,1.042ms,1.042049ms,1.04205ms,1.042099ms,1.0421ms,1.042149ms,1.04215ms,1.042199ms,1.0422ms,1.042249ms,1.04225ms,1.042299ms,1.0423ms,1.042349ms,1.04235ms,1.042399ms,1.0424ms,1.042449ms,1.04245ms,1.042499ms,1.0425ms,1.042549ms,1.04255ms,1.042599ms,1.0426ms,1.042649ms,1.04265ms,1.042699ms,1.0427ms,1.042749ms,1.04275ms,1.042799ms,1.0428ms,1.042849ms,1.04285ms,1.042899ms,1.0429ms,1.042949ms,1.04295ms,1.042999ms,1.043ms,1.043049ms,1.04305ms,1.043099ms,1.0431ms,1.043149ms,1.04315ms,1.043199ms,1.0432ms,1.043249ms,1.04325ms,1.043299ms,1.0433ms,1.043349ms,1.04335ms,1.043399ms,1.0434ms,1.043449ms,1.04345ms,1.043499ms,1.0435ms,1.043549ms,1.04355ms,1.043599ms,1.0436ms,1.043649ms,1.04365ms,1.043699ms,1.0437ms,1.043749ms,1.04375ms,1.043799ms,1.0438ms,1.043849ms,1.04385ms,1.043899ms,1.0439ms,1.043949ms,1.04395ms,1.043999ms,1.044ms,1.044049ms,1.04405ms,1.044099ms,1.0441ms,1.044149ms,1.04415ms,1.044199ms,1.0442ms,1.044249ms,1.04425ms,1.044299ms,1.0443ms,1.044349ms,1.04435ms,1.044399ms,1.0444ms,1.044449ms,1.04445ms,1.044499ms,1.0445ms,1.044549ms,1.04455ms,1.044599ms,1.0446ms,1.044649ms,1.04465ms,1.044699ms,1.0447ms,1.044749ms,1.04475ms,1.044799ms,1.0448ms,1.044849ms,1.04485ms,1.044899ms,1.0449ms,1.044949ms,1.04495ms,1.044999ms,1.045ms,1.045049ms,1.04505ms,1.045099ms,1.0451ms,1.045149ms,1.04515ms,1.045199ms,1.0452ms,1.045249ms,1.04525ms,1.045299ms,1.0453ms,1.045349ms,1.04535ms,1.045399ms,1.0454ms,1.045449ms,1.04545ms,1.045499ms,1.0455ms,1.045549ms,1.04555ms,1.045599ms,1.0456ms,1.045649ms,1.04565ms,1.045699ms,1.0457ms,1.045749ms,1.04575ms,1.045799ms,1.0458ms,1.045849ms,1.04585ms,1.045899ms,1.0459ms,1.045949ms,1.04595ms,1.045999ms,1.046ms,1.046049ms,1.04605ms,1.046099ms,1.0461ms,1.046149ms,1.04615ms,1.046199ms,1.0462ms,1.046249ms,1.04625ms,1.046299ms,1.0463ms,1.046349ms,1.04635ms,1.046399ms,1.0464ms,1.046449ms,1.04645ms,1.046499ms,1.0465ms,1.046549ms,1.04655ms,1.046599ms,1.0466ms,1.046649ms,1.04665ms,1.046699ms,1.0467ms,1.046749ms,1.04675ms,1.046799ms,1.0468ms,1.046849ms,1.04685ms,1.046899ms,1.0469ms,1.046949ms,1.04695ms,1.046999ms,1.047ms,1.047049ms,1.04705ms,1.047099ms,1.0471ms,1.047149ms,1.04715ms,1.047199ms,1.0472ms,1.047249ms,1.04725ms,1.047299ms,1.0473ms,1.047349ms,1.04735ms,1.047399ms,1.0474ms,1.047449ms,1.04745ms,1.047499ms,1.0475ms,1.047549ms,1.04755ms,1.047599ms,1.0476ms,1.047649ms,1.04765ms,1.047699ms,1.0477ms,1.047749ms,1.04775ms,1.047799ms,1.0478ms,1.047849ms,1.04785ms,1.047899ms,1.0479ms,1.047949ms,1.04795ms,1.047999ms,1.048ms,1.048049ms,1.04805ms,1.048099ms,1.0481ms,1.048149ms,1.04815ms,1.048199ms,1.0482ms,1.048249ms,1.04825ms,1.048299ms,1.0483ms,1.048349ms,1.04835ms,1.048399ms,1.0484ms,1.048449ms,1.04845ms,1.048499ms,1.0485ms,1.048549ms,1.04855ms,1.048599ms,1.0486ms,1.048649ms,1.04865ms,1.048699ms,1.0487ms,1.048749ms,1.04875ms,1.048799ms,1.0488ms,1.048849ms,1.04885ms,1.048899ms,1.0489ms,1.048949ms,1.04895ms,1.048999ms,1.049ms,1.049049ms,1.04905ms,1.049099ms,1.0491ms,1.049149ms,1.04915ms,1.049199ms,1.0492ms,1.049249ms,1.04925ms,1.049299ms,1.0493ms,1.049349ms,1.04935ms,1.049399ms,1.0494ms,1.049449ms,1.04945ms,1.049499ms,1.0495ms,1.049549ms,1.04955ms,1.049599ms,1.0496ms,1.049649ms,1.04965ms,1.049699ms,1.0497ms,1.049749ms,1.04975ms,1.049799ms,1.0498ms,1.049849ms,1.04985ms,1.049899ms,1.0499ms,1.049949ms,1.04995ms,1.049999ms,1.05ms,1.050049ms,1.05005ms,1.050099ms,1.0501ms,1.050149ms,1.05015ms,1.050199ms,1.0502ms,1.050249ms,1.05025ms,1.050299ms,1.0503ms,1.050349ms,1.05035ms,1.050399ms,1.0504ms,1.050449ms,1.05045ms,1.050499ms,1.0505ms,1.050549ms,1.05055ms,1.050599ms,1.0506ms,1.050649ms,1.05065ms,1.050699ms,1.0507ms,1.050749ms,1.05075ms,1.050799ms,1.0508ms,1.050849ms,1.05085ms,1.050899ms,1.0509ms,1.050949ms,1.05095ms,1.050999ms,1.051ms,1.051049ms,1.05105ms,1.051099ms,1.0511ms,1.051149ms,1.05115ms,1.051199ms,1.0512ms,1.051249ms,1.05125ms,1.051299ms,1.0513ms,1.051349ms,1.05135ms,1.051399ms,1.0514ms,1.051449ms,1.05145ms,1.051499ms,1.0515ms,1.051549ms,1.05155ms,1.051599ms,1.0516ms,1.051649ms,1.05165ms,1.051699ms,1.0517ms,1.051749ms,1.05175ms,1.051799ms,1.0518ms,1.051849ms,1.05185ms,1.051899ms,1.0519ms,1.051949ms,1.05195ms,1.051999ms,1.052ms,1.052049ms,1.05205ms,1.052099ms,1.0521ms,1.052149ms,1.05215ms,1.052199ms,1.0522ms,1.052249ms,1.05225ms,1.052299ms,1.0523ms,1.052349ms,1.05235ms,1.052399ms,1.0524ms,1.052449ms,1.05245ms,1.052499ms,1.0525ms,1.052549ms,1.05255ms,1.052599ms,1.0526ms,1.052649ms,1.05265ms,1.052699ms,1.0527ms,1.052749ms,1.05275ms,1.052799ms,1.0528ms,1.052849ms,1.05285ms,1.052899ms,1.0529ms,1.052949ms,1.05295ms,1.052999ms,1.053ms,1.053049ms,1.05305ms,1.053099ms,1.0531ms,1.053149ms,1.05315ms,1.053199ms,1.0532ms,1.053249ms,1.05325ms,1.053299ms,1.0533ms,1.053349ms,1.05335ms,1.053399ms,1.0534ms,1.053449ms,1.05345ms,1.053499ms,1.0535ms,1.053549ms,1.05355ms,1.053599ms,1.0536ms,1.053649ms,1.05365ms,1.053699ms,1.0537ms,1.053749ms,1.05375ms,1.053799ms,1.0538ms,1.053849ms,1.05385ms,1.053899ms,1.0539ms,1.053949ms,1.05395ms,1.053999ms,1.054ms,1.054049ms,1.05405ms,1.054099ms,1.0541ms,1.054149ms,1.05415ms,1.054199ms,1.0542ms,1.054249ms,1.05425ms,1.054299ms,1.0543ms,1.054349ms,1.05435ms,1.054399ms,1.0544ms,1.054449ms,1.05445ms,1.054499ms,1.0545ms,1.054549ms,1.05455ms,1.054599ms,1.0546ms,1.054649ms,1.05465ms,1.054699ms,1.0547ms,1.054749ms,1.05475ms,1.054799ms,1.0548ms,1.054849ms,1.05485ms,1.054899ms,1.0549ms,1.054949ms,1.05495ms,1.054999ms,1.055ms,1.055049ms,1.05505ms,1.055099ms,1.0551ms,1.055149ms,1.05515ms,1.055199ms,1.0552ms,1.055249ms,1.05525ms,1.055299ms,1.0553ms,1.055349ms,1.05535ms,1.055399ms,1.0554ms,1.055449ms,1.05545ms,1.055499ms,1.0555ms,1.055549ms,1.05555ms,1.055599ms,1.0556ms,1.055649ms,1.05565ms,1.055699ms,1.0557ms,1.055749ms,1.05575ms,1.055799ms,1.0558ms,1.055849ms,1.05585ms,1.055899ms,1.0559ms,1.055949ms,1.05595ms,1.055999ms,1.056ms,1.056049ms,1.05605ms,1.056099ms,1.0561ms,1.056149ms,1.05615ms,1.056199ms,1.0562ms,1.056249ms,1.05625ms,1.056299ms,1.0563ms,1.056349ms,1.05635ms,1.056399ms,1.0564ms,1.056449ms,1.05645ms,1.056499ms,1.0565ms,1.056549ms,1.05655ms,1.056599ms,1.0566ms,1.056649ms,1.05665ms,1.056699ms,1.0567ms,1.056749ms,1.05675ms,1.056799ms,1.0568ms,1.056849ms,1.05685ms,1.056899ms,1.0569ms,1.056949ms,1.05695ms,1.056999ms,1.057ms,1.057049ms,1.05705ms,1.057099ms,1.0571ms,1.057149ms,1.05715ms,1.057199ms,1.0572ms,1.057249ms,1.05725ms,1.057299ms,1.0573ms,1.057349ms,1.05735ms,1.057399ms,1.0574ms,1.057449ms,1.05745ms,1.057499ms,1.0575ms,1.057549ms,1.05755ms,1.057599ms,1.0576ms,1.057649ms,1.05765ms,1.057699ms,1.0577ms,1.057749ms,1.05775ms,1.057799ms,1.0578ms,1.057849ms,1.05785ms,1.057899ms,1.0579ms,1.057949ms,1.05795ms,1.057999ms,1.058ms,1.058049ms,1.05805ms,1.058099ms,1.0581ms,1.058149ms,1.05815ms,1.058199ms,1.0582ms,1.058249ms,1.05825ms,1.058299ms,1.0583ms,1.058349ms,1.05835ms,1.058399ms,1.0584ms,1.058449ms,1.05845ms,1.058499ms,1.0585ms,1.058549ms,1.05855ms,1.058599ms,1.0586ms,1.058649ms,1.05865ms,1.058699ms,1.0587ms,1.058749ms,1.05875ms,1.058799ms,1.0588ms,1.058849ms,1.05885ms,1.058899ms,1.0589ms,1.058949ms,1.05895ms,1.058999ms,1.059ms,1.059049ms,1.05905ms,1.059099ms,1.0591ms,1.059149ms,1.05915ms,1.059199ms,1.0592ms,1.059249ms,1.05925ms,1.059299ms,1.0593ms,1.059349ms,1.05935ms,1.059399ms,1.0594ms,1.059449ms,1.05945ms,1.059499ms,1.0595ms,1.059549ms,1.05955ms,1.059599ms,1.0596ms,1.059649ms,1.05965ms,1.059699ms,1.0597ms,1.059749ms,1.05975ms,1.059799ms,1.0598ms,1.059849ms,1.05985ms,1.059899ms,1.0599ms,1.059949ms,1.05995ms,1.059999ms,1.06ms,1.060049ms,1.06005ms,1.060099ms,1.0601ms,1.060149ms,1.06015ms,1.060199ms,1.0602ms,1.060249ms,1.06025ms,1.060299ms,1.0603ms,1.060349ms,1.06035ms,1.060399ms,1.0604ms,1.060449ms,1.06045ms,1.060499ms,1.0605ms,1.060549ms,1.06055ms,1.060599ms,1.0606ms,1.060649ms,1.06065ms,1.060699ms,1.0607ms,1.060749ms,1.06075ms,1.060799ms,1.0608ms,1.060849ms,1.06085ms,1.060899ms,1.0609ms,1.060949ms,1.06095ms,1.060999ms,1.061ms,1.061049ms,1.06105ms,1.061099ms,1.0611ms,1.061149ms,1.06115ms,1.061199ms,1.0612ms,1.061249ms,1.06125ms,1.061299ms,1.0613ms,1.061349ms,1.06135ms,1.061399ms,1.0614ms,1.061449ms,1.06145ms,1.061499ms,1.0615ms,1.061549ms,1.06155ms,1.061599ms,1.0616ms,1.061649ms,1.06165ms,1.061699ms,1.0617ms,1.061749ms,1.06175ms,1.061799ms,1.0618ms,1.061849ms,1.06185ms,1.061899ms,1.0619ms,1.061949ms,1.06195ms,1.061999ms,1.062ms,1.062049ms,1.06205ms,1.062099ms,1.0621ms,1.062149ms,1.06215ms,1.062199ms,1.0622ms,1.062249ms,1.06225ms,1.062299ms,1.0623ms,1.062349ms,1.06235ms,1.062399ms,1.0624ms,1.062449ms,1.06245ms,1.062499ms,1.0625ms,1.062549ms,1.06255ms,1.062599ms,1.0626ms,1.062649ms,1.06265ms,1.062699ms,1.0627ms,1.062749ms,1.06275ms,1.062799ms,1.0628ms,1.062849ms,1.06285ms,1.062899ms,1.0629ms,1.062949ms,1.06295ms,1.062999ms,1.063ms,1.063049ms,1.06305ms,1.063099ms,1.0631ms,1.063149ms,1.06315ms,1.063199ms,1.0632ms,1.063249ms,1.06325ms,1.063299ms,1.0633ms,1.063349ms,1.06335ms,1.063399ms,1.0634ms,1.063449ms,1.06345ms,1.063499ms,1.0635ms,1.063549ms,1.06355ms,1.063599ms,1.0636ms,1.063649ms,1.06365ms,1.063699ms,1.0637ms,1.063749ms,1.06375ms,1.063799ms,1.0638ms,1.063849ms,1.06385ms,1.063899ms,1.0639ms,1.063949ms,1.06395ms,1.063999ms,1.064ms,1.064049ms,1.06405ms,1.064099ms,1.0641ms,1.064149ms,1.06415ms,1.064199ms,1.0642ms,1.064249ms,1.06425ms,1.064299ms,1.0643ms,1.064349ms,1.06435ms,1.064399ms,1.0644ms,1.064449ms,1.06445ms,1.064499ms,1.0645ms,1.064549ms,1.06455ms,1.064599ms,1.0646ms,1.064649ms,1.06465ms,1.064699ms,1.0647ms,1.064749ms,1.06475ms,1.064799ms,1.0648ms,1.064849ms,1.06485ms,1.064899ms,1.0649ms,1.064949ms,1.06495ms,1.064999ms,1.065ms,1.065049ms,1.06505ms,1.065099ms,1.0651ms,1.065149ms,1.06515ms,1.065199ms,1.0652ms,1.065249ms,1.06525ms,1.065299ms,1.0653ms,1.065349ms,1.06535ms,1.065399ms,1.0654ms,1.065449ms,1.06545ms,1.065499ms,1.0655ms,1.065549ms,1.06555ms,1.065599ms,1.0656ms,1.065649ms,1.06565ms,1.065699ms,1.0657ms,1.065749ms,1.06575ms,1.065799ms,1.0658ms,1.065849ms,1.06585ms,1.065899ms,1.0659ms,1.065949ms,1.06595ms,1.065999ms,1.066ms,1.066049ms,1.06605ms,1.066099ms,1.0661ms,1.066149ms,1.06615ms,1.066199ms,1.0662ms,1.066249ms,1.06625ms,1.066299ms,1.0663ms,1.066349ms,1.06635ms,1.066399ms,1.0664ms,1.066449ms,1.06645ms,1.066499ms,1.0665ms,1.066549ms,1.06655ms,1.066599ms,1.0666ms,1.066649ms,1.06665ms,1.066699ms,1.0667ms,1.066749ms,1.06675ms,1.066799ms,1.0668ms,1.066849ms,1.06685ms,1.066899ms,1.0669ms,1.066949ms,1.06695ms,1.066999ms,1.067ms,1.067049ms,1.06705ms,1.067099ms,1.0671ms,1.067149ms,1.06715ms,1.067199ms,1.0672ms,1.067249ms,1.06725ms,1.067299ms,1.0673ms,1.067349ms,1.06735ms,1.067399ms,1.0674ms,1.067449ms,1.06745ms,1.067499ms,1.0675ms,1.067549ms,1.06755ms,1.067599ms,1.0676ms,1.067649ms,1.06765ms,1.067699ms,1.0677ms,1.067749ms,1.06775ms,1.067799ms,1.0678ms,1.067849ms,1.06785ms,1.067899ms,1.0679ms,1.067949ms,1.06795ms,1.067999ms,1.068ms,1.068049ms,1.06805ms,1.068099ms,1.0681ms,1.068149ms,1.06815ms,1.068199ms,1.0682ms,1.068249ms,1.06825ms,1.068299ms,1.0683ms,1.068349ms,1.06835ms,1.068399ms,1.0684ms,1.068449ms,1.06845ms,1.068499ms,1.0685ms,1.068549ms,1.06855ms,1.068599ms,1.0686ms,1.068649ms,1.06865ms,1.068699ms,1.0687ms,1.068749ms,1.06875ms,1.068799ms,1.0688ms,1.068849ms,1.06885ms,1.068899ms,1.0689ms,1.068949ms,1.06895ms,1.068999ms,1.069ms,1.069049ms,1.06905ms,1.069099ms,1.0691ms,1.069149ms,1.06915ms,1.069199ms,1.0692ms,1.069249ms,1.06925ms,1.069299ms,1.0693ms,1.069349ms,1.06935ms,1.069399ms,1.0694ms,1.069449ms,1.06945ms,1.069499ms,1.0695ms,1.069549ms,1.06955ms,1.069599ms,1.0696ms,1.069649ms,1.06965ms,1.069699ms,1.0697ms,1.069749ms,1.06975ms,1.069799ms,1.0698ms,1.069849ms,1.06985ms,1.069899ms,1.0699ms,1.069949ms,1.06995ms,1.069999ms,1.07ms,1.070049ms,1.07005ms,1.070099ms,1.0701ms,1.070149ms,1.07015ms,1.070199ms,1.0702ms,1.070249ms,1.07025ms,1.070299ms,1.0703ms,1.070349ms,1.07035ms,1.070399ms,1.0704ms,1.070449ms,1.07045ms,1.070499ms,1.0705ms,1.070549ms,1.07055ms,1.070599ms,1.0706ms,1.070649ms,1.07065ms,1.070699ms,1.0707ms,1.070749ms,1.07075ms,1.070799ms,1.0708ms,1.070849ms,1.07085ms,1.070899ms,1.0709ms,1.070949ms,1.07095ms,1.070999ms,1.071ms,1.071049ms,1.07105ms,1.071099ms,1.0711ms,1.071149ms,1.07115ms,1.071199ms,1.0712ms,1.071249ms,1.07125ms,1.071299ms,1.0713ms,1.071349ms,1.07135ms,1.071399ms,1.0714ms,1.071449ms,1.07145ms,1.071499ms,1.0715ms,1.071549ms,1.07155ms,1.071599ms,1.0716ms,1.071649ms,1.07165ms,1.071699ms,1.0717ms,1.071749ms,1.07175ms,1.071799ms,1.0718ms,1.071849ms,1.07185ms,1.071899ms,1.0719ms,1.071949ms,1.07195ms,1.071999ms,1.072ms,1.072049ms,1.07205ms,1.072099ms,1.0721ms,1.072149ms,1.07215ms,1.072199ms,1.0722ms,1.072249ms,1.07225ms,1.072299ms,1.0723ms,1.072349ms,1.07235ms,1.072399ms,1.0724ms,1.072449ms,1.07245ms,1.072499ms,1.0725ms,1.072549ms,1.07255ms,1.072599ms,1.0726ms,1.072649ms,1.07265ms,1.072699ms,1.0727ms,1.072749ms,1.07275ms,1.072799ms,1.0728ms,1.072849ms,1.07285ms,1.072899ms,1.0729ms,1.072949ms,1.07295ms,1.072999ms,1.073ms,1.073049ms,1.07305ms,1.073099ms,1.0731ms,1.073149ms,1.07315ms,1.073199ms,1.0732ms,1.073249ms,1.07325ms,1.073299ms,1.0733ms,1.073349ms,1.07335ms,1.073399ms,1.0734ms,1.073449ms,1.07345ms,1.073499ms,1.0735ms,1.073549ms,1.07355ms,1.073599ms,1.0736ms,1.073649ms,1.07365ms,1.073699ms,1.0737ms,1.073749ms,1.07375ms,1.073799ms,1.0738ms,1.073849ms,1.07385ms,1.073899ms,1.0739ms,1.073949ms,1.07395ms,1.073999ms,1.074ms,1.074049ms,1.07405ms,1.074099ms,1.0741ms,1.074149ms,1.07415ms,1.074199ms,1.0742ms,1.074249ms,1.07425ms,1.074299ms,1.0743ms,1.074349ms,1.07435ms,1.074399ms,1.0744ms,1.074449ms,1.07445ms,1.074499ms,1.0745ms,1.074549ms,1.07455ms,1.074599ms,1.0746ms,1.074649ms,1.07465ms,1.074699ms,1.0747ms,1.074749ms,1.07475ms,1.074799ms,1.0748ms,1.074849ms,1.07485ms,1.074899ms,1.0749ms,1.074949ms,1.07495ms,1.074999ms,1.075ms,1.075049ms,1.07505ms,1.075099ms,1.0751ms,1.075149ms,1.07515ms,1.075199ms,1.0752ms,1.075249ms,1.07525ms,1.075299ms,1.0753ms,1.075349ms,1.07535ms,1.075399ms,1.0754ms,1.075449ms,1.07545ms,1.075499ms,1.0755ms,1.075549ms,1.07555ms,1.075599ms,1.0756ms,1.075649ms,1.07565ms,1.075699ms,1.0757ms,1.075749ms,1.07575ms,1.075799ms,1.0758ms,1.075849ms,1.07585ms,1.075899ms,1.0759ms,1.075949ms,1.07595ms,1.075999ms,1.076ms,1.076049ms,1.07605ms,1.076099ms,1.0761ms,1.076149ms,1.07615ms,1.076199ms,1.0762ms,1.076249ms,1.07625ms,1.076299ms,1.0763ms,1.076349ms,1.07635ms,1.076399ms,1.0764ms,1.076449ms,1.07645ms,1.076499ms,1.0765ms,1.076549ms,1.07655ms,1.076599ms,1.0766ms,1.076649ms,1.07665ms,1.076699ms,1.0767ms,1.076749ms,1.07675ms,1.076799ms,1.0768ms,1.076849ms,1.07685ms,1.076899ms,1.0769ms,1.076949ms,1.07695ms,1.076999ms,1.077ms,1.077049ms,1.07705ms,1.077099ms,1.0771ms,1.077149ms,1.07715ms,1.077199ms,1.0772ms,1.077249ms,1.07725ms,1.077299ms,1.0773ms,1.077349ms,1.07735ms,1.077399ms,1.0774ms,1.077449ms,1.07745ms,1.077499ms,1.0775ms,1.077549ms,1.07755ms,1.077599ms,1.0776ms,1.077649ms,1.07765ms,1.077699ms,1.0777ms,1.077749ms,1.07775ms,1.077799ms,1.0778ms,1.077849ms,1.07785ms,1.077899ms,1.0779ms,1.077949ms,1.07795ms,1.077999ms,1.078ms,1.078049ms,1.07805ms,1.078099ms,1.0781ms,1.078149ms,1.07815ms,1.078199ms,1.0782ms,1.078249ms,1.07825ms,1.078299ms,1.0783ms,1.078349ms,1.07835ms,1.078399ms,1.0784ms,1.078449ms,1.07845ms,1.078499ms,1.0785ms,1.078549ms,1.07855ms,1.078599ms,1.0786ms,1.078649ms,1.07865ms,1.078699ms,1.0787ms,1.078749ms,1.07875ms,1.078799ms,1.0788ms,1.078849ms,1.07885ms,1.078899ms,1.0789ms,1.078949ms,1.07895ms,1.078999ms,1.079ms,1.079049ms,1.07905ms,1.079099ms,1.0791ms,1.079149ms,1.07915ms,1.079199ms,1.0792ms,1.079249ms,1.07925ms,1.079299ms,1.0793ms,1.079349ms,1.07935ms,1.079399ms,1.0794ms,1.079449ms,1.07945ms,1.079499ms,1.0795ms,1.079549ms,1.07955ms,1.079599ms,1.0796ms,1.079649ms,1.07965ms,1.079699ms,1.0797ms,1.079749ms,1.07975ms,1.079799ms,1.0798ms,1.079849ms,1.07985ms,1.079899ms,1.0799ms,1.079949ms,1.07995ms,1.079999ms,1.08ms,1.080049ms,1.08005ms,1.080099ms,1.0801ms,1.080149ms,1.08015ms,1.080199ms,1.0802ms,1.080249ms,1.08025ms,1.080299ms,1.0803ms,1.080349ms,1.08035ms,1.080399ms,1.0804ms,1.080449ms,1.08045ms,1.080499ms,1.0805ms,1.080549ms,1.08055ms,1.080599ms,1.0806ms,1.080649ms,1.08065ms,1.080699ms,1.0807ms,1.080749ms,1.08075ms,1.080799ms,1.0808ms,1.080849ms,1.08085ms,1.080899ms,1.0809ms,1.080949ms,1.08095ms,1.080999ms,1.081ms,1.081049ms,1.08105ms,1.081099ms,1.0811ms,1.081149ms,1.08115ms,1.081199ms,1.0812ms,1.081249ms,1.08125ms,1.081299ms,1.0813ms,1.081349ms,1.08135ms,1.081399ms,1.0814ms,1.081449ms,1.08145ms,1.081499ms,1.0815ms,1.081549ms,1.08155ms,1.081599ms,1.0816ms,1.081649ms,1.08165ms,1.081699ms,1.0817ms,1.081749ms,1.08175ms,1.081799ms,1.0818ms,1.081849ms,1.08185ms,1.081899ms,1.0819ms,1.081949ms,1.08195ms,1.081999ms,1.082ms,1.082049ms,1.08205ms,1.082099ms,1.0821ms,1.082149ms,1.08215ms,1.082199ms,1.0822ms,1.082249ms,1.08225ms,1.082299ms,1.0823ms,1.082349ms,1.08235ms,1.082399ms,1.0824ms,1.082449ms,1.08245ms,1.082499ms,1.0825ms,1.082549ms,1.08255ms,1.082599ms,1.0826ms,1.082649ms,1.08265ms,1.082699ms,1.0827ms,1.082749ms,1.08275ms,1.082799ms,1.0828ms,1.082849ms,1.08285ms,1.082899ms,1.0829ms,1.082949ms,1.08295ms,1.082999ms,1.083ms,1.083049ms,1.08305ms,1.083099ms,1.0831ms,1.083149ms,1.08315ms,1.083199ms,1.0832ms,1.083249ms,1.08325ms,1.083299ms,1.0833ms,1.083349ms,1.08335ms,1.083399ms,1.0834ms,1.083449ms,1.08345ms,1.083499ms,1.0835ms,1.083549ms,1.08355ms,1.083599ms,1.0836ms,1.083649ms,1.08365ms,1.083699ms,1.0837ms,1.083749ms,1.08375ms,1.083799ms,1.0838ms,1.083849ms,1.08385ms,1.083899ms,1.0839ms,1.083949ms,1.08395ms,1.083999ms,1.084ms,1.084049ms,1.08405ms,1.084099ms,1.0841ms,1.084149ms,1.08415ms,1.084199ms,1.0842ms,1.084249ms,1.08425ms,1.084299ms,1.0843ms,1.084349ms,1.08435ms,1.084399ms,1.0844ms,1.084449ms,1.08445ms,1.084499ms,1.0845ms,1.084549ms,1.08455ms,1.084599ms,1.0846ms,1.084649ms,1.08465ms,1.084699ms,1.0847ms,1.084749ms,1.08475ms,1.084799ms,1.0848ms,1.084849ms,1.08485ms,1.084899ms,1.0849ms,1.084949ms,1.08495ms,1.084999ms,1.085ms,1.085049ms,1.08505ms,1.085099ms,1.0851ms,1.085149ms,1.08515ms,1.085199ms,1.0852ms,1.085249ms,1.08525ms,1.085299ms,1.0853ms,1.085349ms,1.08535ms,1.085399ms,1.0854ms,1.085449ms,1.08545ms,1.085499ms,1.0855ms,1.085549ms,1.08555ms,1.085599ms,1.0856ms,1.085649ms,1.08565ms,1.085699ms,1.0857ms,1.085749ms,1.08575ms,1.085799ms,1.0858ms,1.085849ms,1.08585ms,1.085899ms,1.0859ms,1.085949ms,1.08595ms,1.085999ms,1.086ms,1.086049ms,1.08605ms,1.086099ms,1.0861ms,1.086149ms,1.08615ms,1.086199ms,1.0862ms,1.086249ms,1.08625ms,1.086299ms,1.0863ms,1.086349ms,1.08635ms,1.086399ms,1.0864ms,1.086449ms,1.08645ms,1.086499ms,1.0865ms,1.086549ms,1.08655ms,1.086599ms,1.0866ms,1.086649ms,1.08665ms,1.086699ms,1.0867ms,1.086749ms,1.08675ms,1.086799ms,1.0868ms,1.086849ms,1.08685ms,1.086899ms,1.0869ms,1.086949ms,1.08695ms,1.086999ms,1.087ms,1.087049ms,1.08705ms,1.087099ms,1.0871ms,1.087149ms,1.08715ms,1.087199ms,1.0872ms,1.087249ms,1.08725ms,1.087299ms,1.0873ms,1.087349ms,1.08735ms,1.087399ms,1.0874ms,1.087449ms,1.08745ms,1.087499ms,1.0875ms,1.087549ms,1.08755ms,1.087599ms,1.0876ms,1.087649ms,1.08765ms,1.087699ms,1.0877ms,1.087749ms,1.08775ms,1.087799ms,1.0878ms,1.087849ms,1.08785ms,1.087899ms,1.0879ms,1.087949ms,1.08795ms,1.087999ms,1.088ms,1.088049ms,1.08805ms,1.088099ms,1.0881ms,1.088149ms,1.08815ms,1.088199ms,1.0882ms,1.088249ms,1.08825ms,1.088299ms,1.0883ms,1.088349ms,1.08835ms,1.088399ms,1.0884ms,1.088449ms,1.08845ms,1.088499ms,1.0885ms,1.088549ms,1.08855ms,1.088599ms,1.0886ms,1.088649ms,1.08865ms,1.088699ms,1.0887ms,1.088749ms,1.08875ms,1.088799ms,1.0888ms,1.088849ms,1.08885ms,1.088899ms,1.0889ms,1.088949ms,1.08895ms,1.088999ms,1.089ms,1.089049ms,1.08905ms,1.089099ms,1.0891ms,1.089149ms,1.08915ms,1.089199ms,1.0892ms,1.089249ms,1.08925ms,1.089299ms,1.0893ms,1.089349ms,1.08935ms,1.089399ms,1.0894ms,1.089449ms,1.08945ms,1.089499ms,1.0895ms,1.089549ms,1.08955ms,1.089599ms,1.0896ms,1.089649ms,1.08965ms,1.089699ms,1.0897ms,1.089749ms,1.08975ms,1.089799ms,1.0898ms,1.089849ms,1.08985ms,1.089899ms,1.0899ms,1.089949ms,1.08995ms,1.089999ms,1.09ms,1.090049ms,1.09005ms,1.090099ms,1.0901ms,1.090149ms,1.09015ms,1.090199ms,1.0902ms,1.090249ms,1.09025ms,1.090299ms,1.0903ms,1.090349ms,1.09035ms,1.090399ms,1.0904ms,1.090449ms,1.09045ms,1.090499ms,1.0905ms,1.090549ms,1.09055ms,1.090599ms,1.0906ms,1.090649ms,1.09065ms,1.090699ms,1.0907ms,1.090749ms,1.09075ms,1.090799ms,1.0908ms,1.090849ms,1.09085ms,1.090899ms,1.0909ms,1.090949ms,1.09095ms,1.090999ms,1.091ms,1.091049ms,1.09105ms,1.091099ms,1.0911ms,1.091149ms,1.09115ms,1.091199ms,1.0912ms,1.091249ms,1.09125ms,1.091299ms,1.0913ms,1.091349ms,1.09135ms,1.091399ms,1.0914ms,1.091449ms,1.09145ms,1.091499ms,1.0915ms,1.091549ms,1.09155ms,1.091599ms,1.0916ms,1.091649ms,1.09165ms,1.091699ms,1.0917ms,1.091749ms,1.09175ms,1.091799ms,1.0918ms,1.091849ms,1.09185ms,1.091899ms,1.0919ms,1.091949ms,1.09195ms,1.091999ms,1.092ms,1.092049ms,1.09205ms,1.092099ms,1.0921ms,1.092149ms,1.09215ms,1.092199ms,1.0922ms,1.092249ms,1.09225ms,1.092299ms,1.0923ms,1.092349ms,1.09235ms,1.092399ms,1.0924ms,1.092449ms,1.09245ms,1.092499ms,1.0925ms,1.092549ms,1.09255ms,1.092599ms,1.0926ms,1.092649ms,1.09265ms,1.092699ms,1.0927ms,1.092749ms,1.09275ms,1.092799ms,1.0928ms,1.092849ms,1.09285ms,1.092899ms,1.0929ms,1.092949ms,1.09295ms,1.092999ms,1.093ms,1.093049ms,1.09305ms,1.093099ms,1.0931ms,1.093149ms,1.09315ms,1.093199ms,1.0932ms,1.093249ms,1.09325ms,1.093299ms,1.0933ms,1.093349ms,1.09335ms,1.093399ms,1.0934ms,1.093449ms,1.09345ms,1.093499ms,1.0935ms,1.093549ms,1.09355ms,1.093599ms,1.0936ms,1.093649ms,1.09365ms,1.093699ms,1.0937ms,1.093749ms,1.09375ms,1.093799ms,1.0938ms,1.093849ms,1.09385ms,1.093899ms,1.0939ms,1.093949ms,1.09395ms,1.093999ms,1.094ms,1.094049ms,1.09405ms,1.094099ms,1.0941ms,1.094149ms,1.09415ms,1.094199ms,1.0942ms,1.094249ms,1.09425ms,1.094299ms,1.0943ms,1.094349ms,1.09435ms,1.094399ms,1.0944ms,1.094449ms,1.09445ms,1.094499ms,1.0945ms,1.094549ms,1.09455ms,1.094599ms,1.0946ms,1.094649ms,1.09465ms,1.094699ms,1.0947ms,1.094749ms,1.09475ms,1.094799ms,1.0948ms,1.094849ms,1.09485ms,1.094899ms,1.0949ms,1.094949ms,1.09495ms,1.094999ms,1.095ms,1.095049ms,1.09505ms,1.095099ms,1.0951ms,1.095149ms,1.09515ms,1.095199ms,1.0952ms,1.095249ms,1.09525ms,1.095299ms,1.0953ms,1.095349ms,1.09535ms,1.095399ms,1.0954ms,1.095449ms,1.09545ms,1.095499ms,1.0955ms,1.095549ms,1.09555ms,1.095599ms,1.0956ms,1.095649ms,1.09565ms,1.095699ms,1.0957ms,1.095749ms,1.09575ms,1.095799ms,1.0958ms,1.095849ms,1.09585ms,1.095899ms,1.0959ms,1.095949ms,1.09595ms,1.095999ms,1.096ms,1.096049ms,1.09605ms,1.096099ms,1.0961ms,1.096149ms,1.09615ms,1.096199ms,1.0962ms,1.096249ms,1.09625ms,1.096299ms,1.0963ms,1.096349ms,1.09635ms,1.096399ms,1.0964ms,1.096449ms,1.09645ms,1.096499ms,1.0965ms,1.096549ms,1.09655ms,1.096599ms,1.0966ms,1.096649ms,1.09665ms,1.096699ms,1.0967ms,1.096749ms,1.09675ms,1.096799ms,1.0968ms,1.096849ms,1.09685ms,1.096899ms,1.0969ms,1.096949ms,1.09695ms,1.096999ms,1.097ms,1.097049ms,1.09705ms,1.097099ms,1.0971ms,1.097149ms,1.09715ms,1.097199ms,1.0972ms,1.097249ms,1.09725ms,1.097299ms,1.0973ms,1.097349ms,1.09735ms,1.097399ms,1.0974ms,1.097449ms,1.09745ms,1.097499ms,1.0975ms,1.097549ms,1.09755ms,1.097599ms,1.0976ms,1.097649ms,1.09765ms,1.097699ms,1.0977ms,1.097749ms,1.09775ms,1.097799ms,1.0978ms,1.097849ms,1.09785ms,1.097899ms,1.0979ms,1.097949ms,1.09795ms,1.097999ms,1.098ms,1.098049ms,1.09805ms,1.098099ms,1.0981ms,1.098149ms,1.09815ms,1.098199ms,1.0982ms,1.098249ms,1.09825ms,1.098299ms,1.0983ms,1.098349ms,1.09835ms,1.098399ms,1.0984ms,1.098449ms,1.09845ms,1.098499ms,1.0985ms,1.098549ms,1.09855ms,1.098599ms,1.0986ms,1.098649ms,1.09865ms,1.098699ms,1.0987ms,1.098749ms,1.09875ms,1.098799ms,1.0988ms,1.098849ms,1.09885ms,1.098899ms,1.0989ms,1.098949ms,1.09895ms,1.098999ms,1.099ms,1.099049ms,1.09905ms,1.099099ms,1.0991ms,1.099149ms,1.09915ms,1.099199ms,1.0992ms,1.099249ms,1.09925ms,1.099299ms,1.0993ms,1.099349ms,1.09935ms,1.099399ms,1.0994ms,1.099449ms,1.09945ms,1.099499ms,1.0995ms,1.099549ms,1.09955ms,1.099599ms,1.0996ms,1.099649ms,1.09965ms,1.099699ms,1.0997ms,1.099749ms,1.09975ms,1.099799ms,1.0998ms,1.099849ms,1.09985ms,1.099899ms,1.0999ms,1.099949ms,1.09995ms,1.099999ms,1.1ms,1.100049ms,1.10005ms,1.100099ms,1.1001ms,1.100149ms,1.10015ms,1.100199ms,1.1002ms,1.100249ms,1.10025ms,1.100299ms,1.1003ms,1.100349ms,1.10035ms,1.100399ms,1.1004ms,1.100449ms,1.10045ms,1.100499ms,1.1005ms,1.100549ms,1.10055ms,1.100599ms,1.1006ms,1.100649ms,1.10065ms,1.100699ms,1.1007ms,1.100749ms,1.10075ms,1.100799ms,1.1008ms,1.100849ms,1.10085ms,1.100899ms,1.1009ms,1.100949ms,1.10095ms,1.100999ms,1.101ms,1.101049ms,1.10105ms,1.101099ms,1.1011ms,1.101149ms,1.10115ms,1.101199ms,1.1012ms,1.101249ms,1.10125ms,1.101299ms,1.1013ms,1.101349ms,1.10135ms,1.101399ms,1.1014ms,1.101449ms,1.10145ms,1.101499ms,1.1015ms,1.101549ms,1.10155ms,1.101599ms,1.1016ms,1.101649ms,1.10165ms,1.101699ms,1.1017ms,1.101749ms,1.10175ms,1.101799ms,1.1018ms,1.101849ms,1.10185ms,1.101899ms,1.1019ms,1.101949ms,1.10195ms,1.101999ms,1.102ms,1.102049ms,1.10205ms,1.102099ms,1.1021ms,1.102149ms,1.10215ms,1.102199ms,1.1022ms,1.102249ms,1.10225ms,1.102299ms,1.1023ms,1.102349ms,1.10235ms,1.102399ms,1.1024ms,1.102449ms,1.10245ms,1.102499ms,1.1025ms,1.102549ms,1.10255ms,1.102599ms,1.1026ms,1.102649ms,1.10265ms,1.102699ms,1.1027ms,1.102749ms,1.10275ms,1.102799ms,1.1028ms,1.102849ms,1.10285ms,1.102899ms,1.1029ms,1.102949ms,1.10295ms,1.102999ms,1.103ms,1.103049ms,1.10305ms,1.103099ms,1.1031ms,1.103149ms,1.10315ms,1.103199ms,1.1032ms,1.103249ms,1.10325ms,1.103299ms,1.1033ms,1.103349ms,1.10335ms,1.103399ms,1.1034ms,1.103449ms,1.10345ms,1.103499ms,1.1035ms,1.103549ms,1.10355ms,1.103599ms,1.1036ms,1.103649ms,1.10365ms,1.103699ms,1.1037ms,1.103749ms,1.10375ms,1.103799ms,1.1038ms,1.103849ms,1.10385ms,1.103899ms,1.1039ms,1.103949ms,1.10395ms,1.103999ms,1.104ms,1.104049ms,1.10405ms,1.104099ms,1.1041ms,1.104149ms,1.10415ms,1.104199ms,1.1042ms,1.104249ms,1.10425ms,1.104299ms,1.1043ms,1.104349ms,1.10435ms,1.104399ms,1.1044ms,1.104449ms,1.10445ms,1.104499ms,1.1045ms,1.104549ms,1.10455ms,1.104599ms,1.1046ms,1.104649ms,1.10465ms,1.104699ms,1.1047ms,1.104749ms,1.10475ms,1.104799ms,1.1048ms,1.104849ms,1.10485ms,1.104899ms,1.1049ms,1.104949ms,1.10495ms,1.104999ms,1.105ms,1.105049ms,1.10505ms,1.105099ms,1.1051ms,1.105149ms,1.10515ms,1.105199ms,1.1052ms,1.105249ms,1.10525ms,1.105299ms,1.1053ms,1.105349ms,1.10535ms,1.105399ms,1.1054ms,1.105449ms,1.10545ms,1.105499ms,1.1055ms,1.105549ms,1.10555ms,1.105599ms,1.1056ms,1.105649ms,1.10565ms,1.105699ms,1.1057ms,1.105749ms,1.10575ms,1.105799ms,1.1058ms,1.105849ms,1.10585ms,1.105899ms,1.1059ms,1.105949ms,1.10595ms,1.105999ms,1.106ms,1.106049ms,1.10605ms,1.106099ms,1.1061ms,1.106149ms,1.10615ms,1.106199ms,1.1062ms,1.106249ms,1.10625ms,1.106299ms,1.1063ms,1.106349ms,1.10635ms,1.106399ms,1.1064ms,1.106449ms,1.10645ms,1.106499ms,1.1065ms,1.106549ms,1.10655ms,1.106599ms,1.1066ms,1.106649ms,1.10665ms,1.106699ms,1.1067ms,1.106749ms,1.10675ms,1.106799ms,1.1068ms,1.106849ms,1.10685ms,1.106899ms,1.1069ms,1.106949ms,1.10695ms,1.106999ms,1.107ms,1.107049ms,1.10705ms,1.107099ms,1.1071ms,1.107149ms,1.10715ms,1.107199ms,1.1072ms,1.107249ms,1.10725ms,1.107299ms,1.1073ms,1.107349ms,1.10735ms,1.107399ms,1.1074ms,1.107449ms,1.10745ms,1.107499ms,1.1075ms,1.107549ms,1.10755ms,1.107599ms,1.1076ms,1.107649ms,1.10765ms,1.107699ms,1.1077ms,1.107749ms,1.10775ms,1.107799ms,1.1078ms,1.107849ms,1.10785ms,1.107899ms,1.1079ms,1.107949ms,1.10795ms,1.107999ms,1.108ms,1.108049ms,1.10805ms,1.108099ms,1.1081ms,1.108149ms,1.10815ms,1.108199ms,1.1082ms,1.108249ms,1.10825ms,1.108299ms,1.1083ms,1.108349ms,1.10835ms,1.108399ms,1.1084ms,1.108449ms,1.10845ms,1.108499ms,1.1085ms,1.108549ms,1.10855ms,1.108599ms,1.1086ms,1.108649ms,1.10865ms,1.108699ms,1.1087ms,1.108749ms,1.10875ms,1.108799ms,1.1088ms,1.108849ms,1.10885ms,1.108899ms,1.1089ms,1.108949ms,1.10895ms,1.108999ms,1.109ms,1.109049ms,1.10905ms,1.109099ms,1.1091ms,1.109149ms,1.10915ms,1.109199ms,1.1092ms,1.109249ms,1.10925ms,1.109299ms,1.1093ms,1.109349ms,1.10935ms,1.109399ms,1.1094ms,1.109449ms,1.10945ms,1.109499ms,1.1095ms,1.109549ms,1.10955ms,1.109599ms,1.1096ms,1.109649ms,1.10965ms,1.109699ms,1.1097ms,1.109749ms,1.10975ms,1.109799ms,1.1098ms,1.109849ms,1.10985ms,1.109899ms,1.1099ms,1.109949ms,1.10995ms,1.109999ms,1.11ms,1.110049ms,1.11005ms,1.110099ms,1.1101ms,1.110149ms,1.11015ms,1.110199ms,1.1102ms,1.110249ms,1.11025ms,1.110299ms,1.1103ms,1.110349ms,1.11035ms,1.110399ms,1.1104ms,1.110449ms,1.11045ms,1.110499ms,1.1105ms,1.110549ms,1.11055ms,1.110599ms,1.1106ms,1.110649ms,1.11065ms,1.110699ms,1.1107ms,1.110749ms,1.11075ms,1.110799ms,1.1108ms,1.110849ms,1.11085ms,1.110899ms,1.1109ms,1.110949ms,1.11095ms,1.110999ms,1.111ms,1.111049ms,1.11105ms,1.111099ms,1.1111ms,1.111149ms,1.11115ms,1.111199ms,1.1112ms,1.111249ms,1.11125ms,1.111299ms,1.1113ms,1.111349ms,1.11135ms,1.111399ms,1.1114ms,1.111449ms,1.11145ms,1.111499ms,1.1115ms,1.111549ms,1.11155ms,1.111599ms,1.1116ms,1.111649ms,1.11165ms,1.111699ms,1.1117ms,1.111749ms,1.11175ms,1.111799ms,1.1118ms,1.111849ms,1.11185ms,1.111899ms,1.1119ms,1.111949ms,1.11195ms,1.111999ms,1.112ms,1.112049ms,1.11205ms,1.112099ms,1.1121ms,1.112149ms,1.11215ms,1.112199ms,1.1122ms,1.112249ms,1.11225ms,1.112299ms,1.1123ms,1.112349ms,1.11235ms,1.112399ms,1.1124ms,1.112449ms,1.11245ms,1.112499ms,1.1125ms,1.112549ms,1.11255ms,1.112599ms,1.1126ms,1.112649ms,1.11265ms,1.112699ms,1.1127ms,1.112749ms,1.11275ms,1.112799ms,1.1128ms,1.112849ms,1.11285ms,1.112899ms,1.1129ms,1.112949ms,1.11295ms,1.112999ms,1.113ms,1.113049ms,1.11305ms,1.113099ms,1.1131ms,1.113149ms,1.11315ms,1.113199ms,1.1132ms,1.113249ms,1.11325ms,1.113299ms,1.1133ms,1.113349ms,1.11335ms,1.113399ms,1.1134ms,1.113449ms,1.11345ms,1.113499ms,1.1135ms,1.113549ms,1.11355ms,1.113599ms,1.1136ms,1.113649ms,1.11365ms,1.113699ms,1.1137ms,1.113749ms,1.11375ms,1.113799ms,1.1138ms,1.113849ms,1.11385ms,1.113899ms,1.1139ms,1.113949ms,1.11395ms,1.113999ms,1.114ms,1.114049ms,1.11405ms,1.114099ms,1.1141ms,1.114149ms,1.11415ms,1.114199ms,1.1142ms,1.114249ms,1.11425ms,1.114299ms,1.1143ms,1.114349ms,1.11435ms,1.114399ms,1.1144ms,1.114449ms,1.11445ms,1.114499ms,1.1145ms,1.114549ms,1.11455ms,1.114599ms,1.1146ms,1.114649ms,1.11465ms,1.114699ms,1.1147ms,1.114749ms,1.11475ms,1.114799ms,1.1148ms,1.114849ms,1.11485ms,1.114899ms,1.1149ms,1.114949ms,1.11495ms,1.114999ms,1.115ms,1.115049ms,1.11505ms,1.115099ms,1.1151ms,1.115149ms,1.11515ms,1.115199ms,1.1152ms,1.115249ms,1.11525ms,1.115299ms,1.1153ms,1.115349ms,1.11535ms,1.115399ms,1.1154ms,1.115449ms,1.11545ms,1.115499ms,1.1155ms,1.115549ms,1.11555ms,1.115599ms,1.1156ms,1.115649ms,1.11565ms,1.115699ms,1.1157ms,1.115749ms,1.11575ms,1.115799ms,1.1158ms,1.115849ms,1.11585ms,1.115899ms,1.1159ms,1.115949ms,1.11595ms,1.115999ms,1.116ms,1.116049ms,1.11605ms,1.116099ms,1.1161ms,1.116149ms,1.11615ms,1.116199ms,1.1162ms,1.116249ms,1.11625ms,1.116299ms,1.1163ms,1.116349ms,1.11635ms,1.116399ms,1.1164ms,1.116449ms,1.11645ms,1.116499ms,1.1165ms,1.116549ms,1.11655ms,1.116599ms,1.1166ms,1.116649ms,1.11665ms,1.116699ms,1.1167ms,1.116749ms,1.11675ms,1.116799ms,1.1168ms,1.116849ms,1.11685ms,1.116899ms,1.1169ms,1.116949ms,1.11695ms,1.116999ms,1.117ms,1.117049ms,1.11705ms,1.117099ms,1.1171ms,1.117149ms,1.11715ms,1.117199ms,1.1172ms,1.117249ms,1.11725ms,1.117299ms,1.1173ms,1.117349ms,1.11735ms,1.117399ms,1.1174ms,1.117449ms,1.11745ms,1.117499ms,1.1175ms,1.117549ms,1.11755ms,1.117599ms,1.1176ms,1.117649ms,1.11765ms,1.117699ms,1.1177ms,1.117749ms,1.11775ms,1.117799ms,1.1178ms,1.117849ms,1.11785ms,1.117899ms,1.1179ms,1.117949ms,1.11795ms,1.117999ms,1.118ms,1.118049ms,1.11805ms,1.118099ms,1.1181ms,1.118149ms,1.11815ms,1.118199ms,1.1182ms,1.118249ms,1.11825ms,1.118299ms,1.1183ms,1.118349ms,1.11835ms,1.118399ms,1.1184ms,1.118449ms,1.11845ms,1.118499ms,1.1185ms,1.118549ms,1.11855ms,1.118599ms,1.1186ms,1.118649ms,1.11865ms,1.118699ms,1.1187ms,1.118749ms,1.11875ms,1.118799ms,1.1188ms,1.118849ms,1.11885ms,1.118899ms,1.1189ms,1.118949ms,1.11895ms,1.118999ms,1.119ms,1.119049ms,1.11905ms,1.119099ms,1.1191ms,1.119149ms,1.11915ms,1.119199ms,1.1192ms,1.119249ms,1.11925ms,1.119299ms,1.1193ms,1.119349ms,1.11935ms,1.119399ms,1.1194ms,1.119449ms,1.11945ms,1.119499ms,1.1195ms,1.119549ms,1.11955ms,1.119599ms,1.1196ms,1.119649ms,1.11965ms,1.119699ms,1.1197ms,1.119749ms,1.11975ms,1.119799ms,1.1198ms,1.119849ms,1.11985ms,1.119899ms,1.1199ms,1.119949ms,1.11995ms,1.119999ms,1.12ms,1.120049ms,1.12005ms,1.120099ms,1.1201ms,1.120149ms,1.12015ms,1.120199ms,1.1202ms,1.120249ms,1.12025ms,1.120299ms,1.1203ms,1.120349ms,1.12035ms,1.120399ms,1.1204ms,1.120449ms,1.12045ms,1.120499ms,1.1205ms,1.120549ms,1.12055ms,1.120599ms,1.1206ms,1.120649ms,1.12065ms,1.120699ms,1.1207ms,1.120749ms,1.12075ms,1.120799ms,1.1208ms,1.120849ms,1.12085ms,1.120899ms,1.1209ms,1.120949ms,1.12095ms,1.120999ms,1.121ms,1.121049ms,1.12105ms,1.121099ms,1.1211ms,1.121149ms,1.12115ms,1.121199ms,1.1212ms,1.121249ms,1.12125ms,1.121299ms,1.1213ms,1.121349ms,1.12135ms,1.121399ms,1.1214ms,1.121449ms,1.12145ms,1.121499ms,1.1215ms,1.121549ms,1.12155ms,1.121599ms,1.1216ms,1.121649ms,1.12165ms,1.121699ms,1.1217ms,1.121749ms,1.12175ms,1.121799ms,1.1218ms,1.121849ms,1.12185ms,1.121899ms,1.1219ms,1.121949ms,1.12195ms,1.121999ms,1.122ms,1.122049ms,1.12205ms,1.122099ms,1.1221ms,1.122149ms,1.12215ms,1.122199ms,1.1222ms,1.122249ms,1.12225ms,1.122299ms,1.1223ms,1.122349ms,1.12235ms,1.122399ms,1.1224ms,1.122449ms,1.12245ms,1.122499ms,1.1225ms,1.122549ms,1.12255ms,1.122599ms,1.1226ms,1.122649ms,1.12265ms,1.122699ms,1.1227ms,1.122749ms,1.12275ms,1.122799ms,1.1228ms,1.122849ms,1.12285ms,1.122899ms,1.1229ms,1.122949ms,1.12295ms,1.122999ms,1.123ms,1.123049ms,1.12305ms,1.123099ms,1.1231ms,1.123149ms,1.12315ms,1.123199ms,1.1232ms,1.123249ms,1.12325ms,1.123299ms,1.1233ms,1.123349ms,1.12335ms,1.123399ms,1.1234ms,1.123449ms,1.12345ms,1.123499ms,1.1235ms,1.123549ms,1.12355ms,1.123599ms,1.1236ms,1.123649ms,1.12365ms,1.123699ms,1.1237ms,1.123749ms,1.12375ms,1.123799ms,1.1238ms,1.123849ms,1.12385ms,1.123899ms,1.1239ms,1.123949ms,1.12395ms,1.123999ms,1.124ms,1.124049ms,1.12405ms,1.124099ms,1.1241ms,1.124149ms,1.12415ms,1.124199ms,1.1242ms,1.124249ms,1.12425ms,1.124299ms,1.1243ms,1.124349ms,1.12435ms,1.124399ms,1.1244ms,1.124449ms,1.12445ms,1.124499ms,1.1245ms,1.124549ms,1.12455ms,1.124599ms,1.1246ms,1.124649ms,1.12465ms,1.124699ms,1.1247ms,1.124749ms,1.12475ms,1.124799ms,1.1248ms,1.124849ms,1.12485ms,1.124899ms,1.1249ms,1.124949ms,1.12495ms,1.124999ms,1.125ms,1.125049ms,1.12505ms,1.125099ms,1.1251ms,1.125149ms,1.12515ms,1.125199ms,1.1252ms,1.125249ms,1.12525ms,1.125299ms,1.1253ms,1.125349ms,1.12535ms,1.125399ms,1.1254ms,1.125449ms,1.12545ms,1.125499ms,1.1255ms,1.125549ms,1.12555ms,1.125599ms,1.1256ms,1.125649ms,1.12565ms,1.125699ms,1.1257ms,1.125749ms,1.12575ms,1.125799ms,1.1258ms,1.125849ms,1.12585ms,1.125899ms,1.1259ms,1.125949ms,1.12595ms,1.125999ms,1.126ms,1.126049ms,1.12605ms,1.126099ms,1.1261ms,1.126149ms,1.12615ms,1.126199ms,1.1262ms,1.126249ms,1.12625ms,1.126299ms,1.1263ms,1.126349ms,1.12635ms,1.126399ms,1.1264ms,1.126449ms,1.12645ms,1.126499ms,1.1265ms,1.126549ms,1.12655ms,1.126599ms,1.1266ms,1.126649ms,1.12665ms,1.126699ms,1.1267ms,1.126749ms,1.12675ms,1.126799ms,1.1268ms,1.126849ms,1.12685ms,1.126899ms,1.1269ms,1.126949ms,1.12695ms,1.126999ms,1.127ms,1.127049ms,1.12705ms,1.127099ms,1.1271ms,1.127149ms,1.12715ms,1.127199ms,1.1272ms,1.127249ms,1.12725ms,1.127299ms,1.1273ms,1.127349ms,1.12735ms,1.127399ms,1.1274ms,1.127449ms,1.12745ms,1.127499ms,1.1275ms,1.127549ms,1.12755ms,1.127599ms,1.1276ms,1.127649ms,1.12765ms,1.127699ms,1.1277ms,1.127749ms,1.12775ms,1.127799ms,1.1278ms,1.127849ms,1.12785ms,1.127899ms,1.1279ms,1.127949ms,1.12795ms,1.127999ms,1.128ms,1.128049ms,1.12805ms,1.128099ms,1.1281ms,1.128149ms,1.12815ms,1.128199ms,1.1282ms,1.128249ms,1.12825ms,1.128299ms,1.1283ms,1.128349ms,1.12835ms,1.128399ms,1.1284ms,1.128449ms,1.12845ms,1.128499ms,1.1285ms,1.128549ms,1.12855ms,1.128599ms,1.1286ms,1.128649ms,1.12865ms,1.128699ms,1.1287ms,1.128749ms,1.12875ms,1.128799ms,1.1288ms,1.128849ms,1.12885ms,1.128899ms,1.1289ms,1.128949ms,1.12895ms,1.128999ms,1.129ms,1.129049ms,1.12905ms,1.129099ms,1.1291ms,1.129149ms,1.12915ms,1.129199ms,1.1292ms,1.129249ms,1.12925ms,1.129299ms,1.1293ms,1.129349ms,1.12935ms,1.129399ms,1.1294ms,1.129449ms,1.12945ms,1.129499ms,1.1295ms,1.129549ms,1.12955ms,1.129599ms,1.1296ms,1.129649ms,1.12965ms,1.129699ms,1.1297ms,1.129749ms,1.12975ms,1.129799ms,1.1298ms,1.129849ms,1.12985ms,1.129899ms,1.1299ms,1.129949ms,1.12995ms,1.129999ms,1.13ms,1.130049ms,1.13005ms,1.130099ms,1.1301ms,1.130149ms,1.13015ms,1.130199ms,1.1302ms,1.130249ms,1.13025ms,1.130299ms,1.1303ms,1.130349ms,1.13035ms,1.130399ms,1.1304ms,1.130449ms,1.13045ms,1.130499ms,1.1305ms,1.130549ms,1.13055ms,1.130599ms,1.1306ms,1.130649ms,1.13065ms,1.130699ms,1.1307ms,1.130749ms,1.13075ms,1.130799ms,1.1308ms,1.130849ms,1.13085ms,1.130899ms,1.1309ms,1.130949ms,1.13095ms,1.130999ms,1.131ms,1.131049ms,1.13105ms,1.131099ms,1.1311ms,1.131149ms,1.13115ms,1.131199ms,1.1312ms,1.131249ms,1.13125ms,1.131299ms,1.1313ms,1.131349ms,1.13135ms,1.131399ms,1.1314ms,1.131449ms,1.13145ms,1.131499ms,1.1315ms,1.131549ms,1.13155ms,1.131599ms,1.1316ms,1.131649ms,1.13165ms,1.131699ms,1.1317ms,1.131749ms,1.13175ms,1.131799ms,1.1318ms,1.131849ms,1.13185ms,1.131899ms,1.1319ms,1.131949ms,1.13195ms,1.131999ms,1.132ms,1.132049ms,1.13205ms,1.132099ms,1.1321ms,1.132149ms,1.13215ms,1.132199ms,1.1322ms,1.132249ms,1.13225ms,1.132299ms,1.1323ms,1.132349ms,1.13235ms,1.132399ms,1.1324ms,1.132449ms,1.13245ms,1.132499ms,1.1325ms,1.132549ms,1.13255ms,1.132599ms,1.1326ms,1.132649ms,1.13265ms,1.132699ms,1.1327ms,1.132749ms,1.13275ms,1.132799ms,1.1328ms,1.132849ms,1.13285ms,1.132899ms,1.1329ms,1.132949ms,1.13295ms,1.132999ms,1.133ms,1.133049ms,1.13305ms,1.133099ms,1.1331ms,1.133149ms,1.13315ms,1.133199ms,1.1332ms,1.133249ms,1.13325ms,1.133299ms,1.1333ms,1.133349ms,1.13335ms,1.133399ms,1.1334ms,1.133449ms,1.13345ms,1.133499ms,1.1335ms,1.133549ms,1.13355ms,1.133599ms,1.1336ms,1.133649ms,1.13365ms,1.133699ms,1.1337ms,1.133749ms,1.13375ms,1.133799ms,1.1338ms,1.133849ms,1.13385ms,1.133899ms,1.1339ms,1.133949ms,1.13395ms,1.133999ms,1.134ms,1.134049ms,1.13405ms,1.134099ms,1.1341ms,1.134149ms,1.13415ms,1.134199ms,1.1342ms,1.134249ms,1.13425ms,1.134299ms,1.1343ms,1.134349ms,1.13435ms,1.134399ms,1.1344ms,1.134449ms,1.13445ms,1.134499ms,1.1345ms,1.134549ms,1.13455ms,1.134599ms,1.1346ms,1.134649ms,1.13465ms,1.134699ms,1.1347ms,1.134749ms,1.13475ms,1.134799ms,1.1348ms,1.134849ms,1.13485ms,1.134899ms,1.1349ms,1.134949ms,1.13495ms,1.134999ms,1.135ms,1.135049ms,1.13505ms,1.135099ms,1.1351ms,1.135149ms,1.13515ms,1.135199ms,1.1352ms,1.135249ms,1.13525ms,1.135299ms,1.1353ms,1.135349ms,1.13535ms,1.135399ms,1.1354ms,1.135449ms,1.13545ms,1.135499ms,1.1355ms,1.135549ms,1.13555ms,1.135599ms,1.1356ms,1.135649ms,1.13565ms,1.135699ms,1.1357ms,1.135749ms,1.13575ms,1.135799ms,1.1358ms,1.135849ms,1.13585ms,1.135899ms,1.1359ms,1.135949ms,1.13595ms,1.135999ms,1.136ms,1.136049ms,1.13605ms,1.136099ms,1.1361ms,1.136149ms,1.13615ms,1.136199ms,1.1362ms,1.136249ms,1.13625ms,1.136299ms,1.1363ms,1.136349ms,1.13635ms,1.136399ms,1.1364ms,1.136449ms,1.13645ms,1.136499ms,1.1365ms,1.136549ms,1.13655ms,1.136599ms,1.1366ms,1.136649ms,1.13665ms,1.136699ms,1.1367ms,1.136749ms,1.13675ms,1.136799ms,1.1368ms,1.136849ms,1.13685ms,1.136899ms,1.1369ms,1.136949ms,1.13695ms,1.136999ms,1.137ms,1.137049ms,1.13705ms,1.137099ms,1.1371ms,1.137149ms,1.13715ms,1.137199ms,1.1372ms,1.137249ms,1.13725ms,1.137299ms,1.1373ms,1.137349ms,1.13735ms,1.137399ms,1.1374ms,1.137449ms,1.13745ms,1.137499ms,1.1375ms,1.137549ms,1.13755ms,1.137599ms,1.1376ms,1.137649ms,1.13765ms,1.137699ms,1.1377ms,1.137749ms,1.13775ms,1.137799ms,1.1378ms,1.137849ms,1.13785ms,1.137899ms,1.1379ms,1.137949ms,1.13795ms,1.137999ms,1.138ms,1.138049ms,1.13805ms,1.138099ms,1.1381ms,1.138149ms,1.13815ms,1.138199ms,1.1382ms,1.138249ms,1.13825ms,1.138299ms,1.1383ms,1.138349ms,1.13835ms,1.138399ms,1.1384ms,1.138449ms,1.13845ms,1.138499ms,1.1385ms,1.138549ms,1.13855ms,1.138599ms,1.1386ms,1.138649ms,1.13865ms,1.138699ms,1.1387ms,1.138749ms,1.13875ms,1.138799ms,1.1388ms,1.138849ms,1.13885ms,1.138899ms,1.1389ms,1.138949ms,1.13895ms,1.138999ms,1.139ms,1.139049ms,1.13905ms,1.139099ms,1.1391ms,1.139149ms,1.13915ms,1.139199ms,1.1392ms,1.139249ms,1.13925ms,1.139299ms,1.1393ms,1.139349ms,1.13935ms,1.139399ms,1.1394ms,1.139449ms,1.13945ms,1.139499ms,1.1395ms,1.139549ms,1.13955ms,1.139599ms,1.1396ms,1.139649ms,1.13965ms,1.139699ms,1.1397ms,1.139749ms,1.13975ms,1.139799ms,1.1398ms,1.139849ms,1.13985ms,1.139899ms,1.1399ms,1.139949ms,1.13995ms,1.139999ms,1.14ms,1.140049ms,1.14005ms,1.140099ms,1.1401ms,1.140149ms,1.14015ms,1.140199ms,1.1402ms,1.140249ms,1.14025ms,1.140299ms,1.1403ms,1.140349ms,1.14035ms,1.140399ms,1.1404ms,1.140449ms,1.14045ms,1.140499ms,1.1405ms,1.140549ms,1.14055ms,1.140599ms,1.1406ms,1.140649ms,1.14065ms,1.140699ms,1.1407ms,1.140749ms,1.14075ms,1.140799ms,1.1408ms,1.140849ms,1.14085ms,1.140899ms,1.1409ms,1.140949ms,1.14095ms,1.140999ms,1.141ms,1.141049ms,1.14105ms,1.141099ms,1.1411ms,1.141149ms,1.14115ms,1.141199ms,1.1412ms,1.141249ms,1.14125ms,1.141299ms,1.1413ms,1.141349ms,1.14135ms,1.141399ms,1.1414ms,1.141449ms,1.14145ms,1.141499ms,1.1415ms,1.141549ms,1.14155ms,1.141599ms,1.1416ms,1.141649ms,1.14165ms,1.141699ms,1.1417ms,1.141749ms,1.14175ms,1.141799ms,1.1418ms,1.141849ms,1.14185ms,1.141899ms,1.1419ms,1.141949ms,1.14195ms,1.141999ms,1.142ms,1.142049ms,1.14205ms,1.142099ms,1.1421ms,1.142149ms,1.14215ms,1.142199ms,1.1422ms,1.142249ms,1.14225ms,1.142299ms,1.1423ms,1.142349ms,1.14235ms,1.142399ms,1.1424ms,1.142449ms,1.14245ms,1.142499ms,1.1425ms,1.142549ms,1.14255ms,1.142599ms,1.1426ms,1.142649ms,1.14265ms,1.142699ms,1.1427ms,1.142749ms,1.14275ms,1.142799ms,1.1428ms,1.142849ms,1.14285ms,1.142899ms,1.1429ms,1.142949ms,1.14295ms,1.142999ms,1.143ms,1.143049ms,1.14305ms,1.143099ms,1.1431ms,1.143149ms,1.14315ms,1.143199ms,1.1432ms,1.143249ms,1.14325ms,1.143299ms,1.1433ms,1.143349ms,1.14335ms,1.143399ms,1.1434ms,1.143449ms,1.14345ms,1.143499ms,1.1435ms,1.143549ms,1.14355ms,1.143599ms,1.1436ms,1.143649ms,1.14365ms,1.143699ms,1.1437ms,1.143749ms,1.14375ms,1.143799ms,1.1438ms,1.143849ms,1.14385ms,1.143899ms,1.1439ms,1.143949ms,1.14395ms,1.143999ms,1.144ms,1.144049ms,1.14405ms,1.144099ms,1.1441ms,1.144149ms,1.14415ms,1.144199ms,1.1442ms,1.144249ms,1.14425ms,1.144299ms,1.1443ms,1.144349ms,1.14435ms,1.144399ms,1.1444ms,1.144449ms,1.14445ms,1.144499ms,1.1445ms,1.144549ms,1.14455ms,1.144599ms,1.1446ms,1.144649ms,1.14465ms,1.144699ms,1.1447ms,1.144749ms,1.14475ms,1.144799ms,1.1448ms,1.144849ms,1.14485ms,1.144899ms,1.1449ms,1.144949ms,1.14495ms,1.144999ms,1.145ms,1.145049ms,1.14505ms,1.145099ms,1.1451ms,1.145149ms,1.14515ms,1.145199ms,1.1452ms,1.145249ms,1.14525ms,1.145299ms,1.1453ms,1.145349ms,1.14535ms,1.145399ms,1.1454ms,1.145449ms,1.14545ms,1.145499ms,1.1455ms,1.145549ms,1.14555ms,1.145599ms,1.1456ms,1.145649ms,1.14565ms,1.145699ms,1.1457ms,1.145749ms,1.14575ms,1.145799ms,1.1458ms,1.145849ms,1.14585ms,1.145899ms,1.1459ms,1.145949ms,1.14595ms,1.145999ms,1.146ms,1.146049ms,1.14605ms,1.146099ms,1.1461ms,1.146149ms,1.14615ms,1.146199ms,1.1462ms,1.146249ms,1.14625ms,1.146299ms,1.1463ms,1.146349ms,1.14635ms,1.146399ms,1.1464ms,1.146449ms,1.14645ms,1.146499ms,1.1465ms,1.146549ms,1.14655ms,1.146599ms,1.1466ms,1.146649ms,1.14665ms,1.146699ms,1.1467ms,1.146749ms,1.14675ms,1.146799ms,1.1468ms,1.146849ms,1.14685ms,1.146899ms,1.1469ms,1.146949ms,1.14695ms,1.146999ms,1.147ms,1.147049ms,1.14705ms,1.147099ms,1.1471ms,1.147149ms,1.14715ms,1.147199ms,1.1472ms,1.147249ms,1.14725ms,1.147299ms,1.1473ms,1.147349ms,1.14735ms,1.147399ms,1.1474ms,1.147449ms,1.14745ms,1.147499ms,1.1475ms,1.147549ms,1.14755ms,1.147599ms,1.1476ms,1.147649ms,1.14765ms,1.147699ms,1.1477ms,1.147749ms,1.14775ms,1.147799ms,1.1478ms,1.147849ms,1.14785ms,1.147899ms,1.1479ms,1.147949ms,1.14795ms,1.147999ms,1.148ms,1.148049ms,1.14805ms,1.148099ms,1.1481ms,1.148149ms,1.14815ms,1.148199ms,1.1482ms,1.148249ms,1.14825ms,1.148299ms,1.1483ms,1.148349ms,1.14835ms,1.148399ms,1.1484ms,1.148449ms,1.14845ms,1.148499ms,1.1485ms,1.148549ms,1.14855ms,1.148599ms,1.1486ms,1.148649ms,1.14865ms,1.148699ms,1.1487ms,1.148749ms,1.14875ms,1.148799ms,1.1488ms,1.148849ms,1.14885ms,1.148899ms,1.1489ms,1.148949ms,1.14895ms,1.148999ms,1.149ms,1.149049ms,1.14905ms,1.149099ms,1.1491ms,1.149149ms,1.14915ms,1.149199ms,1.1492ms,1.149249ms,1.14925ms,1.149299ms,1.1493ms,1.149349ms,1.14935ms,1.149399ms,1.1494ms,1.149449ms,1.14945ms,1.149499ms,1.1495ms,1.149549ms,1.14955ms,1.149599ms,1.1496ms,1.149649ms,1.14965ms,1.149699ms,1.1497ms,1.149749ms,1.14975ms,1.149799ms,1.1498ms,1.149849ms,1.14985ms,1.149899ms,1.1499ms,1.149949ms,1.14995ms,1.149999ms,1.15ms,1.150049ms,1.15005ms,1.150099ms,1.1501ms,1.150149ms,1.15015ms,1.150199ms,1.1502ms,1.150249ms,1.15025ms,1.150299ms,1.1503ms,1.150349ms,1.15035ms,1.150399ms,1.1504ms,1.150449ms,1.15045ms,1.150499ms,1.1505ms,1.150549ms,1.15055ms,1.150599ms,1.1506ms,1.150649ms,1.15065ms,1.150699ms,1.1507ms,1.150749ms,1.15075ms,1.150799ms,1.1508ms,1.150849ms,1.15085ms,1.150899ms,1.1509ms,1.150949ms,1.15095ms,1.150999ms,1.151ms,1.151049ms,1.15105ms,1.151099ms,1.1511ms,1.151149ms,1.15115ms,1.151199ms,1.1512ms,1.151249ms,1.15125ms,1.151299ms,1.1513ms,1.151349ms,1.15135ms,1.151399ms,1.1514ms,1.151449ms,1.15145ms,1.151499ms,1.1515ms,1.151549ms,1.15155ms,1.151599ms,1.1516ms,1.151649ms,1.15165ms,1.151699ms,1.1517ms,1.151749ms,1.15175ms,1.151799ms,1.1518ms,1.151849ms,1.15185ms,1.151899ms,1.1519ms,1.151949ms,1.15195ms,1.151999ms,1.152ms,1.152049ms,1.15205ms,1.152099ms,1.1521ms,1.152149ms,1.15215ms,1.152199ms,1.1522ms,1.152249ms,1.15225ms,1.152299ms,1.1523ms,1.152349ms,1.15235ms,1.152399ms,1.1524ms,1.152449ms,1.15245ms,1.152499ms,1.1525ms,1.152549ms,1.15255ms,1.152599ms,1.1526ms,1.152649ms,1.15265ms,1.152699ms,1.1527ms,1.152749ms,1.15275ms,1.152799ms,1.1528ms,1.152849ms,1.15285ms,1.152899ms,1.1529ms,1.152949ms,1.15295ms,1.152999ms,1.153ms,1.153049ms,1.15305ms,1.153099ms,1.1531ms,1.153149ms,1.15315ms,1.153199ms,1.1532ms,1.153249ms,1.15325ms,1.153299ms,1.1533ms,1.153349ms,1.15335ms,1.153399ms,1.1534ms,1.153449ms,1.15345ms,1.153499ms,1.1535ms,1.153549ms,1.15355ms,1.153599ms,1.1536ms,1.153649ms,1.15365ms,1.153699ms,1.1537ms,1.153749ms,1.15375ms,1.153799ms,1.1538ms,1.153849ms,1.15385ms,1.153899ms,1.1539ms,1.153949ms,1.15395ms,1.153999ms,1.154ms,1.154049ms,1.15405ms,1.154099ms,1.1541ms,1.154149ms,1.15415ms,1.154199ms,1.1542ms,1.154249ms,1.15425ms,1.154299ms,1.1543ms,1.154349ms,1.15435ms,1.154399ms,1.1544ms,1.154449ms,1.15445ms,1.154499ms,1.1545ms,1.154549ms,1.15455ms,1.154599ms,1.1546ms,1.154649ms,1.15465ms,1.154699ms,1.1547ms,1.154749ms,1.15475ms,1.154799ms,1.1548ms,1.154849ms,1.15485ms,1.154899ms,1.1549ms,1.154949ms,1.15495ms,1.154999ms,1.155ms,1.155049ms,1.15505ms,1.155099ms,1.1551ms,1.155149ms,1.15515ms,1.155199ms,1.1552ms,1.155249ms,1.15525ms,1.155299ms,1.1553ms,1.155349ms,1.15535ms,1.155399ms,1.1554ms,1.155449ms,1.15545ms,1.155499ms,1.1555ms,1.155549ms,1.15555ms,1.155599ms,1.1556ms,1.155649ms,1.15565ms,1.155699ms,1.1557ms,1.155749ms,1.15575ms,1.155799ms,1.1558ms,1.155849ms,1.15585ms,1.155899ms,1.1559ms,1.155949ms,1.15595ms,1.155999ms,1.156ms,1.156049ms,1.15605ms,1.156099ms,1.1561ms,1.156149ms,1.15615ms,1.156199ms,1.1562ms,1.156249ms,1.15625ms,1.156299ms,1.1563ms,1.156349ms,1.15635ms,1.156399ms,1.1564ms,1.156449ms,1.15645ms,1.156499ms,1.1565ms,1.156549ms,1.15655ms,1.156599ms,1.1566ms,1.156649ms,1.15665ms,1.156699ms,1.1567ms,1.156749ms,1.15675ms,1.156799ms,1.1568ms,1.156849ms,1.15685ms,1.156899ms,1.1569ms,1.156949ms,1.15695ms,1.156999ms,1.157ms,1.157049ms,1.15705ms,1.157099ms,1.1571ms,1.157149ms,1.15715ms,1.157199ms,1.1572ms,1.157249ms,1.15725ms,1.157299ms,1.1573ms,1.157349ms,1.15735ms,1.157399ms,1.1574ms,1.157449ms,1.15745ms,1.157499ms,1.1575ms,1.157549ms,1.15755ms,1.157599ms,1.1576ms,1.157649ms,1.15765ms,1.157699ms,1.1577ms,1.157749ms,1.15775ms,1.157799ms,1.1578ms,1.157849ms,1.15785ms,1.157899ms,1.1579ms,1.157949ms,1.15795ms,1.157999ms,1.158ms,1.158049ms,1.15805ms,1.158099ms,1.1581ms,1.158149ms,1.15815ms,1.158199ms,1.1582ms,1.158249ms,1.15825ms,1.158299ms,1.1583ms,1.158349ms,1.15835ms,1.158399ms,1.1584ms,1.158449ms,1.15845ms,1.158499ms,1.1585ms,1.158549ms,1.15855ms,1.158599ms,1.1586ms,1.158649ms,1.15865ms,1.158699ms,1.1587ms,1.158749ms,1.15875ms,1.158799ms,1.1588ms,1.158849ms,1.15885ms,1.158899ms,1.1589ms,1.158949ms,1.15895ms,1.158999ms,1.159ms,1.159049ms,1.15905ms,1.159099ms,1.1591ms,1.159149ms,1.15915ms,1.159199ms,1.1592ms,1.159249ms,1.15925ms,1.159299ms,1.1593ms,1.159349ms,1.15935ms,1.159399ms,1.1594ms,1.159449ms,1.15945ms,1.159499ms,1.1595ms,1.159549ms,1.15955ms,1.159599ms,1.1596ms,1.159649ms,1.15965ms,1.159699ms,1.1597ms,1.159749ms,1.15975ms,1.159799ms,1.1598ms,1.159849ms,1.15985ms,1.159899ms,1.1599ms,1.159949ms,1.15995ms,1.159999ms,1.16ms,1.160049ms,1.16005ms,1.160099ms,1.1601ms,1.160149ms,1.16015ms,1.160199ms,1.1602ms,1.160249ms,1.16025ms,1.160299ms,1.1603ms,1.160349ms,1.16035ms,1.160399ms,1.1604ms,1.160449ms,1.16045ms,1.160499ms,1.1605ms,1.160549ms,1.16055ms,1.160599ms,1.1606ms,1.160649ms,1.16065ms,1.160699ms,1.1607ms,1.160749ms,1.16075ms,1.160799ms,1.1608ms,1.160849ms,1.16085ms,1.160899ms,1.1609ms,1.160949ms,1.16095ms,1.160999ms,1.161ms,1.161049ms,1.16105ms,1.161099ms,1.1611ms,1.161149ms,1.16115ms,1.161199ms,1.1612ms,1.161249ms,1.16125ms,1.161299ms,1.1613ms,1.161349ms,1.16135ms,1.161399ms,1.1614ms,1.161449ms,1.16145ms,1.161499ms,1.1615ms,1.161549ms,1.16155ms,1.161599ms,1.1616ms,1.161649ms,1.16165ms,1.161699ms,1.1617ms,1.161749ms,1.16175ms,1.161799ms,1.1618ms,1.161849ms,1.16185ms,1.161899ms,1.1619ms,1.161949ms,1.16195ms,1.161999ms,1.162ms,1.162049ms,1.16205ms,1.162099ms,1.1621ms,1.162149ms,1.16215ms,1.162199ms,1.1622ms,1.162249ms,1.16225ms,1.162299ms,1.1623ms,1.162349ms,1.16235ms,1.162399ms,1.1624ms,1.162449ms,1.16245ms,1.162499ms,1.1625ms,1.162549ms,1.16255ms,1.162599ms,1.1626ms,1.162649ms,1.16265ms,1.162699ms,1.1627ms,1.162749ms,1.16275ms,1.162799ms,1.1628ms,1.162849ms,1.16285ms,1.162899ms,1.1629ms,1.162949ms,1.16295ms,1.162999ms,1.163ms,1.163049ms,1.16305ms,1.163099ms,1.1631ms,1.163149ms,1.16315ms,1.163199ms,1.1632ms,1.163249ms,1.16325ms,1.163299ms,1.1633ms,1.163349ms,1.16335ms,1.163399ms,1.1634ms,1.163449ms,1.16345ms,1.163499ms,1.1635ms,1.163549ms,1.16355ms,1.163599ms,1.1636ms,1.163649ms,1.16365ms,1.163699ms,1.1637ms,1.163749ms,1.16375ms,1.163799ms,1.1638ms,1.163849ms,1.16385ms,1.163899ms,1.1639ms,1.163949ms,1.16395ms,1.163999ms,1.164ms,1.164049ms,1.16405ms,1.164099ms,1.1641ms,1.164149ms,1.16415ms,1.164199ms,1.1642ms,1.164249ms,1.16425ms,1.164299ms,1.1643ms,1.164349ms,1.16435ms,1.164399ms,1.1644ms,1.164449ms,1.16445ms,1.164499ms,1.1645ms,1.164549ms,1.16455ms,1.164599ms,1.1646ms,1.164649ms,1.16465ms,1.164699ms,1.1647ms,1.164749ms,1.16475ms,1.164799ms,1.1648ms,1.164849ms,1.16485ms,1.164899ms,1.1649ms,1.164949ms,1.16495ms,1.164999ms,1.165ms,1.165049ms,1.16505ms,1.165099ms,1.1651ms,1.165149ms,1.16515ms,1.165199ms,1.1652ms,1.165249ms,1.16525ms,1.165299ms,1.1653ms,1.165349ms,1.16535ms,1.165399ms,1.1654ms,1.165449ms,1.16545ms,1.165499ms,1.1655ms,1.165549ms,1.16555ms,1.165599ms,1.1656ms,1.165649ms,1.16565ms,1.165699ms,1.1657ms,1.165749ms,1.16575ms,1.165799ms,1.1658ms,1.165849ms,1.16585ms,1.165899ms,1.1659ms,1.165949ms,1.16595ms,1.165999ms,1.166ms,1.166049ms,1.16605ms,1.166099ms,1.1661ms,1.166149ms,1.16615ms,1.166199ms,1.1662ms,1.166249ms,1.16625ms,1.166299ms,1.1663ms,1.166349ms,1.16635ms,1.166399ms,1.1664ms,1.166449ms,1.16645ms,1.166499ms,1.1665ms,1.166549ms,1.16655ms,1.166599ms,1.1666ms,1.166649ms,1.16665ms,1.166699ms,1.1667ms,1.166749ms,1.16675ms,1.166799ms,1.1668ms,1.166849ms,1.16685ms,1.166899ms,1.1669ms,1.166949ms,1.16695ms,1.166999ms,1.167ms,1.167049ms,1.16705ms,1.167099ms,1.1671ms,1.167149ms,1.16715ms,1.167199ms,1.1672ms,1.167249ms,1.16725ms,1.167299ms,1.1673ms,1.167349ms,1.16735ms,1.167399ms,1.1674ms,1.167449ms,1.16745ms,1.167499ms,1.1675ms,1.167549ms,1.16755ms,1.167599ms,1.1676ms,1.167649ms,1.16765ms,1.167699ms,1.1677ms,1.167749ms,1.16775ms,1.167799ms,1.1678ms,1.167849ms,1.16785ms,1.167899ms,1.1679ms,1.167949ms,1.16795ms,1.167999ms,1.168ms,1.168049ms,1.16805ms,1.168099ms,1.1681ms,1.168149ms,1.16815ms,1.168199ms,1.1682ms,1.168249ms,1.16825ms,1.168299ms,1.1683ms,1.168349ms,1.16835ms,1.168399ms,1.1684ms,1.168449ms,1.16845ms,1.168499ms,1.1685ms,1.168549ms,1.16855ms,1.168599ms,1.1686ms,1.168649ms,1.16865ms,1.168699ms,1.1687ms,1.168749ms,1.16875ms,1.168799ms,1.1688ms,1.168849ms,1.16885ms,1.168899ms,1.1689ms,1.168949ms,1.16895ms,1.168999ms,1.169ms,1.169049ms,1.16905ms,1.169099ms,1.1691ms,1.169149ms,1.16915ms,1.169199ms,1.1692ms,1.169249ms,1.16925ms,1.169299ms,1.1693ms,1.169349ms,1.16935ms,1.169399ms,1.1694ms,1.169449ms,1.16945ms,1.169499ms,1.1695ms,1.169549ms,1.16955ms,1.169599ms,1.1696ms,1.169649ms,1.16965ms,1.169699ms,1.1697ms,1.169749ms,1.16975ms,1.169799ms,1.1698ms,1.169849ms,1.16985ms,1.169899ms,1.1699ms,1.169949ms,1.16995ms,1.169999ms,1.17ms,1.170049ms,1.17005ms,1.170099ms,1.1701ms,1.170149ms,1.17015ms,1.170199ms,1.1702ms,1.170249ms,1.17025ms,1.170299ms,1.1703ms,1.170349ms,1.17035ms,1.170399ms,1.1704ms,1.170449ms,1.17045ms,1.170499ms,1.1705ms,1.170549ms,1.17055ms,1.170599ms,1.1706ms,1.170649ms,1.17065ms,1.170699ms,1.1707ms,1.170749ms,1.17075ms,1.170799ms,1.1708ms,1.170849ms,1.17085ms,1.170899ms,1.1709ms,1.170949ms,1.17095ms,1.170999ms,1.171ms,1.171049ms,1.17105ms,1.171099ms,1.1711ms,1.171149ms,1.17115ms,1.171199ms,1.1712ms,1.171249ms,1.17125ms,1.171299ms,1.1713ms,1.171349ms,1.17135ms,1.171399ms,1.1714ms,1.171449ms,1.17145ms,1.171499ms,1.1715ms,1.171549ms,1.17155ms,1.171599ms,1.1716ms,1.171649ms,1.17165ms,1.171699ms,1.1717ms,1.171749ms,1.17175ms,1.171799ms,1.1718ms,1.171849ms,1.17185ms,1.171899ms,1.1719ms,1.171949ms,1.17195ms,1.171999ms,1.172ms,1.172049ms,1.17205ms,1.172099ms,1.1721ms,1.172149ms,1.17215ms,1.172199ms,1.1722ms,1.172249ms,1.17225ms,1.172299ms,1.1723ms,1.172349ms,1.17235ms,1.172399ms,1.1724ms,1.172449ms,1.17245ms,1.172499ms,1.1725ms,1.172549ms,1.17255ms,1.172599ms,1.1726ms,1.172649ms,1.17265ms,1.172699ms,1.1727ms,1.172749ms,1.17275ms,1.172799ms,1.1728ms,1.172849ms,1.17285ms,1.172899ms,1.1729ms,1.172949ms,1.17295ms,1.172999ms,1.173ms,1.173049ms,1.17305ms,1.173099ms,1.1731ms,1.173149ms,1.17315ms,1.173199ms,1.1732ms,1.173249ms,1.17325ms,1.173299ms,1.1733ms,1.173349ms,1.17335ms,1.173399ms,1.1734ms,1.173449ms,1.17345ms,1.173499ms,1.1735ms,1.173549ms,1.17355ms,1.173599ms,1.1736ms,1.173649ms,1.17365ms,1.173699ms,1.1737ms,1.173749ms,1.17375ms,1.173799ms,1.1738ms,1.173849ms,1.17385ms,1.173899ms,1.1739ms,1.173949ms,1.17395ms,1.173999ms,1.174ms,1.174049ms,1.17405ms,1.174099ms,1.1741ms,1.174149ms,1.17415ms,1.174199ms,1.1742ms,1.174249ms,1.17425ms,1.174299ms,1.1743ms,1.174349ms,1.17435ms,1.174399ms,1.1744ms,1.174449ms,1.17445ms,1.174499ms,1.1745ms,1.174549ms,1.17455ms,1.174599ms,1.1746ms,1.174649ms,1.17465ms,1.174699ms,1.1747ms,1.174749ms,1.17475ms,1.174799ms,1.1748ms,1.174849ms,1.17485ms,1.174899ms,1.1749ms,1.174949ms,1.17495ms,1.174999ms,1.175ms,1.175049ms,1.17505ms,1.175099ms,1.1751ms,1.175149ms,1.17515ms,1.175199ms,1.1752ms,1.175249ms,1.17525ms,1.175299ms,1.1753ms,1.175349ms,1.17535ms,1.175399ms,1.1754ms,1.175449ms,1.17545ms,1.175499ms,1.1755ms,1.175549ms,1.17555ms,1.175599ms,1.1756ms,1.175649ms,1.17565ms,1.175699ms,1.1757ms,1.175749ms,1.17575ms,1.175799ms,1.1758ms,1.175849ms,1.17585ms,1.175899ms,1.1759ms,1.175949ms,1.17595ms,1.175999ms,1.176ms,1.176049ms,1.17605ms,1.176099ms,1.1761ms,1.176149ms,1.17615ms,1.176199ms,1.1762ms,1.176249ms,1.17625ms,1.176299ms,1.1763ms,1.176349ms,1.17635ms,1.176399ms,1.1764ms,1.176449ms,1.17645ms,1.176499ms,1.1765ms,1.176549ms,1.17655ms,1.176599ms,1.1766ms,1.176649ms,1.17665ms,1.176699ms,1.1767ms,1.176749ms,1.17675ms,1.176799ms,1.1768ms,1.176849ms,1.17685ms,1.176899ms,1.1769ms,1.176949ms,1.17695ms,1.176999ms,1.177ms,1.177049ms,1.17705ms,1.177099ms,1.1771ms,1.177149ms,1.17715ms,1.177199ms,1.1772ms,1.177249ms,1.17725ms,1.177299ms,1.1773ms,1.177349ms,1.17735ms,1.177399ms,1.1774ms,1.177449ms,1.17745ms,1.177499ms,1.1775ms,1.177549ms,1.17755ms,1.177599ms,1.1776ms,1.177649ms,1.17765ms,1.177699ms,1.1777ms,1.177749ms,1.17775ms,1.177799ms,1.1778ms,1.177849ms,1.17785ms,1.177899ms,1.1779ms,1.177949ms,1.17795ms,1.177999ms,1.178ms,1.178049ms,1.17805ms,1.178099ms,1.1781ms,1.178149ms,1.17815ms,1.178199ms,1.1782ms,1.178249ms,1.17825ms,1.178299ms,1.1783ms,1.178349ms,1.17835ms,1.178399ms,1.1784ms,1.178449ms,1.17845ms,1.178499ms,1.1785ms,1.178549ms,1.17855ms,1.178599ms,1.1786ms,1.178649ms,1.17865ms,1.178699ms,1.1787ms,1.178749ms,1.17875ms,1.178799ms,1.1788ms,1.178849ms,1.17885ms,1.178899ms,1.1789ms,1.178949ms,1.17895ms,1.178999ms,1.179ms,1.179049ms,1.17905ms,1.179099ms,1.1791ms,1.179149ms,1.17915ms,1.179199ms,1.1792ms,1.179249ms,1.17925ms,1.179299ms,1.1793ms,1.179349ms,1.17935ms,1.179399ms,1.1794ms,1.179449ms,1.17945ms,1.179499ms,1.1795ms,1.179549ms,1.17955ms,1.179599ms,1.1796ms,1.179649ms,1.17965ms,1.179699ms,1.1797ms,1.179749ms,1.17975ms,1.179799ms,1.1798ms,1.179849ms,1.17985ms,1.179899ms,1.1799ms,1.179949ms,1.17995ms,1.179999ms,1.18ms,1.180049ms,1.18005ms,1.180099ms,1.1801ms,1.180149ms,1.18015ms,1.180199ms,1.1802ms,1.180249ms,1.18025ms,1.180299ms,1.1803ms,1.180349ms,1.18035ms,1.180399ms,1.1804ms,1.180449ms,1.18045ms,1.180499ms,1.1805ms,1.180549ms,1.18055ms,1.180599ms,1.1806ms,1.180649ms,1.18065ms,1.180699ms,1.1807ms,1.180749ms,1.18075ms,1.180799ms,1.1808ms,1.180849ms,1.18085ms,1.180899ms,1.1809ms,1.180949ms,1.18095ms,1.180999ms,1.181ms,1.181049ms,1.18105ms,1.181099ms,1.1811ms,1.181149ms,1.18115ms,1.181199ms,1.1812ms,1.181249ms,1.18125ms,1.181299ms,1.1813ms,1.181349ms,1.18135ms,1.181399ms,1.1814ms,1.181449ms,1.18145ms,1.181499ms,1.1815ms,1.181549ms,1.18155ms,1.181599ms,1.1816ms,1.181649ms,1.18165ms,1.181699ms,1.1817ms,1.181749ms,1.18175ms,1.181799ms,1.1818ms,1.181849ms,1.18185ms,1.181899ms,1.1819ms,1.181949ms,1.18195ms,1.181999ms,1.182ms,1.182049ms,1.18205ms,1.182099ms,1.1821ms,1.182149ms,1.18215ms,1.182199ms,1.1822ms,1.182249ms,1.18225ms,1.182299ms,1.1823ms,1.182349ms,1.18235ms,1.182399ms,1.1824ms,1.182449ms,1.18245ms,1.182499ms,1.1825ms,1.182549ms,1.18255ms,1.182599ms,1.1826ms,1.182649ms,1.18265ms,1.182699ms,1.1827ms,1.182749ms,1.18275ms,1.182799ms,1.1828ms,1.182849ms,1.18285ms,1.182899ms,1.1829ms,1.182949ms,1.18295ms,1.182999ms,1.183ms,1.183049ms,1.18305ms,1.183099ms,1.1831ms,1.183149ms,1.18315ms,1.183199ms,1.1832ms,1.183249ms,1.18325ms,1.183299ms,1.1833ms,1.183349ms,1.18335ms,1.183399ms,1.1834ms,1.183449ms,1.18345ms,1.183499ms,1.1835ms,1.183549ms,1.18355ms,1.183599ms,1.1836ms,1.183649ms,1.18365ms,1.183699ms,1.1837ms,1.183749ms,1.18375ms,1.183799ms,1.1838ms,1.183849ms,1.18385ms,1.183899ms,1.1839ms,1.183949ms,1.18395ms,1.183999ms,1.184ms,1.184049ms,1.18405ms,1.184099ms,1.1841ms,1.184149ms,1.18415ms,1.184199ms,1.1842ms,1.184249ms,1.18425ms,1.184299ms,1.1843ms,1.184349ms,1.18435ms,1.184399ms,1.1844ms,1.184449ms,1.18445ms,1.184499ms,1.1845ms,1.184549ms,1.18455ms,1.184599ms,1.1846ms,1.184649ms,1.18465ms,1.184699ms,1.1847ms,1.184749ms,1.18475ms,1.184799ms,1.1848ms,1.184849ms,1.18485ms,1.184899ms,1.1849ms,1.184949ms,1.18495ms,1.184999ms,1.185ms,1.185049ms,1.18505ms,1.185099ms,1.1851ms,1.185149ms,1.18515ms,1.185199ms,1.1852ms,1.185249ms,1.18525ms,1.185299ms,1.1853ms,1.185349ms,1.18535ms,1.185399ms,1.1854ms,1.185449ms,1.18545ms,1.185499ms,1.1855ms,1.185549ms,1.18555ms,1.185599ms,1.1856ms,1.185649ms,1.18565ms,1.185699ms,1.1857ms,1.185749ms,1.18575ms,1.185799ms,1.1858ms,1.185849ms,1.18585ms,1.185899ms,1.1859ms,1.185949ms,1.18595ms,1.185999ms,1.186ms,1.186049ms,1.18605ms,1.186099ms,1.1861ms,1.186149ms,1.18615ms,1.186199ms,1.1862ms,1.186249ms,1.18625ms,1.186299ms,1.1863ms,1.186349ms,1.18635ms,1.186399ms,1.1864ms,1.186449ms,1.18645ms,1.186499ms,1.1865ms,1.186549ms,1.18655ms,1.186599ms,1.1866ms,1.186649ms,1.18665ms,1.186699ms,1.1867ms,1.186749ms,1.18675ms,1.186799ms,1.1868ms,1.186849ms,1.18685ms,1.186899ms,1.1869ms,1.186949ms,1.18695ms,1.186999ms,1.187ms,1.187049ms,1.18705ms,1.187099ms,1.1871ms,1.187149ms,1.18715ms,1.187199ms,1.1872ms,1.187249ms,1.18725ms,1.187299ms,1.1873ms,1.187349ms,1.18735ms,1.187399ms,1.1874ms,1.187449ms,1.18745ms,1.187499ms,1.1875ms,1.187549ms,1.18755ms,1.187599ms,1.1876ms,1.187649ms,1.18765ms,1.187699ms,1.1877ms,1.187749ms,1.18775ms,1.187799ms,1.1878ms,1.187849ms,1.18785ms,1.187899ms,1.1879ms,1.187949ms,1.18795ms,1.187999ms,1.188ms,1.188049ms,1.18805ms,1.188099ms,1.1881ms,1.188149ms,1.18815ms,1.188199ms,1.1882ms,1.188249ms,1.18825ms,1.188299ms,1.1883ms,1.188349ms,1.18835ms,1.188399ms,1.1884ms,1.188449ms,1.18845ms,1.188499ms,1.1885ms,1.188549ms,1.18855ms,1.188599ms,1.1886ms,1.188649ms,1.18865ms,1.188699ms,1.1887ms,1.188749ms,1.18875ms,1.188799ms,1.1888ms,1.188849ms,1.18885ms,1.188899ms,1.1889ms,1.188949ms,1.18895ms,1.188999ms,1.189ms,1.189049ms,1.18905ms,1.189099ms,1.1891ms,1.189149ms,1.18915ms,1.189199ms,1.1892ms,1.189249ms,1.18925ms,1.189299ms,1.1893ms,1.189349ms,1.18935ms,1.189399ms,1.1894ms,1.189449ms,1.18945ms,1.189499ms,1.1895ms,1.189549ms,1.18955ms,1.189599ms,1.1896ms,1.189649ms,1.18965ms,1.189699ms,1.1897ms,1.189749ms,1.18975ms,1.189799ms,1.1898ms,1.189849ms,1.18985ms,1.189899ms,1.1899ms,1.189949ms,1.18995ms,1.189999ms,1.19ms,1.190049ms,1.19005ms,1.190099ms,1.1901ms,1.190149ms,1.19015ms,1.190199ms,1.1902ms,1.190249ms,1.19025ms,1.190299ms,1.1903ms,1.190349ms,1.19035ms,1.190399ms,1.1904ms,1.190449ms,1.19045ms,1.190499ms,1.1905ms,1.190549ms,1.19055ms,1.190599ms,1.1906ms,1.190649ms,1.19065ms,1.190699ms,1.1907ms,1.190749ms,1.19075ms,1.190799ms,1.1908ms,1.190849ms,1.19085ms,1.190899ms,1.1909ms,1.190949ms,1.19095ms,1.190999ms,1.191ms,1.191049ms,1.19105ms,1.191099ms,1.1911ms,1.191149ms,1.19115ms,1.191199ms,1.1912ms,1.191249ms,1.19125ms,1.191299ms,1.1913ms,1.191349ms,1.19135ms,1.191399ms,1.1914ms,1.191449ms,1.19145ms,1.191499ms,1.1915ms,1.191549ms,1.19155ms,1.191599ms,1.1916ms,1.191649ms,1.19165ms,1.191699ms,1.1917ms,1.191749ms,1.19175ms,1.191799ms,1.1918ms,1.191849ms,1.19185ms,1.191899ms,1.1919ms,1.191949ms,1.19195ms,1.191999ms,1.192ms,1.192049ms,1.19205ms,1.192099ms,1.1921ms,1.192149ms,1.19215ms,1.192199ms,1.1922ms,1.192249ms,1.19225ms,1.192299ms,1.1923ms,1.192349ms,1.19235ms,1.192399ms,1.1924ms,1.192449ms,1.19245ms,1.192499ms,1.1925ms,1.192549ms,1.19255ms,1.192599ms,1.1926ms,1.192649ms,1.19265ms,1.192699ms,1.1927ms,1.192749ms,1.19275ms,1.192799ms,1.1928ms,1.192849ms,1.19285ms,1.192899ms,1.1929ms,1.192949ms,1.19295ms,1.192999ms,1.193ms,1.193049ms,1.19305ms,1.193099ms,1.1931ms,1.193149ms,1.19315ms,1.193199ms,1.1932ms,1.193249ms,1.19325ms,1.193299ms,1.1933ms,1.193349ms,1.19335ms,1.193399ms,1.1934ms,1.193449ms,1.19345ms,1.193499ms,1.1935ms,1.193549ms,1.19355ms,1.193599ms,1.1936ms,1.193649ms,1.19365ms,1.193699ms,1.1937ms,1.193749ms,1.19375ms,1.193799ms,1.1938ms,1.193849ms,1.19385ms,1.193899ms,1.1939ms,1.193949ms,1.19395ms,1.193999ms,1.194ms,1.194049ms,1.19405ms,1.194099ms,1.1941ms,1.194149ms,1.19415ms,1.194199ms,1.1942ms,1.194249ms,1.19425ms,1.194299ms,1.1943ms,1.194349ms,1.19435ms,1.194399ms,1.1944ms,1.194449ms,1.19445ms,1.194499ms,1.1945ms,1.194549ms,1.19455ms,1.194599ms,1.1946ms,1.194649ms,1.19465ms,1.194699ms,1.1947ms,1.194749ms,1.19475ms,1.194799ms,1.1948ms,1.194849ms,1.19485ms,1.194899ms,1.1949ms,1.194949ms,1.19495ms,1.194999ms,1.195ms,1.195049ms,1.19505ms,1.195099ms,1.1951ms,1.195149ms,1.19515ms,1.195199ms,1.1952ms,1.195249ms,1.19525ms,1.195299ms,1.1953ms,1.195349ms,1.19535ms,1.195399ms,1.1954ms,1.195449ms,1.19545ms,1.195499ms,1.1955ms,1.195549ms,1.19555ms,1.195599ms,1.1956ms,1.195649ms,1.19565ms,1.195699ms,1.1957ms,1.195749ms,1.19575ms,1.195799ms,1.1958ms,1.195849ms,1.19585ms,1.195899ms,1.1959ms,1.195949ms,1.19595ms,1.195999ms,1.196ms,1.196049ms,1.19605ms,1.196099ms,1.1961ms,1.196149ms,1.19615ms,1.196199ms,1.1962ms,1.196249ms,1.19625ms,1.196299ms,1.1963ms,1.196349ms,1.19635ms,1.196399ms,1.1964ms,1.196449ms,1.19645ms,1.196499ms,1.1965ms,1.196549ms,1.19655ms,1.196599ms,1.1966ms,1.196649ms,1.19665ms,1.196699ms,1.1967ms,1.196749ms,1.19675ms,1.196799ms,1.1968ms,1.196849ms,1.19685ms,1.196899ms,1.1969ms,1.196949ms,1.19695ms,1.196999ms,1.197ms,1.197049ms,1.19705ms,1.197099ms,1.1971ms,1.197149ms,1.19715ms,1.197199ms,1.1972ms,1.197249ms,1.19725ms,1.197299ms,1.1973ms,1.197349ms,1.19735ms,1.197399ms,1.1974ms,1.197449ms,1.19745ms,1.197499ms,1.1975ms,1.197549ms,1.19755ms,1.197599ms,1.1976ms,1.197649ms,1.19765ms,1.197699ms,1.1977ms,1.197749ms,1.19775ms,1.197799ms,1.1978ms,1.197849ms,1.19785ms,1.197899ms,1.1979ms,1.197949ms,1.19795ms,1.197999ms,1.198ms,1.198049ms,1.19805ms,1.198099ms,1.1981ms,1.198149ms,1.19815ms,1.198199ms,1.1982ms,1.198249ms,1.19825ms,1.198299ms,1.1983ms,1.198349ms,1.19835ms,1.198399ms,1.1984ms,1.198449ms,1.19845ms,1.198499ms,1.1985ms,1.198549ms,1.19855ms,1.198599ms,1.1986ms,1.198649ms,1.19865ms,1.198699ms,1.1987ms,1.198749ms,1.19875ms,1.198799ms,1.1988ms,1.198849ms,1.19885ms,1.198899ms,1.1989ms,1.198949ms,1.19895ms,1.198999ms,1.199ms,1.199049ms,1.19905ms,1.199099ms,1.1991ms,1.199149ms,1.19915ms,1.199199ms,1.1992ms,1.199249ms,1.19925ms,1.199299ms,1.1993ms,1.199349ms,1.19935ms,1.199399ms,1.1994ms,1.199449ms,1.19945ms,1.199499ms,1.1995ms,1.199549ms,1.19955ms,1.199599ms,1.1996ms,1.199649ms,1.19965ms,1.199699ms,1.1997ms,1.199749ms,1.19975ms,1.199799ms,1.1998ms,1.199849ms,1.19985ms,1.199899ms,1.1999ms,1.199949ms,1.19995ms,1.199999ms,1.2ms,1.200049ms,1.20005ms,1.200099ms,1.2001ms,1.200149ms,1.20015ms,1.200199ms,1.2002ms,1.200249ms,1.20025ms,1.200299ms,1.2003ms,1.200349ms,1.20035ms,1.200399ms,1.2004ms,1.200449ms,1.20045ms,1.200499ms,1.2005ms,1.200549ms,1.20055ms,1.200599ms,1.2006ms,1.200649ms,1.20065ms,1.200699ms,1.2007ms,1.200749ms,1.20075ms,1.200799ms,1.2008ms,1.200849ms,1.20085ms,1.200899ms,1.2009ms,1.200949ms,1.20095ms,1.200999ms,1.201ms,1.201049ms,1.20105ms,1.201099ms,1.2011ms,1.201149ms,1.20115ms,1.201199ms,1.2012ms,1.201249ms,1.20125ms,1.201299ms,1.2013ms,1.201349ms,1.20135ms,1.201399ms,1.2014ms,1.201449ms,1.20145ms,1.201499ms,1.2015ms,1.201549ms,1.20155ms,1.201599ms,1.2016ms,1.201649ms,1.20165ms,1.201699ms,1.2017ms,1.201749ms,1.20175ms,1.201799ms,1.2018ms,1.201849ms,1.20185ms,1.201899ms,1.2019ms,1.201949ms,1.20195ms,1.201999ms,1.202ms,1.202049ms,1.20205ms,1.202099ms,1.2021ms,1.202149ms,1.20215ms,1.202199ms,1.2022ms,1.202249ms,1.20225ms,1.202299ms,1.2023ms,1.202349ms,1.20235ms,1.202399ms,1.2024ms,1.202449ms,1.20245ms,1.202499ms,1.2025ms,1.202549ms,1.20255ms,1.202599ms,1.2026ms,1.202649ms,1.20265ms,1.202699ms,1.2027ms,1.202749ms,1.20275ms,1.202799ms,1.2028ms,1.202849ms,1.20285ms,1.202899ms,1.2029ms,1.202949ms,1.20295ms,1.202999ms,1.203ms,1.203049ms,1.20305ms,1.203099ms,1.2031ms,1.203149ms,1.20315ms,1.203199ms,1.2032ms,1.203249ms,1.20325ms,1.203299ms,1.2033ms,1.203349ms,1.20335ms,1.203399ms,1.2034ms,1.203449ms,1.20345ms,1.203499ms,1.2035ms,1.203549ms,1.20355ms,1.203599ms,1.2036ms,1.203649ms,1.20365ms,1.203699ms,1.2037ms,1.203749ms,1.20375ms,1.203799ms,1.2038ms,1.203849ms,1.20385ms,1.203899ms,1.2039ms,1.203949ms,1.20395ms,1.203999ms,1.204ms,1.204049ms,1.20405ms,1.204099ms,1.2041ms,1.204149ms,1.20415ms,1.204199ms,1.2042ms,1.204249ms,1.20425ms,1.204299ms,1.2043ms,1.204349ms,1.20435ms,1.204399ms,1.2044ms,1.204449ms,1.20445ms,1.204499ms,1.2045ms,1.204549ms,1.20455ms,1.204599ms,1.2046ms,1.204649ms,1.20465ms,1.204699ms,1.2047ms,1.204749ms,1.20475ms,1.204799ms,1.2048ms,1.204849ms,1.20485ms,1.204899ms,1.2049ms,1.204949ms,1.20495ms,1.204999ms,1.205ms,1.205049ms,1.20505ms,1.205099ms,1.2051ms,1.205149ms,1.20515ms,1.205199ms,1.2052ms,1.205249ms,1.20525ms,1.205299ms,1.2053ms,1.205349ms,1.20535ms,1.205399ms,1.2054ms,1.205449ms,1.20545ms,1.205499ms,1.2055ms,1.205549ms,1.20555ms,1.205599ms,1.2056ms,1.205649ms,1.20565ms,1.205699ms,1.2057ms,1.205749ms,1.20575ms,1.205799ms,1.2058ms,1.205849ms,1.20585ms,1.205899ms,1.2059ms,1.205949ms,1.20595ms,1.205999ms,1.206ms,1.206049ms,1.20605ms,1.206099ms,1.2061ms,1.206149ms,1.20615ms,1.206199ms,1.2062ms,1.206249ms,1.20625ms,1.206299ms,1.2063ms,1.206349ms,1.20635ms,1.206399ms,1.2064ms,1.206449ms,1.20645ms,1.206499ms,1.2065ms,1.206549ms,1.20655ms,1.206599ms,1.2066ms,1.206649ms,1.20665ms,1.206699ms,1.2067ms,1.206749ms,1.20675ms,1.206799ms,1.2068ms,1.206849ms,1.20685ms,1.206899ms,1.2069ms,1.206949ms,1.20695ms,1.206999ms,1.207ms,1.207049ms,1.20705ms,1.207099ms,1.2071ms,1.207149ms,1.20715ms,1.207199ms,1.2072ms,1.207249ms,1.20725ms,1.207299ms,1.2073ms,1.207349ms,1.20735ms,1.207399ms,1.2074ms,1.207449ms,1.20745ms,1.207499ms,1.2075ms,1.207549ms,1.20755ms,1.207599ms,1.2076ms,1.207649ms,1.20765ms,1.207699ms,1.2077ms,1.207749ms,1.20775ms,1.207799ms,1.2078ms,1.207849ms,1.20785ms,1.207899ms,1.2079ms,1.207949ms,1.20795ms,1.207999ms,1.208ms,1.208049ms,1.20805ms,1.208099ms,1.2081ms,1.208149ms,1.20815ms,1.208199ms,1.2082ms,1.208249ms,1.20825ms,1.208299ms,1.2083ms,1.208349ms,1.20835ms,1.208399ms,1.2084ms,1.208449ms,1.20845ms,1.208499ms,1.2085ms,1.208549ms,1.20855ms,1.208599ms,1.2086ms,1.208649ms,1.20865ms,1.208699ms,1.2087ms,1.208749ms,1.20875ms,1.208799ms,1.2088ms,1.208849ms,1.20885ms,1.208899ms,1.2089ms,1.208949ms,1.20895ms,1.208999ms,1.209ms,1.209049ms,1.20905ms,1.209099ms,1.2091ms,1.209149ms,1.20915ms,1.209199ms,1.2092ms,1.209249ms,1.20925ms,1.209299ms,1.2093ms,1.209349ms,1.20935ms,1.209399ms,1.2094ms,1.209449ms,1.20945ms,1.209499ms,1.2095ms,1.209549ms,1.20955ms,1.209599ms,1.2096ms,1.209649ms,1.20965ms,1.209699ms,1.2097ms,1.209749ms,1.20975ms,1.209799ms,1.2098ms,1.209849ms,1.20985ms,1.209899ms,1.2099ms,1.209949ms,1.20995ms,1.209999ms,1.21ms,1.210049ms,1.21005ms,1.210099ms,1.2101ms,1.210149ms,1.21015ms,1.210199ms,1.2102ms,1.210249ms,1.21025ms,1.210299ms,1.2103ms,1.210349ms,1.21035ms,1.210399ms,1.2104ms,1.210449ms,1.21045ms,1.210499ms,1.2105ms,1.210549ms,1.21055ms,1.210599ms,1.2106ms,1.210649ms,1.21065ms,1.210699ms,1.2107ms,1.210749ms,1.21075ms,1.210799ms,1.2108ms,1.210849ms,1.21085ms,1.210899ms,1.2109ms,1.210949ms,1.21095ms,1.210999ms,1.211ms,1.211049ms,1.21105ms,1.211099ms,1.2111ms,1.211149ms,1.21115ms,1.211199ms,1.2112ms,1.211249ms,1.21125ms,1.211299ms,1.2113ms,1.211349ms,1.21135ms,1.211399ms,1.2114ms,1.211449ms,1.21145ms,1.211499ms,1.2115ms,1.211549ms,1.21155ms,1.211599ms,1.2116ms,1.211649ms,1.21165ms,1.211699ms,1.2117ms,1.211749ms,1.21175ms,1.211799ms,1.2118ms,1.211849ms,1.21185ms,1.211899ms,1.2119ms,1.211949ms,1.21195ms,1.211999ms,1.212ms,1.212049ms,1.21205ms,1.212099ms,1.2121ms,1.212149ms,1.21215ms,1.212199ms,1.2122ms,1.212249ms,1.21225ms,1.212299ms,1.2123ms,1.212349ms,1.21235ms,1.212399ms,1.2124ms,1.212449ms,1.21245ms,1.212499ms,1.2125ms,1.212549ms,1.21255ms,1.212599ms,1.2126ms,1.212649ms,1.21265ms,1.212699ms,1.2127ms,1.212749ms,1.21275ms,1.212799ms,1.2128ms,1.212849ms,1.21285ms,1.212899ms,1.2129ms,1.212949ms,1.21295ms,1.212999ms,1.213ms,1.213049ms,1.21305ms,1.213099ms,1.2131ms,1.213149ms,1.21315ms,1.213199ms,1.2132ms,1.213249ms,1.21325ms,1.213299ms,1.2133ms,1.213349ms,1.21335ms,1.213399ms,1.2134ms,1.213449ms,1.21345ms,1.213499ms,1.2135ms,1.213549ms,1.21355ms,1.213599ms,1.2136ms,1.213649ms,1.21365ms,1.213699ms,1.2137ms,1.213749ms,1.21375ms,1.213799ms,1.2138ms,1.213849ms,1.21385ms,1.213899ms,1.2139ms,1.213949ms,1.21395ms,1.213999ms,1.214ms,1.214049ms,1.21405ms,1.214099ms,1.2141ms,1.214149ms,1.21415ms,1.214199ms,1.2142ms,1.214249ms,1.21425ms,1.214299ms,1.2143ms,1.214349ms,1.21435ms,1.214399ms,1.2144ms,1.214449ms,1.21445ms,1.214499ms,1.2145ms,1.214549ms,1.21455ms,1.214599ms,1.2146ms,1.214649ms,1.21465ms,1.214699ms,1.2147ms,1.214749ms,1.21475ms,1.214799ms,1.2148ms,1.214849ms,1.21485ms,1.214899ms,1.2149ms,1.214949ms,1.21495ms,1.214999ms,1.215ms,1.215049ms,1.21505ms,1.215099ms,1.2151ms,1.215149ms,1.21515ms,1.215199ms,1.2152ms,1.215249ms,1.21525ms,1.215299ms,1.2153ms,1.215349ms,1.21535ms,1.215399ms,1.2154ms,1.215449ms,1.21545ms,1.215499ms,1.2155ms,1.215549ms,1.21555ms,1.215599ms,1.2156ms,1.215649ms,1.21565ms,1.215699ms,1.2157ms,1.215749ms,1.21575ms,1.215799ms,1.2158ms,1.215849ms,1.21585ms,1.215899ms,1.2159ms,1.215949ms,1.21595ms,1.215999ms,1.216ms,1.216049ms,1.21605ms,1.216099ms,1.2161ms,1.216149ms,1.21615ms,1.216199ms,1.2162ms,1.216249ms,1.21625ms,1.216299ms,1.2163ms,1.216349ms,1.21635ms,1.216399ms,1.2164ms,1.216449ms,1.21645ms,1.216499ms,1.2165ms,1.216549ms,1.21655ms,1.216599ms,1.2166ms,1.216649ms,1.21665ms,1.216699ms,1.2167ms,1.216749ms,1.21675ms,1.216799ms,1.2168ms,1.216849ms,1.21685ms,1.216899ms,1.2169ms,1.216949ms,1.21695ms,1.216999ms,1.217ms,1.217049ms,1.21705ms,1.217099ms,1.2171ms,1.217149ms,1.21715ms,1.217199ms,1.2172ms,1.217249ms,1.21725ms,1.217299ms,1.2173ms,1.217349ms,1.21735ms,1.217399ms,1.2174ms,1.217449ms,1.21745ms,1.217499ms,1.2175ms,1.217549ms,1.21755ms,1.217599ms,1.2176ms,1.217649ms,1.21765ms,1.217699ms,1.2177ms,1.217749ms,1.21775ms,1.217799ms,1.2178ms,1.217849ms,1.21785ms,1.217899ms,1.2179ms,1.217949ms,1.21795ms,1.217999ms,1.218ms,1.218049ms,1.21805ms,1.218099ms,1.2181ms,1.218149ms,1.21815ms,1.218199ms,1.2182ms,1.218249ms,1.21825ms,1.218299ms,1.2183ms,1.218349ms,1.21835ms,1.218399ms,1.2184ms,1.218449ms,1.21845ms,1.218499ms,1.2185ms,1.218549ms,1.21855ms,1.218599ms,1.2186ms,1.218649ms,1.21865ms,1.218699ms,1.2187ms,1.218749ms,1.21875ms,1.218799ms,1.2188ms,1.218849ms,1.21885ms,1.218899ms,1.2189ms,1.218949ms,1.21895ms,1.218999ms,1.219ms,1.219049ms,1.21905ms,1.219099ms,1.2191ms,1.219149ms,1.21915ms,1.219199ms,1.2192ms,1.219249ms,1.21925ms,1.219299ms,1.2193ms,1.219349ms,1.21935ms,1.219399ms,1.2194ms,1.219449ms,1.21945ms,1.219499ms,1.2195ms,1.219549ms,1.21955ms,1.219599ms,1.2196ms,1.219649ms,1.21965ms,1.219699ms,1.2197ms,1.219749ms,1.21975ms,1.219799ms,1.2198ms,1.219849ms,1.21985ms,1.219899ms,1.2199ms,1.219949ms,1.21995ms,1.219999ms,1.22ms,1.220049ms,1.22005ms,1.220099ms,1.2201ms,1.220149ms,1.22015ms,1.220199ms,1.2202ms,1.220249ms,1.22025ms,1.220299ms,1.2203ms,1.220349ms,1.22035ms,1.220399ms,1.2204ms,1.220449ms,1.22045ms,1.220499ms,1.2205ms,1.220549ms,1.22055ms,1.220599ms,1.2206ms,1.220649ms,1.22065ms,1.220699ms,1.2207ms,1.220749ms,1.22075ms,1.220799ms,1.2208ms,1.220849ms,1.22085ms,1.220899ms,1.2209ms,1.220949ms,1.22095ms,1.220999ms,1.221ms,1.221049ms,1.22105ms,1.221099ms,1.2211ms,1.221149ms,1.22115ms,1.221199ms,1.2212ms,1.221249ms,1.22125ms,1.221299ms,1.2213ms,1.221349ms,1.22135ms,1.221399ms,1.2214ms,1.221449ms,1.22145ms,1.221499ms,1.2215ms,1.221549ms,1.22155ms,1.221599ms,1.2216ms,1.221649ms,1.22165ms,1.221699ms,1.2217ms,1.221749ms,1.22175ms,1.221799ms,1.2218ms,1.221849ms,1.22185ms,1.221899ms,1.2219ms,1.221949ms,1.22195ms,1.221999ms,1.222ms,1.222049ms,1.22205ms,1.222099ms,1.2221ms,1.222149ms,1.22215ms,1.222199ms,1.2222ms,1.222249ms,1.22225ms,1.222299ms,1.2223ms,1.222349ms,1.22235ms,1.222399ms,1.2224ms,1.222449ms,1.22245ms,1.222499ms,1.2225ms,1.222549ms,1.22255ms,1.222599ms,1.2226ms,1.222649ms,1.22265ms,1.222699ms,1.2227ms,1.222749ms,1.22275ms,1.222799ms,1.2228ms,1.222849ms,1.22285ms,1.222899ms,1.2229ms,1.222949ms,1.22295ms,1.222999ms,1.223ms,1.223049ms,1.22305ms,1.223099ms,1.2231ms,1.223149ms,1.22315ms,1.223199ms,1.2232ms,1.223249ms,1.22325ms,1.223299ms,1.2233ms,1.223349ms,1.22335ms,1.223399ms,1.2234ms,1.223449ms,1.22345ms,1.223499ms,1.2235ms,1.223549ms,1.22355ms,1.223599ms,1.2236ms,1.223649ms,1.22365ms,1.223699ms,1.2237ms,1.223749ms,1.22375ms,1.223799ms,1.2238ms,1.223849ms,1.22385ms,1.223899ms,1.2239ms,1.223949ms,1.22395ms,1.223999ms,1.224ms,1.224049ms,1.22405ms,1.224099ms,1.2241ms,1.224149ms,1.22415ms,1.224199ms,1.2242ms,1.224249ms,1.22425ms,1.224299ms,1.2243ms,1.224349ms,1.22435ms,1.224399ms,1.2244ms,1.224449ms,1.22445ms,1.224499ms,1.2245ms,1.224549ms,1.22455ms,1.224599ms,1.2246ms,1.224649ms,1.22465ms,1.224699ms,1.2247ms,1.224749ms,1.22475ms,1.224799ms,1.2248ms,1.224849ms,1.22485ms,1.224899ms,1.2249ms,1.224949ms,1.22495ms,1.224999ms,1.225ms,1.225049ms,1.22505ms,1.225099ms,1.2251ms,1.225149ms,1.22515ms,1.225199ms,1.2252ms,1.225249ms,1.22525ms,1.225299ms,1.2253ms,1.225349ms,1.22535ms,1.225399ms,1.2254ms,1.225449ms,1.22545ms,1.225499ms,1.2255ms,1.225549ms,1.22555ms,1.225599ms,1.2256ms,1.225649ms,1.22565ms,1.225699ms,1.2257ms,1.225749ms,1.22575ms,1.225799ms,1.2258ms,1.225849ms,1.22585ms,1.225899ms,1.2259ms,1.225949ms,1.22595ms,1.225999ms,1.226ms,1.226049ms,1.22605ms,1.226099ms,1.2261ms,1.226149ms,1.22615ms,1.226199ms,1.2262ms,1.226249ms,1.22625ms,1.226299ms,1.2263ms,1.226349ms,1.22635ms,1.226399ms,1.2264ms,1.226449ms,1.22645ms,1.226499ms,1.2265ms,1.226549ms,1.22655ms,1.226599ms,1.2266ms,1.226649ms,1.22665ms,1.226699ms,1.2267ms,1.226749ms,1.22675ms,1.226799ms,1.2268ms,1.226849ms,1.22685ms,1.226899ms,1.2269ms,1.226949ms,1.22695ms,1.226999ms,1.227ms,1.227049ms,1.22705ms,1.227099ms,1.2271ms,1.227149ms,1.22715ms,1.227199ms,1.2272ms,1.227249ms,1.22725ms,1.227299ms,1.2273ms,1.227349ms,1.22735ms,1.227399ms,1.2274ms,1.227449ms,1.22745ms,1.227499ms,1.2275ms,1.227549ms,1.22755ms,1.227599ms,1.2276ms,1.227649ms,1.22765ms,1.227699ms,1.2277ms,1.227749ms,1.22775ms,1.227799ms,1.2278ms,1.227849ms,1.22785ms,1.227899ms,1.2279ms,1.227949ms,1.22795ms,1.227999ms,1.228ms,1.228049ms,1.22805ms,1.228099ms,1.2281ms,1.228149ms,1.22815ms,1.228199ms,1.2282ms,1.228249ms,1.22825ms,1.228299ms,1.2283ms,1.228349ms,1.22835ms,1.228399ms,1.2284ms,1.228449ms,1.22845ms,1.228499ms,1.2285ms,1.228549ms,1.22855ms,1.228599ms,1.2286ms,1.228649ms,1.22865ms,1.228699ms,1.2287ms,1.228749ms,1.22875ms,1.228799ms,1.2288ms,1.228849ms,1.22885ms,1.228899ms,1.2289ms,1.228949ms,1.22895ms,1.228999ms,1.229ms,1.229049ms,1.22905ms,1.229099ms,1.2291ms,1.229149ms,1.22915ms,1.229199ms,1.2292ms,1.229249ms,1.22925ms,1.229299ms,1.2293ms,1.229349ms,1.22935ms,1.229399ms,1.2294ms,1.229449ms,1.22945ms,1.229499ms,1.2295ms,1.229549ms,1.22955ms,1.229599ms,1.2296ms,1.229649ms,1.22965ms,1.229699ms,1.2297ms,1.229749ms,1.22975ms,1.229799ms,1.2298ms,1.229849ms,1.22985ms,1.229899ms,1.2299ms,1.229949ms,1.22995ms,1.229999ms,1.23ms,1.230049ms,1.23005ms,1.230099ms,1.2301ms,1.230149ms,1.23015ms,1.230199ms,1.2302ms,1.230249ms,1.23025ms,1.230299ms,1.2303ms,1.230349ms,1.23035ms,1.230399ms,1.2304ms,1.230449ms,1.23045ms,1.230499ms,1.2305ms,1.230549ms,1.23055ms,1.230599ms,1.2306ms,1.230649ms,1.23065ms,1.230699ms,1.2307ms,1.230749ms,1.23075ms,1.230799ms,1.2308ms,1.230849ms,1.23085ms,1.230899ms,1.2309ms,1.230949ms,1.23095ms,1.230999ms,1.231ms,1.231049ms,1.23105ms,1.231099ms,1.2311ms,1.231149ms,1.23115ms,1.231199ms,1.2312ms,1.231249ms,1.23125ms,1.231299ms,1.2313ms,1.231349ms,1.23135ms,1.231399ms,1.2314ms,1.231449ms,1.23145ms,1.231499ms,1.2315ms,1.231549ms,1.23155ms,1.231599ms,1.2316ms,1.231649ms,1.23165ms,1.231699ms,1.2317ms,1.231749ms,1.23175ms,1.231799ms,1.2318ms,1.231849ms,1.23185ms,1.231899ms,1.2319ms,1.231949ms,1.23195ms,1.231999ms,1.232ms,1.232049ms,1.23205ms,1.232099ms,1.2321ms,1.232149ms,1.23215ms,1.232199ms,1.2322ms,1.232249ms,1.23225ms,1.232299ms,1.2323ms,1.232349ms,1.23235ms,1.232399ms,1.2324ms,1.232449ms,1.23245ms,1.232499ms,1.2325ms,1.232549ms,1.23255ms,1.232599ms,1.2326ms,1.232649ms,1.23265ms,1.232699ms,1.2327ms,1.232749ms,1.23275ms,1.232799ms,1.2328ms,1.232849ms,1.23285ms,1.232899ms,1.2329ms,1.232949ms,1.23295ms,1.232999ms,1.233ms,1.233049ms,1.23305ms,1.233099ms,1.2331ms,1.233149ms,1.23315ms,1.233199ms,1.2332ms,1.233249ms,1.23325ms,1.233299ms,1.2333ms,1.233349ms,1.23335ms,1.233399ms,1.2334ms,1.233449ms,1.23345ms,1.233499ms,1.2335ms,1.233549ms,1.23355ms,1.233599ms,1.2336ms,1.233649ms,1.23365ms,1.233699ms,1.2337ms,1.233749ms,1.23375ms,1.233799ms,1.2338ms,1.233849ms,1.23385ms,1.233899ms,1.2339ms,1.233949ms,1.23395ms,1.233999ms,1.234ms,1.234049ms,1.23405ms,1.234099ms,1.2341ms,1.234149ms,1.23415ms,1.234199ms,1.2342ms,1.234249ms,1.23425ms,1.234299ms,1.2343ms,1.234349ms,1.23435ms,1.234399ms,1.2344ms,1.234449ms,1.23445ms,1.234499ms,1.2345ms,1.234549ms,1.23455ms,1.234599ms,1.2346ms,1.234649ms,1.23465ms,1.234699ms,1.2347ms,1.234749ms,1.23475ms,1.234799ms,1.2348ms,1.234849ms,1.23485ms,1.234899ms,1.2349ms,1.234949ms,1.23495ms,1.234999ms,1.235ms,1.235049ms,1.23505ms,1.235099ms,1.2351ms,1.235149ms,1.23515ms,1.235199ms,1.2352ms,1.235249ms,1.23525ms,1.235299ms,1.2353ms,1.235349ms,1.23535ms,1.235399ms,1.2354ms,1.235449ms,1.23545ms,1.235499ms,1.2355ms,1.235549ms,1.23555ms,1.235599ms,1.2356ms,1.235649ms,1.23565ms,1.235699ms,1.2357ms,1.235749ms,1.23575ms,1.235799ms,1.2358ms,1.235849ms,1.23585ms,1.235899ms,1.2359ms,1.235949ms,1.23595ms,1.235999ms,1.236ms,1.236049ms,1.23605ms,1.236099ms,1.2361ms,1.236149ms,1.23615ms,1.236199ms,1.2362ms,1.236249ms,1.23625ms,1.236299ms,1.2363ms,1.236349ms,1.23635ms,1.236399ms,1.2364ms,1.236449ms,1.23645ms,1.236499ms,1.2365ms,1.236549ms,1.23655ms,1.236599ms,1.2366ms,1.236649ms,1.23665ms,1.236699ms,1.2367ms,1.236749ms,1.23675ms,1.236799ms,1.2368ms,1.236849ms,1.23685ms,1.236899ms,1.2369ms,1.236949ms,1.23695ms,1.236999ms,1.237ms,1.237049ms,1.23705ms,1.237099ms,1.2371ms,1.237149ms,1.23715ms,1.237199ms,1.2372ms,1.237249ms,1.23725ms,1.237299ms,1.2373ms,1.237349ms,1.23735ms,1.237399ms,1.2374ms,1.237449ms,1.23745ms,1.237499ms,1.2375ms,1.237549ms,1.23755ms,1.237599ms,1.2376ms,1.237649ms,1.23765ms,1.237699ms,1.2377ms,1.237749ms,1.23775ms,1.237799ms,1.2378ms,1.237849ms,1.23785ms,1.237899ms,1.2379ms,1.237949ms,1.23795ms,1.237999ms,1.238ms,1.238049ms,1.23805ms,1.238099ms,1.2381ms,1.238149ms,1.23815ms,1.238199ms,1.2382ms,1.238249ms,1.23825ms,1.238299ms,1.2383ms,1.238349ms,1.23835ms,1.238399ms,1.2384ms,1.238449ms,1.23845ms,1.238499ms,1.2385ms,1.238549ms,1.23855ms,1.238599ms,1.2386ms,1.238649ms,1.23865ms,1.238699ms,1.2387ms,1.238749ms,1.23875ms,1.238799ms,1.2388ms,1.238849ms,1.23885ms,1.238899ms,1.2389ms,1.238949ms,1.23895ms,1.238999ms,1.239ms,1.239049ms,1.23905ms,1.239099ms,1.2391ms,1.239149ms,1.23915ms,1.239199ms,1.2392ms,1.239249ms,1.23925ms,1.239299ms,1.2393ms,1.239349ms,1.23935ms,1.239399ms,1.2394ms,1.239449ms,1.23945ms,1.239499ms,1.2395ms,1.239549ms,1.23955ms,1.239599ms,1.2396ms,1.239649ms,1.23965ms,1.239699ms,1.2397ms,1.239749ms,1.23975ms,1.239799ms,1.2398ms,1.239849ms,1.23985ms,1.239899ms,1.2399ms,1.239949ms,1.23995ms,1.239999ms,1.24ms,1.240049ms,1.24005ms,1.240099ms,1.2401ms,1.240149ms,1.24015ms,1.240199ms,1.2402ms,1.240249ms,1.24025ms,1.240299ms,1.2403ms,1.240349ms,1.24035ms,1.240399ms,1.2404ms,1.240449ms,1.24045ms,1.240499ms,1.2405ms,1.240549ms,1.24055ms,1.240599ms,1.2406ms,1.240649ms,1.24065ms,1.240699ms,1.2407ms,1.240749ms,1.24075ms,1.240799ms,1.2408ms,1.240849ms,1.24085ms,1.240899ms,1.2409ms,1.240949ms,1.24095ms,1.240999ms,1.241ms,1.241049ms,1.24105ms,1.241099ms,1.2411ms,1.241149ms,1.24115ms,1.241199ms,1.2412ms,1.241249ms,1.24125ms,1.241299ms,1.2413ms,1.241349ms,1.24135ms,1.241399ms,1.2414ms,1.241449ms,1.24145ms,1.241499ms,1.2415ms,1.241549ms,1.24155ms,1.241599ms,1.2416ms,1.241649ms,1.24165ms,1.241699ms,1.2417ms,1.241749ms,1.24175ms,1.241799ms,1.2418ms,1.241849ms,1.24185ms,1.241899ms,1.2419ms,1.241949ms,1.24195ms,1.241999ms,1.242ms,1.242049ms,1.24205ms,1.242099ms,1.2421ms,1.242149ms,1.24215ms,1.242199ms,1.2422ms,1.242249ms,1.24225ms,1.242299ms,1.2423ms,1.242349ms,1.24235ms,1.242399ms,1.2424ms,1.242449ms,1.24245ms,1.242499ms,1.2425ms,1.242549ms,1.24255ms,1.242599ms,1.2426ms,1.242649ms,1.24265ms,1.242699ms,1.2427ms,1.242749ms,1.24275ms,1.242799ms,1.2428ms,1.242849ms,1.24285ms,1.242899ms,1.2429ms,1.242949ms,1.24295ms,1.242999ms,1.243ms,1.243049ms,1.24305ms,1.243099ms,1.2431ms,1.243149ms,1.24315ms,1.243199ms,1.2432ms,1.243249ms,1.24325ms,1.243299ms,1.2433ms,1.243349ms,1.24335ms,1.243399ms,1.2434ms,1.243449ms,1.24345ms,1.243499ms,1.2435ms,1.243549ms,1.24355ms,1.243599ms,1.2436ms,1.243649ms,1.24365ms,1.243699ms,1.2437ms,1.243749ms,1.24375ms,1.243799ms,1.2438ms,1.243849ms,1.24385ms,1.243899ms,1.2439ms,1.243949ms,1.24395ms,1.243999ms,1.244ms,1.244049ms,1.24405ms,1.244099ms,1.2441ms,1.244149ms,1.24415ms,1.244199ms,1.2442ms,1.244249ms,1.24425ms,1.244299ms,1.2443ms,1.244349ms,1.24435ms,1.244399ms,1.2444ms,1.244449ms,1.24445ms,1.244499ms,1.2445ms,1.244549ms,1.24455ms,1.244599ms,1.2446ms,1.244649ms,1.24465ms,1.244699ms,1.2447ms,1.244749ms,1.24475ms,1.244799ms,1.2448ms,1.244849ms,1.24485ms,1.244899ms,1.2449ms,1.244949ms,1.24495ms,1.244999ms,1.245ms,1.245049ms,1.24505ms,1.245099ms,1.2451ms,1.245149ms,1.24515ms,1.245199ms,1.2452ms,1.245249ms,1.24525ms,1.245299ms,1.2453ms,1.245349ms,1.24535ms,1.245399ms,1.2454ms,1.245449ms,1.24545ms,1.245499ms,1.2455ms,1.245549ms,1.24555ms,1.245599ms,1.2456ms,1.245649ms,1.24565ms,1.245699ms,1.2457ms,1.245749ms,1.24575ms,1.245799ms,1.2458ms,1.245849ms,1.24585ms,1.245899ms,1.2459ms,1.245949ms,1.24595ms,1.245999ms,1.246ms,1.246049ms,1.24605ms,1.246099ms,1.2461ms,1.246149ms,1.24615ms,1.246199ms,1.2462ms,1.246249ms,1.24625ms,1.246299ms,1.2463ms,1.246349ms,1.24635ms,1.246399ms,1.2464ms,1.246449ms,1.24645ms,1.246499ms,1.2465ms,1.246549ms,1.24655ms,1.246599ms,1.2466ms,1.246649ms,1.24665ms,1.246699ms,1.2467ms,1.246749ms,1.24675ms,1.246799ms,1.2468ms,1.246849ms,1.24685ms,1.246899ms,1.2469ms,1.246949ms,1.24695ms,1.246999ms,1.247ms,1.247049ms,1.24705ms,1.247099ms,1.2471ms,1.247149ms,1.24715ms,1.247199ms,1.2472ms,1.247249ms,1.24725ms,1.247299ms,1.2473ms,1.247349ms,1.24735ms,1.247399ms,1.2474ms,1.247449ms,1.24745ms,1.247499ms,1.2475ms,1.247549ms,1.24755ms,1.247599ms,1.2476ms,1.247649ms,1.24765ms,1.247699ms,1.2477ms,1.247749ms,1.24775ms,1.247799ms,1.2478ms,1.247849ms,1.24785ms,1.247899ms,1.2479ms,1.247949ms,1.24795ms,1.247999ms,1.248ms,1.248049ms,1.24805ms,1.248099ms,1.2481ms,1.248149ms,1.24815ms,1.248199ms,1.2482ms,1.248249ms,1.24825ms,1.248299ms,1.2483ms,1.248349ms,1.24835ms,1.248399ms,1.2484ms,1.248449ms,1.24845ms,1.248499ms,1.2485ms,1.248549ms,1.24855ms,1.248599ms,1.2486ms,1.248649ms,1.24865ms,1.248699ms,1.2487ms,1.248749ms,1.24875ms,1.248799ms,1.2488ms,1.248849ms,1.24885ms,1.248899ms,1.2489ms,1.248949ms,1.24895ms,1.248999ms,1.249ms,1.249049ms,1.24905ms,1.249099ms,1.2491ms,1.249149ms,1.24915ms,1.249199ms,1.2492ms,1.249249ms,1.24925ms,1.249299ms,1.2493ms,1.249349ms,1.24935ms,1.249399ms,1.2494ms,1.249449ms,1.24945ms,1.249499ms,1.2495ms,1.249549ms,1.24955ms,1.249599ms,1.2496ms,1.249649ms,1.24965ms,1.249699ms,1.2497ms,1.249749ms,1.24975ms,1.249799ms,1.2498ms,1.249849ms,1.24985ms,1.249899ms,1.2499ms,1.249949ms,1.24995ms,1.249999ms,1.25ms,1.250049ms,1.25005ms,1.250099ms,1.2501ms,1.250149ms,1.25015ms,1.250199ms,1.2502ms,1.250249ms,1.25025ms,1.250299ms,1.2503ms,1.250349ms,1.25035ms,1.250399ms,1.2504ms,1.250449ms,1.25045ms,1.250499ms,1.2505ms,1.250549ms,1.25055ms,1.250599ms,1.2506ms,1.250649ms,1.25065ms,1.250699ms,1.2507ms,1.250749ms,1.25075ms,1.250799ms,1.2508ms,1.250849ms,1.25085ms,1.250899ms,1.2509ms,1.250949ms,1.25095ms,1.250999ms,1.251ms,1.251049ms,1.25105ms,1.251099ms,1.2511ms,1.251149ms,1.25115ms,1.251199ms,1.2512ms,1.251249ms,1.25125ms,1.251299ms,1.2513ms,1.251349ms,1.25135ms,1.251399ms,1.2514ms,1.251449ms,1.25145ms,1.251499ms,1.2515ms,1.251549ms,1.25155ms,1.251599ms,1.2516ms,1.251649ms,1.25165ms,1.251699ms,1.2517ms,1.251749ms,1.25175ms,1.251799ms,1.2518ms,1.251849ms,1.25185ms,1.251899ms,1.2519ms,1.251949ms,1.25195ms,1.251999ms,1.252ms,1.252049ms,1.25205ms,1.252099ms,1.2521ms,1.252149ms,1.25215ms,1.252199ms,1.2522ms,1.252249ms,1.25225ms,1.252299ms,1.2523ms,1.252349ms,1.25235ms,1.252399ms,1.2524ms,1.252449ms,1.25245ms,1.252499ms,1.2525ms,1.252549ms,1.25255ms,1.252599ms,1.2526ms,1.252649ms,1.25265ms,1.252699ms,1.2527ms,1.252749ms,1.25275ms,1.252799ms,1.2528ms,1.252849ms,1.25285ms,1.252899ms,1.2529ms,1.252949ms,1.25295ms,1.252999ms,1.253ms,1.253049ms,1.25305ms,1.253099ms,1.2531ms,1.253149ms,1.25315ms,1.253199ms,1.2532ms,1.253249ms,1.25325ms,1.253299ms,1.2533ms,1.253349ms,1.25335ms,1.253399ms,1.2534ms,1.253449ms,1.25345ms,1.253499ms,1.2535ms,1.253549ms,1.25355ms,1.253599ms,1.2536ms,1.253649ms,1.25365ms,1.253699ms,1.2537ms,1.253749ms,1.25375ms,1.253799ms,1.2538ms,1.253849ms,1.25385ms,1.253899ms,1.2539ms,1.253949ms,1.25395ms,1.253999ms,1.254ms,1.254049ms,1.25405ms,1.254099ms,1.2541ms,1.254149ms,1.25415ms,1.254199ms,1.2542ms,1.254249ms,1.25425ms,1.254299ms,1.2543ms,1.254349ms,1.25435ms,1.254399ms,1.2544ms,1.254449ms,1.25445ms,1.254499ms,1.2545ms,1.254549ms,1.25455ms,1.254599ms,1.2546ms,1.254649ms,1.25465ms,1.254699ms,1.2547ms,1.254749ms,1.25475ms,1.254799ms,1.2548ms,1.254849ms,1.25485ms,1.254899ms,1.2549ms,1.254949ms,1.25495ms,1.254999ms,1.255ms,1.255049ms,1.25505ms,1.255099ms,1.2551ms,1.255149ms,1.25515ms,1.255199ms,1.2552ms,1.255249ms,1.25525ms,1.255299ms,1.2553ms,1.255349ms,1.25535ms,1.255399ms,1.2554ms,1.255449ms,1.25545ms,1.255499ms,1.2555ms,1.255549ms,1.25555ms,1.255599ms,1.2556ms,1.255649ms,1.25565ms,1.255699ms,1.2557ms,1.255749ms,1.25575ms,1.255799ms,1.2558ms,1.255849ms,1.25585ms,1.255899ms,1.2559ms,1.255949ms,1.25595ms,1.255999ms,1.256ms,1.256049ms,1.25605ms,1.256099ms,1.2561ms,1.256149ms,1.25615ms,1.256199ms,1.2562ms,1.256249ms,1.25625ms,1.256299ms,1.2563ms,1.256349ms,1.25635ms,1.256399ms,1.2564ms,1.256449ms,1.25645ms,1.256499ms,1.2565ms,1.256549ms,1.25655ms,1.256599ms,1.2566ms,1.256649ms,1.25665ms,1.256699ms,1.2567ms,1.256749ms,1.25675ms,1.256799ms,1.2568ms,1.256849ms,1.25685ms,1.256899ms,1.2569ms,1.256949ms,1.25695ms,1.256999ms,1.257ms,1.257049ms,1.25705ms,1.257099ms,1.2571ms,1.257149ms,1.25715ms,1.257199ms,1.2572ms,1.257249ms,1.25725ms,1.257299ms,1.2573ms,1.257349ms,1.25735ms,1.257399ms,1.2574ms,1.257449ms,1.25745ms,1.257499ms,1.2575ms,1.257549ms,1.25755ms,1.257599ms,1.2576ms,1.257649ms,1.25765ms,1.257699ms,1.2577ms,1.257749ms,1.25775ms,1.257799ms,1.2578ms,1.257849ms,1.25785ms,1.257899ms,1.2579ms,1.257949ms,1.25795ms,1.257999ms,1.258ms,1.258049ms,1.25805ms,1.258099ms,1.2581ms,1.258149ms,1.25815ms,1.258199ms,1.2582ms,1.258249ms,1.25825ms,1.258299ms,1.2583ms,1.258349ms,1.25835ms,1.258399ms,1.2584ms,1.258449ms,1.25845ms,1.258499ms,1.2585ms,1.258549ms,1.25855ms,1.258599ms,1.2586ms,1.258649ms,1.25865ms,1.258699ms,1.2587ms,1.258749ms,1.25875ms,1.258799ms,1.2588ms,1.258849ms,1.25885ms,1.258899ms,1.2589ms,1.258949ms,1.25895ms,1.258999ms,1.259ms,1.259049ms,1.25905ms,1.259099ms,1.2591ms,1.259149ms,1.25915ms,1.259199ms,1.2592ms,1.259249ms,1.25925ms,1.259299ms,1.2593ms,1.259349ms,1.25935ms,1.259399ms,1.2594ms,1.259449ms,1.25945ms,1.259499ms,1.2595ms,1.259549ms,1.25955ms,1.259599ms,1.2596ms,1.259649ms,1.25965ms,1.259699ms,1.2597ms,1.259749ms,1.25975ms,1.259799ms,1.2598ms,1.259849ms,1.25985ms,1.259899ms,1.2599ms,1.259949ms,1.25995ms,1.259999ms,1.26ms,1.260049ms,1.26005ms,1.260099ms,1.2601ms,1.260149ms,1.26015ms,1.260199ms,1.2602ms,1.260249ms,1.26025ms,1.260299ms,1.2603ms,1.260349ms,1.26035ms,1.260399ms,1.2604ms,1.260449ms,1.26045ms,1.260499ms,1.2605ms,1.260549ms,1.26055ms,1.260599ms,1.2606ms,1.260649ms,1.26065ms,1.260699ms,1.2607ms,1.260749ms,1.26075ms,1.260799ms,1.2608ms,1.260849ms,1.26085ms,1.260899ms,1.2609ms,1.260949ms,1.26095ms,1.260999ms,1.261ms,1.261049ms,1.26105ms,1.261099ms,1.2611ms,1.261149ms,1.26115ms,1.261199ms,1.2612ms,1.261249ms,1.26125ms,1.261299ms,1.2613ms,1.261349ms,1.26135ms,1.261399ms,1.2614ms,1.261449ms,1.26145ms,1.261499ms,1.2615ms,1.261549ms,1.26155ms,1.261599ms,1.2616ms,1.261649ms,1.26165ms,1.261699ms,1.2617ms,1.261749ms,1.26175ms,1.261799ms,1.2618ms,1.261849ms,1.26185ms,1.261899ms,1.2619ms,1.261949ms,1.26195ms,1.261999ms,1.262ms,1.262049ms,1.26205ms,1.262099ms,1.2621ms,1.262149ms,1.26215ms,1.262199ms,1.2622ms,1.262249ms,1.26225ms,1.262299ms,1.2623ms,1.262349ms,1.26235ms,1.262399ms,1.2624ms,1.262449ms,1.26245ms,1.262499ms,1.2625ms,1.262549ms,1.26255ms,1.262599ms,1.2626ms,1.262649ms,1.26265ms,1.262699ms,1.2627ms,1.262749ms,1.26275ms,1.262799ms,1.2628ms,1.262849ms,1.26285ms,1.262899ms,1.2629ms,1.262949ms,1.26295ms,1.262999ms,1.263ms,1.263049ms,1.26305ms,1.263099ms,1.2631ms,1.263149ms,1.26315ms,1.263199ms,1.2632ms,1.263249ms,1.26325ms,1.263299ms,1.2633ms,1.263349ms,1.26335ms,1.263399ms,1.2634ms,1.263449ms,1.26345ms,1.263499ms,1.2635ms,1.263549ms,1.26355ms,1.263599ms,1.2636ms,1.263649ms,1.26365ms,1.263699ms,1.2637ms,1.263749ms,1.26375ms,1.263799ms,1.2638ms,1.263849ms,1.26385ms,1.263899ms,1.2639ms,1.263949ms,1.26395ms,1.263999ms,1.264ms,1.264049ms,1.26405ms,1.264099ms,1.2641ms,1.264149ms,1.26415ms,1.264199ms,1.2642ms,1.264249ms,1.26425ms,1.264299ms,1.2643ms,1.264349ms,1.26435ms,1.264399ms,1.2644ms,1.264449ms,1.26445ms,1.264499ms,1.2645ms,1.264549ms,1.26455ms,1.264599ms,1.2646ms,1.264649ms,1.26465ms,1.264699ms,1.2647ms,1.264749ms,1.26475ms,1.264799ms,1.2648ms,1.264849ms,1.26485ms,1.264899ms,1.2649ms,1.264949ms,1.26495ms,1.264999ms,1.265ms,1.265049ms,1.26505ms,1.265099ms,1.2651ms,1.265149ms,1.26515ms,1.265199ms,1.2652ms,1.265249ms,1.26525ms,1.265299ms,1.2653ms,1.265349ms,1.26535ms,1.265399ms,1.2654ms,1.265449ms,1.26545ms,1.265499ms,1.2655ms,1.265549ms,1.26555ms,1.265599ms,1.2656ms,1.265649ms,1.26565ms,1.265699ms,1.2657ms,1.265749ms,1.26575ms,1.265799ms,1.2658ms,1.265849ms,1.26585ms,1.265899ms,1.2659ms,1.265949ms,1.26595ms,1.265999ms,1.266ms,1.266049ms,1.26605ms,1.266099ms,1.2661ms,1.266149ms,1.26615ms,1.266199ms,1.2662ms,1.266249ms,1.26625ms,1.266299ms,1.2663ms,1.266349ms,1.26635ms,1.266399ms,1.2664ms,1.266449ms,1.26645ms,1.266499ms,1.2665ms,1.266549ms,1.26655ms,1.266599ms,1.2666ms,1.266649ms,1.26665ms,1.266699ms,1.2667ms,1.266749ms,1.26675ms,1.266799ms,1.2668ms,1.266849ms,1.26685ms,1.266899ms,1.2669ms,1.266949ms,1.26695ms,1.266999ms,1.267ms,1.267049ms,1.26705ms,1.267099ms,1.2671ms,1.267149ms,1.26715ms,1.267199ms,1.2672ms,1.267249ms,1.26725ms,1.267299ms,1.2673ms,1.267349ms,1.26735ms,1.267399ms,1.2674ms,1.267449ms,1.26745ms,1.267499ms,1.2675ms,1.267549ms,1.26755ms,1.267599ms,1.2676ms,1.267649ms,1.26765ms,1.267699ms,1.2677ms,1.267749ms,1.26775ms,1.267799ms,1.2678ms,1.267849ms,1.26785ms,1.267899ms,1.2679ms,1.267949ms,1.26795ms,1.267999ms,1.268ms,1.268049ms,1.26805ms,1.268099ms,1.2681ms,1.268149ms,1.26815ms,1.268199ms,1.2682ms,1.268249ms,1.26825ms,1.268299ms,1.2683ms,1.268349ms,1.26835ms,1.268399ms,1.2684ms,1.268449ms,1.26845ms,1.268499ms,1.2685ms,1.268549ms,1.26855ms,1.268599ms,1.2686ms,1.268649ms,1.26865ms,1.268699ms,1.2687ms,1.268749ms,1.26875ms,1.268799ms,1.2688ms,1.268849ms,1.26885ms,1.268899ms,1.2689ms,1.268949ms,1.26895ms,1.268999ms,1.269ms,1.269049ms,1.26905ms,1.269099ms,1.2691ms,1.269149ms,1.26915ms,1.269199ms,1.2692ms,1.269249ms,1.26925ms,1.269299ms,1.2693ms,1.269349ms,1.26935ms,1.269399ms,1.2694ms,1.269449ms,1.26945ms,1.269499ms,1.2695ms,1.269549ms,1.26955ms,1.269599ms,1.2696ms,1.269649ms,1.26965ms,1.269699ms,1.2697ms,1.269749ms,1.26975ms,1.269799ms,1.2698ms,1.269849ms,1.26985ms,1.269899ms,1.2699ms,1.269949ms,1.26995ms,1.269999ms,1.27ms,1.270049ms,1.27005ms,1.270099ms,1.2701ms,1.270149ms,1.27015ms,1.270199ms,1.2702ms,1.270249ms,1.27025ms,1.270299ms,1.2703ms,1.270349ms,1.27035ms,1.270399ms,1.2704ms,1.270449ms,1.27045ms,1.270499ms,1.2705ms,1.270549ms,1.27055ms,1.270599ms,1.2706ms,1.270649ms,1.27065ms,1.270699ms,1.2707ms,1.270749ms,1.27075ms,1.270799ms,1.2708ms,1.270849ms,1.27085ms,1.270899ms,1.2709ms,1.270949ms,1.27095ms,1.270999ms,1.271ms,1.271049ms,1.27105ms,1.271099ms,1.2711ms,1.271149ms,1.27115ms,1.271199ms,1.2712ms,1.271249ms,1.27125ms,1.271299ms,1.2713ms,1.271349ms,1.27135ms,1.271399ms,1.2714ms,1.271449ms,1.27145ms,1.271499ms,1.2715ms,1.271549ms,1.27155ms,1.271599ms,1.2716ms,1.271649ms,1.27165ms,1.271699ms,1.2717ms,1.271749ms,1.27175ms,1.271799ms,1.2718ms,1.271849ms,1.27185ms,1.271899ms,1.2719ms,1.271949ms,1.27195ms,1.271999ms,1.272ms,1.272049ms,1.27205ms,1.272099ms,1.2721ms,1.272149ms,1.27215ms,1.272199ms,1.2722ms,1.272249ms,1.27225ms,1.272299ms,1.2723ms,1.272349ms,1.27235ms,1.272399ms,1.2724ms,1.272449ms,1.27245ms,1.272499ms,1.2725ms,1.272549ms,1.27255ms,1.272599ms,1.2726ms,1.272649ms,1.27265ms,1.272699ms,1.2727ms,1.272749ms,1.27275ms,1.272799ms,1.2728ms,1.272849ms,1.27285ms,1.272899ms,1.2729ms,1.272949ms,1.27295ms,1.272999ms,1.273ms,1.273049ms,1.27305ms,1.273099ms,1.2731ms,1.273149ms,1.27315ms,1.273199ms,1.2732ms,1.273249ms,1.27325ms,1.273299ms,1.2733ms,1.273349ms,1.27335ms,1.273399ms,1.2734ms,1.273449ms,1.27345ms,1.273499ms,1.2735ms,1.273549ms,1.27355ms,1.273599ms,1.2736ms,1.273649ms,1.27365ms,1.273699ms,1.2737ms,1.273749ms,1.27375ms,1.273799ms,1.2738ms,1.273849ms,1.27385ms,1.273899ms,1.2739ms,1.273949ms,1.27395ms,1.273999ms,1.274ms,1.274049ms,1.27405ms,1.274099ms,1.2741ms,1.274149ms,1.27415ms,1.274199ms,1.2742ms,1.274249ms,1.27425ms,1.274299ms,1.2743ms,1.274349ms,1.27435ms,1.274399ms,1.2744ms,1.274449ms,1.27445ms,1.274499ms,1.2745ms,1.274549ms,1.27455ms,1.274599ms,1.2746ms,1.274649ms,1.27465ms,1.274699ms,1.2747ms,1.274749ms,1.27475ms,1.274799ms,1.2748ms,1.274849ms,1.27485ms,1.274899ms,1.2749ms,1.274949ms,1.27495ms,1.274999ms,1.275ms,1.275049ms,1.27505ms,1.275099ms,1.2751ms,1.275149ms,1.27515ms,1.275199ms,1.2752ms,1.275249ms,1.27525ms,1.275299ms,1.2753ms,1.275349ms,1.27535ms,1.275399ms,1.2754ms,1.275449ms,1.27545ms,1.275499ms,1.2755ms,1.275549ms,1.27555ms,1.275599ms,1.2756ms,1.275649ms,1.27565ms,1.275699ms,1.2757ms,1.275749ms,1.27575ms,1.275799ms,1.2758ms,1.275849ms,1.27585ms,1.275899ms,1.2759ms,1.275949ms,1.27595ms,1.275999ms,1.276ms,1.276049ms,1.27605ms,1.276099ms,1.2761ms,1.276149ms,1.27615ms,1.276199ms,1.2762ms,1.276249ms,1.27625ms,1.276299ms,1.2763ms,1.276349ms,1.27635ms,1.276399ms,1.2764ms,1.276449ms,1.27645ms,1.276499ms,1.2765ms,1.276549ms,1.27655ms,1.276599ms,1.2766ms,1.276649ms,1.27665ms,1.276699ms,1.2767ms,1.276749ms,1.27675ms,1.276799ms,1.2768ms,1.276849ms,1.27685ms,1.276899ms,1.2769ms,1.276949ms,1.27695ms,1.276999ms,1.277ms,1.277049ms,1.27705ms,1.277099ms,1.2771ms,1.277149ms,1.27715ms,1.277199ms,1.2772ms,1.277249ms,1.27725ms,1.277299ms,1.2773ms,1.277349ms,1.27735ms,1.277399ms,1.2774ms,1.277449ms,1.27745ms,1.277499ms,1.2775ms,1.277549ms,1.27755ms,1.277599ms,1.2776ms,1.277649ms,1.27765ms,1.277699ms,1.2777ms,1.277749ms,1.27775ms,1.277799ms,1.2778ms,1.277849ms,1.27785ms,1.277899ms,1.2779ms,1.277949ms,1.27795ms,1.277999ms,1.278ms,1.278049ms,1.27805ms,1.278099ms,1.2781ms,1.278149ms,1.27815ms,1.278199ms,1.2782ms,1.278249ms,1.27825ms,1.278299ms,1.2783ms,1.278349ms,1.27835ms,1.278399ms,1.2784ms,1.278449ms,1.27845ms,1.278499ms,1.2785ms,1.278549ms,1.27855ms,1.278599ms,1.2786ms,1.278649ms,1.27865ms,1.278699ms,1.2787ms,1.278749ms,1.27875ms,1.278799ms,1.2788ms,1.278849ms,1.27885ms,1.278899ms,1.2789ms,1.278949ms,1.27895ms,1.278999ms,1.279ms,1.279049ms,1.27905ms,1.279099ms,1.2791ms,1.279149ms,1.27915ms,1.279199ms,1.2792ms,1.279249ms,1.27925ms,1.279299ms,1.2793ms,1.279349ms,1.27935ms,1.279399ms,1.2794ms,1.279449ms,1.27945ms,1.279499ms,1.2795ms,1.279549ms,1.27955ms,1.279599ms,1.2796ms,1.279649ms,1.27965ms,1.279699ms,1.2797ms,1.279749ms,1.27975ms,1.279799ms,1.2798ms,1.279849ms,1.27985ms,1.279899ms,1.2799ms,1.279949ms,1.27995ms,1.279999ms,1.28ms,1.280049ms,1.28005ms,1.280099ms,1.2801ms,1.280149ms,1.28015ms,1.280199ms,1.2802ms,1.280249ms,1.28025ms,1.280299ms,1.2803ms,1.280349ms,1.28035ms,1.280399ms,1.2804ms,1.280449ms,1.28045ms,1.280499ms,1.2805ms,1.280549ms,1.28055ms,1.280599ms,1.2806ms,1.280649ms,1.28065ms,1.280699ms,1.2807ms,1.280749ms,1.28075ms,1.280799ms,1.2808ms,1.280849ms,1.28085ms,1.280899ms,1.2809ms,1.280949ms,1.28095ms,1.280999ms,1.281ms,1.281049ms,1.28105ms,1.281099ms,1.2811ms,1.281149ms,1.28115ms,1.281199ms,1.2812ms,1.281249ms,1.28125ms,1.281299ms,1.2813ms,1.281349ms,1.28135ms,1.281399ms,1.2814ms,1.281449ms,1.28145ms,1.281499ms,1.2815ms,1.281549ms,1.28155ms,1.281599ms,1.2816ms,1.281649ms,1.28165ms,1.281699ms,1.2817ms,1.281749ms,1.28175ms,1.281799ms,1.2818ms,1.281849ms,1.28185ms,1.281899ms,1.2819ms,1.281949ms,1.28195ms,1.281999ms,1.282ms,1.282049ms,1.28205ms,1.282099ms,1.2821ms,1.282149ms,1.28215ms,1.282199ms,1.2822ms,1.282249ms,1.28225ms,1.282299ms,1.2823ms,1.282349ms,1.28235ms,1.282399ms,1.2824ms,1.282449ms,1.28245ms,1.282499ms,1.2825ms,1.282549ms,1.28255ms,1.282599ms,1.2826ms,1.282649ms,1.28265ms,1.282699ms,1.2827ms,1.282749ms,1.28275ms,1.282799ms,1.2828ms,1.282849ms,1.28285ms,1.282899ms,1.2829ms,1.282949ms,1.28295ms,1.282999ms,1.283ms,1.283049ms,1.28305ms,1.283099ms,1.2831ms,1.283149ms,1.28315ms,1.283199ms,1.2832ms,1.283249ms,1.28325ms,1.283299ms,1.2833ms,1.283349ms,1.28335ms,1.283399ms,1.2834ms,1.283449ms,1.28345ms,1.283499ms,1.2835ms,1.283549ms,1.28355ms,1.283599ms,1.2836ms,1.283649ms,1.28365ms,1.283699ms,1.2837ms,1.283749ms,1.28375ms,1.283799ms,1.2838ms,1.283849ms,1.28385ms,1.283899ms,1.2839ms,1.283949ms,1.28395ms,1.283999ms,1.284ms,1.284049ms,1.28405ms,1.284099ms,1.2841ms,1.284149ms,1.28415ms,1.284199ms,1.2842ms,1.284249ms,1.28425ms,1.284299ms,1.2843ms,1.284349ms,1.28435ms,1.284399ms,1.2844ms,1.284449ms,1.28445ms,1.284499ms,1.2845ms,1.284549ms,1.28455ms,1.284599ms,1.2846ms,1.284649ms,1.28465ms,1.284699ms,1.2847ms,1.284749ms,1.28475ms,1.284799ms,1.2848ms,1.284849ms,1.28485ms,1.284899ms,1.2849ms,1.284949ms,1.28495ms,1.284999ms,1.285ms,1.285049ms,1.28505ms,1.285099ms,1.2851ms,1.285149ms,1.28515ms,1.285199ms,1.2852ms,1.285249ms,1.28525ms,1.285299ms,1.2853ms,1.285349ms,1.28535ms,1.285399ms,1.2854ms,1.285449ms,1.28545ms,1.285499ms,1.2855ms,1.285549ms,1.28555ms,1.285599ms,1.2856ms,1.285649ms,1.28565ms,1.285699ms,1.2857ms,1.285749ms,1.28575ms,1.285799ms,1.2858ms,1.285849ms,1.28585ms,1.285899ms,1.2859ms,1.285949ms,1.28595ms,1.285999ms,1.286ms,1.286049ms,1.28605ms,1.286099ms,1.2861ms,1.286149ms,1.28615ms,1.286199ms,1.2862ms,1.286249ms,1.28625ms,1.286299ms,1.2863ms,1.286349ms,1.28635ms,1.286399ms,1.2864ms,1.286449ms,1.28645ms,1.286499ms,1.2865ms,1.286549ms,1.28655ms,1.286599ms,1.2866ms,1.286649ms,1.28665ms,1.286699ms,1.2867ms,1.286749ms,1.28675ms,1.286799ms,1.2868ms,1.286849ms,1.28685ms,1.286899ms,1.2869ms,1.286949ms,1.28695ms,1.286999ms,1.287ms,1.287049ms,1.28705ms,1.287099ms,1.2871ms,1.287149ms,1.28715ms,1.287199ms,1.2872ms,1.287249ms,1.28725ms,1.287299ms,1.2873ms,1.287349ms,1.28735ms,1.287399ms,1.2874ms,1.287449ms,1.28745ms,1.287499ms,1.2875ms,1.287549ms,1.28755ms,1.287599ms,1.2876ms,1.287649ms,1.28765ms,1.287699ms,1.2877ms,1.287749ms,1.28775ms,1.287799ms,1.2878ms,1.287849ms,1.28785ms,1.287899ms,1.2879ms,1.287949ms,1.28795ms,1.287999ms,1.288ms,1.288049ms,1.28805ms,1.288099ms,1.2881ms,1.288149ms,1.28815ms,1.288199ms,1.2882ms,1.288249ms,1.28825ms,1.288299ms,1.2883ms,1.288349ms,1.28835ms,1.288399ms,1.2884ms,1.288449ms,1.28845ms,1.288499ms,1.2885ms,1.288549ms,1.28855ms,1.288599ms,1.2886ms,1.288649ms,1.28865ms,1.288699ms,1.2887ms,1.288749ms,1.28875ms,1.288799ms,1.2888ms,1.288849ms,1.28885ms,1.288899ms,1.2889ms,1.288949ms,1.28895ms,1.288999ms,1.289ms,1.289049ms,1.28905ms,1.289099ms,1.2891ms,1.289149ms,1.28915ms,1.289199ms,1.2892ms,1.289249ms,1.28925ms,1.289299ms,1.2893ms,1.289349ms,1.28935ms,1.289399ms,1.2894ms,1.289449ms,1.28945ms,1.289499ms,1.2895ms,1.289549ms,1.28955ms,1.289599ms,1.2896ms,1.289649ms,1.28965ms,1.289699ms,1.2897ms,1.289749ms,1.28975ms,1.289799ms,1.2898ms,1.289849ms,1.28985ms,1.289899ms,1.2899ms,1.289949ms,1.28995ms,1.289999ms,1.29ms,1.290049ms,1.29005ms,1.290099ms,1.2901ms,1.290149ms,1.29015ms,1.290199ms,1.2902ms,1.290249ms,1.29025ms,1.290299ms,1.2903ms,1.290349ms,1.29035ms,1.290399ms,1.2904ms,1.290449ms,1.29045ms,1.290499ms,1.2905ms,1.290549ms,1.29055ms,1.290599ms,1.2906ms,1.290649ms,1.29065ms,1.290699ms,1.2907ms,1.290749ms,1.29075ms,1.290799ms,1.2908ms,1.290849ms,1.29085ms,1.290899ms,1.2909ms,1.290949ms,1.29095ms,1.290999ms,1.291ms,1.291049ms,1.29105ms,1.291099ms,1.2911ms,1.291149ms,1.29115ms,1.291199ms,1.2912ms,1.291249ms,1.29125ms,1.291299ms,1.2913ms,1.291349ms,1.29135ms,1.291399ms,1.2914ms,1.291449ms,1.29145ms,1.291499ms,1.2915ms,1.291549ms,1.29155ms,1.291599ms,1.2916ms,1.291649ms,1.29165ms,1.291699ms,1.2917ms,1.291749ms,1.29175ms,1.291799ms,1.2918ms,1.291849ms,1.29185ms,1.291899ms,1.2919ms,1.291949ms,1.29195ms,1.291999ms,1.292ms,1.292049ms,1.29205ms,1.292099ms,1.2921ms,1.292149ms,1.29215ms,1.292199ms,1.2922ms,1.292249ms,1.29225ms,1.292299ms,1.2923ms,1.292349ms,1.29235ms,1.292399ms,1.2924ms,1.292449ms,1.29245ms,1.292499ms,1.2925ms,1.292549ms,1.29255ms,1.292599ms,1.2926ms,1.292649ms,1.29265ms,1.292699ms,1.2927ms,1.292749ms,1.29275ms,1.292799ms,1.2928ms,1.292849ms,1.29285ms,1.292899ms,1.2929ms,1.292949ms,1.29295ms,1.292999ms,1.293ms,1.293049ms,1.29305ms,1.293099ms,1.2931ms,1.293149ms,1.29315ms,1.293199ms,1.2932ms,1.293249ms,1.29325ms,1.293299ms,1.2933ms,1.293349ms,1.29335ms,1.293399ms,1.2934ms,1.293449ms,1.29345ms,1.293499ms,1.2935ms,1.293549ms,1.29355ms,1.293599ms,1.2936ms,1.293649ms,1.29365ms,1.293699ms,1.2937ms,1.293749ms,1.29375ms,1.293799ms,1.2938ms,1.293849ms,1.29385ms,1.293899ms,1.2939ms,1.293949ms,1.29395ms,1.293999ms,1.294ms,1.294049ms,1.29405ms,1.294099ms,1.2941ms,1.294149ms,1.29415ms,1.294199ms,1.2942ms,1.294249ms,1.29425ms,1.294299ms,1.2943ms,1.294349ms,1.29435ms,1.294399ms,1.2944ms,1.294449ms,1.29445ms,1.294499ms,1.2945ms,1.294549ms,1.29455ms,1.294599ms,1.2946ms,1.294649ms,1.29465ms,1.294699ms,1.2947ms,1.294749ms,1.29475ms,1.294799ms,1.2948ms,1.294849ms,1.29485ms,1.294899ms,1.2949ms,1.294949ms,1.29495ms,1.294999ms,1.295ms,1.295049ms,1.29505ms,1.295099ms,1.2951ms,1.295149ms,1.29515ms,1.295199ms,1.2952ms,1.295249ms,1.29525ms,1.295299ms,1.2953ms,1.295349ms,1.29535ms,1.295399ms,1.2954ms,1.295449ms,1.29545ms,1.295499ms,1.2955ms,1.295549ms,1.29555ms,1.295599ms,1.2956ms,1.295649ms,1.29565ms,1.295699ms,1.2957ms,1.295749ms,1.29575ms,1.295799ms,1.2958ms,1.295849ms,1.29585ms,1.295899ms,1.2959ms,1.295949ms,1.29595ms,1.295999ms,1.296ms,1.296049ms,1.29605ms,1.296099ms,1.2961ms,1.296149ms,1.29615ms,1.296199ms,1.2962ms,1.296249ms,1.29625ms,1.296299ms,1.2963ms,1.296349ms,1.29635ms,1.296399ms,1.2964ms,1.296449ms,1.29645ms,1.296499ms,1.2965ms,1.296549ms,1.29655ms,1.296599ms,1.2966ms,1.296649ms,1.29665ms,1.296699ms,1.2967ms,1.296749ms,1.29675ms,1.296799ms,1.2968ms,1.296849ms,1.29685ms,1.296899ms,1.2969ms,1.296949ms,1.29695ms,1.296999ms,1.297ms,1.297049ms,1.29705ms,1.297099ms,1.2971ms,1.297149ms,1.29715ms,1.297199ms,1.2972ms,1.297249ms,1.29725ms,1.297299ms,1.2973ms,1.297349ms,1.29735ms,1.297399ms,1.2974ms,1.297449ms,1.29745ms,1.297499ms,1.2975ms,1.297549ms,1.29755ms,1.297599ms,1.2976ms,1.297649ms,1.29765ms,1.297699ms,1.2977ms,1.297749ms,1.29775ms,1.297799ms,1.2978ms,1.297849ms,1.29785ms,1.297899ms,1.2979ms,1.297949ms,1.29795ms,1.297999ms,1.298ms,1.298049ms,1.29805ms,1.298099ms,1.2981ms,1.298149ms,1.29815ms,1.298199ms,1.2982ms,1.298249ms,1.29825ms,1.298299ms,1.2983ms,1.298349ms,1.29835ms,1.298399ms,1.2984ms,1.298449ms,1.29845ms,1.298499ms,1.2985ms,1.298549ms,1.29855ms,1.298599ms,1.2986ms,1.298649ms,1.29865ms,1.298699ms,1.2987ms,1.298749ms,1.29875ms,1.298799ms,1.2988ms,1.298849ms,1.29885ms,1.298899ms,1.2989ms,1.298949ms,1.29895ms,1.298999ms,1.299ms,1.299049ms,1.29905ms,1.299099ms,1.2991ms,1.299149ms,1.29915ms,1.299199ms,1.2992ms,1.299249ms,1.29925ms,1.299299ms,1.2993ms,1.299349ms,1.29935ms,1.299399ms,1.2994ms,1.299449ms,1.29945ms,1.299499ms,1.2995ms,1.299549ms,1.29955ms,1.299599ms,1.2996ms,1.299649ms,1.29965ms,1.299699ms,1.2997ms,1.299749ms,1.29975ms,1.299799ms,1.2998ms,1.299849ms,1.29985ms,1.299899ms,1.2999ms,1.299949ms,1.29995ms,1.299999ms,1.3ms,1.300049ms,1.30005ms,1.300099ms,1.3001ms,1.300149ms,1.30015ms,1.300199ms,1.3002ms,1.300249ms,1.30025ms,1.300299ms,1.3003ms,1.300349ms,1.30035ms,1.300399ms,1.3004ms,1.300449ms,1.30045ms,1.300499ms,1.3005ms,1.300549ms,1.30055ms,1.300599ms,1.3006ms,1.300649ms,1.30065ms,1.300699ms,1.3007ms,1.300749ms,1.30075ms,1.300799ms,1.3008ms,1.300849ms,1.30085ms,1.300899ms,1.3009ms,1.300949ms,1.30095ms,1.300999ms,1.301ms,1.301049ms,1.30105ms,1.301099ms,1.3011ms,1.301149ms,1.30115ms,1.301199ms,1.3012ms,1.301249ms,1.30125ms,1.301299ms,1.3013ms,1.301349ms,1.30135ms,1.301399ms,1.3014ms,1.301449ms,1.30145ms,1.301499ms,1.3015ms,1.301549ms,1.30155ms,1.301599ms,1.3016ms,1.301649ms,1.30165ms,1.301699ms,1.3017ms,1.301749ms,1.30175ms,1.301799ms,1.3018ms,1.301849ms,1.30185ms,1.301899ms,1.3019ms,1.301949ms,1.30195ms,1.301999ms,1.302ms,1.302049ms,1.30205ms,1.302099ms,1.3021ms,1.302149ms,1.30215ms,1.302199ms,1.3022ms,1.302249ms,1.30225ms,1.302299ms,1.3023ms,1.302349ms,1.30235ms,1.302399ms,1.3024ms,1.302449ms,1.30245ms,1.302499ms,1.3025ms,1.302549ms,1.30255ms,1.302599ms,1.3026ms,1.302649ms,1.30265ms,1.302699ms,1.3027ms,1.302749ms,1.30275ms,1.302799ms,1.3028ms,1.302849ms,1.30285ms,1.302899ms,1.3029ms,1.302949ms,1.30295ms,1.302999ms,1.303ms,1.303049ms,1.30305ms,1.303099ms,1.3031ms,1.303149ms,1.30315ms,1.303199ms,1.3032ms,1.303249ms,1.30325ms,1.303299ms,1.3033ms,1.303349ms,1.30335ms,1.303399ms,1.3034ms,1.303449ms,1.30345ms,1.303499ms,1.3035ms,1.303549ms,1.30355ms,1.303599ms,1.3036ms,1.303649ms,1.30365ms,1.303699ms,1.3037ms,1.303749ms,1.30375ms,1.303799ms,1.3038ms,1.303849ms,1.30385ms,1.303899ms,1.3039ms,1.303949ms,1.30395ms,1.303999ms,1.304ms,1.304049ms,1.30405ms,1.304099ms,1.3041ms,1.304149ms,1.30415ms,1.304199ms,1.3042ms,1.304249ms,1.30425ms,1.304299ms,1.3043ms,1.304349ms,1.30435ms,1.304399ms,1.3044ms,1.304449ms,1.30445ms,1.304499ms,1.3045ms,1.304549ms,1.30455ms,1.304599ms,1.3046ms,1.304649ms,1.30465ms,1.304699ms,1.3047ms,1.304749ms,1.30475ms,1.304799ms,1.3048ms,1.304849ms,1.30485ms,1.304899ms,1.3049ms,1.304949ms,1.30495ms,1.304999ms,1.305ms,1.305049ms,1.30505ms,1.305099ms,1.3051ms,1.305149ms,1.30515ms,1.305199ms,1.3052ms,1.305249ms,1.30525ms,1.305299ms,1.3053ms,1.305349ms,1.30535ms,1.305399ms,1.3054ms,1.305449ms,1.30545ms,1.305499ms,1.3055ms,1.305549ms,1.30555ms,1.305599ms,1.3056ms,1.305649ms,1.30565ms,1.305699ms,1.3057ms,1.305749ms,1.30575ms,1.305799ms,1.3058ms,1.305849ms,1.30585ms,1.305899ms,1.3059ms,1.305949ms,1.30595ms,1.305999ms,1.306ms,1.306049ms,1.30605ms,1.306099ms,1.3061ms,1.306149ms,1.30615ms,1.306199ms,1.3062ms,1.306249ms,1.30625ms,1.306299ms,1.3063ms,1.306349ms,1.30635ms,1.306399ms,1.3064ms,1.306449ms,1.30645ms,1.306499ms,1.3065ms,1.306549ms,1.30655ms,1.306599ms,1.3066ms,1.306649ms,1.30665ms,1.306699ms,1.3067ms,1.306749ms,1.30675ms,1.306799ms,1.3068ms,1.306849ms,1.30685ms,1.306899ms,1.3069ms,1.306949ms,1.30695ms,1.306999ms,1.307ms,1.307049ms,1.30705ms,1.307099ms,1.3071ms,1.307149ms,1.30715ms,1.307199ms,1.3072ms,1.307249ms,1.30725ms,1.307299ms,1.3073ms,1.307349ms,1.30735ms,1.307399ms,1.3074ms,1.307449ms,1.30745ms,1.307499ms,1.3075ms,1.307549ms,1.30755ms,1.307599ms,1.3076ms,1.307649ms,1.30765ms,1.307699ms,1.3077ms,1.307749ms,1.30775ms,1.307799ms,1.3078ms,1.307849ms,1.30785ms,1.307899ms,1.3079ms,1.307949ms,1.30795ms,1.307999ms,1.308ms,1.308049ms,1.30805ms,1.308099ms,1.3081ms,1.308149ms,1.30815ms,1.308199ms,1.3082ms,1.308249ms,1.30825ms,1.308299ms,1.3083ms,1.308349ms,1.30835ms,1.308399ms,1.3084ms,1.308449ms,1.30845ms,1.308499ms,1.3085ms,1.308549ms,1.30855ms,1.308599ms,1.3086ms,1.308649ms,1.30865ms,1.308699ms,1.3087ms,1.308749ms,1.30875ms,1.308799ms,1.3088ms,1.308849ms,1.30885ms,1.308899ms,1.3089ms,1.308949ms,1.30895ms,1.308999ms,1.309ms,1.309049ms,1.30905ms,1.309099ms,1.3091ms,1.309149ms,1.30915ms,1.309199ms,1.3092ms,1.309249ms,1.30925ms,1.309299ms,1.3093ms,1.309349ms,1.30935ms,1.309399ms,1.3094ms,1.309449ms,1.30945ms,1.309499ms,1.3095ms,1.309549ms,1.30955ms,1.309599ms,1.3096ms,1.309649ms,1.30965ms,1.309699ms,1.3097ms,1.309749ms,1.30975ms,1.309799ms,1.3098ms,1.309849ms,1.30985ms,1.309899ms,1.3099ms,1.309949ms,1.30995ms,1.309999ms,1.31ms,1.310049ms,1.31005ms,1.310099ms,1.3101ms,1.310149ms,1.31015ms,1.310199ms,1.3102ms,1.310249ms,1.31025ms,1.310299ms,1.3103ms,1.310349ms,1.31035ms,1.310399ms,1.3104ms,1.310449ms,1.31045ms,1.310499ms,1.3105ms,1.310549ms,1.31055ms,1.310599ms,1.3106ms,1.310649ms,1.31065ms,1.310699ms,1.3107ms,1.310749ms,1.31075ms,1.310799ms,1.3108ms,1.310849ms,1.31085ms,1.310899ms,1.3109ms,1.310949ms,1.31095ms,1.310999ms,1.311ms,1.311049ms,1.31105ms,1.311099ms,1.3111ms,1.311149ms,1.31115ms,1.311199ms,1.3112ms,1.311249ms,1.31125ms,1.311299ms,1.3113ms,1.311349ms,1.31135ms,1.311399ms,1.3114ms,1.311449ms,1.31145ms,1.311499ms,1.3115ms,1.311549ms,1.31155ms,1.311599ms,1.3116ms,1.311649ms,1.31165ms,1.311699ms,1.3117ms,1.311749ms,1.31175ms,1.311799ms,1.3118ms,1.311849ms,1.31185ms,1.311899ms,1.3119ms,1.311949ms,1.31195ms,1.311999ms,1.312ms,1.312049ms,1.31205ms,1.312099ms,1.3121ms,1.312149ms,1.31215ms,1.312199ms,1.3122ms,1.312249ms,1.31225ms,1.312299ms,1.3123ms,1.312349ms,1.31235ms,1.312399ms,1.3124ms,1.312449ms,1.31245ms,1.312499ms,1.3125ms,1.312549ms,1.31255ms,1.312599ms,1.3126ms,1.312649ms,1.31265ms,1.312699ms,1.3127ms,1.312749ms,1.31275ms,1.312799ms,1.3128ms,1.312849ms,1.31285ms,1.312899ms,1.3129ms,1.312949ms,1.31295ms,1.312999ms,1.313ms,1.313049ms,1.31305ms,1.313099ms,1.3131ms,1.313149ms,1.31315ms,1.313199ms,1.3132ms,1.313249ms,1.31325ms,1.313299ms,1.3133ms,1.313349ms,1.31335ms,1.313399ms,1.3134ms,1.313449ms,1.31345ms,1.313499ms,1.3135ms,1.313549ms,1.31355ms,1.313599ms,1.3136ms,1.313649ms,1.31365ms,1.313699ms,1.3137ms,1.313749ms,1.31375ms,1.313799ms,1.3138ms,1.313849ms,1.31385ms,1.313899ms,1.3139ms,1.313949ms,1.31395ms,1.313999ms,1.314ms,1.314049ms,1.31405ms,1.314099ms,1.3141ms,1.314149ms,1.31415ms,1.314199ms,1.3142ms,1.314249ms,1.31425ms,1.314299ms,1.3143ms,1.314349ms,1.31435ms,1.314399ms,1.3144ms,1.314449ms,1.31445ms,1.314499ms,1.3145ms,1.314549ms,1.31455ms,1.314599ms,1.3146ms,1.314649ms,1.31465ms,1.314699ms,1.3147ms,1.314749ms,1.31475ms,1.314799ms,1.3148ms,1.314849ms,1.31485ms,1.314899ms,1.3149ms,1.314949ms,1.31495ms,1.314999ms,1.315ms,1.315049ms,1.31505ms,1.315099ms,1.3151ms,1.315149ms,1.31515ms,1.315199ms,1.3152ms,1.315249ms,1.31525ms,1.315299ms,1.3153ms,1.315349ms,1.31535ms,1.315399ms,1.3154ms,1.315449ms,1.31545ms,1.315499ms,1.3155ms,1.315549ms,1.31555ms,1.315599ms,1.3156ms,1.315649ms,1.31565ms,1.315699ms,1.3157ms,1.315749ms,1.31575ms,1.315799ms,1.3158ms,1.315849ms,1.31585ms,1.315899ms,1.3159ms,1.315949ms,1.31595ms,1.315999ms,1.316ms,1.316049ms,1.31605ms,1.316099ms,1.3161ms,1.316149ms,1.31615ms,1.316199ms,1.3162ms,1.316249ms,1.31625ms,1.316299ms,1.3163ms,1.316349ms,1.31635ms,1.316399ms,1.3164ms,1.316449ms,1.31645ms,1.316499ms,1.3165ms,1.316549ms,1.31655ms,1.316599ms,1.3166ms,1.316649ms,1.31665ms,1.316699ms,1.3167ms,1.316749ms,1.31675ms,1.316799ms,1.3168ms,1.316849ms,1.31685ms,1.316899ms,1.3169ms,1.316949ms,1.31695ms,1.316999ms,1.317ms,1.317049ms,1.31705ms,1.317099ms,1.3171ms,1.317149ms,1.31715ms,1.317199ms,1.3172ms,1.317249ms,1.31725ms,1.317299ms,1.3173ms,1.317349ms,1.31735ms,1.317399ms,1.3174ms,1.317449ms,1.31745ms,1.317499ms,1.3175ms,1.317549ms,1.31755ms,1.317599ms,1.3176ms,1.317649ms,1.31765ms,1.317699ms,1.3177ms,1.317749ms,1.31775ms,1.317799ms,1.3178ms,1.317849ms,1.31785ms,1.317899ms,1.3179ms,1.317949ms,1.31795ms,1.317999ms,1.318ms,1.318049ms,1.31805ms,1.318099ms,1.3181ms,1.318149ms,1.31815ms,1.318199ms,1.3182ms,1.318249ms,1.31825ms,1.318299ms,1.3183ms,1.318349ms,1.31835ms,1.318399ms,1.3184ms,1.318449ms,1.31845ms,1.318499ms,1.3185ms,1.318549ms,1.31855ms,1.318599ms,1.3186ms,1.318649ms,1.31865ms,1.318699ms,1.3187ms,1.318749ms,1.31875ms,1.318799ms,1.3188ms,1.318849ms,1.31885ms,1.318899ms,1.3189ms,1.318949ms,1.31895ms,1.318999ms,1.319ms,1.319049ms,1.31905ms,1.319099ms,1.3191ms,1.319149ms,1.31915ms,1.319199ms,1.3192ms,1.319249ms,1.31925ms,1.319299ms,1.3193ms,1.319349ms,1.31935ms,1.319399ms,1.3194ms,1.319449ms,1.31945ms,1.319499ms,1.3195ms,1.319549ms,1.31955ms,1.319599ms,1.3196ms,1.319649ms,1.31965ms,1.319699ms,1.3197ms,1.319749ms,1.31975ms,1.319799ms,1.3198ms,1.319849ms,1.31985ms,1.319899ms,1.3199ms,1.319949ms,1.31995ms,1.319999ms,1.32ms,1.320049ms,1.32005ms,1.320099ms,1.3201ms,1.320149ms,1.32015ms,1.320199ms,1.3202ms,1.320249ms,1.32025ms,1.320299ms,1.3203ms,1.320349ms,1.32035ms,1.320399ms,1.3204ms,1.320449ms,1.32045ms,1.320499ms,1.3205ms,1.320549ms,1.32055ms,1.320599ms,1.3206ms,1.320649ms,1.32065ms,1.320699ms,1.3207ms,1.320749ms,1.32075ms,1.320799ms,1.3208ms,1.320849ms,1.32085ms,1.320899ms,1.3209ms,1.320949ms,1.32095ms,1.320999ms,1.321ms,1.321049ms,1.32105ms,1.321099ms,1.3211ms,1.321149ms,1.32115ms,1.321199ms,1.3212ms,1.321249ms,1.32125ms,1.321299ms,1.3213ms,1.321349ms,1.32135ms,1.321399ms,1.3214ms,1.321449ms,1.32145ms,1.321499ms,1.3215ms,1.321549ms,1.32155ms,1.321599ms,1.3216ms,1.321649ms,1.32165ms,1.321699ms,1.3217ms,1.321749ms,1.32175ms,1.321799ms,1.3218ms,1.321849ms,1.32185ms,1.321899ms,1.3219ms,1.321949ms,1.32195ms,1.321999ms,1.322ms,1.322049ms,1.32205ms,1.322099ms,1.3221ms,1.322149ms,1.32215ms,1.322199ms,1.3222ms,1.322249ms,1.32225ms,1.322299ms,1.3223ms,1.322349ms,1.32235ms,1.322399ms,1.3224ms,1.322449ms,1.32245ms,1.322499ms,1.3225ms,1.322549ms,1.32255ms,1.322599ms,1.3226ms,1.322649ms,1.32265ms,1.322699ms,1.3227ms,1.322749ms,1.32275ms,1.322799ms,1.3228ms,1.322849ms,1.32285ms,1.322899ms,1.3229ms,1.322949ms,1.32295ms,1.322999ms,1.323ms,1.323049ms,1.32305ms,1.323099ms,1.3231ms,1.323149ms,1.32315ms,1.323199ms,1.3232ms,1.323249ms,1.32325ms,1.323299ms,1.3233ms,1.323349ms,1.32335ms,1.323399ms,1.3234ms,1.323449ms,1.32345ms,1.323499ms,1.3235ms,1.323549ms,1.32355ms,1.323599ms,1.3236ms,1.323649ms,1.32365ms,1.323699ms,1.3237ms,1.323749ms,1.32375ms,1.323799ms,1.3238ms,1.323849ms,1.32385ms,1.323899ms,1.3239ms,1.323949ms,1.32395ms,1.323999ms,1.324ms,1.324049ms,1.32405ms,1.324099ms,1.3241ms,1.324149ms,1.32415ms,1.324199ms,1.3242ms,1.324249ms,1.32425ms,1.324299ms,1.3243ms,1.324349ms,1.32435ms,1.324399ms,1.3244ms,1.324449ms,1.32445ms,1.324499ms,1.3245ms,1.324549ms,1.32455ms,1.324599ms,1.3246ms,1.324649ms,1.32465ms,1.324699ms,1.3247ms,1.324749ms,1.32475ms,1.324799ms,1.3248ms,1.324849ms,1.32485ms,1.324899ms,1.3249ms,1.324949ms,1.32495ms,1.324999ms,1.325ms,1.325049ms,1.32505ms,1.325099ms,1.3251ms,1.325149ms,1.32515ms,1.325199ms,1.3252ms,1.325249ms,1.32525ms,1.325299ms,1.3253ms,1.325349ms,1.32535ms,1.325399ms,1.3254ms,1.325449ms,1.32545ms,1.325499ms,1.3255ms,1.325549ms,1.32555ms,1.325599ms,1.3256ms,1.325649ms,1.32565ms,1.325699ms,1.3257ms,1.325749ms,1.32575ms,1.325799ms,1.3258ms,1.325849ms,1.32585ms,1.325899ms,1.3259ms,1.325949ms,1.32595ms,1.325999ms,1.326ms,1.326049ms,1.32605ms,1.326099ms,1.3261ms,1.326149ms,1.32615ms,1.326199ms,1.3262ms,1.326249ms,1.32625ms,1.326299ms,1.3263ms,1.326349ms,1.32635ms,1.326399ms,1.3264ms,1.326449ms,1.32645ms,1.326499ms,1.3265ms,1.326549ms,1.32655ms,1.326599ms,1.3266ms,1.326649ms,1.32665ms,1.326699ms,1.3267ms,1.326749ms,1.32675ms,1.326799ms,1.3268ms,1.326849ms,1.32685ms,1.326899ms,1.3269ms,1.326949ms,1.32695ms,1.326999ms,1.327ms,1.327049ms,1.32705ms,1.327099ms,1.3271ms,1.327149ms,1.32715ms,1.327199ms,1.3272ms,1.327249ms,1.32725ms,1.327299ms,1.3273ms,1.327349ms,1.32735ms,1.327399ms,1.3274ms,1.327449ms,1.32745ms,1.327499ms,1.3275ms,1.327549ms,1.32755ms,1.327599ms,1.3276ms,1.327649ms,1.32765ms,1.327699ms,1.3277ms,1.327749ms,1.32775ms,1.327799ms,1.3278ms,1.327849ms,1.32785ms,1.327899ms,1.3279ms,1.327949ms,1.32795ms,1.327999ms,1.328ms,1.328049ms,1.32805ms,1.328099ms,1.3281ms,1.328149ms,1.32815ms,1.328199ms,1.3282ms,1.328249ms,1.32825ms,1.328299ms,1.3283ms,1.328349ms,1.32835ms,1.328399ms,1.3284ms,1.328449ms,1.32845ms,1.328499ms,1.3285ms,1.328549ms,1.32855ms,1.328599ms,1.3286ms,1.328649ms,1.32865ms,1.328699ms,1.3287ms,1.328749ms,1.32875ms,1.328799ms,1.3288ms,1.328849ms,1.32885ms,1.328899ms,1.3289ms,1.328949ms,1.32895ms,1.328999ms,1.329ms,1.329049ms,1.32905ms,1.329099ms,1.3291ms,1.329149ms,1.32915ms,1.329199ms,1.3292ms,1.329249ms,1.32925ms,1.329299ms,1.3293ms,1.329349ms,1.32935ms,1.329399ms,1.3294ms,1.329449ms,1.32945ms,1.329499ms,1.3295ms,1.329549ms,1.32955ms,1.329599ms,1.3296ms,1.329649ms,1.32965ms,1.329699ms,1.3297ms,1.329749ms,1.32975ms,1.329799ms,1.3298ms,1.329849ms,1.32985ms,1.329899ms,1.3299ms,1.329949ms,1.32995ms,1.329999ms,1.33ms,1.330049ms,1.33005ms,1.330099ms,1.3301ms,1.330149ms,1.33015ms,1.330199ms,1.3302ms,1.330249ms,1.33025ms,1.330299ms,1.3303ms,1.330349ms,1.33035ms,1.330399ms,1.3304ms,1.330449ms,1.33045ms,1.330499ms,1.3305ms,1.330549ms,1.33055ms,1.330599ms,1.3306ms,1.330649ms,1.33065ms,1.330699ms,1.3307ms,1.330749ms,1.33075ms,1.330799ms,1.3308ms,1.330849ms,1.33085ms,1.330899ms,1.3309ms,1.330949ms,1.33095ms,1.330999ms,1.331ms,1.331049ms,1.33105ms,1.331099ms,1.3311ms,1.331149ms,1.33115ms,1.331199ms,1.3312ms,1.331249ms,1.33125ms,1.331299ms,1.3313ms,1.331349ms,1.33135ms,1.331399ms,1.3314ms,1.331449ms,1.33145ms,1.331499ms,1.3315ms,1.331549ms,1.33155ms,1.331599ms,1.3316ms,1.331649ms,1.33165ms,1.331699ms,1.3317ms,1.331749ms,1.33175ms,1.331799ms,1.3318ms,1.331849ms,1.33185ms,1.331899ms,1.3319ms,1.331949ms,1.33195ms,1.331999ms,1.332ms,1.332049ms,1.33205ms,1.332099ms,1.3321ms,1.332149ms,1.33215ms,1.332199ms,1.3322ms,1.332249ms,1.33225ms,1.332299ms,1.3323ms,1.332349ms,1.33235ms,1.332399ms,1.3324ms,1.332449ms,1.33245ms,1.332499ms,1.3325ms,1.332549ms,1.33255ms,1.332599ms,1.3326ms,1.332649ms,1.33265ms,1.332699ms,1.3327ms,1.332749ms,1.33275ms,1.332799ms,1.3328ms,1.332849ms,1.33285ms,1.332899ms,1.3329ms,1.332949ms,1.33295ms,1.332999ms,1.333ms,1.333049ms,1.33305ms,1.333099ms,1.3331ms,1.333149ms,1.33315ms,1.333199ms,1.3332ms,1.333249ms,1.33325ms,1.333299ms,1.3333ms,1.333349ms,1.33335ms,1.333399ms,1.3334ms,1.333449ms,1.33345ms,1.333499ms,1.3335ms,1.333549ms,1.33355ms,1.333599ms,1.3336ms,1.333649ms,1.33365ms,1.333699ms,1.3337ms,1.333749ms,1.33375ms,1.333799ms,1.3338ms,1.333849ms,1.33385ms,1.333899ms,1.3339ms,1.333949ms,1.33395ms,1.333999ms,1.334ms,1.334049ms,1.33405ms,1.334099ms,1.3341ms,1.334149ms,1.33415ms,1.334199ms,1.3342ms,1.334249ms,1.33425ms,1.334299ms,1.3343ms,1.334349ms,1.33435ms,1.334399ms,1.3344ms,1.334449ms,1.33445ms,1.334499ms,1.3345ms,1.334549ms,1.33455ms,1.334599ms,1.3346ms,1.334649ms,1.33465ms,1.334699ms,1.3347ms,1.334749ms,1.33475ms,1.334799ms,1.3348ms,1.334849ms,1.33485ms,1.334899ms,1.3349ms,1.334949ms,1.33495ms,1.334999ms,1.335ms,1.335049ms,1.33505ms,1.335099ms,1.3351ms,1.335149ms,1.33515ms,1.335199ms,1.3352ms,1.335249ms,1.33525ms,1.335299ms,1.3353ms,1.335349ms,1.33535ms,1.335399ms,1.3354ms,1.335449ms,1.33545ms,1.335499ms,1.3355ms,1.335549ms,1.33555ms,1.335599ms,1.3356ms,1.335649ms,1.33565ms,1.335699ms,1.3357ms,1.335749ms,1.33575ms,1.335799ms,1.3358ms,1.335849ms,1.33585ms,1.335899ms,1.3359ms,1.335949ms,1.33595ms,1.335999ms,1.336ms,1.336049ms,1.33605ms,1.336099ms,1.3361ms,1.336149ms,1.33615ms,1.336199ms,1.3362ms,1.336249ms,1.33625ms,1.336299ms,1.3363ms,1.336349ms,1.33635ms,1.336399ms,1.3364ms,1.336449ms,1.33645ms,1.336499ms,1.3365ms,1.336549ms,1.33655ms,1.336599ms,1.3366ms,1.336649ms,1.33665ms,1.336699ms,1.3367ms,1.336749ms,1.33675ms,1.336799ms,1.3368ms,1.336849ms,1.33685ms,1.336899ms,1.3369ms,1.336949ms,1.33695ms,1.336999ms,1.337ms,1.337049ms,1.33705ms,1.337099ms,1.3371ms,1.337149ms,1.33715ms,1.337199ms,1.3372ms,1.337249ms,1.33725ms,1.337299ms,1.3373ms,1.337349ms,1.33735ms,1.337399ms,1.3374ms,1.337449ms,1.33745ms,1.337499ms,1.3375ms,1.337549ms,1.33755ms,1.337599ms,1.3376ms,1.337649ms,1.33765ms,1.337699ms,1.3377ms,1.337749ms,1.33775ms,1.337799ms,1.3378ms,1.337849ms,1.33785ms,1.337899ms,1.3379ms,1.337949ms,1.33795ms,1.337999ms,1.338ms,1.338049ms,1.33805ms,1.338099ms,1.3381ms,1.338149ms,1.33815ms,1.338199ms,1.3382ms,1.338249ms,1.33825ms,1.338299ms,1.3383ms,1.338349ms,1.33835ms,1.338399ms,1.3384ms,1.338449ms,1.33845ms,1.338499ms,1.3385ms,1.338549ms,1.33855ms,1.338599ms,1.3386ms,1.338649ms,1.33865ms,1.338699ms,1.3387ms,1.338749ms,1.33875ms,1.338799ms,1.3388ms,1.338849ms,1.33885ms,1.338899ms,1.3389ms,1.338949ms,1.33895ms,1.338999ms,1.339ms,1.339049ms,1.33905ms,1.339099ms,1.3391ms,1.339149ms,1.33915ms,1.339199ms,1.3392ms,1.339249ms,1.33925ms,1.339299ms,1.3393ms,1.339349ms,1.33935ms,1.339399ms,1.3394ms,1.339449ms,1.33945ms,1.339499ms,1.3395ms,1.339549ms,1.33955ms,1.339599ms,1.3396ms,1.339649ms,1.33965ms,1.339699ms,1.3397ms,1.339749ms,1.33975ms,1.339799ms,1.3398ms,1.339849ms,1.33985ms,1.339899ms,1.3399ms,1.339949ms,1.33995ms,1.339999ms,1.34ms,1.340049ms,1.34005ms,1.340099ms,1.3401ms,1.340149ms,1.34015ms,1.340199ms,1.3402ms,1.340249ms,1.34025ms,1.340299ms,1.3403ms,1.340349ms,1.34035ms,1.340399ms,1.3404ms,1.340449ms,1.34045ms,1.340499ms,1.3405ms,1.340549ms,1.34055ms,1.340599ms,1.3406ms,1.340649ms,1.34065ms,1.340699ms,1.3407ms,1.340749ms,1.34075ms,1.340799ms,1.3408ms,1.340849ms,1.34085ms,1.340899ms,1.3409ms,1.340949ms,1.34095ms,1.340999ms,1.341ms,1.341049ms,1.34105ms,1.341099ms,1.3411ms,1.341149ms,1.34115ms,1.341199ms,1.3412ms,1.341249ms,1.34125ms,1.341299ms,1.3413ms,1.341349ms,1.34135ms,1.341399ms,1.3414ms,1.341449ms,1.34145ms,1.341499ms,1.3415ms,1.341549ms,1.34155ms,1.341599ms,1.3416ms,1.341649ms,1.34165ms,1.341699ms,1.3417ms,1.341749ms,1.34175ms,1.341799ms,1.3418ms,1.341849ms,1.34185ms,1.341899ms,1.3419ms,1.341949ms,1.34195ms,1.341999ms,1.342ms,1.342049ms,1.34205ms,1.342099ms,1.3421ms,1.342149ms,1.34215ms,1.342199ms,1.3422ms,1.342249ms,1.34225ms,1.342299ms,1.3423ms,1.342349ms,1.34235ms,1.342399ms,1.3424ms,1.342449ms,1.34245ms,1.342499ms,1.3425ms,1.342549ms,1.34255ms,1.342599ms,1.3426ms,1.342649ms,1.34265ms,1.342699ms,1.3427ms,1.342749ms,1.34275ms,1.342799ms,1.3428ms,1.342849ms,1.34285ms,1.342899ms,1.3429ms,1.342949ms,1.34295ms,1.342999ms,1.343ms,1.343049ms,1.34305ms,1.343099ms,1.3431ms,1.343149ms,1.34315ms,1.343199ms,1.3432ms,1.343249ms,1.34325ms,1.343299ms,1.3433ms,1.343349ms,1.34335ms,1.343399ms,1.3434ms,1.343449ms,1.34345ms,1.343499ms,1.3435ms,1.343549ms,1.34355ms,1.343599ms,1.3436ms,1.343649ms,1.34365ms,1.343699ms,1.3437ms,1.343749ms,1.34375ms,1.343799ms,1.3438ms,1.343849ms,1.34385ms,1.343899ms,1.3439ms,1.343949ms,1.34395ms,1.343999ms,1.344ms,1.344049ms,1.34405ms,1.344099ms,1.3441ms,1.344149ms,1.34415ms,1.344199ms,1.3442ms,1.344249ms,1.34425ms,1.344299ms,1.3443ms,1.344349ms,1.34435ms,1.344399ms,1.3444ms,1.344449ms,1.34445ms,1.344499ms,1.3445ms,1.344549ms,1.34455ms,1.344599ms,1.3446ms,1.344649ms,1.34465ms,1.344699ms,1.3447ms,1.344749ms,1.34475ms,1.344799ms,1.3448ms,1.344849ms,1.34485ms,1.344899ms,1.3449ms,1.344949ms,1.34495ms,1.344999ms,1.345ms,1.345049ms,1.34505ms,1.345099ms,1.3451ms,1.345149ms,1.34515ms,1.345199ms,1.3452ms,1.345249ms,1.34525ms,1.345299ms,1.3453ms,1.345349ms,1.34535ms,1.345399ms,1.3454ms,1.345449ms,1.34545ms,1.345499ms,1.3455ms,1.345549ms,1.34555ms,1.345599ms,1.3456ms,1.345649ms,1.34565ms,1.345699ms,1.3457ms,1.345749ms,1.34575ms,1.345799ms,1.3458ms,1.345849ms,1.34585ms,1.345899ms,1.3459ms,1.345949ms,1.34595ms,1.345999ms,1.346ms,1.346049ms,1.34605ms,1.346099ms,1.3461ms,1.346149ms,1.34615ms,1.346199ms,1.3462ms,1.346249ms,1.34625ms,1.346299ms,1.3463ms,1.346349ms,1.34635ms,1.346399ms,1.3464ms,1.346449ms,1.34645ms,1.346499ms,1.3465ms,1.346549ms,1.34655ms,1.346599ms,1.3466ms,1.346649ms,1.34665ms,1.346699ms,1.3467ms,1.346749ms,1.34675ms,1.346799ms,1.3468ms,1.346849ms,1.34685ms,1.346899ms,1.3469ms,1.346949ms,1.34695ms,1.346999ms,1.347ms,1.347049ms,1.34705ms,1.347099ms,1.3471ms,1.347149ms,1.34715ms,1.347199ms,1.3472ms,1.347249ms,1.34725ms,1.347299ms,1.3473ms,1.347349ms,1.34735ms,1.347399ms,1.3474ms,1.347449ms,1.34745ms,1.347499ms,1.3475ms,1.347549ms,1.34755ms,1.347599ms,1.3476ms,1.347649ms,1.34765ms,1.347699ms,1.3477ms,1.347749ms,1.34775ms,1.347799ms,1.3478ms,1.347849ms,1.34785ms,1.347899ms,1.3479ms,1.347949ms,1.34795ms,1.347999ms,1.348ms,1.348049ms,1.34805ms,1.348099ms,1.3481ms,1.348149ms,1.34815ms,1.348199ms,1.3482ms,1.348249ms,1.34825ms,1.348299ms,1.3483ms,1.348349ms,1.34835ms,1.348399ms,1.3484ms,1.348449ms,1.34845ms,1.348499ms,1.3485ms,1.348549ms,1.34855ms,1.348599ms,1.3486ms,1.348649ms,1.34865ms,1.348699ms,1.3487ms,1.348749ms,1.34875ms,1.348799ms,1.3488ms,1.348849ms,1.34885ms,1.348899ms,1.3489ms,1.348949ms,1.34895ms,1.348999ms,1.349ms,1.349049ms,1.34905ms,1.349099ms,1.3491ms,1.349149ms,1.34915ms,1.349199ms,1.3492ms,1.349249ms,1.34925ms,1.349299ms,1.3493ms,1.349349ms,1.34935ms,1.349399ms,1.3494ms,1.349449ms,1.34945ms,1.349499ms,1.3495ms,1.349549ms,1.34955ms,1.349599ms,1.3496ms,1.349649ms,1.34965ms,1.349699ms,1.3497ms,1.349749ms,1.34975ms,1.349799ms,1.3498ms,1.349849ms,1.34985ms,1.349899ms,1.3499ms,1.349949ms,1.34995ms,1.349999ms,1.35ms,1.350049ms,1.35005ms,1.350099ms,1.3501ms,1.350149ms,1.35015ms,1.350199ms,1.3502ms,1.350249ms,1.35025ms,1.350299ms,1.3503ms,1.350349ms,1.35035ms,1.350399ms,1.3504ms,1.350449ms,1.35045ms,1.350499ms,1.3505ms,1.350549ms,1.35055ms,1.350599ms,1.3506ms,1.350649ms,1.35065ms,1.350699ms,1.3507ms,1.350749ms,1.35075ms,1.350799ms,1.3508ms,1.350849ms,1.35085ms,1.350899ms,1.3509ms,1.350949ms,1.35095ms,1.350999ms,1.351ms,1.351049ms,1.35105ms,1.351099ms,1.3511ms,1.351149ms,1.35115ms,1.351199ms,1.3512ms,1.351249ms,1.35125ms,1.351299ms,1.3513ms,1.351349ms,1.35135ms,1.351399ms,1.3514ms,1.351449ms,1.35145ms,1.351499ms,1.3515ms,1.351549ms,1.35155ms,1.351599ms,1.3516ms,1.351649ms,1.35165ms,1.351699ms,1.3517ms,1.351749ms,1.35175ms,1.351799ms,1.3518ms,1.351849ms,1.35185ms,1.351899ms,1.3519ms,1.351949ms,1.35195ms,1.351999ms,1.352ms,1.352049ms,1.35205ms,1.352099ms,1.3521ms,1.352149ms,1.35215ms,1.352199ms,1.3522ms,1.352249ms,1.35225ms,1.352299ms,1.3523ms,1.352349ms,1.35235ms,1.352399ms,1.3524ms,1.352449ms,1.35245ms,1.352499ms,1.3525ms,1.352549ms,1.35255ms,1.352599ms,1.3526ms,1.352649ms,1.35265ms,1.352699ms,1.3527ms,1.352749ms,1.35275ms,1.352799ms,1.3528ms,1.352849ms,1.35285ms,1.352899ms,1.3529ms,1.352949ms,1.35295ms,1.352999ms,1.353ms,1.353049ms,1.35305ms,1.353099ms,1.3531ms,1.353149ms,1.35315ms,1.353199ms,1.3532ms,1.353249ms,1.35325ms,1.353299ms,1.3533ms,1.353349ms,1.35335ms,1.353399ms,1.3534ms,1.353449ms,1.35345ms,1.353499ms,1.3535ms,1.353549ms,1.35355ms,1.353599ms,1.3536ms,1.353649ms,1.35365ms,1.353699ms,1.3537ms,1.353749ms,1.35375ms,1.353799ms,1.3538ms,1.353849ms,1.35385ms,1.353899ms,1.3539ms,1.353949ms,1.35395ms,1.353999ms,1.354ms,1.354049ms,1.35405ms,1.354099ms,1.3541ms,1.354149ms,1.35415ms,1.354199ms,1.3542ms,1.354249ms,1.35425ms,1.354299ms,1.3543ms,1.354349ms,1.35435ms,1.354399ms,1.3544ms,1.354449ms,1.35445ms,1.354499ms,1.3545ms,1.354549ms,1.35455ms,1.354599ms,1.3546ms,1.354649ms,1.35465ms,1.354699ms,1.3547ms,1.354749ms,1.35475ms,1.354799ms,1.3548ms,1.354849ms,1.35485ms,1.354899ms,1.3549ms,1.354949ms,1.35495ms,1.354999ms,1.355ms,1.355049ms,1.35505ms,1.355099ms,1.3551ms,1.355149ms,1.35515ms,1.355199ms,1.3552ms,1.355249ms,1.35525ms,1.355299ms,1.3553ms,1.355349ms,1.35535ms,1.355399ms,1.3554ms,1.355449ms,1.35545ms,1.355499ms,1.3555ms,1.355549ms,1.35555ms,1.355599ms,1.3556ms,1.355649ms,1.35565ms,1.355699ms,1.3557ms,1.355749ms,1.35575ms,1.355799ms,1.3558ms,1.355849ms,1.35585ms,1.355899ms,1.3559ms,1.355949ms,1.35595ms,1.355999ms,1.356ms,1.356049ms,1.35605ms,1.356099ms,1.3561ms,1.356149ms,1.35615ms,1.356199ms,1.3562ms,1.356249ms,1.35625ms,1.356299ms,1.3563ms,1.356349ms,1.35635ms,1.356399ms,1.3564ms,1.356449ms,1.35645ms,1.356499ms,1.3565ms,1.356549ms,1.35655ms,1.356599ms,1.3566ms,1.356649ms,1.35665ms,1.356699ms,1.3567ms,1.356749ms,1.35675ms,1.356799ms,1.3568ms,1.356849ms,1.35685ms,1.356899ms,1.3569ms,1.356949ms,1.35695ms,1.356999ms,1.357ms,1.357049ms,1.35705ms,1.357099ms,1.3571ms,1.357149ms,1.35715ms,1.357199ms,1.3572ms,1.357249ms,1.35725ms,1.357299ms,1.3573ms,1.357349ms,1.35735ms,1.357399ms,1.3574ms,1.357449ms,1.35745ms,1.357499ms,1.3575ms,1.357549ms,1.35755ms,1.357599ms,1.3576ms,1.357649ms,1.35765ms,1.357699ms,1.3577ms,1.357749ms,1.35775ms,1.357799ms,1.3578ms,1.357849ms,1.35785ms,1.357899ms,1.3579ms,1.357949ms,1.35795ms,1.357999ms,1.358ms,1.358049ms,1.35805ms,1.358099ms,1.3581ms,1.358149ms,1.35815ms,1.358199ms,1.3582ms,1.358249ms,1.35825ms,1.358299ms,1.3583ms,1.358349ms,1.35835ms,1.358399ms,1.3584ms,1.358449ms,1.35845ms,1.358499ms,1.3585ms,1.358549ms,1.35855ms,1.358599ms,1.3586ms,1.358649ms,1.35865ms,1.358699ms,1.3587ms,1.358749ms,1.35875ms,1.358799ms,1.3588ms,1.358849ms,1.35885ms,1.358899ms,1.3589ms,1.358949ms,1.35895ms,1.358999ms,1.359ms,1.359049ms,1.35905ms,1.359099ms,1.3591ms,1.359149ms,1.35915ms,1.359199ms,1.3592ms,1.359249ms,1.35925ms,1.359299ms,1.3593ms,1.359349ms,1.35935ms,1.359399ms,1.3594ms,1.359449ms,1.35945ms,1.359499ms,1.3595ms,1.359549ms,1.35955ms,1.359599ms,1.3596ms,1.359649ms,1.35965ms,1.359699ms,1.3597ms,1.359749ms,1.35975ms,1.359799ms,1.3598ms,1.359849ms,1.35985ms,1.359899ms,1.3599ms,1.359949ms,1.35995ms,1.359999ms,1.36ms,1.360049ms,1.36005ms,1.360099ms,1.3601ms,1.360149ms,1.36015ms,1.360199ms,1.3602ms,1.360249ms,1.36025ms,1.360299ms,1.3603ms,1.360349ms,1.36035ms,1.360399ms,1.3604ms,1.360449ms,1.36045ms,1.360499ms,1.3605ms,1.360549ms,1.36055ms,1.360599ms,1.3606ms,1.360649ms,1.36065ms,1.360699ms,1.3607ms,1.360749ms,1.36075ms,1.360799ms,1.3608ms,1.360849ms,1.36085ms,1.360899ms,1.3609ms,1.360949ms,1.36095ms,1.360999ms,1.361ms,1.361049ms,1.36105ms,1.361099ms,1.3611ms,1.361149ms,1.36115ms,1.361199ms,1.3612ms,1.361249ms,1.36125ms,1.361299ms,1.3613ms,1.361349ms,1.36135ms,1.361399ms,1.3614ms,1.361449ms,1.36145ms,1.361499ms,1.3615ms,1.361549ms,1.36155ms,1.361599ms,1.3616ms,1.361649ms,1.36165ms,1.361699ms,1.3617ms,1.361749ms,1.36175ms,1.361799ms,1.3618ms,1.361849ms,1.36185ms,1.361899ms,1.3619ms,1.361949ms,1.36195ms,1.361999ms,1.362ms,1.362049ms,1.36205ms,1.362099ms,1.3621ms,1.362149ms,1.36215ms,1.362199ms,1.3622ms,1.362249ms,1.36225ms,1.362299ms,1.3623ms,1.362349ms,1.36235ms,1.362399ms,1.3624ms,1.362449ms,1.36245ms,1.362499ms,1.3625ms,1.362549ms,1.36255ms,1.362599ms,1.3626ms,1.362649ms,1.36265ms,1.362699ms,1.3627ms,1.362749ms,1.36275ms,1.362799ms,1.3628ms,1.362849ms,1.36285ms,1.362899ms,1.3629ms,1.362949ms,1.36295ms,1.362999ms,1.363ms,1.363049ms,1.36305ms,1.363099ms,1.3631ms,1.363149ms,1.36315ms,1.363199ms,1.3632ms,1.363249ms,1.36325ms,1.363299ms,1.3633ms,1.363349ms,1.36335ms,1.363399ms,1.3634ms,1.363449ms,1.36345ms,1.363499ms,1.3635ms,1.363549ms,1.36355ms,1.363599ms,1.3636ms,1.363649ms,1.36365ms,1.363699ms,1.3637ms,1.363749ms,1.36375ms,1.363799ms,1.3638ms,1.363849ms,1.36385ms,1.363899ms,1.3639ms,1.363949ms,1.36395ms,1.363999ms,1.364ms,1.364049ms,1.36405ms,1.364099ms,1.3641ms,1.364149ms,1.36415ms,1.364199ms,1.3642ms,1.364249ms,1.36425ms,1.364299ms,1.3643ms,1.364349ms,1.36435ms,1.364399ms,1.3644ms,1.364449ms,1.36445ms,1.364499ms,1.3645ms,1.364549ms,1.36455ms,1.364599ms,1.3646ms,1.364649ms,1.36465ms,1.364699ms,1.3647ms,1.364749ms,1.36475ms,1.364799ms,1.3648ms,1.364849ms,1.36485ms,1.364899ms,1.3649ms,1.364949ms,1.36495ms,1.364999ms,1.365ms,1.365049ms,1.36505ms,1.365099ms,1.3651ms,1.365149ms,1.36515ms,1.365199ms,1.3652ms,1.365249ms,1.36525ms,1.365299ms,1.3653ms,1.365349ms,1.36535ms,1.365399ms,1.3654ms,1.365449ms,1.36545ms,1.365499ms,1.3655ms,1.365549ms,1.36555ms,1.365599ms,1.3656ms,1.365649ms,1.36565ms,1.365699ms,1.3657ms,1.365749ms,1.36575ms,1.365799ms,1.3658ms,1.365849ms,1.36585ms,1.365899ms,1.3659ms,1.365949ms,1.36595ms,1.365999ms,1.366ms,1.366049ms,1.36605ms,1.366099ms,1.3661ms,1.366149ms,1.36615ms,1.366199ms,1.3662ms,1.366249ms,1.36625ms,1.366299ms,1.3663ms,1.366349ms,1.36635ms,1.366399ms,1.3664ms,1.366449ms,1.36645ms,1.366499ms,1.3665ms,1.366549ms,1.36655ms,1.366599ms,1.3666ms,1.366649ms,1.36665ms,1.366699ms,1.3667ms,1.366749ms,1.36675ms,1.366799ms,1.3668ms,1.366849ms,1.36685ms,1.366899ms,1.3669ms,1.366949ms,1.36695ms,1.366999ms,1.367ms,1.367049ms,1.36705ms,1.367099ms,1.3671ms,1.367149ms,1.36715ms,1.367199ms,1.3672ms,1.367249ms,1.36725ms,1.367299ms,1.3673ms,1.367349ms,1.36735ms,1.367399ms,1.3674ms,1.367449ms,1.36745ms,1.367499ms,1.3675ms,1.367549ms,1.36755ms,1.367599ms,1.3676ms,1.367649ms,1.36765ms,1.367699ms,1.3677ms,1.367749ms,1.36775ms,1.367799ms,1.3678ms,1.367849ms,1.36785ms,1.367899ms,1.3679ms,1.367949ms,1.36795ms,1.367999ms,1.368ms,1.368049ms,1.36805ms,1.368099ms,1.3681ms,1.368149ms,1.36815ms,1.368199ms,1.3682ms,1.368249ms,1.36825ms,1.368299ms,1.3683ms,1.368349ms,1.36835ms,1.368399ms,1.3684ms,1.368449ms,1.36845ms,1.368499ms,1.3685ms,1.368549ms,1.36855ms,1.368599ms,1.3686ms,1.368649ms,1.36865ms,1.368699ms,1.3687ms,1.368749ms,1.36875ms,1.368799ms,1.3688ms,1.368849ms,1.36885ms,1.368899ms,1.3689ms,1.368949ms,1.36895ms,1.368999ms,1.369ms,1.369049ms,1.36905ms,1.369099ms,1.3691ms,1.369149ms,1.36915ms,1.369199ms,1.3692ms,1.369249ms,1.36925ms,1.369299ms,1.3693ms,1.369349ms,1.36935ms,1.369399ms,1.3694ms,1.369449ms,1.36945ms,1.369499ms,1.3695ms,1.369549ms,1.36955ms,1.369599ms,1.3696ms,1.369649ms,1.36965ms,1.369699ms,1.3697ms,1.369749ms,1.36975ms,1.369799ms,1.3698ms,1.369849ms,1.36985ms,1.369899ms,1.3699ms,1.369949ms,1.36995ms,1.369999ms,1.37ms,1.370049ms,1.37005ms,1.370099ms,1.3701ms,1.370149ms,1.37015ms,1.370199ms,1.3702ms,1.370249ms,1.37025ms,1.370299ms,1.3703ms,1.370349ms,1.37035ms,1.370399ms,1.3704ms,1.370449ms,1.37045ms,1.370499ms,1.3705ms,1.370549ms,1.37055ms,1.370599ms,1.3706ms,1.370649ms,1.37065ms,1.370699ms,1.3707ms,1.370749ms,1.37075ms,1.370799ms,1.3708ms,1.370849ms,1.37085ms,1.370899ms,1.3709ms,1.370949ms,1.37095ms,1.370999ms,1.371ms,1.371049ms,1.37105ms,1.371099ms,1.3711ms,1.371149ms,1.37115ms,1.371199ms,1.3712ms,1.371249ms,1.37125ms,1.371299ms,1.3713ms,1.371349ms,1.37135ms,1.371399ms,1.3714ms,1.371449ms,1.37145ms,1.371499ms,1.3715ms,1.371549ms,1.37155ms,1.371599ms,1.3716ms,1.371649ms,1.37165ms,1.371699ms,1.3717ms,1.371749ms,1.37175ms,1.371799ms,1.3718ms,1.371849ms,1.37185ms,1.371899ms,1.3719ms,1.371949ms,1.37195ms,1.371999ms,1.372ms,1.372049ms,1.37205ms,1.372099ms,1.3721ms,1.372149ms,1.37215ms,1.372199ms,1.3722ms,1.372249ms,1.37225ms,1.372299ms,1.3723ms,1.372349ms,1.37235ms,1.372399ms,1.3724ms,1.372449ms,1.37245ms,1.372499ms,1.3725ms,1.372549ms,1.37255ms,1.372599ms,1.3726ms,1.372649ms,1.37265ms,1.372699ms,1.3727ms,1.372749ms,1.37275ms,1.372799ms,1.3728ms,1.372849ms,1.37285ms,1.372899ms,1.3729ms,1.372949ms,1.37295ms,1.372999ms,1.373ms,1.373049ms,1.37305ms,1.373099ms,1.3731ms,1.373149ms,1.37315ms,1.373199ms,1.3732ms,1.373249ms,1.37325ms,1.373299ms,1.3733ms,1.373349ms,1.37335ms,1.373399ms,1.3734ms,1.373449ms,1.37345ms,1.373499ms,1.3735ms,1.373549ms,1.37355ms,1.373599ms,1.3736ms,1.373649ms,1.37365ms,1.373699ms,1.3737ms,1.373749ms,1.37375ms,1.373799ms,1.3738ms,1.373849ms,1.37385ms,1.373899ms,1.3739ms,1.373949ms,1.37395ms,1.373999ms,1.374ms,1.374049ms,1.37405ms,1.374099ms,1.3741ms,1.374149ms,1.37415ms,1.374199ms,1.3742ms,1.374249ms,1.37425ms,1.374299ms,1.3743ms,1.374349ms,1.37435ms,1.374399ms,1.3744ms,1.374449ms,1.37445ms,1.374499ms,1.3745ms,1.374549ms,1.37455ms,1.374599ms,1.3746ms,1.374649ms,1.37465ms,1.374699ms,1.3747ms,1.374749ms,1.37475ms,1.374799ms,1.3748ms,1.374849ms,1.37485ms,1.374899ms,1.3749ms,1.374949ms,1.37495ms,1.374999ms,1.375ms,1.375049ms,1.37505ms,1.375099ms,1.3751ms,1.375149ms,1.37515ms,1.375199ms,1.3752ms,1.375249ms,1.37525ms,1.375299ms,1.3753ms,1.375349ms,1.37535ms,1.375399ms,1.3754ms,1.375449ms,1.37545ms,1.375499ms,1.3755ms,1.375549ms,1.37555ms,1.375599ms,1.3756ms,1.375649ms,1.37565ms,1.375699ms,1.3757ms,1.375749ms,1.37575ms,1.375799ms,1.3758ms,1.375849ms,1.37585ms,1.375899ms,1.3759ms,1.375949ms,1.37595ms,1.375999ms,1.376ms,1.376049ms,1.37605ms,1.376099ms,1.3761ms,1.376149ms,1.37615ms,1.376199ms,1.3762ms,1.376249ms,1.37625ms,1.376299ms,1.3763ms,1.376349ms,1.37635ms,1.376399ms,1.3764ms,1.376449ms,1.37645ms,1.376499ms,1.3765ms,1.376549ms,1.37655ms,1.376599ms,1.3766ms,1.376649ms,1.37665ms,1.376699ms,1.3767ms,1.376749ms,1.37675ms,1.376799ms,1.3768ms,1.376849ms,1.37685ms,1.376899ms,1.3769ms,1.376949ms,1.37695ms,1.376999ms,1.377ms,1.377049ms,1.37705ms,1.377099ms,1.3771ms,1.377149ms,1.37715ms,1.377199ms,1.3772ms,1.377249ms,1.37725ms,1.377299ms,1.3773ms,1.377349ms,1.37735ms,1.377399ms,1.3774ms,1.377449ms,1.37745ms,1.377499ms,1.3775ms,1.377549ms,1.37755ms,1.377599ms,1.3776ms,1.377649ms,1.37765ms,1.377699ms,1.3777ms,1.377749ms,1.37775ms,1.377799ms,1.3778ms,1.377849ms,1.37785ms,1.377899ms,1.3779ms,1.377949ms,1.37795ms,1.377999ms,1.378ms,1.378049ms,1.37805ms,1.378099ms,1.3781ms,1.378149ms,1.37815ms,1.378199ms,1.3782ms,1.378249ms,1.37825ms,1.378299ms,1.3783ms,1.378349ms,1.37835ms,1.378399ms,1.3784ms,1.378449ms,1.37845ms,1.378499ms,1.3785ms,1.378549ms,1.37855ms,1.378599ms,1.3786ms,1.378649ms,1.37865ms,1.378699ms,1.3787ms,1.378749ms,1.37875ms,1.378799ms,1.3788ms,1.378849ms,1.37885ms,1.378899ms,1.3789ms,1.378949ms,1.37895ms,1.378999ms,1.379ms,1.379049ms,1.37905ms,1.379099ms,1.3791ms,1.379149ms,1.37915ms,1.379199ms,1.3792ms,1.379249ms,1.37925ms,1.379299ms,1.3793ms,1.379349ms,1.37935ms,1.379399ms,1.3794ms,1.379449ms,1.37945ms,1.379499ms,1.3795ms,1.379549ms,1.37955ms,1.379599ms,1.3796ms,1.379649ms,1.37965ms,1.379699ms,1.3797ms,1.379749ms,1.37975ms,1.379799ms,1.3798ms,1.379849ms,1.37985ms,1.379899ms,1.3799ms,1.379949ms,1.37995ms,1.379999ms,1.38ms,1.380049ms,1.38005ms,1.380099ms,1.3801ms,1.380149ms,1.38015ms,1.380199ms,1.3802ms,1.380249ms,1.38025ms,1.380299ms,1.3803ms,1.380349ms,1.38035ms,1.380399ms,1.3804ms,1.380449ms,1.38045ms,1.380499ms,1.3805ms,1.380549ms,1.38055ms,1.380599ms,1.3806ms,1.380649ms,1.38065ms,1.380699ms,1.3807ms,1.380749ms,1.38075ms,1.380799ms,1.3808ms,1.380849ms,1.38085ms,1.380899ms,1.3809ms,1.380949ms,1.38095ms,1.380999ms,1.381ms,1.381049ms,1.38105ms,1.381099ms,1.3811ms,1.381149ms,1.38115ms,1.381199ms,1.3812ms,1.381249ms,1.38125ms,1.381299ms,1.3813ms,1.381349ms,1.38135ms,1.381399ms,1.3814ms,1.381449ms,1.38145ms,1.381499ms,1.3815ms,1.381549ms,1.38155ms,1.381599ms,1.3816ms,1.381649ms,1.38165ms,1.381699ms,1.3817ms,1.381749ms,1.38175ms,1.381799ms,1.3818ms,1.381849ms,1.38185ms,1.381899ms,1.3819ms,1.381949ms,1.38195ms,1.381999ms,1.382ms,1.382049ms,1.38205ms,1.382099ms,1.3821ms,1.382149ms,1.38215ms,1.382199ms,1.3822ms,1.382249ms,1.38225ms,1.382299ms,1.3823ms,1.382349ms,1.38235ms,1.382399ms,1.3824ms,1.382449ms,1.38245ms,1.382499ms,1.3825ms,1.382549ms,1.38255ms,1.382599ms,1.3826ms,1.382649ms,1.38265ms,1.382699ms,1.3827ms,1.382749ms,1.38275ms,1.382799ms,1.3828ms,1.382849ms,1.38285ms,1.382899ms,1.3829ms,1.382949ms,1.38295ms,1.382999ms,1.383ms,1.383049ms,1.38305ms,1.383099ms,1.3831ms,1.383149ms,1.38315ms,1.383199ms,1.3832ms,1.383249ms,1.38325ms,1.383299ms,1.3833ms,1.383349ms,1.38335ms,1.383399ms,1.3834ms,1.383449ms,1.38345ms,1.383499ms,1.3835ms,1.383549ms,1.38355ms,1.383599ms,1.3836ms,1.383649ms,1.38365ms,1.383699ms,1.3837ms,1.383749ms,1.38375ms,1.383799ms,1.3838ms,1.383849ms,1.38385ms,1.383899ms,1.3839ms,1.383949ms,1.38395ms,1.383999ms,1.384ms,1.384049ms,1.38405ms,1.384099ms,1.3841ms,1.384149ms,1.38415ms,1.384199ms,1.3842ms,1.384249ms,1.38425ms,1.384299ms,1.3843ms,1.384349ms,1.38435ms,1.384399ms,1.3844ms,1.384449ms,1.38445ms,1.384499ms,1.3845ms,1.384549ms,1.38455ms,1.384599ms,1.3846ms,1.384649ms,1.38465ms,1.384699ms,1.3847ms,1.384749ms,1.38475ms,1.384799ms,1.3848ms,1.384849ms,1.38485ms,1.384899ms,1.3849ms,1.384949ms,1.38495ms,1.384999ms,1.385ms,1.385049ms,1.38505ms,1.385099ms,1.3851ms,1.385149ms,1.38515ms,1.385199ms,1.3852ms,1.385249ms,1.38525ms,1.385299ms,1.3853ms,1.385349ms,1.38535ms,1.385399ms,1.3854ms,1.385449ms,1.38545ms,1.385499ms,1.3855ms,1.385549ms,1.38555ms,1.385599ms,1.3856ms,1.385649ms,1.38565ms,1.385699ms,1.3857ms,1.385749ms,1.38575ms,1.385799ms,1.3858ms,1.385849ms,1.38585ms,1.385899ms,1.3859ms,1.385949ms,1.38595ms,1.385999ms,1.386ms,1.386049ms,1.38605ms,1.386099ms,1.3861ms,1.386149ms,1.38615ms,1.386199ms,1.3862ms,1.386249ms,1.38625ms,1.386299ms,1.3863ms,1.386349ms,1.38635ms,1.386399ms,1.3864ms,1.386449ms,1.38645ms,1.386499ms,1.3865ms,1.386549ms,1.38655ms,1.386599ms,1.3866ms,1.386649ms,1.38665ms,1.386699ms,1.3867ms,1.386749ms,1.38675ms,1.386799ms,1.3868ms,1.386849ms,1.38685ms,1.386899ms,1.3869ms,1.386949ms,1.38695ms,1.386999ms,1.387ms,1.387049ms,1.38705ms,1.387099ms,1.3871ms,1.387149ms,1.38715ms,1.387199ms,1.3872ms,1.387249ms,1.38725ms,1.387299ms,1.3873ms,1.387349ms,1.38735ms,1.387399ms,1.3874ms,1.387449ms,1.38745ms,1.387499ms,1.3875ms,1.387549ms,1.38755ms,1.387599ms,1.3876ms,1.387649ms,1.38765ms,1.387699ms,1.3877ms,1.387749ms,1.38775ms,1.387799ms,1.3878ms,1.387849ms,1.38785ms,1.387899ms,1.3879ms,1.387949ms,1.38795ms,1.387999ms,1.388ms,1.388049ms,1.38805ms,1.388099ms,1.3881ms,1.388149ms,1.38815ms,1.388199ms,1.3882ms,1.388249ms,1.38825ms,1.388299ms,1.3883ms,1.388349ms,1.38835ms,1.388399ms,1.3884ms,1.388449ms,1.38845ms,1.388499ms,1.3885ms,1.388549ms,1.38855ms,1.388599ms,1.3886ms,1.388649ms,1.38865ms,1.388699ms,1.3887ms,1.388749ms,1.38875ms,1.388799ms,1.3888ms,1.388849ms,1.38885ms,1.388899ms,1.3889ms,1.388949ms,1.38895ms,1.388999ms,1.389ms,1.389049ms,1.38905ms,1.389099ms,1.3891ms,1.389149ms,1.38915ms,1.389199ms,1.3892ms,1.389249ms,1.38925ms,1.389299ms,1.3893ms,1.389349ms,1.38935ms,1.389399ms,1.3894ms,1.389449ms,1.38945ms,1.389499ms,1.3895ms,1.389549ms,1.38955ms,1.389599ms,1.3896ms,1.389649ms,1.38965ms,1.389699ms,1.3897ms,1.389749ms,1.38975ms,1.389799ms,1.3898ms,1.389849ms,1.38985ms,1.389899ms,1.3899ms,1.389949ms,1.38995ms,1.389999ms,1.39ms,1.390049ms,1.39005ms,1.390099ms,1.3901ms,1.390149ms,1.39015ms,1.390199ms,1.3902ms,1.390249ms,1.39025ms,1.390299ms,1.3903ms,1.390349ms,1.39035ms,1.390399ms,1.3904ms,1.390449ms,1.39045ms,1.390499ms,1.3905ms,1.390549ms,1.39055ms,1.390599ms,1.3906ms,1.390649ms,1.39065ms,1.390699ms,1.3907ms,1.390749ms,1.39075ms,1.390799ms,1.3908ms,1.390849ms,1.39085ms,1.390899ms,1.3909ms,1.390949ms,1.39095ms,1.390999ms,1.391ms,1.391049ms,1.39105ms,1.391099ms,1.3911ms,1.391149ms,1.39115ms,1.391199ms,1.3912ms,1.391249ms,1.39125ms,1.391299ms,1.3913ms,1.391349ms,1.39135ms,1.391399ms,1.3914ms,1.391449ms,1.39145ms,1.391499ms,1.3915ms,1.391549ms,1.39155ms,1.391599ms,1.3916ms,1.391649ms,1.39165ms,1.391699ms,1.3917ms,1.391749ms,1.39175ms,1.391799ms,1.3918ms,1.391849ms,1.39185ms,1.391899ms,1.3919ms,1.391949ms,1.39195ms,1.391999ms,1.392ms,1.392049ms,1.39205ms,1.392099ms,1.3921ms,1.392149ms,1.39215ms,1.392199ms,1.3922ms,1.392249ms,1.39225ms,1.392299ms,1.3923ms,1.392349ms,1.39235ms,1.392399ms,1.3924ms,1.392449ms,1.39245ms,1.392499ms,1.3925ms,1.392549ms,1.39255ms,1.392599ms,1.3926ms,1.392649ms,1.39265ms,1.392699ms,1.3927ms,1.392749ms,1.39275ms,1.392799ms,1.3928ms,1.392849ms,1.39285ms,1.392899ms,1.3929ms,1.392949ms,1.39295ms,1.392999ms,1.393ms,1.393049ms,1.39305ms,1.393099ms,1.3931ms,1.393149ms,1.39315ms,1.393199ms,1.3932ms,1.393249ms,1.39325ms,1.393299ms,1.3933ms,1.393349ms,1.39335ms,1.393399ms,1.3934ms,1.393449ms,1.39345ms,1.393499ms,1.3935ms,1.393549ms,1.39355ms,1.393599ms,1.3936ms,1.393649ms,1.39365ms,1.393699ms,1.3937ms,1.393749ms,1.39375ms,1.393799ms,1.3938ms,1.393849ms,1.39385ms,1.393899ms,1.3939ms,1.393949ms,1.39395ms,1.393999ms,1.394ms,1.394049ms,1.39405ms,1.394099ms,1.3941ms,1.394149ms,1.39415ms,1.394199ms,1.3942ms,1.394249ms,1.39425ms,1.394299ms,1.3943ms,1.394349ms,1.39435ms,1.394399ms,1.3944ms,1.394449ms,1.39445ms,1.394499ms,1.3945ms,1.394549ms,1.39455ms,1.394599ms,1.3946ms,1.394649ms,1.39465ms,1.394699ms,1.3947ms,1.394749ms,1.39475ms,1.394799ms,1.3948ms,1.394849ms,1.39485ms,1.394899ms,1.3949ms,1.394949ms,1.39495ms,1.394999ms,1.395ms,1.395049ms,1.39505ms,1.395099ms,1.3951ms,1.395149ms,1.39515ms,1.395199ms,1.3952ms,1.395249ms,1.39525ms,1.395299ms,1.3953ms,1.395349ms,1.39535ms,1.395399ms,1.3954ms,1.395449ms,1.39545ms,1.395499ms,1.3955ms,1.395549ms,1.39555ms,1.395599ms,1.3956ms,1.395649ms,1.39565ms,1.395699ms,1.3957ms,1.395749ms,1.39575ms,1.395799ms,1.3958ms,1.395849ms,1.39585ms,1.395899ms,1.3959ms,1.395949ms,1.39595ms,1.395999ms,1.396ms,1.396049ms,1.39605ms,1.396099ms,1.3961ms,1.396149ms,1.39615ms,1.396199ms,1.3962ms,1.396249ms,1.39625ms,1.396299ms,1.3963ms,1.396349ms,1.39635ms,1.396399ms,1.3964ms,1.396449ms,1.39645ms,1.396499ms,1.3965ms,1.396549ms,1.39655ms,1.396599ms,1.3966ms,1.396649ms,1.39665ms,1.396699ms,1.3967ms,1.396749ms,1.39675ms,1.396799ms,1.3968ms,1.396849ms,1.39685ms,1.396899ms,1.3969ms,1.396949ms,1.39695ms,1.396999ms,1.397ms,1.397049ms,1.39705ms,1.397099ms,1.3971ms,1.397149ms,1.39715ms,1.397199ms,1.3972ms,1.397249ms,1.39725ms,1.397299ms,1.3973ms,1.397349ms,1.39735ms,1.397399ms,1.3974ms,1.397449ms,1.39745ms,1.397499ms,1.3975ms,1.397549ms,1.39755ms,1.397599ms,1.3976ms,1.397649ms,1.39765ms,1.397699ms,1.3977ms,1.397749ms,1.39775ms,1.397799ms,1.3978ms,1.397849ms,1.39785ms,1.397899ms,1.3979ms,1.397949ms,1.39795ms,1.397999ms,1.398ms,1.398049ms,1.39805ms,1.398099ms,1.3981ms,1.398149ms,1.39815ms,1.398199ms,1.3982ms,1.398249ms,1.39825ms,1.398299ms,1.3983ms,1.398349ms,1.39835ms,1.398399ms,1.3984ms,1.398449ms,1.39845ms,1.398499ms,1.3985ms,1.398549ms,1.39855ms,1.398599ms,1.3986ms,1.398649ms,1.39865ms,1.398699ms,1.3987ms,1.398749ms,1.39875ms,1.398799ms,1.3988ms,1.398849ms,1.39885ms,1.398899ms,1.3989ms,1.398949ms,1.39895ms,1.398999ms,1.399ms,1.399049ms,1.39905ms,1.399099ms,1.3991ms,1.399149ms,1.39915ms,1.399199ms,1.3992ms,1.399249ms,1.39925ms,1.399299ms,1.3993ms,1.399349ms,1.39935ms,1.399399ms,1.3994ms,1.399449ms,1.39945ms,1.399499ms,1.3995ms,1.399549ms,1.39955ms,1.399599ms,1.3996ms,1.399649ms,1.39965ms,1.399699ms,1.3997ms,1.399749ms,1.39975ms,1.399799ms,1.3998ms,1.399849ms,1.39985ms,1.399899ms,1.3999ms,1.399949ms,1.39995ms,1.399999ms,1.4ms,1.400049ms,1.40005ms,1.400099ms,1.4001ms,1.400149ms,1.40015ms,1.400199ms,1.4002ms,1.400249ms,1.40025ms,1.400299ms,1.4003ms,1.400349ms,1.40035ms,1.400399ms,1.4004ms,1.400449ms,1.40045ms,1.400499ms,1.4005ms,1.400549ms,1.40055ms,1.400599ms,1.4006ms,1.400649ms,1.40065ms,1.400699ms,1.4007ms,1.400749ms,1.40075ms,1.400799ms,1.4008ms,1.400849ms,1.40085ms,1.400899ms,1.4009ms,1.400949ms,1.40095ms,1.400999ms,1.401ms,1.401049ms,1.40105ms,1.401099ms,1.4011ms,1.401149ms,1.40115ms,1.401199ms,1.4012ms,1.401249ms,1.40125ms,1.401299ms,1.4013ms,1.401349ms,1.40135ms,1.401399ms,1.4014ms,1.401449ms,1.40145ms,1.401499ms,1.4015ms,1.401549ms,1.40155ms,1.401599ms,1.4016ms,1.401649ms,1.40165ms,1.401699ms,1.4017ms,1.401749ms,1.40175ms,1.401799ms,1.4018ms,1.401849ms,1.40185ms,1.401899ms,1.4019ms,1.401949ms,1.40195ms,1.401999ms,1.402ms,1.402049ms,1.40205ms,1.402099ms,1.4021ms,1.402149ms,1.40215ms,1.402199ms,1.4022ms,1.402249ms,1.40225ms,1.402299ms,1.4023ms,1.402349ms,1.40235ms,1.402399ms,1.4024ms,1.402449ms,1.40245ms,1.402499ms,1.4025ms,1.402549ms,1.40255ms,1.402599ms,1.4026ms,1.402649ms,1.40265ms,1.402699ms,1.4027ms,1.402749ms,1.40275ms,1.402799ms,1.4028ms,1.402849ms,1.40285ms,1.402899ms,1.4029ms,1.402949ms,1.40295ms,1.402999ms,1.403ms,1.403049ms,1.40305ms,1.403099ms,1.4031ms,1.403149ms,1.40315ms,1.403199ms,1.4032ms,1.403249ms,1.40325ms,1.403299ms,1.4033ms,1.403349ms,1.40335ms,1.403399ms,1.4034ms,1.403449ms,1.40345ms,1.403499ms,1.4035ms,1.403549ms,1.40355ms,1.403599ms,1.4036ms,1.403649ms,1.40365ms,1.403699ms,1.4037ms,1.403749ms,1.40375ms,1.403799ms,1.4038ms,1.403849ms,1.40385ms,1.403899ms,1.4039ms,1.403949ms,1.40395ms,1.403999ms,1.404ms,1.404049ms,1.40405ms,1.404099ms,1.4041ms,1.404149ms,1.40415ms,1.404199ms,1.4042ms,1.404249ms,1.40425ms,1.404299ms,1.4043ms,1.404349ms,1.40435ms,1.404399ms,1.4044ms,1.404449ms,1.40445ms,1.404499ms,1.4045ms,1.404549ms,1.40455ms,1.404599ms,1.4046ms,1.404649ms,1.40465ms,1.404699ms,1.4047ms,1.404749ms,1.40475ms,1.404799ms,1.4048ms,1.404849ms,1.40485ms,1.404899ms,1.4049ms,1.404949ms,1.40495ms,1.404999ms,1.405ms,1.405049ms,1.40505ms,1.405099ms,1.4051ms,1.405149ms,1.40515ms,1.405199ms,1.4052ms,1.405249ms,1.40525ms,1.405299ms,1.4053ms,1.405349ms,1.40535ms,1.405399ms,1.4054ms,1.405449ms,1.40545ms,1.405499ms,1.4055ms,1.405549ms,1.40555ms,1.405599ms,1.4056ms,1.405649ms,1.40565ms,1.405699ms,1.4057ms,1.405749ms,1.40575ms,1.405799ms,1.4058ms,1.405849ms,1.40585ms,1.405899ms,1.4059ms,1.405949ms,1.40595ms,1.405999ms,1.406ms,1.406049ms,1.40605ms,1.406099ms,1.4061ms,1.406149ms,1.40615ms,1.406199ms,1.4062ms,1.406249ms,1.40625ms,1.406299ms,1.4063ms,1.406349ms,1.40635ms,1.406399ms,1.4064ms,1.406449ms,1.40645ms,1.406499ms,1.4065ms,1.406549ms,1.40655ms,1.406599ms,1.4066ms,1.406649ms,1.40665ms,1.406699ms,1.4067ms,1.406749ms,1.40675ms,1.406799ms,1.4068ms,1.406849ms,1.40685ms,1.406899ms,1.4069ms,1.406949ms,1.40695ms,1.406999ms,1.407ms,1.407049ms,1.40705ms,1.407099ms,1.4071ms,1.407149ms,1.40715ms,1.407199ms,1.4072ms,1.407249ms,1.40725ms,1.407299ms,1.4073ms,1.407349ms,1.40735ms,1.407399ms,1.4074ms,1.407449ms,1.40745ms,1.407499ms,1.4075ms,1.407549ms,1.40755ms,1.407599ms,1.4076ms,1.407649ms,1.40765ms,1.407699ms,1.4077ms,1.407749ms,1.40775ms,1.407799ms,1.4078ms,1.407849ms,1.40785ms,1.407899ms,1.4079ms,1.407949ms,1.40795ms,1.407999ms,1.408ms,1.408049ms,1.40805ms,1.408099ms,1.4081ms,1.408149ms,1.40815ms,1.408199ms,1.4082ms,1.408249ms,1.40825ms,1.408299ms,1.4083ms,1.408349ms,1.40835ms,1.408399ms,1.4084ms,1.408449ms,1.40845ms,1.408499ms,1.4085ms,1.408549ms,1.40855ms,1.408599ms,1.4086ms,1.408649ms,1.40865ms,1.408699ms,1.4087ms,1.408749ms,1.40875ms,1.408799ms,1.4088ms,1.408849ms,1.40885ms,1.408899ms,1.4089ms,1.408949ms,1.40895ms,1.408999ms,1.409ms,1.409049ms,1.40905ms,1.409099ms,1.4091ms,1.409149ms,1.40915ms,1.409199ms,1.4092ms,1.409249ms,1.40925ms,1.409299ms,1.4093ms,1.409349ms,1.40935ms,1.409399ms,1.4094ms,1.409449ms,1.40945ms,1.409499ms,1.4095ms,1.409549ms,1.40955ms,1.409599ms,1.4096ms,1.409649ms,1.40965ms,1.409699ms,1.4097ms,1.409749ms,1.40975ms,1.409799ms,1.4098ms,1.409849ms,1.40985ms,1.409899ms,1.4099ms,1.409949ms,1.40995ms,1.409999ms,1.41ms,1.410049ms,1.41005ms,1.410099ms,1.4101ms,1.410149ms,1.41015ms,1.410199ms,1.4102ms,1.410249ms,1.41025ms,1.410299ms,1.4103ms,1.410349ms,1.41035ms,1.410399ms,1.4104ms,1.410449ms,1.41045ms,1.410499ms,1.4105ms,1.410549ms,1.41055ms,1.410599ms,1.4106ms,1.410649ms,1.41065ms,1.410699ms,1.4107ms,1.410749ms,1.41075ms,1.410799ms,1.4108ms,1.410849ms,1.41085ms,1.410899ms,1.4109ms,1.410949ms,1.41095ms,1.410999ms,1.411ms,1.411049ms,1.41105ms,1.411099ms,1.4111ms,1.411149ms,1.41115ms,1.411199ms,1.4112ms,1.411249ms,1.41125ms,1.411299ms,1.4113ms,1.411349ms,1.41135ms,1.411399ms,1.4114ms,1.411449ms,1.41145ms,1.411499ms,1.4115ms,1.411549ms,1.41155ms,1.411599ms,1.4116ms,1.411649ms,1.41165ms,1.411699ms,1.4117ms,1.411749ms,1.41175ms,1.411799ms,1.4118ms,1.411849ms,1.41185ms,1.411899ms,1.4119ms,1.411949ms,1.41195ms,1.411999ms,1.412ms,1.412049ms,1.41205ms,1.412099ms,1.4121ms,1.412149ms,1.41215ms,1.412199ms,1.4122ms,1.412249ms,1.41225ms,1.412299ms,1.4123ms,1.412349ms,1.41235ms,1.412399ms,1.4124ms,1.412449ms,1.41245ms,1.412499ms,1.4125ms,1.412549ms,1.41255ms,1.412599ms,1.4126ms,1.412649ms,1.41265ms,1.412699ms,1.4127ms,1.412749ms,1.41275ms,1.412799ms,1.4128ms,1.412849ms,1.41285ms,1.412899ms,1.4129ms,1.412949ms,1.41295ms,1.412999ms,1.413ms,1.413049ms,1.41305ms,1.413099ms,1.4131ms,1.413149ms,1.41315ms,1.413199ms,1.4132ms,1.413249ms,1.41325ms,1.413299ms,1.4133ms,1.413349ms,1.41335ms,1.413399ms,1.4134ms,1.413449ms,1.41345ms,1.413499ms,1.4135ms,1.413549ms,1.41355ms,1.413599ms,1.4136ms,1.413649ms,1.41365ms,1.413699ms,1.4137ms,1.413749ms,1.41375ms,1.413799ms,1.4138ms,1.413849ms,1.41385ms,1.413899ms,1.4139ms,1.413949ms,1.41395ms,1.413999ms,1.414ms,1.414049ms,1.41405ms,1.414099ms,1.4141ms,1.414149ms,1.41415ms,1.414199ms,1.4142ms,1.414249ms,1.41425ms,1.414299ms,1.4143ms,1.414349ms,1.41435ms,1.414399ms,1.4144ms,1.414449ms,1.41445ms,1.414499ms,1.4145ms,1.414549ms,1.41455ms,1.414599ms,1.4146ms,1.414649ms,1.41465ms,1.414699ms,1.4147ms,1.414749ms,1.41475ms,1.414799ms,1.4148ms,1.414849ms,1.41485ms,1.414899ms,1.4149ms,1.414949ms,1.41495ms,1.414999ms,1.415ms,1.415049ms,1.41505ms,1.415099ms,1.4151ms,1.415149ms,1.41515ms,1.415199ms,1.4152ms,1.415249ms,1.41525ms,1.415299ms,1.4153ms,1.415349ms,1.41535ms,1.415399ms,1.4154ms,1.415449ms,1.41545ms,1.415499ms,1.4155ms,1.415549ms,1.41555ms,1.415599ms,1.4156ms,1.415649ms,1.41565ms,1.415699ms,1.4157ms,1.415749ms,1.41575ms,1.415799ms,1.4158ms,1.415849ms,1.41585ms,1.415899ms,1.4159ms,1.415949ms,1.41595ms,1.415999ms,1.416ms,1.416049ms,1.41605ms,1.416099ms,1.4161ms,1.416149ms,1.41615ms,1.416199ms,1.4162ms,1.416249ms,1.41625ms,1.416299ms,1.4163ms,1.416349ms,1.41635ms,1.416399ms,1.4164ms,1.416449ms,1.41645ms,1.416499ms,1.4165ms,1.416549ms,1.41655ms,1.416599ms,1.4166ms,1.416649ms,1.41665ms,1.416699ms,1.4167ms,1.416749ms,1.41675ms,1.416799ms,1.4168ms,1.416849ms,1.41685ms,1.416899ms,1.4169ms,1.416949ms,1.41695ms,1.416999ms,1.417ms,1.417049ms,1.41705ms,1.417099ms,1.4171ms,1.417149ms,1.41715ms,1.417199ms,1.4172ms,1.417249ms,1.41725ms,1.417299ms,1.4173ms,1.417349ms,1.41735ms,1.417399ms,1.4174ms,1.417449ms,1.41745ms,1.417499ms,1.4175ms,1.417549ms,1.41755ms,1.417599ms,1.4176ms,1.417649ms,1.41765ms,1.417699ms,1.4177ms,1.417749ms,1.41775ms,1.417799ms,1.4178ms,1.417849ms,1.41785ms,1.417899ms,1.4179ms,1.417949ms,1.41795ms,1.417999ms,1.418ms,1.418049ms,1.41805ms,1.418099ms,1.4181ms,1.418149ms,1.41815ms,1.418199ms,1.4182ms,1.418249ms,1.41825ms,1.418299ms,1.4183ms,1.418349ms,1.41835ms,1.418399ms,1.4184ms,1.418449ms,1.41845ms,1.418499ms,1.4185ms,1.418549ms,1.41855ms,1.418599ms,1.4186ms,1.418649ms,1.41865ms,1.418699ms,1.4187ms,1.418749ms,1.41875ms,1.418799ms,1.4188ms,1.418849ms,1.41885ms,1.418899ms,1.4189ms,1.418949ms,1.41895ms,1.418999ms,1.419ms,1.419049ms,1.41905ms,1.419099ms,1.4191ms,1.419149ms,1.41915ms,1.419199ms,1.4192ms,1.419249ms,1.41925ms,1.419299ms,1.4193ms,1.419349ms,1.41935ms,1.419399ms,1.4194ms,1.419449ms,1.41945ms,1.419499ms,1.4195ms,1.419549ms,1.41955ms,1.419599ms,1.4196ms,1.419649ms,1.41965ms,1.419699ms,1.4197ms,1.419749ms,1.41975ms,1.419799ms,1.4198ms,1.419849ms,1.41985ms,1.419899ms,1.4199ms,1.419949ms,1.41995ms,1.419999ms,1.42ms,1.420049ms,1.42005ms,1.420099ms,1.4201ms,1.420149ms,1.42015ms,1.420199ms,1.4202ms,1.420249ms,1.42025ms,1.420299ms,1.4203ms,1.420349ms,1.42035ms,1.420399ms,1.4204ms,1.420449ms,1.42045ms,1.420499ms,1.4205ms,1.420549ms,1.42055ms,1.420599ms,1.4206ms,1.420649ms,1.42065ms,1.420699ms,1.4207ms,1.420749ms,1.42075ms,1.420799ms,1.4208ms,1.420849ms,1.42085ms,1.420899ms,1.4209ms,1.420949ms,1.42095ms,1.420999ms,1.421ms,1.421049ms,1.42105ms,1.421099ms,1.4211ms,1.421149ms,1.42115ms,1.421199ms,1.4212ms,1.421249ms,1.42125ms,1.421299ms,1.4213ms,1.421349ms,1.42135ms,1.421399ms,1.4214ms,1.421449ms,1.42145ms,1.421499ms,1.4215ms,1.421549ms,1.42155ms,1.421599ms,1.4216ms,1.421649ms,1.42165ms,1.421699ms,1.4217ms,1.421749ms,1.42175ms,1.421799ms,1.4218ms,1.421849ms,1.42185ms,1.421899ms,1.4219ms,1.421949ms,1.42195ms,1.421999ms,1.422ms,1.422049ms,1.42205ms,1.422099ms,1.4221ms,1.422149ms,1.42215ms,1.422199ms,1.4222ms,1.422249ms,1.42225ms,1.422299ms,1.4223ms,1.422349ms,1.42235ms,1.422399ms,1.4224ms,1.422449ms,1.42245ms,1.422499ms,1.4225ms,1.422549ms,1.42255ms,1.422599ms,1.4226ms,1.422649ms,1.42265ms,1.422699ms,1.4227ms,1.422749ms,1.42275ms,1.422799ms,1.4228ms,1.422849ms,1.42285ms,1.422899ms,1.4229ms,1.422949ms,1.42295ms,1.422999ms,1.423ms,1.423049ms,1.42305ms,1.423099ms,1.4231ms,1.423149ms,1.42315ms,1.423199ms,1.4232ms,1.423249ms,1.42325ms,1.423299ms,1.4233ms,1.423349ms,1.42335ms,1.423399ms,1.4234ms,1.423449ms,1.42345ms,1.423499ms,1.4235ms,1.423549ms,1.42355ms,1.423599ms,1.4236ms,1.423649ms,1.42365ms,1.423699ms,1.4237ms,1.423749ms,1.42375ms,1.423799ms,1.4238ms,1.423849ms,1.42385ms,1.423899ms,1.4239ms,1.423949ms,1.42395ms,1.423999ms,1.424ms,1.424049ms,1.42405ms,1.424099ms,1.4241ms,1.424149ms,1.42415ms,1.424199ms,1.4242ms,1.424249ms,1.42425ms,1.424299ms,1.4243ms,1.424349ms,1.42435ms,1.424399ms,1.4244ms,1.424449ms,1.42445ms,1.424499ms,1.4245ms,1.424549ms,1.42455ms,1.424599ms,1.4246ms,1.424649ms,1.42465ms,1.424699ms,1.4247ms,1.424749ms,1.42475ms,1.424799ms,1.4248ms,1.424849ms,1.42485ms,1.424899ms,1.4249ms,1.424949ms,1.42495ms,1.424999ms,1.425ms,1.425049ms,1.42505ms,1.425099ms,1.4251ms,1.425149ms,1.42515ms,1.425199ms,1.4252ms,1.425249ms,1.42525ms,1.425299ms,1.4253ms,1.425349ms,1.42535ms,1.425399ms,1.4254ms,1.425449ms,1.42545ms,1.425499ms,1.4255ms,1.425549ms,1.42555ms,1.425599ms,1.4256ms,1.425649ms,1.42565ms,1.425699ms,1.4257ms,1.425749ms,1.42575ms,1.425799ms,1.4258ms,1.425849ms,1.42585ms,1.425899ms,1.4259ms,1.425949ms,1.42595ms,1.425999ms,1.426ms,1.426049ms,1.42605ms,1.426099ms,1.4261ms,1.426149ms,1.42615ms,1.426199ms,1.4262ms,1.426249ms,1.42625ms,1.426299ms,1.4263ms,1.426349ms,1.42635ms,1.426399ms,1.4264ms,1.426449ms,1.42645ms,1.426499ms,1.4265ms,1.426549ms,1.42655ms,1.426599ms,1.4266ms,1.426649ms,1.42665ms,1.426699ms,1.4267ms,1.426749ms,1.42675ms,1.426799ms,1.4268ms,1.426849ms,1.42685ms,1.426899ms,1.4269ms,1.426949ms,1.42695ms,1.426999ms,1.427ms,1.427049ms,1.42705ms,1.427099ms,1.4271ms,1.427149ms,1.42715ms,1.427199ms,1.4272ms,1.427249ms,1.42725ms,1.427299ms,1.4273ms,1.427349ms,1.42735ms,1.427399ms,1.4274ms,1.427449ms,1.42745ms,1.427499ms,1.4275ms,1.427549ms,1.42755ms,1.427599ms,1.4276ms,1.427649ms,1.42765ms,1.427699ms,1.4277ms,1.427749ms,1.42775ms,1.427799ms,1.4278ms,1.427849ms,1.42785ms,1.427899ms,1.4279ms,1.427949ms,1.42795ms,1.427999ms,1.428ms,1.428049ms,1.42805ms,1.428099ms,1.4281ms,1.428149ms,1.42815ms,1.428199ms,1.4282ms,1.428249ms,1.42825ms,1.428299ms,1.4283ms,1.428349ms,1.42835ms,1.428399ms,1.4284ms,1.428449ms,1.42845ms,1.428499ms,1.4285ms,1.428549ms,1.42855ms,1.428599ms,1.4286ms,1.428649ms,1.42865ms,1.428699ms,1.4287ms,1.428749ms,1.42875ms,1.428799ms,1.4288ms,1.428849ms,1.42885ms,1.428899ms,1.4289ms,1.428949ms,1.42895ms,1.428999ms,1.429ms,1.429049ms,1.42905ms,1.429099ms,1.4291ms,1.429149ms,1.42915ms,1.429199ms,1.4292ms,1.429249ms,1.42925ms,1.429299ms,1.4293ms,1.429349ms,1.42935ms,1.429399ms,1.4294ms,1.429449ms,1.42945ms,1.429499ms,1.4295ms,1.429549ms,1.42955ms,1.429599ms,1.4296ms,1.429649ms,1.42965ms,1.429699ms,1.4297ms,1.429749ms,1.42975ms,1.429799ms,1.4298ms,1.429849ms,1.42985ms,1.429899ms,1.4299ms,1.429949ms,1.42995ms,1.429999ms,1.43ms,1.430049ms,1.43005ms,1.430099ms,1.4301ms,1.430149ms,1.43015ms,1.430199ms,1.4302ms,1.430249ms,1.43025ms,1.430299ms,1.4303ms,1.430349ms,1.43035ms,1.430399ms,1.4304ms,1.430449ms,1.43045ms,1.430499ms,1.4305ms,1.430549ms,1.43055ms,1.430599ms,1.4306ms,1.430649ms,1.43065ms,1.430699ms,1.4307ms,1.430749ms,1.43075ms,1.430799ms,1.4308ms,1.430849ms,1.43085ms,1.430899ms,1.4309ms,1.430949ms,1.43095ms,1.430999ms,1.431ms,1.431049ms,1.43105ms,1.431099ms,1.4311ms,1.431149ms,1.43115ms,1.431199ms,1.4312ms,1.431249ms,1.43125ms,1.431299ms,1.4313ms,1.431349ms,1.43135ms,1.431399ms,1.4314ms,1.431449ms,1.43145ms,1.431499ms,1.4315ms,1.431549ms,1.43155ms,1.431599ms,1.4316ms,1.431649ms,1.43165ms,1.431699ms,1.4317ms,1.431749ms,1.43175ms,1.431799ms,1.4318ms,1.431849ms,1.43185ms,1.431899ms,1.4319ms,1.431949ms,1.43195ms,1.431999ms,1.432ms,1.432049ms,1.43205ms,1.432099ms,1.4321ms,1.432149ms,1.43215ms,1.432199ms,1.4322ms,1.432249ms,1.43225ms,1.432299ms,1.4323ms,1.432349ms,1.43235ms,1.432399ms,1.4324ms,1.432449ms,1.43245ms,1.432499ms,1.4325ms,1.432549ms,1.43255ms,1.432599ms,1.4326ms,1.432649ms,1.43265ms,1.432699ms,1.4327ms,1.432749ms,1.43275ms,1.432799ms,1.4328ms,1.432849ms,1.43285ms,1.432899ms,1.4329ms,1.432949ms,1.43295ms,1.432999ms,1.433ms,1.433049ms,1.43305ms,1.433099ms,1.4331ms,1.433149ms,1.43315ms,1.433199ms,1.4332ms,1.433249ms,1.43325ms,1.433299ms,1.4333ms,1.433349ms,1.43335ms,1.433399ms,1.4334ms,1.433449ms,1.43345ms,1.433499ms,1.4335ms,1.433549ms,1.43355ms,1.433599ms,1.4336ms,1.433649ms,1.43365ms,1.433699ms,1.4337ms,1.433749ms,1.43375ms,1.433799ms,1.4338ms,1.433849ms,1.43385ms,1.433899ms,1.4339ms,1.433949ms,1.43395ms,1.433999ms,1.434ms,1.434049ms,1.43405ms,1.434099ms,1.4341ms,1.434149ms,1.43415ms,1.434199ms,1.4342ms,1.434249ms,1.43425ms,1.434299ms,1.4343ms,1.434349ms,1.43435ms,1.434399ms,1.4344ms,1.434449ms,1.43445ms,1.434499ms,1.4345ms,1.434549ms,1.43455ms,1.434599ms,1.4346ms,1.434649ms,1.43465ms,1.434699ms,1.4347ms,1.434749ms,1.43475ms,1.434799ms,1.4348ms,1.434849ms,1.43485ms,1.434899ms,1.4349ms,1.434949ms,1.43495ms,1.434999ms,1.435ms,1.435049ms,1.43505ms,1.435099ms,1.4351ms,1.435149ms,1.43515ms,1.435199ms,1.4352ms,1.435249ms,1.43525ms,1.435299ms,1.4353ms,1.435349ms,1.43535ms,1.435399ms,1.4354ms,1.435449ms,1.43545ms,1.435499ms,1.4355ms,1.435549ms,1.43555ms,1.435599ms,1.4356ms,1.435649ms,1.43565ms,1.435699ms,1.4357ms,1.435749ms,1.43575ms,1.435799ms,1.4358ms,1.435849ms,1.43585ms,1.435899ms,1.4359ms,1.435949ms,1.43595ms,1.435999ms,1.436ms,1.436049ms,1.43605ms,1.436099ms,1.4361ms,1.436149ms,1.43615ms,1.436199ms,1.4362ms,1.436249ms,1.43625ms,1.436299ms,1.4363ms,1.436349ms,1.43635ms,1.436399ms,1.4364ms,1.436449ms,1.43645ms,1.436499ms,1.4365ms,1.436549ms,1.43655ms,1.436599ms,1.4366ms,1.436649ms,1.43665ms,1.436699ms,1.4367ms,1.436749ms,1.43675ms,1.436799ms,1.4368ms,1.436849ms,1.43685ms,1.436899ms,1.4369ms,1.436949ms,1.43695ms,1.436999ms,1.437ms,1.437049ms,1.43705ms,1.437099ms,1.4371ms,1.437149ms,1.43715ms,1.437199ms,1.4372ms,1.437249ms,1.43725ms,1.437299ms,1.4373ms,1.437349ms,1.43735ms,1.437399ms,1.4374ms,1.437449ms,1.43745ms,1.437499ms,1.4375ms,1.437549ms,1.43755ms,1.437599ms,1.4376ms,1.437649ms,1.43765ms,1.437699ms,1.4377ms,1.437749ms,1.43775ms,1.437799ms,1.4378ms,1.437849ms,1.43785ms,1.437899ms,1.4379ms,1.437949ms,1.43795ms,1.437999ms,1.438ms,1.438049ms,1.43805ms,1.438099ms,1.4381ms,1.438149ms,1.43815ms,1.438199ms,1.4382ms,1.438249ms,1.43825ms,1.438299ms,1.4383ms,1.438349ms,1.43835ms,1.438399ms,1.4384ms,1.438449ms,1.43845ms,1.438499ms,1.4385ms,1.438549ms,1.43855ms,1.438599ms,1.4386ms,1.438649ms,1.43865ms,1.438699ms,1.4387ms,1.438749ms,1.43875ms,1.438799ms,1.4388ms,1.438849ms,1.43885ms,1.438899ms,1.4389ms,1.438949ms,1.43895ms,1.438999ms,1.439ms,1.439049ms,1.43905ms,1.439099ms,1.4391ms,1.439149ms,1.43915ms,1.439199ms,1.4392ms,1.439249ms,1.43925ms,1.439299ms,1.4393ms,1.439349ms,1.43935ms,1.439399ms,1.4394ms,1.439449ms,1.43945ms,1.439499ms,1.4395ms,1.439549ms,1.43955ms,1.439599ms,1.4396ms,1.439649ms,1.43965ms,1.439699ms,1.4397ms,1.439749ms,1.43975ms,1.439799ms,1.4398ms,1.439849ms,1.43985ms,1.439899ms,1.4399ms,1.439949ms,1.43995ms,1.439999ms,1.44ms,1.440049ms,1.44005ms,1.440099ms,1.4401ms,1.440149ms,1.44015ms,1.440199ms,1.4402ms,1.440249ms,1.44025ms,1.440299ms,1.4403ms,1.440349ms,1.44035ms,1.440399ms,1.4404ms,1.440449ms,1.44045ms,1.440499ms,1.4405ms,1.440549ms,1.44055ms,1.440599ms,1.4406ms,1.440649ms,1.44065ms,1.440699ms,1.4407ms,1.440749ms,1.44075ms,1.440799ms,1.4408ms,1.440849ms,1.44085ms,1.440899ms,1.4409ms,1.440949ms,1.44095ms,1.440999ms,1.441ms,1.441049ms,1.44105ms,1.441099ms,1.4411ms,1.441149ms,1.44115ms,1.441199ms,1.4412ms,1.441249ms,1.44125ms,1.441299ms,1.4413ms,1.441349ms,1.44135ms,1.441399ms,1.4414ms,1.441449ms,1.44145ms,1.441499ms,1.4415ms,1.441549ms,1.44155ms,1.441599ms,1.4416ms,1.441649ms,1.44165ms,1.441699ms,1.4417ms,1.441749ms,1.44175ms,1.441799ms,1.4418ms,1.441849ms,1.44185ms,1.441899ms,1.4419ms,1.441949ms,1.44195ms,1.441999ms,1.442ms,1.442049ms,1.44205ms,1.442099ms,1.4421ms,1.442149ms,1.44215ms,1.442199ms,1.4422ms,1.442249ms,1.44225ms,1.442299ms,1.4423ms,1.442349ms,1.44235ms,1.442399ms,1.4424ms,1.442449ms,1.44245ms,1.442499ms,1.4425ms,1.442549ms,1.44255ms,1.442599ms,1.4426ms,1.442649ms,1.44265ms,1.442699ms,1.4427ms,1.442749ms,1.44275ms,1.442799ms,1.4428ms,1.442849ms,1.44285ms,1.442899ms,1.4429ms,1.442949ms,1.44295ms,1.442999ms,1.443ms,1.443049ms,1.44305ms,1.443099ms,1.4431ms,1.443149ms,1.44315ms,1.443199ms,1.4432ms,1.443249ms,1.44325ms,1.443299ms,1.4433ms,1.443349ms,1.44335ms,1.443399ms,1.4434ms,1.443449ms,1.44345ms,1.443499ms,1.4435ms,1.443549ms,1.44355ms,1.443599ms,1.4436ms,1.443649ms,1.44365ms,1.443699ms,1.4437ms,1.443749ms,1.44375ms,1.443799ms,1.4438ms,1.443849ms,1.44385ms,1.443899ms,1.4439ms,1.443949ms,1.44395ms,1.443999ms,1.444ms,1.444049ms,1.44405ms,1.444099ms,1.4441ms,1.444149ms,1.44415ms,1.444199ms,1.4442ms,1.444249ms,1.44425ms,1.444299ms,1.4443ms,1.444349ms,1.44435ms,1.444399ms,1.4444ms,1.444449ms,1.44445ms,1.444499ms,1.4445ms,1.444549ms,1.44455ms,1.444599ms,1.4446ms,1.444649ms,1.44465ms,1.444699ms,1.4447ms,1.444749ms,1.44475ms,1.444799ms,1.4448ms,1.444849ms,1.44485ms,1.444899ms,1.4449ms,1.444949ms,1.44495ms,1.444999ms,1.445ms,1.445049ms,1.44505ms,1.445099ms,1.4451ms,1.445149ms,1.44515ms,1.445199ms,1.4452ms,1.445249ms,1.44525ms,1.445299ms,1.4453ms,1.445349ms,1.44535ms,1.445399ms,1.4454ms,1.445449ms,1.44545ms,1.445499ms,1.4455ms,1.445549ms,1.44555ms,1.445599ms,1.4456ms,1.445649ms,1.44565ms,1.445699ms,1.4457ms,1.445749ms,1.44575ms,1.445799ms,1.4458ms,1.445849ms,1.44585ms,1.445899ms,1.4459ms,1.445949ms,1.44595ms,1.445999ms,1.446ms,1.446049ms,1.44605ms,1.446099ms,1.4461ms,1.446149ms,1.44615ms,1.446199ms,1.4462ms,1.446249ms,1.44625ms,1.446299ms,1.4463ms,1.446349ms,1.44635ms,1.446399ms,1.4464ms,1.446449ms,1.44645ms,1.446499ms,1.4465ms,1.446549ms,1.44655ms,1.446599ms,1.4466ms,1.446649ms,1.44665ms,1.446699ms,1.4467ms,1.446749ms,1.44675ms,1.446799ms,1.4468ms,1.446849ms,1.44685ms,1.446899ms,1.4469ms,1.446949ms,1.44695ms,1.446999ms,1.447ms,1.447049ms,1.44705ms,1.447099ms,1.4471ms,1.447149ms,1.44715ms,1.447199ms,1.4472ms,1.447249ms,1.44725ms,1.447299ms,1.4473ms,1.447349ms,1.44735ms,1.447399ms,1.4474ms,1.447449ms,1.44745ms,1.447499ms,1.4475ms,1.447549ms,1.44755ms,1.447599ms,1.4476ms,1.447649ms,1.44765ms,1.447699ms,1.4477ms,1.447749ms,1.44775ms,1.447799ms,1.4478ms,1.447849ms,1.44785ms,1.447899ms,1.4479ms,1.447949ms,1.44795ms,1.447999ms,1.448ms,1.448049ms,1.44805ms,1.448099ms,1.4481ms,1.448149ms,1.44815ms,1.448199ms,1.4482ms,1.448249ms,1.44825ms,1.448299ms,1.4483ms,1.448349ms,1.44835ms,1.448399ms,1.4484ms,1.448449ms,1.44845ms,1.448499ms,1.4485ms,1.448549ms,1.44855ms,1.448599ms,1.4486ms,1.448649ms,1.44865ms,1.448699ms,1.4487ms,1.448749ms,1.44875ms,1.448799ms,1.4488ms,1.448849ms,1.44885ms,1.448899ms,1.4489ms,1.448949ms,1.44895ms,1.448999ms,1.449ms,1.449049ms,1.44905ms,1.449099ms,1.4491ms,1.449149ms,1.44915ms,1.449199ms,1.4492ms,1.449249ms,1.44925ms,1.449299ms,1.4493ms,1.449349ms,1.44935ms,1.449399ms,1.4494ms,1.449449ms,1.44945ms,1.449499ms,1.4495ms,1.449549ms,1.44955ms,1.449599ms,1.4496ms,1.449649ms,1.44965ms,1.449699ms,1.4497ms,1.449749ms,1.44975ms,1.449799ms,1.4498ms,1.449849ms,1.44985ms,1.449899ms,1.4499ms,1.449949ms,1.44995ms,1.449999ms,1.45ms,1.450049ms,1.45005ms,1.450099ms,1.4501ms,1.450149ms,1.45015ms,1.450199ms,1.4502ms,1.450249ms,1.45025ms,1.450299ms,1.4503ms,1.450349ms,1.45035ms,1.450399ms,1.4504ms,1.450449ms,1.45045ms,1.450499ms,1.4505ms,1.450549ms,1.45055ms,1.450599ms,1.4506ms,1.450649ms,1.45065ms,1.450699ms,1.4507ms,1.450749ms,1.45075ms,1.450799ms,1.4508ms,1.450849ms,1.45085ms,1.450899ms,1.4509ms,1.450949ms,1.45095ms,1.450999ms,1.451ms,1.451049ms,1.45105ms,1.451099ms,1.4511ms,1.451149ms,1.45115ms,1.451199ms,1.4512ms,1.451249ms,1.45125ms,1.451299ms,1.4513ms,1.451349ms,1.45135ms,1.451399ms,1.4514ms,1.451449ms,1.45145ms,1.451499ms,1.4515ms,1.451549ms,1.45155ms,1.451599ms,1.4516ms,1.451649ms,1.45165ms,1.451699ms,1.4517ms,1.451749ms,1.45175ms,1.451799ms,1.4518ms,1.451849ms,1.45185ms,1.451899ms,1.4519ms,1.451949ms,1.45195ms,1.451999ms,1.452ms,1.452049ms,1.45205ms,1.452099ms,1.4521ms,1.452149ms,1.45215ms,1.452199ms,1.4522ms,1.452249ms,1.45225ms,1.452299ms,1.4523ms,1.452349ms,1.45235ms,1.452399ms,1.4524ms,1.452449ms,1.45245ms,1.452499ms,1.4525ms,1.452549ms,1.45255ms,1.452599ms,1.4526ms,1.452649ms,1.45265ms,1.452699ms,1.4527ms,1.452749ms,1.45275ms,1.452799ms,1.4528ms,1.452849ms,1.45285ms,1.452899ms,1.4529ms,1.452949ms,1.45295ms,1.452999ms,1.453ms,1.453049ms,1.45305ms,1.453099ms,1.4531ms,1.453149ms,1.45315ms,1.453199ms,1.4532ms,1.453249ms,1.45325ms,1.453299ms,1.4533ms,1.453349ms,1.45335ms,1.453399ms,1.4534ms,1.453449ms,1.45345ms,1.453499ms,1.4535ms,1.453549ms,1.45355ms,1.453599ms,1.4536ms,1.453649ms,1.45365ms,1.453699ms,1.4537ms,1.453749ms,1.45375ms,1.453799ms,1.4538ms,1.453849ms,1.45385ms,1.453899ms,1.4539ms,1.453949ms,1.45395ms,1.453999ms,1.454ms,1.454049ms,1.45405ms,1.454099ms,1.4541ms,1.454149ms,1.45415ms,1.454199ms,1.4542ms,1.454249ms,1.45425ms,1.454299ms,1.4543ms,1.454349ms,1.45435ms,1.454399ms,1.4544ms,1.454449ms,1.45445ms,1.454499ms,1.4545ms,1.454549ms,1.45455ms,1.454599ms,1.4546ms,1.454649ms,1.45465ms,1.454699ms,1.4547ms,1.454749ms,1.45475ms,1.454799ms,1.4548ms,1.454849ms,1.45485ms,1.454899ms,1.4549ms,1.454949ms,1.45495ms,1.454999ms,1.455ms,1.455049ms,1.45505ms,1.455099ms,1.4551ms,1.455149ms,1.45515ms,1.455199ms,1.4552ms,1.455249ms,1.45525ms,1.455299ms,1.4553ms,1.455349ms,1.45535ms,1.455399ms,1.4554ms,1.455449ms,1.45545ms,1.455499ms,1.4555ms,1.455549ms,1.45555ms,1.455599ms,1.4556ms,1.455649ms,1.45565ms,1.455699ms,1.4557ms,1.455749ms,1.45575ms,1.455799ms,1.4558ms,1.455849ms,1.45585ms,1.455899ms,1.4559ms,1.455949ms,1.45595ms,1.455999ms,1.456ms,1.456049ms,1.45605ms,1.456099ms,1.4561ms,1.456149ms,1.45615ms,1.456199ms,1.4562ms,1.456249ms,1.45625ms,1.456299ms,1.4563ms,1.456349ms,1.45635ms,1.456399ms,1.4564ms,1.456449ms,1.45645ms,1.456499ms,1.4565ms,1.456549ms,1.45655ms,1.456599ms,1.4566ms,1.456649ms,1.45665ms,1.456699ms,1.4567ms,1.456749ms,1.45675ms,1.456799ms,1.4568ms,1.456849ms,1.45685ms,1.456899ms,1.4569ms,1.456949ms,1.45695ms,1.456999ms,1.457ms,1.457049ms,1.45705ms,1.457099ms,1.4571ms,1.457149ms,1.45715ms,1.457199ms,1.4572ms,1.457249ms,1.45725ms,1.457299ms,1.4573ms,1.457349ms,1.45735ms,1.457399ms,1.4574ms,1.457449ms,1.45745ms,1.457499ms,1.4575ms,1.457549ms,1.45755ms,1.457599ms,1.4576ms,1.457649ms,1.45765ms,1.457699ms,1.4577ms,1.457749ms,1.45775ms,1.457799ms,1.4578ms,1.457849ms,1.45785ms,1.457899ms,1.4579ms,1.457949ms,1.45795ms,1.457999ms,1.458ms,1.458049ms,1.45805ms,1.458099ms,1.4581ms,1.458149ms,1.45815ms,1.458199ms,1.4582ms,1.458249ms,1.45825ms,1.458299ms,1.4583ms,1.458349ms,1.45835ms,1.458399ms,1.4584ms,1.458449ms,1.45845ms,1.458499ms,1.4585ms,1.458549ms,1.45855ms,1.458599ms,1.4586ms,1.458649ms,1.45865ms,1.458699ms,1.4587ms,1.458749ms,1.45875ms,1.458799ms,1.4588ms,1.458849ms,1.45885ms,1.458899ms,1.4589ms,1.458949ms,1.45895ms,1.458999ms,1.459ms,1.459049ms,1.45905ms,1.459099ms,1.4591ms,1.459149ms,1.45915ms,1.459199ms,1.4592ms,1.459249ms,1.45925ms,1.459299ms,1.4593ms,1.459349ms,1.45935ms,1.459399ms,1.4594ms,1.459449ms,1.45945ms,1.459499ms,1.4595ms,1.459549ms,1.45955ms,1.459599ms,1.4596ms,1.459649ms,1.45965ms,1.459699ms,1.4597ms,1.459749ms,1.45975ms,1.459799ms,1.4598ms,1.459849ms,1.45985ms,1.459899ms,1.4599ms,1.459949ms,1.45995ms,1.459999ms,1.46ms,1.460049ms,1.46005ms,1.460099ms,1.4601ms,1.460149ms,1.46015ms,1.460199ms,1.4602ms,1.460249ms,1.46025ms,1.460299ms,1.4603ms,1.460349ms,1.46035ms,1.460399ms,1.4604ms,1.460449ms,1.46045ms,1.460499ms,1.4605ms,1.460549ms,1.46055ms,1.460599ms,1.4606ms,1.460649ms,1.46065ms,1.460699ms,1.4607ms,1.460749ms,1.46075ms,1.460799ms,1.4608ms,1.460849ms,1.46085ms,1.460899ms,1.4609ms,1.460949ms,1.46095ms,1.460999ms,1.461ms,1.461049ms,1.46105ms,1.461099ms,1.4611ms,1.461149ms,1.46115ms,1.461199ms,1.4612ms,1.461249ms,1.46125ms,1.461299ms,1.4613ms,1.461349ms,1.46135ms,1.461399ms,1.4614ms,1.461449ms,1.46145ms,1.461499ms,1.4615ms,1.461549ms,1.46155ms,1.461599ms,1.4616ms,1.461649ms,1.46165ms,1.461699ms,1.4617ms,1.461749ms,1.46175ms,1.461799ms,1.4618ms,1.461849ms,1.46185ms,1.461899ms,1.4619ms,1.461949ms,1.46195ms,1.461999ms,1.462ms,1.462049ms,1.46205ms,1.462099ms,1.4621ms,1.462149ms,1.46215ms,1.462199ms,1.4622ms,1.462249ms,1.46225ms,1.462299ms,1.4623ms,1.462349ms,1.46235ms,1.462399ms,1.4624ms,1.462449ms,1.46245ms,1.462499ms,1.4625ms,1.462549ms,1.46255ms,1.462599ms,1.4626ms,1.462649ms,1.46265ms,1.462699ms,1.4627ms,1.462749ms,1.46275ms,1.462799ms,1.4628ms,1.462849ms,1.46285ms,1.462899ms,1.4629ms,1.462949ms,1.46295ms,1.462999ms,1.463ms,1.463049ms,1.46305ms,1.463099ms,1.4631ms,1.463149ms,1.46315ms,1.463199ms,1.4632ms,1.463249ms,1.46325ms,1.463299ms,1.4633ms,1.463349ms,1.46335ms,1.463399ms,1.4634ms,1.463449ms,1.46345ms,1.463499ms,1.4635ms,1.463549ms,1.46355ms,1.463599ms,1.4636ms,1.463649ms,1.46365ms,1.463699ms,1.4637ms,1.463749ms,1.46375ms,1.463799ms,1.4638ms,1.463849ms,1.46385ms,1.463899ms,1.4639ms,1.463949ms,1.46395ms,1.463999ms,1.464ms,1.464049ms,1.46405ms,1.464099ms,1.4641ms,1.464149ms,1.46415ms,1.464199ms,1.4642ms,1.464249ms,1.46425ms,1.464299ms,1.4643ms,1.464349ms,1.46435ms,1.464399ms,1.4644ms,1.464449ms,1.46445ms,1.464499ms,1.4645ms,1.464549ms,1.46455ms,1.464599ms,1.4646ms,1.464649ms,1.46465ms,1.464699ms,1.4647ms,1.464749ms,1.46475ms,1.464799ms,1.4648ms,1.464849ms,1.46485ms,1.464899ms,1.4649ms,1.464949ms,1.46495ms,1.464999ms,1.465ms,1.465049ms,1.46505ms,1.465099ms,1.4651ms,1.465149ms,1.46515ms,1.465199ms,1.4652ms,1.465249ms,1.46525ms,1.465299ms,1.4653ms,1.465349ms,1.46535ms,1.465399ms,1.4654ms,1.465449ms,1.46545ms,1.465499ms,1.4655ms,1.465549ms,1.46555ms,1.465599ms,1.4656ms,1.465649ms,1.46565ms,1.465699ms,1.4657ms,1.465749ms,1.46575ms,1.465799ms,1.4658ms,1.465849ms,1.46585ms,1.465899ms,1.4659ms,1.465949ms,1.46595ms,1.465999ms,1.466ms,1.466049ms,1.46605ms,1.466099ms,1.4661ms,1.466149ms,1.46615ms,1.466199ms,1.4662ms,1.466249ms,1.46625ms,1.466299ms,1.4663ms,1.466349ms,1.46635ms,1.466399ms,1.4664ms,1.466449ms,1.46645ms,1.466499ms,1.4665ms,1.466549ms,1.46655ms,1.466599ms,1.4666ms,1.466649ms,1.46665ms,1.466699ms,1.4667ms,1.466749ms,1.46675ms,1.466799ms,1.4668ms,1.466849ms,1.46685ms,1.466899ms,1.4669ms,1.466949ms,1.46695ms,1.466999ms,1.467ms,1.467049ms,1.46705ms,1.467099ms,1.4671ms,1.467149ms,1.46715ms,1.467199ms,1.4672ms,1.467249ms,1.46725ms,1.467299ms,1.4673ms,1.467349ms,1.46735ms,1.467399ms,1.4674ms,1.467449ms,1.46745ms,1.467499ms,1.4675ms,1.467549ms,1.46755ms,1.467599ms,1.4676ms,1.467649ms,1.46765ms,1.467699ms,1.4677ms,1.467749ms,1.46775ms,1.467799ms,1.4678ms,1.467849ms,1.46785ms,1.467899ms,1.4679ms,1.467949ms,1.46795ms,1.467999ms,1.468ms,1.468049ms,1.46805ms,1.468099ms,1.4681ms,1.468149ms,1.46815ms,1.468199ms,1.4682ms,1.468249ms,1.46825ms,1.468299ms,1.4683ms,1.468349ms,1.46835ms,1.468399ms,1.4684ms,1.468449ms,1.46845ms,1.468499ms,1.4685ms,1.468549ms,1.46855ms,1.468599ms,1.4686ms,1.468649ms,1.46865ms,1.468699ms,1.4687ms,1.468749ms,1.46875ms,1.468799ms,1.4688ms,1.468849ms,1.46885ms,1.468899ms,1.4689ms,1.468949ms,1.46895ms,1.468999ms,1.469ms,1.469049ms,1.46905ms,1.469099ms,1.4691ms,1.469149ms,1.46915ms,1.469199ms,1.4692ms,1.469249ms,1.46925ms,1.469299ms,1.4693ms,1.469349ms,1.46935ms,1.469399ms,1.4694ms,1.469449ms,1.46945ms,1.469499ms,1.4695ms,1.469549ms,1.46955ms,1.469599ms,1.4696ms,1.469649ms,1.46965ms,1.469699ms,1.4697ms,1.469749ms,1.46975ms,1.469799ms,1.4698ms,1.469849ms,1.46985ms,1.469899ms,1.4699ms,1.469949ms,1.46995ms,1.469999ms,1.47ms,1.470049ms,1.47005ms,1.470099ms,1.4701ms,1.470149ms,1.47015ms,1.470199ms,1.4702ms,1.470249ms,1.47025ms,1.470299ms,1.4703ms,1.470349ms,1.47035ms,1.470399ms,1.4704ms,1.470449ms,1.47045ms,1.470499ms,1.4705ms,1.470549ms,1.47055ms,1.470599ms,1.4706ms,1.470649ms,1.47065ms,1.470699ms,1.4707ms,1.470749ms,1.47075ms,1.470799ms,1.4708ms,1.470849ms,1.47085ms,1.470899ms,1.4709ms,1.470949ms,1.47095ms,1.470999ms,1.471ms,1.471049ms,1.47105ms,1.471099ms,1.4711ms,1.471149ms,1.47115ms,1.471199ms,1.4712ms,1.471249ms,1.47125ms,1.471299ms,1.4713ms,1.471349ms,1.47135ms,1.471399ms,1.4714ms,1.471449ms,1.47145ms,1.471499ms,1.4715ms,1.471549ms,1.47155ms,1.471599ms,1.4716ms,1.471649ms,1.47165ms,1.471699ms,1.4717ms,1.471749ms,1.47175ms,1.471799ms,1.4718ms,1.471849ms,1.47185ms,1.471899ms,1.4719ms,1.471949ms,1.47195ms,1.471999ms,1.472ms,1.472049ms,1.47205ms,1.472099ms,1.4721ms,1.472149ms,1.47215ms,1.472199ms,1.4722ms,1.472249ms,1.47225ms,1.472299ms,1.4723ms,1.472349ms,1.47235ms,1.472399ms,1.4724ms,1.472449ms,1.47245ms,1.472499ms,1.4725ms,1.472549ms,1.47255ms,1.472599ms,1.4726ms,1.472649ms,1.47265ms,1.472699ms,1.4727ms,1.472749ms,1.47275ms,1.472799ms,1.4728ms,1.472849ms,1.47285ms,1.472899ms,1.4729ms,1.472949ms,1.47295ms,1.472999ms,1.473ms,1.473049ms,1.47305ms,1.473099ms,1.4731ms,1.473149ms,1.47315ms,1.473199ms,1.4732ms,1.473249ms,1.47325ms,1.473299ms,1.4733ms,1.473349ms,1.47335ms,1.473399ms,1.4734ms,1.473449ms,1.47345ms,1.473499ms,1.4735ms,1.473549ms,1.47355ms,1.473599ms,1.4736ms,1.473649ms,1.47365ms,1.473699ms,1.4737ms,1.473749ms,1.47375ms,1.473799ms,1.4738ms,1.473849ms,1.47385ms,1.473899ms,1.4739ms,1.473949ms,1.47395ms,1.473999ms,1.474ms,1.474049ms,1.47405ms,1.474099ms,1.4741ms,1.474149ms,1.47415ms,1.474199ms,1.4742ms,1.474249ms,1.47425ms,1.474299ms,1.4743ms,1.474349ms,1.47435ms,1.474399ms,1.4744ms,1.474449ms,1.47445ms,1.474499ms,1.4745ms,1.474549ms,1.47455ms,1.474599ms,1.4746ms,1.474649ms,1.47465ms,1.474699ms,1.4747ms,1.474749ms,1.47475ms,1.474799ms,1.4748ms,1.474849ms,1.47485ms,1.474899ms,1.4749ms,1.474949ms,1.47495ms,1.474999ms,1.475ms,1.475049ms,1.47505ms,1.475099ms,1.4751ms,1.475149ms,1.47515ms,1.475199ms,1.4752ms,1.475249ms,1.47525ms,1.475299ms,1.4753ms,1.475349ms,1.47535ms,1.475399ms,1.4754ms,1.475449ms,1.47545ms,1.475499ms,1.4755ms,1.475549ms,1.47555ms,1.475599ms,1.4756ms,1.475649ms,1.47565ms,1.475699ms,1.4757ms,1.475749ms,1.47575ms,1.475799ms,1.4758ms,1.475849ms,1.47585ms,1.475899ms,1.4759ms,1.475949ms,1.47595ms,1.475999ms,1.476ms,1.476049ms,1.47605ms,1.476099ms,1.4761ms,1.476149ms,1.47615ms,1.476199ms,1.4762ms,1.476249ms,1.47625ms,1.476299ms,1.4763ms,1.476349ms,1.47635ms,1.476399ms,1.4764ms,1.476449ms,1.47645ms,1.476499ms,1.4765ms,1.476549ms,1.47655ms,1.476599ms,1.4766ms,1.476649ms,1.47665ms,1.476699ms,1.4767ms,1.476749ms,1.47675ms,1.476799ms,1.4768ms,1.476849ms,1.47685ms,1.476899ms,1.4769ms,1.476949ms,1.47695ms,1.476999ms,1.477ms,1.477049ms,1.47705ms,1.477099ms,1.4771ms,1.477149ms,1.47715ms,1.477199ms,1.4772ms,1.477249ms,1.47725ms,1.477299ms,1.4773ms,1.477349ms,1.47735ms,1.477399ms,1.4774ms,1.477449ms,1.47745ms,1.477499ms,1.4775ms,1.477549ms,1.47755ms,1.477599ms,1.4776ms,1.477649ms,1.47765ms,1.477699ms,1.4777ms,1.477749ms,1.47775ms,1.477799ms,1.4778ms,1.477849ms,1.47785ms,1.477899ms,1.4779ms,1.477949ms,1.47795ms,1.477999ms,1.478ms,1.478049ms,1.47805ms,1.478099ms,1.4781ms,1.478149ms,1.47815ms,1.478199ms,1.4782ms,1.478249ms,1.47825ms,1.478299ms,1.4783ms,1.478349ms,1.47835ms,1.478399ms,1.4784ms,1.478449ms,1.47845ms,1.478499ms,1.4785ms,1.478549ms,1.47855ms,1.478599ms,1.4786ms,1.478649ms,1.47865ms,1.478699ms,1.4787ms,1.478749ms,1.47875ms,1.478799ms,1.4788ms,1.478849ms,1.47885ms,1.478899ms,1.4789ms,1.478949ms,1.47895ms,1.478999ms,1.479ms,1.479049ms,1.47905ms,1.479099ms,1.4791ms,1.479149ms,1.47915ms,1.479199ms,1.4792ms,1.479249ms,1.47925ms,1.479299ms,1.4793ms,1.479349ms,1.47935ms,1.479399ms,1.4794ms,1.479449ms,1.47945ms,1.479499ms,1.4795ms,1.479549ms,1.47955ms,1.479599ms,1.4796ms,1.479649ms,1.47965ms,1.479699ms,1.4797ms,1.479749ms,1.47975ms,1.479799ms,1.4798ms,1.479849ms,1.47985ms,1.479899ms,1.4799ms,1.479949ms,1.47995ms,1.479999ms,1.48ms,1.480049ms,1.48005ms,1.480099ms,1.4801ms,1.480149ms,1.48015ms,1.480199ms,1.4802ms,1.480249ms,1.48025ms,1.480299ms,1.4803ms,1.480349ms,1.48035ms,1.480399ms,1.4804ms,1.480449ms,1.48045ms,1.480499ms,1.4805ms,1.480549ms,1.48055ms,1.480599ms,1.4806ms,1.480649ms,1.48065ms,1.480699ms,1.4807ms,1.480749ms,1.48075ms,1.480799ms,1.4808ms,1.480849ms,1.48085ms,1.480899ms,1.4809ms,1.480949ms,1.48095ms,1.480999ms,1.481ms,1.481049ms,1.48105ms,1.481099ms,1.4811ms,1.481149ms,1.48115ms,1.481199ms,1.4812ms,1.481249ms,1.48125ms,1.481299ms,1.4813ms,1.481349ms,1.48135ms,1.481399ms,1.4814ms,1.481449ms,1.48145ms,1.481499ms,1.4815ms,1.481549ms,1.48155ms,1.481599ms,1.4816ms,1.481649ms,1.48165ms,1.481699ms,1.4817ms,1.481749ms,1.48175ms,1.481799ms,1.4818ms,1.481849ms,1.48185ms,1.481899ms,1.4819ms,1.481949ms,1.48195ms,1.481999ms,1.482ms,1.482049ms,1.48205ms,1.482099ms,1.4821ms,1.482149ms,1.48215ms,1.482199ms,1.4822ms,1.482249ms,1.48225ms,1.482299ms,1.4823ms,1.482349ms,1.48235ms,1.482399ms,1.4824ms,1.482449ms,1.48245ms,1.482499ms,1.4825ms,1.482549ms,1.48255ms,1.482599ms,1.4826ms,1.482649ms,1.48265ms,1.482699ms,1.4827ms,1.482749ms,1.48275ms,1.482799ms,1.4828ms,1.482849ms,1.48285ms,1.482899ms,1.4829ms,1.482949ms,1.48295ms,1.482999ms,1.483ms,1.483049ms,1.48305ms,1.483099ms,1.4831ms,1.483149ms,1.48315ms,1.483199ms,1.4832ms,1.483249ms,1.48325ms,1.483299ms,1.4833ms,1.483349ms,1.48335ms,1.483399ms,1.4834ms,1.483449ms,1.48345ms,1.483499ms,1.4835ms,1.483549ms,1.48355ms,1.483599ms,1.4836ms,1.483649ms,1.48365ms,1.483699ms,1.4837ms,1.483749ms,1.48375ms,1.483799ms,1.4838ms,1.483849ms,1.48385ms,1.483899ms,1.4839ms,1.483949ms,1.48395ms,1.483999ms,1.484ms,1.484049ms,1.48405ms,1.484099ms,1.4841ms,1.484149ms,1.48415ms,1.484199ms,1.4842ms,1.484249ms,1.48425ms,1.484299ms,1.4843ms,1.484349ms,1.48435ms,1.484399ms,1.4844ms,1.484449ms,1.48445ms,1.484499ms,1.4845ms,1.484549ms,1.48455ms,1.484599ms,1.4846ms,1.484649ms,1.48465ms,1.484699ms,1.4847ms,1.484749ms,1.48475ms,1.484799ms,1.4848ms,1.484849ms,1.48485ms,1.484899ms,1.4849ms,1.484949ms,1.48495ms,1.484999ms,1.485ms,1.485049ms,1.48505ms,1.485099ms,1.4851ms,1.485149ms,1.48515ms,1.485199ms,1.4852ms,1.485249ms,1.48525ms,1.485299ms,1.4853ms,1.485349ms,1.48535ms,1.485399ms,1.4854ms,1.485449ms,1.48545ms,1.485499ms,1.4855ms,1.485549ms,1.48555ms,1.485599ms,1.4856ms,1.485649ms,1.48565ms,1.485699ms,1.4857ms,1.485749ms,1.48575ms,1.485799ms,1.4858ms,1.485849ms,1.48585ms,1.485899ms,1.4859ms,1.485949ms,1.48595ms,1.485999ms,1.486ms,1.486049ms,1.48605ms,1.486099ms,1.4861ms,1.486149ms,1.48615ms,1.486199ms,1.4862ms,1.486249ms,1.48625ms,1.486299ms,1.4863ms,1.486349ms,1.48635ms,1.486399ms,1.4864ms,1.486449ms,1.48645ms,1.486499ms,1.4865ms,1.486549ms,1.48655ms,1.486599ms,1.4866ms,1.486649ms,1.48665ms,1.486699ms,1.4867ms,1.486749ms,1.48675ms,1.486799ms,1.4868ms,1.486849ms,1.48685ms,1.486899ms,1.4869ms,1.486949ms,1.48695ms,1.486999ms,1.487ms,1.487049ms,1.48705ms,1.487099ms,1.4871ms,1.487149ms,1.48715ms,1.487199ms,1.4872ms,1.487249ms,1.48725ms,1.487299ms,1.4873ms,1.487349ms,1.48735ms,1.487399ms,1.4874ms,1.487449ms,1.48745ms,1.487499ms,1.4875ms,1.487549ms,1.48755ms,1.487599ms,1.4876ms,1.487649ms,1.48765ms,1.487699ms,1.4877ms,1.487749ms,1.48775ms,1.487799ms,1.4878ms,1.487849ms,1.48785ms,1.487899ms,1.4879ms,1.487949ms,1.48795ms,1.487999ms,1.488ms,1.488049ms,1.48805ms,1.488099ms,1.4881ms,1.488149ms,1.48815ms,1.488199ms,1.4882ms,1.488249ms,1.48825ms,1.488299ms,1.4883ms,1.488349ms,1.48835ms,1.488399ms,1.4884ms,1.488449ms,1.48845ms,1.488499ms,1.4885ms,1.488549ms,1.48855ms,1.488599ms,1.4886ms,1.488649ms,1.48865ms,1.488699ms,1.4887ms,1.488749ms,1.48875ms,1.488799ms,1.4888ms,1.488849ms,1.48885ms,1.488899ms,1.4889ms,1.488949ms,1.48895ms,1.488999ms,1.489ms,1.489049ms,1.48905ms,1.489099ms,1.4891ms,1.489149ms,1.48915ms,1.489199ms,1.4892ms,1.489249ms,1.48925ms,1.489299ms,1.4893ms,1.489349ms,1.48935ms,1.489399ms,1.4894ms,1.489449ms,1.48945ms,1.489499ms,1.4895ms,1.489549ms,1.48955ms,1.489599ms,1.4896ms,1.489649ms,1.48965ms,1.489699ms,1.4897ms,1.489749ms,1.48975ms,1.489799ms,1.4898ms,1.489849ms,1.48985ms,1.489899ms,1.4899ms,1.489949ms,1.48995ms,1.489999ms,1.49ms,1.490049ms,1.49005ms,1.490099ms,1.4901ms,1.490149ms,1.49015ms,1.490199ms,1.4902ms,1.490249ms,1.49025ms,1.490299ms,1.4903ms,1.490349ms,1.49035ms,1.490399ms,1.4904ms,1.490449ms,1.49045ms,1.490499ms,1.4905ms,1.490549ms,1.49055ms,1.490599ms,1.4906ms,1.490649ms,1.49065ms,1.490699ms,1.4907ms,1.490749ms,1.49075ms,1.490799ms,1.4908ms,1.490849ms,1.49085ms,1.490899ms,1.4909ms,1.490949ms,1.49095ms,1.490999ms,1.491ms,1.491049ms,1.49105ms,1.491099ms,1.4911ms,1.491149ms,1.49115ms,1.491199ms,1.4912ms,1.491249ms,1.49125ms,1.491299ms,1.4913ms,1.491349ms,1.49135ms,1.491399ms,1.4914ms,1.491449ms,1.49145ms,1.491499ms,1.4915ms,1.491549ms,1.49155ms,1.491599ms,1.4916ms,1.491649ms,1.49165ms,1.491699ms,1.4917ms,1.491749ms,1.49175ms,1.491799ms,1.4918ms,1.491849ms,1.49185ms,1.491899ms,1.4919ms,1.491949ms,1.49195ms,1.491999ms,1.492ms,1.492049ms,1.49205ms,1.492099ms,1.4921ms,1.492149ms,1.49215ms,1.492199ms,1.4922ms,1.492249ms,1.49225ms,1.492299ms,1.4923ms,1.492349ms,1.49235ms,1.492399ms,1.4924ms,1.492449ms,1.49245ms,1.492499ms,1.4925ms,1.492549ms,1.49255ms,1.492599ms,1.4926ms,1.492649ms,1.49265ms,1.492699ms,1.4927ms,1.492749ms,1.49275ms,1.492799ms,1.4928ms,1.492849ms,1.49285ms,1.492899ms,1.4929ms,1.492949ms,1.49295ms,1.492999ms,1.493ms,1.493049ms,1.49305ms,1.493099ms,1.4931ms,1.493149ms,1.49315ms,1.493199ms,1.4932ms,1.493249ms,1.49325ms,1.493299ms,1.4933ms,1.493349ms,1.49335ms,1.493399ms,1.4934ms,1.493449ms,1.49345ms,1.493499ms,1.4935ms,1.493549ms,1.49355ms,1.493599ms,1.4936ms,1.493649ms,1.49365ms,1.493699ms,1.4937ms,1.493749ms,1.49375ms,1.493799ms,1.4938ms,1.493849ms,1.49385ms,1.493899ms,1.4939ms,1.493949ms,1.49395ms,1.493999ms,1.494ms,1.494049ms,1.49405ms,1.494099ms,1.4941ms,1.494149ms,1.49415ms,1.494199ms,1.4942ms,1.494249ms,1.49425ms,1.494299ms,1.4943ms,1.494349ms,1.49435ms,1.494399ms,1.4944ms,1.494449ms,1.49445ms,1.494499ms,1.4945ms,1.494549ms,1.49455ms,1.494599ms,1.4946ms,1.494649ms,1.49465ms,1.494699ms,1.4947ms,1.494749ms,1.49475ms,1.494799ms,1.4948ms,1.494849ms,1.49485ms,1.494899ms,1.4949ms,1.494949ms,1.49495ms,1.494999ms,1.495ms,1.495049ms,1.49505ms,1.495099ms,1.4951ms,1.495149ms,1.49515ms,1.495199ms,1.4952ms,1.495249ms,1.49525ms,1.495299ms,1.4953ms,1.495349ms,1.49535ms,1.495399ms,1.4954ms,1.495449ms,1.49545ms,1.495499ms,1.4955ms,1.495549ms,1.49555ms,1.495599ms,1.4956ms,1.495649ms,1.49565ms,1.495699ms,1.4957ms,1.495749ms,1.49575ms,1.495799ms,1.4958ms,1.495849ms,1.49585ms,1.495899ms,1.4959ms,1.495949ms,1.49595ms,1.495999ms,1.496ms,1.496049ms,1.49605ms,1.496099ms,1.4961ms,1.496149ms,1.49615ms,1.496199ms,1.4962ms,1.496249ms,1.49625ms,1.496299ms,1.4963ms,1.496349ms,1.49635ms,1.496399ms,1.4964ms,1.496449ms,1.49645ms,1.496499ms,1.4965ms,1.496549ms,1.49655ms,1.496599ms,1.4966ms,1.496649ms,1.49665ms,1.496699ms,1.4967ms,1.496749ms,1.49675ms,1.496799ms,1.4968ms,1.496849ms,1.49685ms,1.496899ms,1.4969ms,1.496949ms,1.49695ms,1.496999ms,1.497ms,1.497049ms,1.49705ms,1.497099ms,1.4971ms,1.497149ms,1.49715ms,1.497199ms,1.4972ms,1.497249ms,1.49725ms,1.497299ms,1.4973ms,1.497349ms,1.49735ms,1.497399ms,1.4974ms,1.497449ms,1.49745ms,1.497499ms,1.4975ms,1.497549ms,1.49755ms,1.497599ms,1.4976ms,1.497649ms,1.49765ms,1.497699ms,1.4977ms,1.497749ms,1.49775ms,1.497799ms,1.4978ms,1.497849ms,1.49785ms,1.497899ms,1.4979ms,1.497949ms,1.49795ms,1.497999ms,1.498ms,1.498049ms,1.49805ms,1.498099ms,1.4981ms,1.498149ms,1.49815ms,1.498199ms,1.4982ms,1.498249ms,1.49825ms,1.498299ms,1.4983ms,1.498349ms,1.49835ms,1.498399ms,1.4984ms,1.498449ms,1.49845ms,1.498499ms,1.4985ms,1.498549ms,1.49855ms,1.498599ms,1.4986ms,1.498649ms,1.49865ms,1.498699ms,1.4987ms,1.498749ms,1.49875ms,1.498799ms,1.4988ms,1.498849ms,1.49885ms,1.498899ms,1.4989ms,1.498949ms,1.49895ms,1.498999ms,1.499ms,1.499049ms,1.49905ms,1.499099ms,1.4991ms,1.499149ms,1.49915ms,1.499199ms,1.4992ms,1.499249ms,1.49925ms,1.499299ms,1.4993ms,1.499349ms,1.49935ms,1.499399ms,1.4994ms,1.499449ms,1.49945ms,1.499499ms,1.4995ms,1.499549ms,1.49955ms,1.499599ms,1.4996ms,1.499649ms,1.49965ms,1.499699ms,1.4997ms,1.499749ms,1.49975ms,1.499799ms,1.4998ms,1.499849ms,1.49985ms,1.499899ms,1.4999ms,1.499949ms,1.49995ms,1.499999ms,1.5ms,1.500049ms,1.50005ms,1.500099ms,1.5001ms,1.500149ms,1.50015ms,1.500199ms,1.5002ms,1.500249ms,1.50025ms,1.500299ms,1.5003ms,1.500349ms,1.50035ms,1.500399ms,1.5004ms,1.500449ms,1.50045ms,1.500499ms,1.5005ms,1.500549ms,1.50055ms,1.500599ms,1.5006ms,1.500649ms,1.50065ms,1.500699ms,1.5007ms,1.500749ms,1.50075ms,1.500799ms,1.5008ms,1.500849ms,1.50085ms,1.500899ms,1.5009ms,1.500949ms,1.50095ms,1.500999ms,1.501ms,1.501049ms,1.50105ms,1.501099ms,1.5011ms,1.501149ms,1.50115ms,1.501199ms,1.5012ms,1.501249ms,1.50125ms,1.501299ms,1.5013ms,1.501349ms,1.50135ms,1.501399ms,1.5014ms,1.501449ms,1.50145ms,1.501499ms,1.5015ms,1.501549ms,1.50155ms,1.501599ms,1.5016ms,1.501649ms,1.50165ms,1.501699ms,1.5017ms,1.501749ms,1.50175ms,1.501799ms,1.5018ms,1.501849ms,1.50185ms,1.501899ms,1.5019ms,1.501949ms,1.50195ms,1.501999ms,1.502ms,1.502049ms,1.50205ms,1.502099ms,1.5021ms,1.502149ms,1.50215ms,1.502199ms,1.5022ms,1.502249ms,1.50225ms,1.502299ms,1.5023ms,1.502349ms,1.50235ms,1.502399ms,1.5024ms,1.502449ms,1.50245ms,1.502499ms,1.5025ms,1.502549ms,1.50255ms,1.502599ms,1.5026ms,1.502649ms,1.50265ms,1.502699ms,1.5027ms,1.502749ms,1.50275ms,1.502799ms,1.5028ms,1.502849ms,1.50285ms,1.502899ms,1.5029ms,1.502949ms,1.50295ms,1.502999ms,1.503ms,1.503049ms,1.50305ms,1.503099ms,1.5031ms,1.503149ms,1.50315ms,1.503199ms,1.5032ms,1.503249ms,1.50325ms,1.503299ms,1.5033ms,1.503349ms,1.50335ms,1.503399ms,1.5034ms,1.503449ms,1.50345ms,1.503499ms,1.5035ms,1.503549ms,1.50355ms,1.503599ms,1.5036ms,1.503649ms,1.50365ms,1.503699ms,1.5037ms,1.503749ms,1.50375ms,1.503799ms,1.5038ms,1.503849ms,1.50385ms,1.503899ms,1.5039ms,1.503949ms,1.50395ms,1.503999ms,1.504ms,1.504049ms,1.50405ms,1.504099ms,1.5041ms,1.504149ms,1.50415ms,1.504199ms,1.5042ms,1.504249ms,1.50425ms,1.504299ms,1.5043ms,1.504349ms,1.50435ms,1.504399ms,1.5044ms,1.504449ms,1.50445ms,1.504499ms,1.5045ms,1.504549ms,1.50455ms,1.504599ms,1.5046ms,1.504649ms,1.50465ms,1.504699ms,1.5047ms,1.504749ms,1.50475ms,1.504799ms,1.5048ms,1.504849ms,1.50485ms,1.504899ms,1.5049ms,1.504949ms,1.50495ms,1.504999ms,1.505ms,1.505049ms,1.50505ms,1.505099ms,1.5051ms,1.505149ms,1.50515ms,1.505199ms,1.5052ms,1.505249ms,1.50525ms,1.505299ms,1.5053ms,1.505349ms,1.50535ms,1.505399ms,1.5054ms,1.505449ms,1.50545ms,1.505499ms,1.5055ms,1.505549ms,1.50555ms,1.505599ms,1.5056ms,1.505649ms,1.50565ms,1.505699ms,1.5057ms,1.505749ms,1.50575ms,1.505799ms,1.5058ms,1.505849ms,1.50585ms,1.505899ms,1.5059ms,1.505949ms,1.50595ms,1.505999ms,1.506ms,1.506049ms,1.50605ms,1.506099ms,1.5061ms,1.506149ms,1.50615ms,1.506199ms,1.5062ms,1.506249ms,1.50625ms,1.506299ms,1.5063ms,1.506349ms,1.50635ms,1.506399ms,1.5064ms,1.506449ms,1.50645ms,1.506499ms,1.5065ms,1.506549ms,1.50655ms,1.506599ms,1.5066ms,1.506649ms,1.50665ms,1.506699ms,1.5067ms,1.506749ms,1.50675ms,1.506799ms,1.5068ms,1.506849ms,1.50685ms,1.506899ms,1.5069ms,1.506949ms,1.50695ms,1.506999ms,1.507ms,1.507049ms,1.50705ms,1.507099ms,1.5071ms,1.507149ms,1.50715ms,1.507199ms,1.5072ms,1.507249ms,1.50725ms,1.507299ms,1.5073ms,1.507349ms,1.50735ms,1.507399ms,1.5074ms,1.507449ms,1.50745ms,1.507499ms,1.5075ms,1.507549ms,1.50755ms,1.507599ms,1.5076ms,1.507649ms,1.50765ms,1.507699ms,1.5077ms,1.507749ms,1.50775ms,1.507799ms,1.5078ms,1.507849ms,1.50785ms,1.507899ms,1.5079ms,1.507949ms,1.50795ms,1.507999ms,1.508ms,1.508049ms,1.50805ms,1.508099ms,1.5081ms,1.508149ms,1.50815ms,1.508199ms,1.5082ms,1.508249ms,1.50825ms,1.508299ms,1.5083ms,1.508349ms,1.50835ms,1.508399ms,1.5084ms,1.508449ms,1.50845ms,1.508499ms,1.5085ms,1.508549ms,1.50855ms,1.508599ms,1.5086ms,1.508649ms,1.50865ms,1.508699ms,1.5087ms,1.508749ms,1.50875ms,1.508799ms,1.5088ms,1.508849ms,1.50885ms,1.508899ms,1.5089ms,1.508949ms,1.50895ms,1.508999ms,1.509ms,1.509049ms,1.50905ms,1.509099ms,1.5091ms,1.509149ms,1.50915ms,1.509199ms,1.5092ms,1.509249ms,1.50925ms,1.509299ms,1.5093ms,1.509349ms,1.50935ms,1.509399ms,1.5094ms,1.509449ms,1.50945ms,1.509499ms,1.5095ms,1.509549ms,1.50955ms,1.509599ms,1.5096ms,1.509649ms,1.50965ms,1.509699ms,1.5097ms,1.509749ms,1.50975ms,1.509799ms,1.5098ms,1.509849ms,1.50985ms,1.509899ms,1.5099ms,1.509949ms,1.50995ms,1.509999ms,1.51ms,1.510049ms,1.51005ms,1.510099ms,1.5101ms,1.510149ms,1.51015ms,1.510199ms,1.5102ms,1.510249ms,1.51025ms,1.510299ms,1.5103ms,1.510349ms,1.51035ms,1.510399ms,1.5104ms,1.510449ms,1.51045ms,1.510499ms,1.5105ms,1.510549ms,1.51055ms,1.510599ms,1.5106ms,1.510649ms,1.51065ms,1.510699ms,1.5107ms,1.510749ms,1.51075ms,1.510799ms,1.5108ms,1.510849ms,1.51085ms,1.510899ms,1.5109ms,1.510949ms,1.51095ms,1.510999ms,1.511ms,1.511049ms,1.51105ms,1.511099ms,1.5111ms,1.511149ms,1.51115ms,1.511199ms,1.5112ms,1.511249ms,1.51125ms,1.511299ms,1.5113ms,1.511349ms,1.51135ms,1.511399ms,1.5114ms,1.511449ms,1.51145ms,1.511499ms,1.5115ms,1.511549ms,1.51155ms,1.511599ms,1.5116ms,1.511649ms,1.51165ms,1.511699ms,1.5117ms,1.511749ms,1.51175ms,1.511799ms,1.5118ms,1.511849ms,1.51185ms,1.511899ms,1.5119ms,1.511949ms,1.51195ms,1.511999ms,1.512ms,1.512049ms,1.51205ms,1.512099ms,1.5121ms,1.512149ms,1.51215ms,1.512199ms,1.5122ms,1.512249ms,1.51225ms,1.512299ms,1.5123ms,1.512349ms,1.51235ms,1.512399ms,1.5124ms,1.512449ms,1.51245ms,1.512499ms,1.5125ms,1.512549ms,1.51255ms,1.512599ms,1.5126ms,1.512649ms,1.51265ms,1.512699ms,1.5127ms,1.512749ms,1.51275ms,1.512799ms,1.5128ms,1.512849ms,1.51285ms,1.512899ms,1.5129ms,1.512949ms,1.51295ms,1.512999ms,1.513ms,1.513049ms,1.51305ms,1.513099ms,1.5131ms,1.513149ms,1.51315ms,1.513199ms,1.5132ms,1.513249ms,1.51325ms,1.513299ms,1.5133ms,1.513349ms,1.51335ms,1.513399ms,1.5134ms,1.513449ms,1.51345ms,1.513499ms,1.5135ms,1.513549ms,1.51355ms,1.513599ms,1.5136ms,1.513649ms,1.51365ms,1.513699ms,1.5137ms,1.513749ms,1.51375ms,1.513799ms,1.5138ms,1.513849ms,1.51385ms,1.513899ms,1.5139ms,1.513949ms,1.51395ms,1.513999ms,1.514ms,1.514049ms,1.51405ms,1.514099ms,1.5141ms,1.514149ms,1.51415ms,1.514199ms,1.5142ms,1.514249ms,1.51425ms,1.514299ms,1.5143ms,1.514349ms,1.51435ms,1.514399ms,1.5144ms,1.514449ms,1.51445ms,1.514499ms,1.5145ms,1.514549ms,1.51455ms,1.514599ms,1.5146ms,1.514649ms,1.51465ms,1.514699ms,1.5147ms,1.514749ms,1.51475ms,1.514799ms,1.5148ms,1.514849ms,1.51485ms,1.514899ms,1.5149ms,1.514949ms,1.51495ms,1.514999ms,1.515ms,1.515049ms,1.51505ms,1.515099ms,1.5151ms,1.515149ms,1.51515ms,1.515199ms,1.5152ms,1.515249ms,1.51525ms,1.515299ms,1.5153ms,1.515349ms,1.51535ms,1.515399ms,1.5154ms,1.515449ms,1.51545ms,1.515499ms,1.5155ms,1.515549ms,1.51555ms,1.515599ms,1.5156ms,1.515649ms,1.51565ms,1.515699ms,1.5157ms,1.515749ms,1.51575ms,1.515799ms,1.5158ms,1.515849ms,1.51585ms,1.515899ms,1.5159ms,1.515949ms,1.51595ms,1.515999ms,1.516ms,1.516049ms,1.51605ms,1.516099ms,1.5161ms,1.516149ms,1.51615ms,1.516199ms,1.5162ms,1.516249ms,1.51625ms,1.516299ms,1.5163ms,1.516349ms,1.51635ms,1.516399ms,1.5164ms,1.516449ms,1.51645ms,1.516499ms,1.5165ms,1.516549ms,1.51655ms,1.516599ms,1.5166ms,1.516649ms,1.51665ms,1.516699ms,1.5167ms,1.516749ms,1.51675ms,1.516799ms,1.5168ms,1.516849ms,1.51685ms,1.516899ms,1.5169ms,1.516949ms,1.51695ms,1.516999ms,1.517ms,1.517049ms,1.51705ms,1.517099ms,1.5171ms,1.517149ms,1.51715ms,1.517199ms,1.5172ms,1.517249ms,1.51725ms,1.517299ms,1.5173ms,1.517349ms,1.51735ms,1.517399ms,1.5174ms,1.517449ms,1.51745ms,1.517499ms,1.5175ms,1.517549ms,1.51755ms,1.517599ms,1.5176ms,1.517649ms,1.51765ms,1.517699ms,1.5177ms,1.517749ms,1.51775ms,1.517799ms,1.5178ms,1.517849ms,1.51785ms,1.517899ms,1.5179ms,1.517949ms,1.51795ms,1.517999ms,1.518ms,1.518049ms,1.51805ms,1.518099ms,1.5181ms,1.518149ms,1.51815ms,1.518199ms,1.5182ms,1.518249ms,1.51825ms,1.518299ms,1.5183ms,1.518349ms,1.51835ms,1.518399ms,1.5184ms,1.518449ms,1.51845ms,1.518499ms,1.5185ms,1.518549ms,1.51855ms,1.518599ms,1.5186ms,1.518649ms,1.51865ms,1.518699ms,1.5187ms,1.518749ms,1.51875ms,1.518799ms,1.5188ms,1.518849ms,1.51885ms,1.518899ms,1.5189ms,1.518949ms,1.51895ms,1.518999ms,1.519ms,1.519049ms,1.51905ms,1.519099ms,1.5191ms,1.519149ms,1.51915ms,1.519199ms,1.5192ms,1.519249ms,1.51925ms,1.519299ms,1.5193ms,1.519349ms,1.51935ms,1.519399ms,1.5194ms,1.519449ms,1.51945ms,1.519499ms,1.5195ms,1.519549ms,1.51955ms,1.519599ms,1.5196ms,1.519649ms,1.51965ms,1.519699ms,1.5197ms,1.519749ms,1.51975ms,1.519799ms,1.5198ms,1.519849ms,1.51985ms,1.519899ms,1.5199ms,1.519949ms,1.51995ms,1.519999ms,1.52ms,1.520049ms,1.52005ms,1.520099ms,1.5201ms,1.520149ms,1.52015ms,1.520199ms,1.5202ms,1.520249ms,1.52025ms,1.520299ms,1.5203ms,1.520349ms,1.52035ms,1.520399ms,1.5204ms,1.520449ms,1.52045ms,1.520499ms,1.5205ms,1.520549ms,1.52055ms,1.520599ms,1.5206ms,1.520649ms,1.52065ms,1.520699ms,1.5207ms,1.520749ms,1.52075ms,1.520799ms,1.5208ms,1.520849ms,1.52085ms,1.520899ms,1.5209ms,1.520949ms,1.52095ms,1.520999ms,1.521ms,1.521049ms,1.52105ms,1.521099ms,1.5211ms,1.521149ms,1.52115ms,1.521199ms,1.5212ms,1.521249ms,1.52125ms,1.521299ms,1.5213ms,1.521349ms,1.52135ms,1.521399ms,1.5214ms,1.521449ms,1.52145ms,1.521499ms,1.5215ms,1.521549ms,1.52155ms,1.521599ms,1.5216ms,1.521649ms,1.52165ms,1.521699ms,1.5217ms,1.521749ms,1.52175ms,1.521799ms,1.5218ms,1.521849ms,1.52185ms,1.521899ms,1.5219ms,1.521949ms,1.52195ms,1.521999ms,1.522ms,1.522049ms,1.52205ms,1.522099ms,1.5221ms,1.522149ms,1.52215ms,1.522199ms,1.5222ms,1.522249ms,1.52225ms,1.522299ms,1.5223ms,1.522349ms,1.52235ms,1.522399ms,1.5224ms,1.522449ms,1.52245ms,1.522499ms,1.5225ms,1.522549ms,1.52255ms,1.522599ms,1.5226ms,1.522649ms,1.52265ms,1.522699ms,1.5227ms,1.522749ms,1.52275ms,1.522799ms,1.5228ms,1.522849ms,1.52285ms,1.522899ms,1.5229ms,1.522949ms,1.52295ms,1.522999ms,1.523ms,1.523049ms,1.52305ms,1.523099ms,1.5231ms,1.523149ms,1.52315ms,1.523199ms,1.5232ms,1.523249ms,1.52325ms,1.523299ms,1.5233ms,1.523349ms,1.52335ms,1.523399ms,1.5234ms,1.523449ms,1.52345ms,1.523499ms,1.5235ms,1.523549ms,1.52355ms,1.523599ms,1.5236ms,1.523649ms,1.52365ms,1.523699ms,1.5237ms,1.523749ms,1.52375ms,1.523799ms,1.5238ms,1.523849ms,1.52385ms,1.523899ms,1.5239ms,1.523949ms,1.52395ms,1.523999ms,1.524ms,1.524049ms,1.52405ms,1.524099ms,1.5241ms,1.524149ms,1.52415ms,1.524199ms,1.5242ms,1.524249ms,1.52425ms,1.524299ms,1.5243ms,1.524349ms,1.52435ms,1.524399ms,1.5244ms,1.524449ms,1.52445ms,1.524499ms,1.5245ms,1.524549ms,1.52455ms,1.524599ms,1.5246ms,1.524649ms,1.52465ms,1.524699ms,1.5247ms,1.524749ms,1.52475ms,1.524799ms,1.5248ms,1.524849ms,1.52485ms,1.524899ms,1.5249ms,1.524949ms,1.52495ms,1.524999ms,1.525ms,1.525049ms,1.52505ms,1.525099ms,1.5251ms,1.525149ms,1.52515ms,1.525199ms,1.5252ms,1.525249ms,1.52525ms,1.525299ms,1.5253ms,1.525349ms,1.52535ms,1.525399ms,1.5254ms,1.525449ms,1.52545ms,1.525499ms,1.5255ms,1.525549ms,1.52555ms,1.525599ms,1.5256ms,1.525649ms,1.52565ms,1.525699ms,1.5257ms,1.525749ms,1.52575ms,1.525799ms,1.5258ms,1.525849ms,1.52585ms,1.525899ms,1.5259ms,1.525949ms,1.52595ms,1.525999ms,1.526ms,1.526049ms,1.52605ms,1.526099ms,1.5261ms,1.526149ms,1.52615ms,1.526199ms,1.5262ms,1.526249ms,1.52625ms,1.526299ms,1.5263ms,1.526349ms,1.52635ms,1.526399ms,1.5264ms,1.526449ms,1.52645ms,1.526499ms,1.5265ms,1.526549ms,1.52655ms,1.526599ms,1.5266ms,1.526649ms,1.52665ms,1.526699ms,1.5267ms,1.526749ms,1.52675ms,1.526799ms,1.5268ms,1.526849ms,1.52685ms,1.526899ms,1.5269ms,1.526949ms,1.52695ms,1.526999ms,1.527ms,1.527049ms,1.52705ms,1.527099ms,1.5271ms,1.527149ms,1.52715ms,1.527199ms,1.5272ms,1.527249ms,1.52725ms,1.527299ms,1.5273ms,1.527349ms,1.52735ms,1.527399ms,1.5274ms,1.527449ms,1.52745ms,1.527499ms,1.5275ms,1.527549ms,1.52755ms,1.527599ms,1.5276ms,1.527649ms,1.52765ms,1.527699ms,1.5277ms,1.527749ms,1.52775ms,1.527799ms,1.5278ms,1.527849ms,1.52785ms,1.527899ms,1.5279ms,1.527949ms,1.52795ms,1.527999ms,1.528ms,1.528049ms,1.52805ms,1.528099ms,1.5281ms,1.528149ms,1.52815ms,1.528199ms,1.5282ms,1.528249ms,1.52825ms,1.528299ms,1.5283ms,1.528349ms,1.52835ms,1.528399ms,1.5284ms,1.528449ms,1.52845ms,1.528499ms,1.5285ms,1.528549ms,1.52855ms,1.528599ms,1.5286ms,1.528649ms,1.52865ms,1.528699ms,1.5287ms,1.528749ms,1.52875ms,1.528799ms,1.5288ms,1.528849ms,1.52885ms,1.528899ms,1.5289ms,1.528949ms,1.52895ms,1.528999ms,1.529ms,1.529049ms,1.52905ms,1.529099ms,1.5291ms,1.529149ms,1.52915ms,1.529199ms,1.5292ms,1.529249ms,1.52925ms,1.529299ms,1.5293ms,1.529349ms,1.52935ms,1.529399ms,1.5294ms,1.529449ms,1.52945ms,1.529499ms,1.5295ms,1.529549ms,1.52955ms,1.529599ms,1.5296ms,1.529649ms,1.52965ms,1.529699ms,1.5297ms,1.529749ms,1.52975ms,1.529799ms,1.5298ms,1.529849ms,1.52985ms,1.529899ms,1.5299ms,1.529949ms,1.52995ms,1.529999ms,1.53ms,1.530049ms,1.53005ms,1.530099ms,1.5301ms,1.530149ms,1.53015ms,1.530199ms,1.5302ms,1.530249ms,1.53025ms,1.530299ms,1.5303ms,1.530349ms,1.53035ms,1.530399ms,1.5304ms,1.530449ms,1.53045ms,1.530499ms,1.5305ms,1.530549ms,1.53055ms,1.530599ms,1.5306ms,1.530649ms,1.53065ms,1.530699ms,1.5307ms,1.530749ms,1.53075ms,1.530799ms,1.5308ms,1.530849ms,1.53085ms,1.530899ms,1.5309ms,1.530949ms,1.53095ms,1.530999ms,1.531ms,1.531049ms,1.53105ms,1.531099ms,1.5311ms,1.531149ms,1.53115ms,1.531199ms,1.5312ms,1.531249ms,1.53125ms,1.531299ms,1.5313ms,1.531349ms,1.53135ms,1.531399ms,1.5314ms,1.531449ms,1.53145ms,1.531499ms,1.5315ms,1.531549ms,1.53155ms,1.531599ms,1.5316ms,1.531649ms,1.53165ms,1.531699ms,1.5317ms,1.531749ms,1.53175ms,1.531799ms,1.5318ms,1.531849ms,1.53185ms,1.531899ms,1.5319ms,1.531949ms,1.53195ms,1.531999ms,1.532ms,1.532049ms,1.53205ms,1.532099ms,1.5321ms,1.532149ms,1.53215ms,1.532199ms,1.5322ms,1.532249ms,1.53225ms,1.532299ms,1.5323ms,1.532349ms,1.53235ms,1.532399ms,1.5324ms,1.532449ms,1.53245ms,1.532499ms,1.5325ms,1.532549ms,1.53255ms,1.532599ms,1.5326ms,1.532649ms,1.53265ms,1.532699ms,1.5327ms,1.532749ms,1.53275ms,1.532799ms,1.5328ms,1.532849ms,1.53285ms,1.532899ms,1.5329ms,1.532949ms,1.53295ms,1.532999ms,1.533ms,1.533049ms,1.53305ms,1.533099ms,1.5331ms,1.533149ms,1.53315ms,1.533199ms,1.5332ms,1.533249ms,1.53325ms,1.533299ms,1.5333ms,1.533349ms,1.53335ms,1.533399ms,1.5334ms,1.533449ms,1.53345ms,1.533499ms,1.5335ms,1.533549ms,1.53355ms,1.533599ms,1.5336ms,1.533649ms,1.53365ms,1.533699ms,1.5337ms,1.533749ms,1.53375ms,1.533799ms,1.5338ms,1.533849ms,1.53385ms,1.533899ms,1.5339ms,1.533949ms,1.53395ms,1.533999ms,1.534ms,1.534049ms,1.53405ms,1.534099ms,1.5341ms,1.534149ms,1.53415ms,1.534199ms,1.5342ms,1.534249ms,1.53425ms,1.534299ms,1.5343ms,1.534349ms,1.53435ms,1.534399ms,1.5344ms,1.534449ms,1.53445ms,1.534499ms,1.5345ms,1.534549ms,1.53455ms,1.534599ms,1.5346ms,1.534649ms,1.53465ms,1.534699ms,1.5347ms,1.534749ms,1.53475ms,1.534799ms,1.5348ms,1.534849ms,1.53485ms,1.534899ms,1.5349ms,1.534949ms,1.53495ms,1.534999ms,1.535ms,1.535049ms,1.53505ms,1.535099ms,1.5351ms,1.535149ms,1.53515ms,1.535199ms,1.5352ms,1.535249ms,1.53525ms,1.535299ms,1.5353ms,1.535349ms,1.53535ms,1.535399ms,1.5354ms,1.535449ms,1.53545ms,1.535499ms,1.5355ms,1.535549ms,1.53555ms,1.535599ms,1.5356ms,1.535649ms,1.53565ms,1.535699ms,1.5357ms,1.535749ms,1.53575ms,1.535799ms,1.5358ms,1.535849ms,1.53585ms,1.535899ms,1.5359ms,1.535949ms,1.53595ms,1.535999ms,1.536ms,1.536049ms,1.53605ms,1.536099ms,1.5361ms,1.536149ms,1.53615ms,1.536199ms,1.5362ms,1.536249ms,1.53625ms,1.536299ms,1.5363ms,1.536349ms,1.53635ms,1.536399ms,1.5364ms,1.536449ms,1.53645ms,1.536499ms,1.5365ms,1.536549ms,1.53655ms,1.536599ms,1.5366ms,1.536649ms,1.53665ms,1.536699ms,1.5367ms,1.536749ms,1.53675ms,1.536799ms,1.5368ms,1.536849ms,1.53685ms,1.536899ms,1.5369ms,1.536949ms,1.53695ms,1.536999ms,1.537ms,1.537049ms,1.53705ms,1.537099ms,1.5371ms,1.537149ms,1.53715ms,1.537199ms,1.5372ms,1.537249ms,1.53725ms,1.537299ms,1.5373ms,1.537349ms,1.53735ms,1.537399ms,1.5374ms,1.537449ms,1.53745ms,1.537499ms,1.5375ms,1.537549ms,1.53755ms,1.537599ms,1.5376ms,1.537649ms,1.53765ms,1.537699ms,1.5377ms,1.537749ms,1.53775ms,1.537799ms,1.5378ms,1.537849ms,1.53785ms,1.537899ms,1.5379ms,1.537949ms,1.53795ms,1.537999ms,1.538ms,1.538049ms,1.53805ms,1.538099ms,1.5381ms,1.538149ms,1.53815ms,1.538199ms,1.5382ms,1.538249ms,1.53825ms,1.538299ms,1.5383ms,1.538349ms,1.53835ms,1.538399ms,1.5384ms,1.538449ms,1.53845ms,1.538499ms,1.5385ms,1.538549ms,1.53855ms,1.538599ms,1.5386ms,1.538649ms,1.53865ms,1.538699ms,1.5387ms,1.538749ms,1.53875ms,1.538799ms,1.5388ms,1.538849ms,1.53885ms,1.538899ms,1.5389ms,1.538949ms,1.53895ms,1.538999ms,1.539ms,1.539049ms,1.53905ms,1.539099ms,1.5391ms,1.539149ms,1.53915ms,1.539199ms,1.5392ms,1.539249ms,1.53925ms,1.539299ms,1.5393ms,1.539349ms,1.53935ms,1.539399ms,1.5394ms,1.539449ms,1.53945ms,1.539499ms,1.5395ms,1.539549ms,1.53955ms,1.539599ms,1.5396ms,1.539649ms,1.53965ms,1.539699ms,1.5397ms,1.539749ms,1.53975ms,1.539799ms,1.5398ms,1.539849ms,1.53985ms,1.539899ms,1.5399ms,1.539949ms,1.53995ms,1.539999ms,1.54ms,1.540049ms,1.54005ms,1.540099ms,1.5401ms,1.540149ms,1.54015ms,1.540199ms,1.5402ms,1.540249ms,1.54025ms,1.540299ms,1.5403ms,1.540349ms,1.54035ms,1.540399ms,1.5404ms,1.540449ms,1.54045ms,1.540499ms,1.5405ms,1.540549ms,1.54055ms,1.540599ms,1.5406ms,1.540649ms,1.54065ms,1.540699ms,1.5407ms,1.540749ms,1.54075ms,1.540799ms,1.5408ms,1.540849ms,1.54085ms,1.540899ms,1.5409ms,1.540949ms,1.54095ms,1.540999ms,1.541ms,1.541049ms,1.54105ms,1.541099ms,1.5411ms,1.541149ms,1.54115ms,1.541199ms,1.5412ms,1.541249ms,1.54125ms,1.541299ms,1.5413ms,1.541349ms,1.54135ms,1.541399ms,1.5414ms,1.541449ms,1.54145ms,1.541499ms,1.5415ms,1.541549ms,1.54155ms,1.541599ms,1.5416ms,1.541649ms,1.54165ms,1.541699ms,1.5417ms,1.541749ms,1.54175ms,1.541799ms,1.5418ms,1.541849ms,1.54185ms,1.541899ms,1.5419ms,1.541949ms,1.54195ms,1.541999ms,1.542ms,1.542049ms,1.54205ms,1.542099ms,1.5421ms,1.542149ms,1.54215ms,1.542199ms,1.5422ms,1.542249ms,1.54225ms,1.542299ms,1.5423ms,1.542349ms,1.54235ms,1.542399ms,1.5424ms,1.542449ms,1.54245ms,1.542499ms,1.5425ms,1.542549ms,1.54255ms,1.542599ms,1.5426ms,1.542649ms,1.54265ms,1.542699ms,1.5427ms,1.542749ms,1.54275ms,1.542799ms,1.5428ms,1.542849ms,1.54285ms,1.542899ms,1.5429ms,1.542949ms,1.54295ms,1.542999ms,1.543ms,1.543049ms,1.54305ms,1.543099ms,1.5431ms,1.543149ms,1.54315ms,1.543199ms,1.5432ms,1.543249ms,1.54325ms,1.543299ms,1.5433ms,1.543349ms,1.54335ms,1.543399ms,1.5434ms,1.543449ms,1.54345ms,1.543499ms,1.5435ms,1.543549ms,1.54355ms,1.543599ms,1.5436ms,1.543649ms,1.54365ms,1.543699ms,1.5437ms,1.543749ms,1.54375ms,1.543799ms,1.5438ms,1.543849ms,1.54385ms,1.543899ms,1.5439ms,1.543949ms,1.54395ms,1.543999ms,1.544ms,1.544049ms,1.54405ms,1.544099ms,1.5441ms,1.544149ms,1.54415ms,1.544199ms,1.5442ms,1.544249ms,1.54425ms,1.544299ms,1.5443ms,1.544349ms,1.54435ms,1.544399ms,1.5444ms,1.544449ms,1.54445ms,1.544499ms,1.5445ms,1.544549ms,1.54455ms,1.544599ms,1.5446ms,1.544649ms,1.54465ms,1.544699ms,1.5447ms,1.544749ms,1.54475ms,1.544799ms,1.5448ms,1.544849ms,1.54485ms,1.544899ms,1.5449ms,1.544949ms,1.54495ms,1.544999ms,1.545ms,1.545049ms,1.54505ms,1.545099ms,1.5451ms,1.545149ms,1.54515ms,1.545199ms,1.5452ms,1.545249ms,1.54525ms,1.545299ms,1.5453ms,1.545349ms,1.54535ms,1.545399ms,1.5454ms,1.545449ms,1.54545ms,1.545499ms,1.5455ms,1.545549ms,1.54555ms,1.545599ms,1.5456ms,1.545649ms,1.54565ms,1.545699ms,1.5457ms,1.545749ms,1.54575ms,1.545799ms,1.5458ms,1.545849ms,1.54585ms,1.545899ms,1.5459ms,1.545949ms,1.54595ms,1.545999ms,1.546ms,1.546049ms,1.54605ms,1.546099ms,1.5461ms,1.546149ms,1.54615ms,1.546199ms,1.5462ms,1.546249ms,1.54625ms,1.546299ms,1.5463ms,1.546349ms,1.54635ms,1.546399ms,1.5464ms,1.546449ms,1.54645ms,1.546499ms,1.5465ms,1.546549ms,1.54655ms,1.546599ms,1.5466ms,1.546649ms,1.54665ms,1.546699ms,1.5467ms,1.546749ms,1.54675ms,1.546799ms,1.5468ms,1.546849ms,1.54685ms,1.546899ms,1.5469ms,1.546949ms,1.54695ms,1.546999ms,1.547ms,1.547049ms,1.54705ms,1.547099ms,1.5471ms,1.547149ms,1.54715ms,1.547199ms,1.5472ms,1.547249ms,1.54725ms,1.547299ms,1.5473ms,1.547349ms,1.54735ms,1.547399ms,1.5474ms,1.547449ms,1.54745ms,1.547499ms,1.5475ms,1.547549ms,1.54755ms,1.547599ms,1.5476ms,1.547649ms,1.54765ms,1.547699ms,1.5477ms,1.547749ms,1.54775ms,1.547799ms,1.5478ms,1.547849ms,1.54785ms,1.547899ms,1.5479ms,1.547949ms,1.54795ms,1.547999ms,1.548ms,1.548049ms,1.54805ms,1.548099ms,1.5481ms,1.548149ms,1.54815ms,1.548199ms,1.5482ms,1.548249ms,1.54825ms,1.548299ms,1.5483ms,1.548349ms,1.54835ms,1.548399ms,1.5484ms,1.548449ms,1.54845ms,1.548499ms,1.5485ms,1.548549ms,1.54855ms,1.548599ms,1.5486ms,1.548649ms,1.54865ms,1.548699ms,1.5487ms,1.548749ms,1.54875ms,1.548799ms,1.5488ms,1.548849ms,1.54885ms,1.548899ms,1.5489ms,1.548949ms,1.54895ms,1.548999ms,1.549ms,1.549049ms,1.54905ms,1.549099ms,1.5491ms,1.549149ms,1.54915ms,1.549199ms,1.5492ms,1.549249ms,1.54925ms,1.549299ms,1.5493ms,1.549349ms,1.54935ms,1.549399ms,1.5494ms,1.549449ms,1.54945ms,1.549499ms,1.5495ms,1.549549ms,1.54955ms,1.549599ms,1.5496ms,1.549649ms,1.54965ms,1.549699ms,1.5497ms,1.549749ms,1.54975ms,1.549799ms,1.5498ms,1.549849ms,1.54985ms,1.549899ms,1.5499ms,1.549949ms,1.54995ms,1.549999ms,1.55ms,1.550049ms,1.55005ms,1.550099ms,1.5501ms,1.550149ms,1.55015ms,1.550199ms,1.5502ms,1.550249ms,1.55025ms,1.550299ms,1.5503ms,1.550349ms,1.55035ms,1.550399ms,1.5504ms,1.550449ms,1.55045ms,1.550499ms,1.5505ms,1.550549ms,1.55055ms,1.550599ms,1.5506ms,1.550649ms,1.55065ms,1.550699ms,1.5507ms,1.550749ms,1.55075ms,1.550799ms,1.5508ms,1.550849ms,1.55085ms,1.550899ms,1.5509ms,1.550949ms,1.55095ms,1.550999ms,1.551ms,1.551049ms,1.55105ms,1.551099ms,1.5511ms,1.551149ms,1.55115ms,1.551199ms,1.5512ms,1.551249ms,1.55125ms,1.551299ms,1.5513ms,1.551349ms,1.55135ms,1.551399ms,1.5514ms,1.551449ms,1.55145ms,1.551499ms,1.5515ms,1.551549ms,1.55155ms,1.551599ms,1.5516ms,1.551649ms,1.55165ms,1.551699ms,1.5517ms,1.551749ms,1.55175ms,1.551799ms,1.5518ms,1.551849ms,1.55185ms,1.551899ms,1.5519ms,1.551949ms,1.55195ms,1.551999ms,1.552ms,1.552049ms,1.55205ms,1.552099ms,1.5521ms,1.552149ms,1.55215ms,1.552199ms,1.5522ms,1.552249ms,1.55225ms,1.552299ms,1.5523ms,1.552349ms,1.55235ms,1.552399ms,1.5524ms,1.552449ms,1.55245ms,1.552499ms,1.5525ms,1.552549ms,1.55255ms,1.552599ms,1.5526ms,1.552649ms,1.55265ms,1.552699ms,1.5527ms,1.552749ms,1.55275ms,1.552799ms,1.5528ms,1.552849ms,1.55285ms,1.552899ms,1.5529ms,1.552949ms,1.55295ms,1.552999ms,1.553ms,1.553049ms,1.55305ms,1.553099ms,1.5531ms,1.553149ms,1.55315ms,1.553199ms,1.5532ms,1.553249ms,1.55325ms,1.553299ms,1.5533ms,1.553349ms,1.55335ms,1.553399ms,1.5534ms,1.553449ms,1.55345ms,1.553499ms,1.5535ms,1.553549ms,1.55355ms,1.553599ms,1.5536ms,1.553649ms,1.55365ms,1.553699ms,1.5537ms,1.553749ms,1.55375ms,1.553799ms,1.5538ms,1.553849ms,1.55385ms,1.553899ms,1.5539ms,1.553949ms,1.55395ms,1.553999ms,1.554ms,1.554049ms,1.55405ms,1.554099ms,1.5541ms,1.554149ms,1.55415ms,1.554199ms,1.5542ms,1.554249ms,1.55425ms,1.554299ms,1.5543ms,1.554349ms,1.55435ms,1.554399ms,1.5544ms,1.554449ms,1.55445ms,1.554499ms,1.5545ms,1.554549ms,1.55455ms,1.554599ms,1.5546ms,1.554649ms,1.55465ms,1.554699ms,1.5547ms,1.554749ms,1.55475ms,1.554799ms,1.5548ms,1.554849ms,1.55485ms,1.554899ms,1.5549ms,1.554949ms,1.55495ms,1.554999ms,1.555ms,1.555049ms,1.55505ms,1.555099ms,1.5551ms,1.555149ms,1.55515ms,1.555199ms,1.5552ms,1.555249ms,1.55525ms,1.555299ms,1.5553ms,1.555349ms,1.55535ms,1.555399ms,1.5554ms,1.555449ms,1.55545ms,1.555499ms,1.5555ms,1.555549ms,1.55555ms,1.555599ms,1.5556ms,1.555649ms,1.55565ms,1.555699ms,1.5557ms,1.555749ms,1.55575ms,1.555799ms,1.5558ms,1.555849ms,1.55585ms,1.555899ms,1.5559ms,1.555949ms,1.55595ms,1.555999ms,1.556ms,1.556049ms,1.55605ms,1.556099ms,1.5561ms,1.556149ms,1.55615ms,1.556199ms,1.5562ms,1.556249ms,1.55625ms,1.556299ms,1.5563ms,1.556349ms,1.55635ms,1.556399ms,1.5564ms,1.556449ms,1.55645ms,1.556499ms,1.5565ms,1.556549ms,1.55655ms,1.556599ms,1.5566ms,1.556649ms,1.55665ms,1.556699ms,1.5567ms,1.556749ms,1.55675ms,1.556799ms,1.5568ms,1.556849ms,1.55685ms,1.556899ms,1.5569ms,1.556949ms,1.55695ms,1.556999ms,1.557ms,1.557049ms,1.55705ms,1.557099ms,1.5571ms,1.557149ms,1.55715ms,1.557199ms,1.5572ms,1.557249ms,1.55725ms,1.557299ms,1.5573ms,1.557349ms,1.55735ms,1.557399ms,1.5574ms,1.557449ms,1.55745ms,1.557499ms,1.5575ms,1.557549ms,1.55755ms,1.557599ms,1.5576ms,1.557649ms,1.55765ms,1.557699ms,1.5577ms,1.557749ms,1.55775ms,1.557799ms,1.5578ms,1.557849ms,1.55785ms,1.557899ms,1.5579ms,1.557949ms,1.55795ms,1.557999ms,1.558ms,1.558049ms,1.55805ms,1.558099ms,1.5581ms,1.558149ms,1.55815ms,1.558199ms,1.5582ms,1.558249ms,1.55825ms,1.558299ms,1.5583ms,1.558349ms,1.55835ms,1.558399ms,1.5584ms,1.558449ms,1.55845ms,1.558499ms,1.5585ms,1.558549ms,1.55855ms,1.558599ms,1.5586ms,1.558649ms,1.55865ms,1.558699ms,1.5587ms,1.558749ms,1.55875ms,1.558799ms,1.5588ms,1.558849ms,1.55885ms,1.558899ms,1.5589ms,1.558949ms,1.55895ms,1.558999ms,1.559ms,1.559049ms,1.55905ms,1.559099ms,1.5591ms,1.559149ms,1.55915ms,1.559199ms,1.5592ms,1.559249ms,1.55925ms,1.559299ms,1.5593ms,1.559349ms,1.55935ms,1.559399ms,1.5594ms,1.559449ms,1.55945ms,1.559499ms,1.5595ms,1.559549ms,1.55955ms,1.559599ms,1.5596ms,1.559649ms,1.55965ms,1.559699ms,1.5597ms,1.559749ms,1.55975ms,1.559799ms,1.5598ms,1.559849ms,1.55985ms,1.559899ms,1.5599ms,1.559949ms,1.55995ms,1.559999ms,1.56ms,1.560049ms,1.56005ms,1.560099ms,1.5601ms,1.560149ms,1.56015ms,1.560199ms,1.5602ms,1.560249ms,1.56025ms,1.560299ms,1.5603ms,1.560349ms,1.56035ms,1.560399ms,1.5604ms,1.560449ms,1.56045ms,1.560499ms,1.5605ms,1.560549ms,1.56055ms,1.560599ms,1.5606ms,1.560649ms,1.56065ms,1.560699ms,1.5607ms,1.560749ms,1.56075ms,1.560799ms,1.5608ms,1.560849ms,1.56085ms,1.560899ms,1.5609ms,1.560949ms,1.56095ms,1.560999ms,1.561ms,1.561049ms,1.56105ms,1.561099ms,1.5611ms,1.561149ms,1.56115ms,1.561199ms,1.5612ms,1.561249ms,1.56125ms,1.561299ms,1.5613ms,1.561349ms,1.56135ms,1.561399ms,1.5614ms,1.561449ms,1.56145ms,1.561499ms,1.5615ms,1.561549ms,1.56155ms,1.561599ms,1.5616ms,1.561649ms,1.56165ms,1.561699ms,1.5617ms,1.561749ms,1.56175ms,1.561799ms,1.5618ms,1.561849ms,1.56185ms,1.561899ms,1.5619ms,1.561949ms,1.56195ms,1.561999ms,1.562ms,1.562049ms,1.56205ms,1.562099ms,1.5621ms,1.562149ms,1.56215ms,1.562199ms,1.5622ms,1.562249ms,1.56225ms,1.562299ms,1.5623ms,1.562349ms,1.56235ms,1.562399ms,1.5624ms,1.562449ms,1.56245ms,1.562499ms,1.5625ms,1.562549ms,1.56255ms,1.562599ms,1.5626ms,1.562649ms,1.56265ms,1.562699ms,1.5627ms,1.562749ms,1.56275ms,1.562799ms,1.5628ms,1.562849ms,1.56285ms,1.562899ms,1.5629ms,1.562949ms,1.56295ms,1.562999ms,1.563ms,1.563049ms,1.56305ms,1.563099ms,1.5631ms,1.563149ms,1.56315ms,1.563199ms,1.5632ms,1.563249ms,1.56325ms,1.563299ms,1.5633ms,1.563349ms,1.56335ms,1.563399ms,1.5634ms,1.563449ms,1.56345ms,1.563499ms,1.5635ms,1.563549ms,1.56355ms,1.563599ms,1.5636ms,1.563649ms,1.56365ms,1.563699ms,1.5637ms,1.563749ms,1.56375ms,1.563799ms,1.5638ms,1.563849ms,1.56385ms,1.563899ms,1.5639ms,1.563949ms,1.56395ms,1.563999ms,1.564ms,1.564049ms,1.56405ms,1.564099ms,1.5641ms,1.564149ms,1.56415ms,1.564199ms,1.5642ms,1.564249ms,1.56425ms,1.564299ms,1.5643ms,1.564349ms,1.56435ms,1.564399ms,1.5644ms,1.564449ms,1.56445ms,1.564499ms,1.5645ms,1.564549ms,1.56455ms,1.564599ms,1.5646ms,1.564649ms,1.56465ms,1.564699ms,1.5647ms,1.564749ms,1.56475ms,1.564799ms,1.5648ms,1.564849ms,1.56485ms,1.564899ms,1.5649ms,1.564949ms,1.56495ms,1.564999ms,1.565ms,1.565049ms,1.56505ms,1.565099ms,1.5651ms,1.565149ms,1.56515ms,1.565199ms,1.5652ms,1.565249ms,1.56525ms,1.565299ms,1.5653ms,1.565349ms,1.56535ms,1.565399ms,1.5654ms,1.565449ms,1.56545ms,1.565499ms,1.5655ms,1.565549ms,1.56555ms,1.565599ms,1.5656ms,1.565649ms,1.56565ms,1.565699ms,1.5657ms,1.565749ms,1.56575ms,1.565799ms,1.5658ms,1.565849ms,1.56585ms,1.565899ms,1.5659ms,1.565949ms,1.56595ms,1.565999ms,1.566ms,1.566049ms,1.56605ms,1.566099ms,1.5661ms,1.566149ms,1.56615ms,1.566199ms,1.5662ms,1.566249ms,1.56625ms,1.566299ms,1.5663ms,1.566349ms,1.56635ms,1.566399ms,1.5664ms,1.566449ms,1.56645ms,1.566499ms,1.5665ms,1.566549ms,1.56655ms,1.566599ms,1.5666ms,1.566649ms,1.56665ms,1.566699ms,1.5667ms,1.566749ms,1.56675ms,1.566799ms,1.5668ms,1.566849ms,1.56685ms,1.566899ms,1.5669ms,1.566949ms,1.56695ms,1.566999ms,1.567ms,1.567049ms,1.56705ms,1.567099ms,1.5671ms,1.567149ms,1.56715ms,1.567199ms,1.5672ms,1.567249ms,1.56725ms,1.567299ms,1.5673ms,1.567349ms,1.56735ms,1.567399ms,1.5674ms,1.567449ms,1.56745ms,1.567499ms,1.5675ms,1.567549ms,1.56755ms,1.567599ms,1.5676ms,1.567649ms,1.56765ms,1.567699ms,1.5677ms,1.567749ms,1.56775ms,1.567799ms,1.5678ms,1.567849ms,1.56785ms,1.567899ms,1.5679ms,1.567949ms,1.56795ms,1.567999ms,1.568ms,1.568049ms,1.56805ms,1.568099ms,1.5681ms,1.568149ms,1.56815ms,1.568199ms,1.5682ms,1.568249ms,1.56825ms,1.568299ms,1.5683ms,1.568349ms,1.56835ms,1.568399ms,1.5684ms,1.568449ms,1.56845ms,1.568499ms,1.5685ms,1.568549ms,1.56855ms,1.568599ms,1.5686ms,1.568649ms,1.56865ms,1.568699ms,1.5687ms,1.568749ms,1.56875ms,1.568799ms,1.5688ms,1.568849ms,1.56885ms,1.568899ms,1.5689ms,1.568949ms,1.56895ms,1.568999ms,1.569ms,1.569049ms,1.56905ms,1.569099ms,1.5691ms,1.569149ms,1.56915ms,1.569199ms,1.5692ms,1.569249ms,1.56925ms,1.569299ms,1.5693ms,1.569349ms,1.56935ms,1.569399ms,1.5694ms,1.569449ms,1.56945ms,1.569499ms,1.5695ms,1.569549ms,1.56955ms,1.569599ms,1.5696ms,1.569649ms,1.56965ms,1.569699ms,1.5697ms,1.569749ms,1.56975ms,1.569799ms,1.5698ms,1.569849ms,1.56985ms,1.569899ms,1.5699ms,1.569949ms,1.56995ms,1.569999ms,1.57ms,1.570049ms,1.57005ms,1.570099ms,1.5701ms,1.570149ms,1.57015ms,1.570199ms,1.5702ms,1.570249ms,1.57025ms,1.570299ms,1.5703ms,1.570349ms,1.57035ms,1.570399ms,1.5704ms,1.570449ms,1.57045ms,1.570499ms,1.5705ms,1.570549ms,1.57055ms,1.570599ms,1.5706ms,1.570649ms,1.57065ms,1.570699ms,1.5707ms,1.570749ms,1.57075ms,1.570799ms,1.5708ms,1.570849ms,1.57085ms,1.570899ms,1.5709ms,1.570949ms,1.57095ms,1.570999ms,1.571ms,1.571049ms,1.57105ms,1.571099ms,1.5711ms,1.571149ms,1.57115ms,1.571199ms,1.5712ms,1.571249ms,1.57125ms,1.571299ms,1.5713ms,1.571349ms,1.57135ms,1.571399ms,1.5714ms,1.571449ms,1.57145ms,1.571499ms,1.5715ms,1.571549ms,1.57155ms,1.571599ms,1.5716ms,1.571649ms,1.57165ms,1.571699ms,1.5717ms,1.571749ms,1.57175ms,1.571799ms,1.5718ms,1.571849ms,1.57185ms,1.571899ms,1.5719ms,1.571949ms,1.57195ms,1.571999ms,1.572ms,1.572049ms,1.57205ms,1.572099ms,1.5721ms,1.572149ms,1.57215ms,1.572199ms,1.5722ms,1.572249ms,1.57225ms,1.572299ms,1.5723ms,1.572349ms,1.57235ms,1.572399ms,1.5724ms,1.572449ms,1.57245ms,1.572499ms,1.5725ms,1.572549ms,1.57255ms,1.572599ms,1.5726ms,1.572649ms,1.57265ms,1.572699ms,1.5727ms,1.572749ms,1.57275ms,1.572799ms,1.5728ms,1.572849ms,1.57285ms,1.572899ms,1.5729ms,1.572949ms,1.57295ms,1.572999ms,1.573ms,1.573049ms,1.57305ms,1.573099ms,1.5731ms,1.573149ms,1.57315ms,1.573199ms,1.5732ms,1.573249ms,1.57325ms,1.573299ms,1.5733ms,1.573349ms,1.57335ms,1.573399ms,1.5734ms,1.573449ms,1.57345ms,1.573499ms,1.5735ms,1.573549ms,1.57355ms,1.573599ms,1.5736ms,1.573649ms,1.57365ms,1.573699ms,1.5737ms,1.573749ms,1.57375ms,1.573799ms,1.5738ms,1.573849ms,1.57385ms,1.573899ms,1.5739ms,1.573949ms,1.57395ms,1.573999ms,1.574ms,1.574049ms,1.57405ms,1.574099ms,1.5741ms,1.574149ms,1.57415ms,1.574199ms,1.5742ms,1.574249ms,1.57425ms,1.574299ms,1.5743ms,1.574349ms,1.57435ms,1.574399ms,1.5744ms,1.574449ms,1.57445ms,1.574499ms,1.5745ms,1.574549ms,1.57455ms,1.574599ms,1.5746ms,1.574649ms,1.57465ms,1.574699ms,1.5747ms,1.574749ms,1.57475ms,1.574799ms,1.5748ms,1.574849ms,1.57485ms,1.574899ms,1.5749ms,1.574949ms,1.57495ms,1.574999ms,1.575ms,1.575049ms,1.57505ms,1.575099ms,1.5751ms,1.575149ms,1.57515ms,1.575199ms,1.5752ms,1.575249ms,1.57525ms,1.575299ms,1.5753ms,1.575349ms,1.57535ms,1.575399ms,1.5754ms,1.575449ms,1.57545ms,1.575499ms,1.5755ms,1.575549ms,1.57555ms,1.575599ms,1.5756ms,1.575649ms,1.57565ms,1.575699ms,1.5757ms,1.575749ms,1.57575ms,1.575799ms,1.5758ms,1.575849ms,1.57585ms,1.575899ms,1.5759ms,1.575949ms,1.57595ms,1.575999ms,1.576ms,1.576049ms,1.57605ms,1.576099ms,1.5761ms,1.576149ms,1.57615ms,1.576199ms,1.5762ms,1.576249ms,1.57625ms,1.576299ms,1.5763ms,1.576349ms,1.57635ms,1.576399ms,1.5764ms,1.576449ms,1.57645ms,1.576499ms,1.5765ms,1.576549ms,1.57655ms,1.576599ms,1.5766ms,1.576649ms,1.57665ms,1.576699ms,1.5767ms,1.576749ms,1.57675ms,1.576799ms,1.5768ms,1.576849ms,1.57685ms,1.576899ms,1.5769ms,1.576949ms,1.57695ms,1.576999ms,1.577ms,1.577049ms,1.57705ms,1.577099ms,1.5771ms,1.577149ms,1.57715ms,1.577199ms,1.5772ms,1.577249ms,1.57725ms,1.577299ms,1.5773ms,1.577349ms,1.57735ms,1.577399ms,1.5774ms,1.577449ms,1.57745ms,1.577499ms,1.5775ms,1.577549ms,1.57755ms,1.577599ms,1.5776ms,1.577649ms,1.57765ms,1.577699ms,1.5777ms,1.577749ms,1.57775ms,1.577799ms,1.5778ms,1.577849ms,1.57785ms,1.577899ms,1.5779ms,1.577949ms,1.57795ms,1.577999ms,1.578ms,1.578049ms,1.57805ms,1.578099ms,1.5781ms,1.578149ms,1.57815ms,1.578199ms,1.5782ms,1.578249ms,1.57825ms,1.578299ms,1.5783ms,1.578349ms,1.57835ms,1.578399ms,1.5784ms,1.578449ms,1.57845ms,1.578499ms,1.5785ms,1.578549ms,1.57855ms,1.578599ms,1.5786ms,1.578649ms,1.57865ms,1.578699ms,1.5787ms,1.578749ms,1.57875ms,1.578799ms,1.5788ms,1.578849ms,1.57885ms,1.578899ms,1.5789ms,1.578949ms,1.57895ms,1.578999ms,1.579ms,1.579049ms,1.57905ms,1.579099ms,1.5791ms,1.579149ms,1.57915ms,1.579199ms,1.5792ms,1.579249ms,1.57925ms,1.579299ms,1.5793ms,1.579349ms,1.57935ms,1.579399ms,1.5794ms,1.579449ms,1.57945ms,1.579499ms,1.5795ms,1.579549ms,1.57955ms,1.579599ms,1.5796ms,1.579649ms,1.57965ms,1.579699ms,1.5797ms,1.579749ms,1.57975ms,1.579799ms,1.5798ms,1.579849ms,1.57985ms,1.579899ms,1.5799ms,1.579949ms,1.57995ms,1.579999ms,1.58ms,1.580049ms,1.58005ms,1.580099ms,1.5801ms,1.580149ms,1.58015ms,1.580199ms,1.5802ms,1.580249ms,1.58025ms,1.580299ms,1.5803ms,1.580349ms,1.58035ms,1.580399ms,1.5804ms,1.580449ms,1.58045ms,1.580499ms,1.5805ms,1.580549ms,1.58055ms,1.580599ms,1.5806ms,1.580649ms,1.58065ms,1.580699ms,1.5807ms,1.580749ms,1.58075ms,1.580799ms,1.5808ms,1.580849ms,1.58085ms,1.580899ms,1.5809ms,1.580949ms,1.58095ms,1.580999ms,1.581ms,1.581049ms,1.58105ms,1.581099ms,1.5811ms,1.581149ms,1.58115ms,1.581199ms,1.5812ms,1.581249ms,1.58125ms,1.581299ms,1.5813ms,1.581349ms,1.58135ms,1.581399ms,1.5814ms,1.581449ms,1.58145ms,1.581499ms,1.5815ms,1.581549ms,1.58155ms,1.581599ms,1.5816ms,1.581649ms,1.58165ms,1.581699ms,1.5817ms,1.581749ms,1.58175ms,1.581799ms,1.5818ms,1.581849ms,1.58185ms,1.581899ms,1.5819ms,1.581949ms,1.58195ms,1.581999ms,1.582ms,1.582049ms,1.58205ms,1.582099ms,1.5821ms,1.582149ms,1.58215ms,1.582199ms,1.5822ms,1.582249ms,1.58225ms,1.582299ms,1.5823ms,1.582349ms,1.58235ms,1.582399ms,1.5824ms,1.582449ms,1.58245ms,1.582499ms,1.5825ms,1.582549ms,1.58255ms,1.582599ms,1.5826ms,1.582649ms,1.58265ms,1.582699ms,1.5827ms,1.582749ms,1.58275ms,1.582799ms,1.5828ms,1.582849ms,1.58285ms,1.582899ms,1.5829ms,1.582949ms,1.58295ms,1.582999ms,1.583ms,1.583049ms,1.58305ms,1.583099ms,1.5831ms,1.583149ms,1.58315ms,1.583199ms,1.5832ms,1.583249ms,1.58325ms,1.583299ms,1.5833ms,1.583349ms,1.58335ms,1.583399ms,1.5834ms,1.583449ms,1.58345ms,1.583499ms,1.5835ms,1.583549ms,1.58355ms,1.583599ms,1.5836ms,1.583649ms,1.58365ms,1.583699ms,1.5837ms,1.583749ms,1.58375ms,1.583799ms,1.5838ms,1.583849ms,1.58385ms,1.583899ms,1.5839ms,1.583949ms,1.58395ms,1.583999ms,1.584ms,1.584049ms,1.58405ms,1.584099ms,1.5841ms,1.584149ms,1.58415ms,1.584199ms,1.5842ms,1.584249ms,1.58425ms,1.584299ms,1.5843ms,1.584349ms,1.58435ms,1.584399ms,1.5844ms,1.584449ms,1.58445ms,1.584499ms,1.5845ms,1.584549ms,1.58455ms,1.584599ms,1.5846ms,1.584649ms,1.58465ms,1.584699ms,1.5847ms,1.584749ms,1.58475ms,1.584799ms,1.5848ms,1.584849ms,1.58485ms,1.584899ms,1.5849ms,1.584949ms,1.58495ms,1.584999ms,1.585ms,1.585049ms,1.58505ms,1.585099ms,1.5851ms,1.585149ms,1.58515ms,1.585199ms,1.5852ms,1.585249ms,1.58525ms,1.585299ms,1.5853ms,1.585349ms,1.58535ms,1.585399ms,1.5854ms,1.585449ms,1.58545ms,1.585499ms,1.5855ms,1.585549ms,1.58555ms,1.585599ms,1.5856ms,1.585649ms,1.58565ms,1.585699ms,1.5857ms,1.585749ms,1.58575ms,1.585799ms,1.5858ms,1.585849ms,1.58585ms,1.585899ms,1.5859ms,1.585949ms,1.58595ms,1.585999ms,1.586ms,1.586049ms,1.58605ms,1.586099ms,1.5861ms,1.586149ms,1.58615ms,1.586199ms,1.5862ms,1.586249ms,1.58625ms,1.586299ms,1.5863ms,1.586349ms,1.58635ms,1.586399ms,1.5864ms,1.586449ms,1.58645ms,1.586499ms,1.5865ms,1.586549ms,1.58655ms,1.586599ms,1.5866ms,1.586649ms,1.58665ms,1.586699ms,1.5867ms,1.586749ms,1.58675ms,1.586799ms,1.5868ms,1.586849ms,1.58685ms,1.586899ms,1.5869ms,1.586949ms,1.58695ms,1.586999ms,1.587ms,1.587049ms,1.58705ms,1.587099ms,1.5871ms,1.587149ms,1.58715ms,1.587199ms,1.5872ms,1.587249ms,1.58725ms,1.587299ms,1.5873ms,1.587349ms,1.58735ms,1.587399ms,1.5874ms,1.587449ms,1.58745ms,1.587499ms,1.5875ms,1.587549ms,1.58755ms,1.587599ms,1.5876ms,1.587649ms,1.58765ms,1.587699ms,1.5877ms,1.587749ms,1.58775ms,1.587799ms,1.5878ms,1.587849ms,1.58785ms,1.587899ms,1.5879ms,1.587949ms,1.58795ms,1.587999ms,1.588ms,1.588049ms,1.58805ms,1.588099ms,1.5881ms,1.588149ms,1.58815ms,1.588199ms,1.5882ms,1.588249ms,1.58825ms,1.588299ms,1.5883ms,1.588349ms,1.58835ms,1.588399ms,1.5884ms,1.588449ms,1.58845ms,1.588499ms,1.5885ms,1.588549ms,1.58855ms,1.588599ms,1.5886ms,1.588649ms,1.58865ms,1.588699ms,1.5887ms,1.588749ms,1.58875ms,1.588799ms,1.5888ms,1.588849ms,1.58885ms,1.588899ms,1.5889ms,1.588949ms,1.58895ms,1.588999ms,1.589ms,1.589049ms,1.58905ms,1.589099ms,1.5891ms,1.589149ms,1.58915ms,1.589199ms,1.5892ms,1.589249ms,1.58925ms,1.589299ms,1.5893ms,1.589349ms,1.58935ms,1.589399ms,1.5894ms,1.589449ms,1.58945ms,1.589499ms,1.5895ms,1.589549ms,1.58955ms,1.589599ms,1.5896ms,1.589649ms,1.58965ms,1.589699ms,1.5897ms,1.589749ms,1.58975ms,1.589799ms,1.5898ms,1.589849ms,1.58985ms,1.589899ms,1.5899ms,1.589949ms,1.58995ms,1.589999ms,1.59ms,1.590049ms,1.59005ms,1.590099ms,1.5901ms,1.590149ms,1.59015ms,1.590199ms,1.5902ms,1.590249ms,1.59025ms,1.590299ms,1.5903ms,1.590349ms,1.59035ms,1.590399ms,1.5904ms,1.590449ms,1.59045ms,1.590499ms,1.5905ms,1.590549ms,1.59055ms,1.590599ms,1.5906ms,1.590649ms,1.59065ms,1.590699ms,1.5907ms,1.590749ms,1.59075ms,1.590799ms,1.5908ms,1.590849ms,1.59085ms,1.590899ms,1.5909ms,1.590949ms,1.59095ms,1.590999ms,1.591ms,1.591049ms,1.59105ms,1.591099ms,1.5911ms,1.591149ms,1.59115ms,1.591199ms,1.5912ms,1.591249ms,1.59125ms,1.591299ms,1.5913ms,1.591349ms,1.59135ms,1.591399ms,1.5914ms,1.591449ms,1.59145ms,1.591499ms,1.5915ms,1.591549ms,1.59155ms,1.591599ms,1.5916ms,1.591649ms,1.59165ms,1.591699ms,1.5917ms,1.591749ms,1.59175ms,1.591799ms,1.5918ms,1.591849ms,1.59185ms,1.591899ms,1.5919ms,1.591949ms,1.59195ms,1.591999ms,1.592ms,1.592049ms,1.59205ms,1.592099ms,1.5921ms,1.592149ms,1.59215ms,1.592199ms,1.5922ms,1.592249ms,1.59225ms,1.592299ms,1.5923ms,1.592349ms,1.59235ms,1.592399ms,1.5924ms,1.592449ms,1.59245ms,1.592499ms,1.5925ms,1.592549ms,1.59255ms,1.592599ms,1.5926ms,1.592649ms,1.59265ms,1.592699ms,1.5927ms,1.592749ms,1.59275ms,1.592799ms,1.5928ms,1.592849ms,1.59285ms,1.592899ms,1.5929ms,1.592949ms,1.59295ms,1.592999ms,1.593ms,1.593049ms,1.59305ms,1.593099ms,1.5931ms,1.593149ms,1.59315ms,1.593199ms,1.5932ms,1.593249ms,1.59325ms,1.593299ms,1.5933ms,1.593349ms,1.59335ms,1.593399ms,1.5934ms,1.593449ms,1.59345ms,1.593499ms,1.5935ms,1.593549ms,1.59355ms,1.593599ms,1.5936ms,1.593649ms,1.59365ms,1.593699ms,1.5937ms,1.593749ms,1.59375ms,1.593799ms,1.5938ms,1.593849ms,1.59385ms,1.593899ms,1.5939ms,1.593949ms,1.59395ms,1.593999ms,1.594ms,1.594049ms,1.59405ms,1.594099ms,1.5941ms,1.594149ms,1.59415ms,1.594199ms,1.5942ms,1.594249ms,1.59425ms,1.594299ms,1.5943ms,1.594349ms,1.59435ms,1.594399ms,1.5944ms,1.594449ms,1.59445ms,1.594499ms,1.5945ms,1.594549ms,1.59455ms,1.594599ms,1.5946ms,1.594649ms,1.59465ms,1.594699ms,1.5947ms,1.594749ms,1.59475ms,1.594799ms,1.5948ms,1.594849ms,1.59485ms,1.594899ms,1.5949ms,1.594949ms,1.59495ms,1.594999ms,1.595ms,1.595049ms,1.59505ms,1.595099ms,1.5951ms,1.595149ms,1.59515ms,1.595199ms,1.5952ms,1.595249ms,1.59525ms,1.595299ms,1.5953ms,1.595349ms,1.59535ms,1.595399ms,1.5954ms,1.595449ms,1.59545ms,1.595499ms,1.5955ms,1.595549ms,1.59555ms,1.595599ms,1.5956ms,1.595649ms,1.59565ms,1.595699ms,1.5957ms,1.595749ms,1.59575ms,1.595799ms,1.5958ms,1.595849ms,1.59585ms,1.595899ms,1.5959ms,1.595949ms,1.59595ms,1.595999ms,1.596ms,1.596049ms,1.59605ms,1.596099ms,1.5961ms,1.596149ms,1.59615ms,1.596199ms,1.5962ms,1.596249ms,1.59625ms,1.596299ms,1.5963ms,1.596349ms,1.59635ms,1.596399ms,1.5964ms,1.596449ms,1.59645ms,1.596499ms,1.5965ms,1.596549ms,1.59655ms,1.596599ms,1.5966ms,1.596649ms,1.59665ms,1.596699ms,1.5967ms,1.596749ms,1.59675ms,1.596799ms,1.5968ms,1.596849ms,1.59685ms,1.596899ms,1.5969ms,1.596949ms,1.59695ms,1.596999ms,1.597ms,1.597049ms,1.59705ms,1.597099ms,1.5971ms,1.597149ms,1.59715ms,1.597199ms,1.5972ms,1.597249ms,1.59725ms,1.597299ms,1.5973ms,1.597349ms,1.59735ms,1.597399ms,1.5974ms,1.597449ms,1.59745ms,1.597499ms,1.5975ms,1.597549ms,1.59755ms,1.597599ms,1.5976ms,1.597649ms,1.59765ms,1.597699ms,1.5977ms,1.597749ms,1.59775ms,1.597799ms,1.5978ms,1.597849ms,1.59785ms,1.597899ms,1.5979ms,1.597949ms,1.59795ms,1.597999ms,1.598ms,1.598049ms,1.59805ms,1.598099ms,1.5981ms,1.598149ms,1.59815ms,1.598199ms,1.5982ms,1.598249ms,1.59825ms,1.598299ms,1.5983ms,1.598349ms,1.59835ms,1.598399ms,1.5984ms,1.598449ms,1.59845ms,1.598499ms,1.5985ms,1.598549ms,1.59855ms,1.598599ms,1.5986ms,1.598649ms,1.59865ms,1.598699ms,1.5987ms,1.598749ms,1.59875ms,1.598799ms,1.5988ms,1.598849ms,1.59885ms,1.598899ms,1.5989ms,1.598949ms,1.59895ms,1.598999ms,1.599ms,1.599049ms,1.59905ms,1.599099ms,1.5991ms,1.599149ms,1.59915ms,1.599199ms,1.5992ms,1.599249ms,1.59925ms,1.599299ms,1.5993ms,1.599349ms,1.59935ms,1.599399ms,1.5994ms,1.599449ms,1.59945ms,1.599499ms,1.5995ms,1.599549ms,1.59955ms,1.599599ms,1.5996ms,1.599649ms,1.59965ms,1.599699ms,1.5997ms,1.599749ms,1.59975ms,1.599799ms,1.5998ms,1.599849ms,1.59985ms,1.599899ms,1.5999ms,1.599949ms,1.59995ms,1.599999ms,1.6ms,1.600049ms,1.60005ms,1.600099ms,1.6001ms,1.600149ms,1.60015ms,1.600199ms,1.6002ms,1.600249ms,1.60025ms,1.600299ms,1.6003ms,1.600349ms,1.60035ms,1.600399ms,1.6004ms,1.600449ms,1.60045ms,1.600499ms,1.6005ms,1.600549ms,1.60055ms,1.600599ms,1.6006ms,1.600649ms,1.60065ms,1.600699ms,1.6007ms,1.600749ms,1.60075ms,1.600799ms,1.6008ms,1.600849ms,1.60085ms,1.600899ms,1.6009ms,1.600949ms,1.60095ms,1.600999ms,1.601ms,1.601049ms,1.60105ms,1.601099ms,1.6011ms,1.601149ms,1.60115ms,1.601199ms,1.6012ms,1.601249ms,1.60125ms,1.601299ms,1.6013ms,1.601349ms,1.60135ms,1.601399ms,1.6014ms,1.601449ms,1.60145ms,1.601499ms,1.6015ms,1.601549ms,1.60155ms,1.601599ms,1.6016ms,1.601649ms,1.60165ms,1.601699ms,1.6017ms,1.601749ms,1.60175ms,1.601799ms,1.6018ms,1.601849ms,1.60185ms,1.601899ms,1.6019ms,1.601949ms,1.60195ms,1.601999ms,1.602ms,1.602049ms,1.60205ms,1.602099ms,1.6021ms,1.602149ms,1.60215ms,1.602199ms,1.6022ms,1.602249ms,1.60225ms,1.602299ms,1.6023ms,1.602349ms,1.60235ms,1.602399ms,1.6024ms,1.602449ms,1.60245ms,1.602499ms,1.6025ms,1.602549ms,1.60255ms,1.602599ms,1.6026ms,1.602649ms,1.60265ms,1.602699ms,1.6027ms,1.602749ms,1.60275ms,1.602799ms,1.6028ms,1.602849ms,1.60285ms,1.602899ms,1.6029ms,1.602949ms,1.60295ms,1.602999ms,1.603ms,1.603049ms,1.60305ms,1.603099ms,1.6031ms,1.603149ms,1.60315ms,1.603199ms,1.6032ms,1.603249ms,1.60325ms,1.603299ms,1.6033ms,1.603349ms,1.60335ms,1.603399ms,1.6034ms,1.603449ms,1.60345ms,1.603499ms,1.6035ms,1.603549ms,1.60355ms,1.603599ms,1.6036ms,1.603649ms,1.60365ms,1.603699ms,1.6037ms,1.603749ms,1.60375ms,1.603799ms,1.6038ms,1.603849ms,1.60385ms,1.603899ms,1.6039ms,1.603949ms,1.60395ms,1.603999ms,1.604ms,1.604049ms,1.60405ms,1.604099ms,1.6041ms,1.604149ms,1.60415ms,1.604199ms,1.6042ms,1.604249ms,1.60425ms,1.604299ms,1.6043ms,1.604349ms,1.60435ms,1.604399ms,1.6044ms,1.604449ms,1.60445ms,1.604499ms,1.6045ms,1.604549ms,1.60455ms,1.604599ms,1.6046ms,1.604649ms,1.60465ms,1.604699ms,1.6047ms,1.604749ms,1.60475ms,1.604799ms,1.6048ms,1.604849ms,1.60485ms,1.604899ms,1.6049ms,1.604949ms,1.60495ms,1.604999ms,1.605ms,1.605049ms,1.60505ms,1.605099ms,1.6051ms,1.605149ms,1.60515ms,1.605199ms,1.6052ms,1.605249ms,1.60525ms,1.605299ms,1.6053ms,1.605349ms,1.60535ms,1.605399ms,1.6054ms,1.605449ms,1.60545ms,1.605499ms,1.6055ms,1.605549ms,1.60555ms,1.605599ms,1.6056ms,1.605649ms,1.60565ms,1.605699ms,1.6057ms,1.605749ms,1.60575ms,1.605799ms,1.6058ms,1.605849ms,1.60585ms,1.605899ms,1.6059ms,1.605949ms,1.60595ms,1.605999ms,1.606ms,1.606049ms,1.60605ms,1.606099ms,1.6061ms,1.606149ms,1.60615ms,1.606199ms,1.6062ms,1.606249ms,1.60625ms,1.606299ms,1.6063ms,1.606349ms,1.60635ms,1.606399ms,1.6064ms,1.606449ms,1.60645ms,1.606499ms,1.6065ms,1.606549ms,1.60655ms,1.606599ms,1.6066ms,1.606649ms,1.60665ms,1.606699ms,1.6067ms,1.606749ms,1.60675ms,1.606799ms,1.6068ms,1.606849ms,1.60685ms,1.606899ms,1.6069ms,1.606949ms,1.60695ms,1.606999ms,1.607ms,1.607049ms,1.60705ms,1.607099ms,1.6071ms,1.607149ms,1.60715ms,1.607199ms,1.6072ms,1.607249ms,1.60725ms,1.607299ms,1.6073ms,1.607349ms,1.60735ms,1.607399ms,1.6074ms,1.607449ms,1.60745ms,1.607499ms,1.6075ms,1.607549ms,1.60755ms,1.607599ms,1.6076ms,1.607649ms,1.60765ms,1.607699ms,1.6077ms,1.607749ms,1.60775ms,1.607799ms,1.6078ms,1.607849ms,1.60785ms,1.607899ms,1.6079ms,1.607949ms,1.60795ms,1.607999ms,1.608ms,1.608049ms,1.60805ms,1.608099ms,1.6081ms,1.608149ms,1.60815ms,1.608199ms,1.6082ms,1.608249ms,1.60825ms,1.608299ms,1.6083ms,1.608349ms,1.60835ms,1.608399ms,1.6084ms,1.608449ms,1.60845ms,1.608499ms,1.6085ms,1.608549ms,1.60855ms,1.608599ms,1.6086ms,1.608649ms,1.60865ms,1.608699ms,1.6087ms,1.608749ms,1.60875ms,1.608799ms,1.6088ms,1.608849ms,1.60885ms,1.608899ms,1.6089ms,1.608949ms,1.60895ms,1.608999ms,1.609ms,1.609049ms,1.60905ms,1.609099ms,1.6091ms,1.609149ms,1.60915ms,1.609199ms,1.6092ms,1.609249ms,1.60925ms,1.609299ms,1.6093ms,1.609349ms,1.60935ms,1.609399ms,1.6094ms,1.609449ms,1.60945ms,1.609499ms,1.6095ms,1.609549ms,1.60955ms,1.609599ms,1.6096ms,1.609649ms,1.60965ms,1.609699ms,1.6097ms,1.609749ms,1.60975ms,1.609799ms,1.6098ms,1.609849ms,1.60985ms,1.609899ms,1.6099ms,1.609949ms,1.60995ms,1.609999ms,1.61ms,1.610049ms,1.61005ms,1.610099ms,1.6101ms,1.610149ms,1.61015ms,1.610199ms,1.6102ms,1.610249ms,1.61025ms,1.610299ms,1.6103ms,1.610349ms,1.61035ms,1.610399ms,1.6104ms,1.610449ms,1.61045ms,1.610499ms,1.6105ms,1.610549ms,1.61055ms,1.610599ms,1.6106ms,1.610649ms,1.61065ms,1.610699ms,1.6107ms,1.610749ms,1.61075ms,1.610799ms,1.6108ms,1.610849ms,1.61085ms,1.610899ms,1.6109ms,1.610949ms,1.61095ms,1.610999ms,1.611ms,1.611049ms,1.61105ms,1.611099ms,1.6111ms,1.611149ms,1.61115ms,1.611199ms,1.6112ms,1.611249ms,1.61125ms,1.611299ms,1.6113ms,1.611349ms,1.61135ms,1.611399ms,1.6114ms,1.611449ms,1.61145ms,1.611499ms,1.6115ms,1.611549ms,1.61155ms,1.611599ms,1.6116ms,1.611649ms,1.61165ms,1.611699ms,1.6117ms,1.611749ms,1.61175ms,1.611799ms,1.6118ms,1.611849ms,1.61185ms,1.611899ms,1.6119ms,1.611949ms,1.61195ms,1.611999ms,1.612ms,1.612049ms,1.61205ms,1.612099ms,1.6121ms,1.612149ms,1.61215ms,1.612199ms,1.6122ms,1.612249ms,1.61225ms,1.612299ms,1.6123ms,1.612349ms,1.61235ms,1.612399ms,1.6124ms,1.612449ms,1.61245ms,1.612499ms,1.6125ms,1.612549ms,1.61255ms,1.612599ms,1.6126ms,1.612649ms,1.61265ms,1.612699ms,1.6127ms,1.612749ms,1.61275ms,1.612799ms,1.6128ms,1.612849ms,1.61285ms,1.612899ms,1.6129ms,1.612949ms,1.61295ms,1.612999ms,1.613ms,1.613049ms,1.61305ms,1.613099ms,1.6131ms,1.613149ms,1.61315ms,1.613199ms,1.6132ms,1.613249ms,1.61325ms,1.613299ms,1.6133ms,1.613349ms,1.61335ms,1.613399ms,1.6134ms,1.613449ms,1.61345ms,1.613499ms,1.6135ms,1.613549ms,1.61355ms,1.613599ms,1.6136ms,1.613649ms,1.61365ms,1.613699ms,1.6137ms,1.613749ms,1.61375ms,1.613799ms,1.6138ms,1.613849ms,1.61385ms,1.613899ms,1.6139ms,1.613949ms,1.61395ms,1.613999ms,1.614ms,1.614049ms,1.61405ms,1.614099ms,1.6141ms,1.614149ms,1.61415ms,1.614199ms,1.6142ms,1.614249ms,1.61425ms,1.614299ms,1.6143ms,1.614349ms,1.61435ms,1.614399ms,1.6144ms,1.614449ms,1.61445ms,1.614499ms,1.6145ms,1.614549ms,1.61455ms,1.614599ms,1.6146ms,1.614649ms,1.61465ms,1.614699ms,1.6147ms,1.614749ms,1.61475ms,1.614799ms,1.6148ms,1.614849ms,1.61485ms,1.614899ms,1.6149ms,1.614949ms,1.61495ms,1.614999ms,1.615ms,1.615049ms,1.61505ms,1.615099ms,1.6151ms,1.615149ms,1.61515ms,1.615199ms,1.6152ms,1.615249ms,1.61525ms,1.615299ms,1.6153ms,1.615349ms,1.61535ms,1.615399ms,1.6154ms,1.615449ms,1.61545ms,1.615499ms,1.6155ms,1.615549ms,1.61555ms,1.615599ms,1.6156ms,1.615649ms,1.61565ms,1.615699ms,1.6157ms,1.615749ms,1.61575ms,1.615799ms,1.6158ms,1.615849ms,1.61585ms,1.615899ms,1.6159ms,1.615949ms,1.61595ms,1.615999ms,1.616ms,1.616049ms,1.61605ms,1.616099ms,1.6161ms,1.616149ms,1.61615ms,1.616199ms,1.6162ms,1.616249ms,1.61625ms,1.616299ms,1.6163ms,1.616349ms,1.61635ms,1.616399ms,1.6164ms,1.616449ms,1.61645ms,1.616499ms,1.6165ms,1.616549ms,1.61655ms,1.616599ms,1.6166ms,1.616649ms,1.61665ms,1.616699ms,1.6167ms,1.616749ms,1.61675ms,1.616799ms,1.6168ms,1.616849ms,1.61685ms,1.616899ms,1.6169ms,1.616949ms,1.61695ms,1.616999ms,1.617ms,1.617049ms,1.61705ms,1.617099ms,1.6171ms,1.617149ms,1.61715ms,1.617199ms,1.6172ms,1.617249ms,1.61725ms,1.617299ms,1.6173ms,1.617349ms,1.61735ms,1.617399ms,1.6174ms,1.617449ms,1.61745ms,1.617499ms,1.6175ms,1.617549ms,1.61755ms,1.617599ms,1.6176ms,1.617649ms,1.61765ms,1.617699ms,1.6177ms,1.617749ms,1.61775ms,1.617799ms,1.6178ms,1.617849ms,1.61785ms,1.617899ms,1.6179ms,1.617949ms,1.61795ms,1.617999ms,1.618ms,1.618049ms,1.61805ms,1.618099ms,1.6181ms,1.618149ms,1.61815ms,1.618199ms,1.6182ms,1.618249ms,1.61825ms,1.618299ms,1.6183ms,1.618349ms,1.61835ms,1.618399ms,1.6184ms,1.618449ms,1.61845ms,1.618499ms,1.6185ms,1.618549ms,1.61855ms,1.618599ms,1.6186ms,1.618649ms,1.61865ms,1.618699ms,1.6187ms,1.618749ms,1.61875ms,1.618799ms,1.6188ms,1.618849ms,1.61885ms,1.618899ms,1.6189ms,1.618949ms,1.61895ms,1.618999ms,1.619ms,1.619049ms,1.61905ms,1.619099ms,1.6191ms,1.619149ms,1.61915ms,1.619199ms,1.6192ms,1.619249ms,1.61925ms,1.619299ms,1.6193ms,1.619349ms,1.61935ms,1.619399ms,1.6194ms,1.619449ms,1.61945ms,1.619499ms,1.6195ms,1.619549ms,1.61955ms,1.619599ms,1.6196ms,1.619649ms,1.61965ms,1.619699ms,1.6197ms,1.619749ms,1.61975ms,1.619799ms,1.6198ms,1.619849ms,1.61985ms,1.619899ms,1.6199ms,1.619949ms,1.61995ms,1.619999ms,1.62ms,1.620049ms,1.62005ms,1.620099ms,1.6201ms,1.620149ms,1.62015ms,1.620199ms,1.6202ms,1.620249ms,1.62025ms,1.620299ms,1.6203ms,1.620349ms,1.62035ms,1.620399ms,1.6204ms,1.620449ms,1.62045ms,1.620499ms,1.6205ms,1.620549ms,1.62055ms,1.620599ms,1.6206ms,1.620649ms,1.62065ms,1.620699ms,1.6207ms,1.620749ms,1.62075ms,1.620799ms,1.6208ms,1.620849ms,1.62085ms,1.620899ms,1.6209ms,1.620949ms,1.62095ms,1.620999ms,1.621ms,1.621049ms,1.62105ms,1.621099ms,1.6211ms,1.621149ms,1.62115ms,1.621199ms,1.6212ms,1.621249ms,1.62125ms,1.621299ms,1.6213ms,1.621349ms,1.62135ms,1.621399ms,1.6214ms,1.621449ms,1.62145ms,1.621499ms,1.6215ms,1.621549ms,1.62155ms,1.621599ms,1.6216ms,1.621649ms,1.62165ms,1.621699ms,1.6217ms,1.621749ms,1.62175ms,1.621799ms,1.6218ms,1.621849ms,1.62185ms,1.621899ms,1.6219ms,1.621949ms,1.62195ms,1.621999ms,1.622ms,1.622049ms,1.62205ms,1.622099ms,1.6221ms,1.622149ms,1.62215ms,1.622199ms,1.6222ms,1.622249ms,1.62225ms,1.622299ms,1.6223ms,1.622349ms,1.62235ms,1.622399ms,1.6224ms,1.622449ms,1.62245ms,1.622499ms,1.6225ms,1.622549ms,1.62255ms,1.622599ms,1.6226ms,1.622649ms,1.62265ms,1.622699ms,1.6227ms,1.622749ms,1.62275ms,1.622799ms,1.6228ms,1.622849ms,1.62285ms,1.622899ms,1.6229ms,1.622949ms,1.62295ms,1.622999ms,1.623ms,1.623049ms,1.62305ms,1.623099ms,1.6231ms,1.623149ms,1.62315ms,1.623199ms,1.6232ms,1.623249ms,1.62325ms,1.623299ms,1.6233ms,1.623349ms,1.62335ms,1.623399ms,1.6234ms,1.623449ms,1.62345ms,1.623499ms,1.6235ms,1.623549ms,1.62355ms,1.623599ms,1.6236ms,1.623649ms,1.62365ms,1.623699ms,1.6237ms,1.623749ms,1.62375ms,1.623799ms,1.6238ms,1.623849ms,1.62385ms,1.623899ms,1.6239ms,1.623949ms,1.62395ms,1.623999ms,1.624ms,1.624049ms,1.62405ms,1.624099ms,1.6241ms,1.624149ms,1.62415ms,1.624199ms,1.6242ms,1.624249ms,1.62425ms,1.624299ms,1.6243ms,1.624349ms,1.62435ms,1.624399ms,1.6244ms,1.624449ms,1.62445ms,1.624499ms,1.6245ms,1.624549ms,1.62455ms,1.624599ms,1.6246ms,1.624649ms,1.62465ms,1.624699ms,1.6247ms,1.624749ms,1.62475ms,1.624799ms,1.6248ms,1.624849ms,1.62485ms,1.624899ms,1.6249ms,1.624949ms,1.62495ms,1.624999ms,1.625ms,1.625049ms,1.62505ms,1.625099ms,1.6251ms,1.625149ms,1.62515ms,1.625199ms,1.6252ms,1.625249ms,1.62525ms,1.625299ms,1.6253ms,1.625349ms,1.62535ms,1.625399ms,1.6254ms,1.625449ms,1.62545ms,1.625499ms,1.6255ms,1.625549ms,1.62555ms,1.625599ms,1.6256ms,1.625649ms,1.62565ms,1.625699ms,1.6257ms,1.625749ms,1.62575ms,1.625799ms,1.6258ms,1.625849ms,1.62585ms,1.625899ms,1.6259ms,1.625949ms,1.62595ms,1.625999ms,1.626ms,1.626049ms,1.62605ms,1.626099ms,1.6261ms,1.626149ms,1.62615ms,1.626199ms,1.6262ms,1.626249ms,1.62625ms,1.626299ms,1.6263ms,1.626349ms,1.62635ms,1.626399ms,1.6264ms,1.626449ms,1.62645ms,1.626499ms,1.6265ms,1.626549ms,1.62655ms,1.626599ms,1.6266ms,1.626649ms,1.62665ms,1.626699ms,1.6267ms,1.626749ms,1.62675ms,1.626799ms,1.6268ms,1.626849ms,1.62685ms,1.626899ms,1.6269ms,1.626949ms,1.62695ms,1.626999ms,1.627ms,1.627049ms,1.62705ms,1.627099ms,1.6271ms,1.627149ms,1.62715ms,1.627199ms,1.6272ms,1.627249ms,1.62725ms,1.627299ms,1.6273ms,1.627349ms,1.62735ms,1.627399ms,1.6274ms,1.627449ms,1.62745ms,1.627499ms,1.6275ms,1.627549ms,1.62755ms,1.627599ms,1.6276ms,1.627649ms,1.62765ms,1.627699ms,1.6277ms,1.627749ms,1.62775ms,1.627799ms,1.6278ms,1.627849ms,1.62785ms,1.627899ms,1.6279ms,1.627949ms,1.62795ms,1.627999ms,1.628ms,1.628049ms,1.62805ms,1.628099ms,1.6281ms,1.628149ms,1.62815ms,1.628199ms,1.6282ms,1.628249ms,1.62825ms,1.628299ms,1.6283ms,1.628349ms,1.62835ms,1.628399ms,1.6284ms,1.628449ms,1.62845ms,1.628499ms,1.6285ms,1.628549ms,1.62855ms,1.628599ms,1.6286ms,1.628649ms,1.62865ms,1.628699ms,1.6287ms,1.628749ms,1.62875ms,1.628799ms,1.6288ms,1.628849ms,1.62885ms,1.628899ms,1.6289ms,1.628949ms,1.62895ms,1.628999ms,1.629ms,1.629049ms,1.62905ms,1.629099ms,1.6291ms,1.629149ms,1.62915ms,1.629199ms,1.6292ms,1.629249ms,1.62925ms,1.629299ms,1.6293ms,1.629349ms,1.62935ms,1.629399ms,1.6294ms,1.629449ms,1.62945ms,1.629499ms,1.6295ms,1.629549ms,1.62955ms,1.629599ms,1.6296ms,1.629649ms,1.62965ms,1.629699ms,1.6297ms,1.629749ms,1.62975ms,1.629799ms,1.6298ms,1.629849ms,1.62985ms,1.629899ms,1.6299ms,1.629949ms,1.62995ms,1.629999ms,1.63ms,1.630049ms,1.63005ms,1.630099ms,1.6301ms,1.630149ms,1.63015ms,1.630199ms,1.6302ms,1.630249ms,1.63025ms,1.630299ms,1.6303ms,1.630349ms,1.63035ms,1.630399ms,1.6304ms,1.630449ms,1.63045ms,1.630499ms,1.6305ms,1.630549ms,1.63055ms,1.630599ms,1.6306ms,1.630649ms,1.63065ms,1.630699ms,1.6307ms,1.630749ms,1.63075ms,1.630799ms,1.6308ms,1.630849ms,1.63085ms,1.630899ms,1.6309ms,1.630949ms,1.63095ms,1.630999ms,1.631ms,1.631049ms,1.63105ms,1.631099ms,1.6311ms,1.631149ms,1.63115ms,1.631199ms,1.6312ms,1.631249ms,1.63125ms,1.631299ms,1.6313ms,1.631349ms,1.63135ms,1.631399ms,1.6314ms,1.631449ms,1.63145ms,1.631499ms,1.6315ms,1.631549ms,1.63155ms,1.631599ms,1.6316ms,1.631649ms,1.63165ms,1.631699ms,1.6317ms,1.631749ms,1.63175ms,1.631799ms,1.6318ms,1.631849ms,1.63185ms,1.631899ms,1.6319ms,1.631949ms,1.63195ms,1.631999ms,1.632ms,1.632049ms,1.63205ms,1.632099ms,1.6321ms,1.632149ms,1.63215ms,1.632199ms,1.6322ms,1.632249ms,1.63225ms,1.632299ms,1.6323ms,1.632349ms,1.63235ms,1.632399ms,1.6324ms,1.632449ms,1.63245ms,1.632499ms,1.6325ms,1.632549ms,1.63255ms,1.632599ms,1.6326ms,1.632649ms,1.63265ms,1.632699ms,1.6327ms,1.632749ms,1.63275ms,1.632799ms,1.6328ms,1.632849ms,1.63285ms,1.632899ms,1.6329ms,1.632949ms,1.63295ms,1.632999ms,1.633ms,1.633049ms,1.63305ms,1.633099ms,1.6331ms,1.633149ms,1.63315ms,1.633199ms,1.6332ms,1.633249ms,1.63325ms,1.633299ms,1.6333ms,1.633349ms,1.63335ms,1.633399ms,1.6334ms,1.633449ms,1.63345ms,1.633499ms,1.6335ms,1.633549ms,1.63355ms,1.633599ms,1.6336ms,1.633649ms,1.63365ms,1.633699ms,1.6337ms,1.633749ms,1.63375ms,1.633799ms,1.6338ms,1.633849ms,1.63385ms,1.633899ms,1.6339ms,1.633949ms,1.63395ms,1.633999ms,1.634ms,1.634049ms,1.63405ms,1.634099ms,1.6341ms,1.634149ms,1.63415ms,1.634199ms,1.6342ms,1.634249ms,1.63425ms,1.634299ms,1.6343ms,1.634349ms,1.63435ms,1.634399ms,1.6344ms,1.634449ms,1.63445ms,1.634499ms,1.6345ms,1.634549ms,1.63455ms,1.634599ms,1.6346ms,1.634649ms,1.63465ms,1.634699ms,1.6347ms,1.634749ms,1.63475ms,1.634799ms,1.6348ms,1.634849ms,1.63485ms,1.634899ms,1.6349ms,1.634949ms,1.63495ms,1.634999ms,1.635ms,1.635049ms,1.63505ms,1.635099ms,1.6351ms,1.635149ms,1.63515ms,1.635199ms,1.6352ms,1.635249ms,1.63525ms,1.635299ms,1.6353ms,1.635349ms,1.63535ms,1.635399ms,1.6354ms,1.635449ms,1.63545ms,1.635499ms,1.6355ms,1.635549ms,1.63555ms,1.635599ms,1.6356ms,1.635649ms,1.63565ms,1.635699ms,1.6357ms,1.635749ms,1.63575ms,1.635799ms,1.6358ms,1.635849ms,1.63585ms,1.635899ms,1.6359ms,1.635949ms,1.63595ms,1.635999ms,1.636ms,1.636049ms,1.63605ms,1.636099ms,1.6361ms,1.636149ms,1.63615ms,1.636199ms,1.6362ms,1.636249ms,1.63625ms,1.636299ms,1.6363ms,1.636349ms,1.63635ms,1.636399ms,1.6364ms,1.636449ms,1.63645ms,1.636499ms,1.6365ms,1.636549ms,1.63655ms,1.636599ms,1.6366ms,1.636649ms,1.63665ms,1.636699ms,1.6367ms,1.636749ms,1.63675ms,1.636799ms,1.6368ms,1.636849ms,1.63685ms,1.636899ms,1.6369ms,1.636949ms,1.63695ms,1.636999ms,1.637ms,1.637049ms,1.63705ms,1.637099ms,1.6371ms,1.637149ms,1.63715ms,1.637199ms,1.6372ms,1.637249ms,1.63725ms,1.637299ms,1.6373ms,1.637349ms,1.63735ms,1.637399ms,1.6374ms,1.637449ms,1.63745ms,1.637499ms,1.6375ms,1.637549ms,1.63755ms,1.637599ms,1.6376ms,1.637649ms,1.63765ms,1.637699ms,1.6377ms,1.637749ms,1.63775ms,1.637799ms,1.6378ms,1.637849ms,1.63785ms,1.637899ms,1.6379ms,1.637949ms,1.63795ms,1.637999ms,1.638ms,1.638049ms,1.63805ms,1.638099ms,1.6381ms,1.638149ms,1.63815ms,1.638199ms,1.6382ms,1.638249ms,1.63825ms,1.638299ms,1.6383ms,1.638349ms,1.63835ms,1.638399ms,1.6384ms,1.638449ms,1.63845ms,1.638499ms,1.6385ms,1.638549ms,1.63855ms,1.638599ms,1.6386ms,1.638649ms,1.63865ms,1.638699ms,1.6387ms,1.638749ms,1.63875ms,1.638799ms,1.6388ms,1.638849ms,1.63885ms,1.638899ms,1.6389ms,1.638949ms,1.63895ms,1.638999ms,1.639ms,1.639049ms,1.63905ms,1.639099ms,1.6391ms,1.639149ms,1.63915ms,1.639199ms,1.6392ms,1.639249ms,1.63925ms,1.639299ms,1.6393ms,1.639349ms,1.63935ms,1.639399ms,1.6394ms,1.639449ms,1.63945ms,1.639499ms,1.6395ms,1.639549ms,1.63955ms,1.639599ms,1.6396ms,1.639649ms,1.63965ms,1.639699ms,1.6397ms,1.639749ms,1.63975ms,1.639799ms,1.6398ms,1.639849ms,1.63985ms,1.639899ms,1.6399ms,1.639949ms,1.63995ms,1.639999ms,1.64ms,1.640049ms,1.64005ms,1.640099ms,1.6401ms,1.640149ms,1.64015ms,1.640199ms,1.6402ms,1.640249ms,1.64025ms,1.640299ms,1.6403ms,1.640349ms,1.64035ms,1.640399ms,1.6404ms,1.640449ms,1.64045ms,1.640499ms,1.6405ms,1.640549ms,1.64055ms,1.640599ms,1.6406ms,1.640649ms,1.64065ms,1.640699ms,1.6407ms,1.640749ms,1.64075ms,1.640799ms,1.6408ms,1.640849ms,1.64085ms,1.640899ms,1.6409ms,1.640949ms,1.64095ms,1.640999ms,1.641ms,1.641049ms,1.64105ms,1.641099ms,1.6411ms,1.641149ms,1.64115ms,1.641199ms,1.6412ms,1.641249ms,1.64125ms,1.641299ms,1.6413ms,1.641349ms,1.64135ms,1.641399ms,1.6414ms,1.641449ms,1.64145ms,1.641499ms,1.6415ms,1.641549ms,1.64155ms,1.641599ms,1.6416ms,1.641649ms,1.64165ms,1.641699ms,1.6417ms,1.641749ms,1.64175ms,1.641799ms,1.6418ms,1.641849ms,1.64185ms,1.641899ms,1.6419ms,1.641949ms,1.64195ms,1.641999ms,1.642ms,1.642049ms,1.64205ms,1.642099ms,1.6421ms,1.642149ms,1.64215ms,1.642199ms,1.6422ms,1.642249ms,1.64225ms,1.642299ms,1.6423ms,1.642349ms,1.64235ms,1.642399ms,1.6424ms,1.642449ms,1.64245ms,1.642499ms,1.6425ms,1.642549ms,1.64255ms,1.642599ms,1.6426ms,1.642649ms,1.64265ms,1.642699ms,1.6427ms,1.642749ms,1.64275ms,1.642799ms,1.6428ms,1.642849ms,1.64285ms,1.642899ms,1.6429ms,1.642949ms,1.64295ms,1.642999ms,1.643ms,1.643049ms,1.64305ms,1.643099ms,1.6431ms,1.643149ms,1.64315ms,1.643199ms,1.6432ms,1.643249ms,1.64325ms,1.643299ms,1.6433ms,1.643349ms,1.64335ms,1.643399ms,1.6434ms,1.643449ms,1.64345ms,1.643499ms,1.6435ms,1.643549ms,1.64355ms,1.643599ms,1.6436ms,1.643649ms,1.64365ms,1.643699ms,1.6437ms,1.643749ms,1.64375ms,1.643799ms,1.6438ms,1.643849ms,1.64385ms,1.643899ms,1.6439ms,1.643949ms,1.64395ms,1.643999ms,1.644ms,1.644049ms,1.64405ms,1.644099ms,1.6441ms,1.644149ms,1.64415ms,1.644199ms,1.6442ms,1.644249ms,1.64425ms,1.644299ms,1.6443ms,1.644349ms,1.64435ms,1.644399ms,1.6444ms,1.644449ms,1.64445ms,1.644499ms,1.6445ms,1.644549ms,1.64455ms,1.644599ms,1.6446ms,1.644649ms,1.64465ms,1.644699ms,1.6447ms,1.644749ms,1.64475ms,1.644799ms,1.6448ms,1.644849ms,1.64485ms,1.644899ms,1.6449ms,1.644949ms,1.64495ms,1.644999ms,1.645ms,1.645049ms,1.64505ms,1.645099ms,1.6451ms,1.645149ms,1.64515ms,1.645199ms,1.6452ms,1.645249ms,1.64525ms,1.645299ms,1.6453ms,1.645349ms,1.64535ms,1.645399ms,1.6454ms,1.645449ms,1.64545ms,1.645499ms,1.6455ms,1.645549ms,1.64555ms,1.645599ms,1.6456ms,1.645649ms,1.64565ms,1.645699ms,1.6457ms,1.645749ms,1.64575ms,1.645799ms,1.6458ms,1.645849ms,1.64585ms,1.645899ms,1.6459ms,1.645949ms,1.64595ms,1.645999ms,1.646ms,1.646049ms,1.64605ms,1.646099ms,1.6461ms,1.646149ms,1.64615ms,1.646199ms,1.6462ms,1.646249ms,1.64625ms,1.646299ms,1.6463ms,1.646349ms,1.64635ms,1.646399ms,1.6464ms,1.646449ms,1.64645ms,1.646499ms,1.6465ms,1.646549ms,1.64655ms,1.646599ms,1.6466ms,1.646649ms,1.64665ms,1.646699ms,1.6467ms,1.646749ms,1.64675ms,1.646799ms,1.6468ms,1.646849ms,1.64685ms,1.646899ms,1.6469ms,1.646949ms,1.64695ms,1.646999ms,1.647ms,1.647049ms,1.64705ms,1.647099ms,1.6471ms,1.647149ms,1.64715ms,1.647199ms,1.6472ms,1.647249ms,1.64725ms,1.647299ms,1.6473ms,1.647349ms,1.64735ms,1.647399ms,1.6474ms,1.647449ms,1.64745ms,1.647499ms,1.6475ms,1.647549ms,1.64755ms,1.647599ms,1.6476ms,1.647649ms,1.64765ms,1.647699ms,1.6477ms,1.647749ms,1.64775ms,1.647799ms,1.6478ms,1.647849ms,1.64785ms,1.647899ms,1.6479ms,1.647949ms,1.64795ms,1.647999ms,1.648ms,1.648049ms,1.64805ms,1.648099ms,1.6481ms,1.648149ms,1.64815ms,1.648199ms,1.6482ms,1.648249ms,1.64825ms,1.648299ms,1.6483ms,1.648349ms,1.64835ms,1.648399ms,1.6484ms,1.648449ms,1.64845ms,1.648499ms,1.6485ms,1.648549ms,1.64855ms,1.648599ms,1.6486ms,1.648649ms,1.64865ms,1.648699ms,1.6487ms,1.648749ms,1.64875ms,1.648799ms,1.6488ms,1.648849ms,1.64885ms,1.648899ms,1.6489ms,1.648949ms,1.64895ms,1.648999ms,1.649ms,1.649049ms,1.64905ms,1.649099ms,1.6491ms,1.649149ms,1.64915ms,1.649199ms,1.6492ms,1.649249ms,1.64925ms,1.649299ms,1.6493ms,1.649349ms,1.64935ms,1.649399ms,1.6494ms,1.649449ms,1.64945ms,1.649499ms,1.6495ms,1.649549ms,1.64955ms,1.649599ms,1.6496ms,1.649649ms,1.64965ms,1.649699ms,1.6497ms,1.649749ms,1.64975ms,1.649799ms,1.6498ms,1.649849ms,1.64985ms,1.649899ms,1.6499ms,1.649949ms,1.64995ms,1.649999ms,1.65ms,1.650049ms,1.65005ms,1.650099ms,1.6501ms,1.650149ms,1.65015ms,1.650199ms,1.6502ms,1.650249ms,1.65025ms,1.650299ms,1.6503ms,1.650349ms,1.65035ms,1.650399ms,1.6504ms,1.650449ms,1.65045ms,1.650499ms,1.6505ms,1.650549ms,1.65055ms,1.650599ms,1.6506ms,1.650649ms,1.65065ms,1.650699ms,1.6507ms,1.650749ms,1.65075ms,1.650799ms,1.6508ms,1.650849ms,1.65085ms,1.650899ms,1.6509ms,1.650949ms,1.65095ms,1.650999ms,1.651ms,1.651049ms,1.65105ms,1.651099ms,1.6511ms,1.651149ms,1.65115ms,1.651199ms,1.6512ms,1.651249ms,1.65125ms,1.651299ms,1.6513ms,1.651349ms,1.65135ms,1.651399ms,1.6514ms,1.651449ms,1.65145ms,1.651499ms,1.6515ms,1.651549ms,1.65155ms,1.651599ms,1.6516ms,1.651649ms,1.65165ms,1.651699ms,1.6517ms,1.651749ms,1.65175ms,1.651799ms,1.6518ms,1.651849ms,1.65185ms,1.651899ms,1.6519ms,1.651949ms,1.65195ms,1.651999ms,1.652ms,1.652049ms,1.65205ms,1.652099ms,1.6521ms,1.652149ms,1.65215ms,1.652199ms,1.6522ms,1.652249ms,1.65225ms,1.652299ms,1.6523ms,1.652349ms,1.65235ms,1.652399ms,1.6524ms,1.652449ms,1.65245ms,1.652499ms,1.6525ms,1.652549ms,1.65255ms,1.652599ms,1.6526ms,1.652649ms,1.65265ms,1.652699ms,1.6527ms,1.652749ms,1.65275ms,1.652799ms,1.6528ms,1.652849ms,1.65285ms,1.652899ms,1.6529ms,1.652949ms,1.65295ms,1.652999ms,1.653ms,1.653049ms,1.65305ms,1.653099ms,1.6531ms,1.653149ms,1.65315ms,1.653199ms,1.6532ms,1.653249ms,1.65325ms,1.653299ms,1.6533ms,1.653349ms,1.65335ms,1.653399ms,1.6534ms,1.653449ms,1.65345ms,1.653499ms,1.6535ms,1.653549ms,1.65355ms,1.653599ms,1.6536ms,1.653649ms,1.65365ms,1.653699ms,1.6537ms,1.653749ms,1.65375ms,1.653799ms,1.6538ms,1.653849ms,1.65385ms,1.653899ms,1.6539ms,1.653949ms,1.65395ms,1.653999ms,1.654ms,1.654049ms,1.65405ms,1.654099ms,1.6541ms,1.654149ms,1.65415ms,1.654199ms,1.6542ms,1.654249ms,1.65425ms,1.654299ms,1.6543ms,1.654349ms,1.65435ms,1.654399ms,1.6544ms,1.654449ms,1.65445ms,1.654499ms,1.6545ms,1.654549ms,1.65455ms,1.654599ms,1.6546ms,1.654649ms,1.65465ms,1.654699ms,1.6547ms,1.654749ms,1.65475ms,1.654799ms,1.6548ms,1.654849ms,1.65485ms,1.654899ms,1.6549ms,1.654949ms,1.65495ms,1.654999ms,1.655ms,1.655049ms,1.65505ms,1.655099ms,1.6551ms,1.655149ms,1.65515ms,1.655199ms,1.6552ms,1.655249ms,1.65525ms,1.655299ms,1.6553ms,1.655349ms,1.65535ms,1.655399ms,1.6554ms,1.655449ms,1.65545ms,1.655499ms,1.6555ms,1.655549ms,1.65555ms,1.655599ms,1.6556ms,1.655649ms,1.65565ms,1.655699ms,1.6557ms,1.655749ms,1.65575ms,1.655799ms,1.6558ms,1.655849ms,1.65585ms,1.655899ms,1.6559ms,1.655949ms,1.65595ms,1.655999ms,1.656ms,1.656049ms,1.65605ms,1.656099ms,1.6561ms,1.656149ms,1.65615ms,1.656199ms,1.6562ms,1.656249ms,1.65625ms,1.656299ms,1.6563ms,1.656349ms,1.65635ms,1.656399ms,1.6564ms,1.656449ms,1.65645ms,1.656499ms,1.6565ms,1.656549ms,1.65655ms,1.656599ms,1.6566ms,1.656649ms,1.65665ms,1.656699ms,1.6567ms,1.656749ms,1.65675ms,1.656799ms,1.6568ms,1.656849ms,1.65685ms,1.656899ms,1.6569ms,1.656949ms,1.65695ms,1.656999ms,1.657ms,1.657049ms,1.65705ms,1.657099ms,1.6571ms,1.657149ms,1.65715ms,1.657199ms,1.6572ms,1.657249ms,1.65725ms,1.657299ms,1.6573ms,1.657349ms,1.65735ms,1.657399ms,1.6574ms,1.657449ms,1.65745ms,1.657499ms,1.6575ms,1.657549ms,1.65755ms,1.657599ms,1.6576ms,1.657649ms,1.65765ms,1.657699ms,1.6577ms,1.657749ms,1.65775ms,1.657799ms,1.6578ms,1.657849ms,1.65785ms,1.657899ms,1.6579ms,1.657949ms,1.65795ms,1.657999ms,1.658ms,1.658049ms,1.65805ms,1.658099ms,1.6581ms,1.658149ms,1.65815ms,1.658199ms,1.6582ms,1.658249ms,1.65825ms,1.658299ms,1.6583ms,1.658349ms,1.65835ms,1.658399ms,1.6584ms,1.658449ms,1.65845ms,1.658499ms,1.6585ms,1.658549ms,1.65855ms,1.658599ms,1.6586ms,1.658649ms,1.65865ms,1.658699ms,1.6587ms,1.658749ms,1.65875ms,1.658799ms,1.6588ms,1.658849ms,1.65885ms,1.658899ms,1.6589ms,1.658949ms,1.65895ms,1.658999ms,1.659ms,1.659049ms,1.65905ms,1.659099ms,1.6591ms,1.659149ms,1.65915ms,1.659199ms,1.6592ms,1.659249ms,1.65925ms,1.659299ms,1.6593ms,1.659349ms,1.65935ms,1.659399ms,1.6594ms,1.659449ms,1.65945ms,1.659499ms,1.6595ms,1.659549ms,1.65955ms,1.659599ms,1.6596ms,1.659649ms,1.65965ms,1.659699ms,1.6597ms,1.659749ms,1.65975ms,1.659799ms,1.6598ms,1.659849ms,1.65985ms,1.659899ms,1.6599ms,1.659949ms,1.65995ms,1.659999ms,1.66ms,1.660049ms,1.66005ms,1.660099ms,1.6601ms,1.660149ms,1.66015ms,1.660199ms,1.6602ms,1.660249ms,1.66025ms,1.660299ms,1.6603ms,1.660349ms,1.66035ms,1.660399ms,1.6604ms,1.660449ms,1.66045ms,1.660499ms,1.6605ms,1.660549ms,1.66055ms,1.660599ms,1.6606ms,1.660649ms,1.66065ms,1.660699ms,1.6607ms,1.660749ms,1.66075ms,1.660799ms,1.6608ms,1.660849ms,1.66085ms,1.660899ms,1.6609ms,1.660949ms,1.66095ms,1.660999ms,1.661ms,1.661049ms,1.66105ms,1.661099ms,1.6611ms,1.661149ms,1.66115ms,1.661199ms,1.6612ms,1.661249ms,1.66125ms,1.661299ms,1.6613ms,1.661349ms,1.66135ms,1.661399ms,1.6614ms,1.661449ms,1.66145ms,1.661499ms,1.6615ms,1.661549ms,1.66155ms,1.661599ms,1.6616ms,1.661649ms,1.66165ms,1.661699ms,1.6617ms,1.661749ms,1.66175ms,1.661799ms,1.6618ms,1.661849ms,1.66185ms,1.661899ms,1.6619ms,1.661949ms,1.66195ms,1.661999ms,1.662ms,1.662049ms,1.66205ms,1.662099ms,1.6621ms,1.662149ms,1.66215ms,1.662199ms,1.6622ms,1.662249ms,1.66225ms,1.662299ms,1.6623ms,1.662349ms,1.66235ms,1.662399ms,1.6624ms,1.662449ms,1.66245ms,1.662499ms,1.6625ms,1.662549ms,1.66255ms,1.662599ms,1.6626ms,1.662649ms,1.66265ms,1.662699ms,1.6627ms,1.662749ms,1.66275ms,1.662799ms,1.6628ms,1.662849ms,1.66285ms,1.662899ms,1.6629ms,1.662949ms,1.66295ms,1.662999ms,1.663ms,1.663049ms,1.66305ms,1.663099ms,1.6631ms,1.663149ms,1.66315ms,1.663199ms,1.6632ms,1.663249ms,1.66325ms,1.663299ms,1.6633ms,1.663349ms,1.66335ms,1.663399ms,1.6634ms,1.663449ms,1.66345ms,1.663499ms,1.6635ms,1.663549ms,1.66355ms,1.663599ms,1.6636ms,1.663649ms,1.66365ms,1.663699ms,1.6637ms,1.663749ms,1.66375ms,1.663799ms,1.6638ms,1.663849ms,1.66385ms,1.663899ms,1.6639ms,1.663949ms,1.66395ms,1.663999ms,1.664ms,1.664049ms,1.66405ms,1.664099ms,1.6641ms,1.664149ms,1.66415ms,1.664199ms,1.6642ms,1.664249ms,1.66425ms,1.664299ms,1.6643ms,1.664349ms,1.66435ms,1.664399ms,1.6644ms,1.664449ms,1.66445ms,1.664499ms,1.6645ms,1.664549ms,1.66455ms,1.664599ms,1.6646ms,1.664649ms,1.66465ms,1.664699ms,1.6647ms,1.664749ms,1.66475ms,1.664799ms,1.6648ms,1.664849ms,1.66485ms,1.664899ms,1.6649ms,1.664949ms,1.66495ms,1.664999ms,1.665ms,1.665049ms,1.66505ms,1.665099ms,1.6651ms,1.665149ms,1.66515ms,1.665199ms,1.6652ms,1.665249ms,1.66525ms,1.665299ms,1.6653ms,1.665349ms,1.66535ms,1.665399ms,1.6654ms,1.665449ms,1.66545ms,1.665499ms,1.6655ms,1.665549ms,1.66555ms,1.665599ms,1.6656ms,1.665649ms,1.66565ms,1.665699ms,1.6657ms,1.665749ms,1.66575ms,1.665799ms,1.6658ms,1.665849ms,1.66585ms,1.665899ms,1.6659ms,1.665949ms,1.66595ms,1.665999ms,1.666ms,1.666049ms,1.66605ms,1.666099ms,1.6661ms,1.666149ms,1.66615ms,1.666199ms,1.6662ms,1.666249ms,1.66625ms,1.666299ms,1.6663ms,1.666349ms,1.66635ms,1.666399ms,1.6664ms,1.666449ms,1.66645ms,1.666499ms,1.6665ms,1.666549ms,1.66655ms,1.666599ms,1.6666ms,1.666649ms,1.66665ms,1.666699ms,1.6667ms,1.666749ms,1.66675ms,1.666799ms,1.6668ms,1.666849ms,1.66685ms,1.666899ms,1.6669ms,1.666949ms,1.66695ms,1.666999ms,1.667ms,1.667049ms,1.66705ms,1.667099ms,1.6671ms,1.667149ms,1.66715ms,1.667199ms,1.6672ms,1.667249ms,1.66725ms,1.667299ms,1.6673ms,1.667349ms,1.66735ms,1.667399ms,1.6674ms,1.667449ms,1.66745ms,1.667499ms,1.6675ms,1.667549ms,1.66755ms,1.667599ms,1.6676ms,1.667649ms,1.66765ms,1.667699ms,1.6677ms,1.667749ms,1.66775ms,1.667799ms,1.6678ms,1.667849ms,1.66785ms,1.667899ms,1.6679ms,1.667949ms,1.66795ms,1.667999ms,1.668ms,1.668049ms,1.66805ms,1.668099ms,1.6681ms,1.668149ms,1.66815ms,1.668199ms,1.6682ms,1.668249ms,1.66825ms,1.668299ms,1.6683ms,1.668349ms,1.66835ms,1.668399ms,1.6684ms,1.668449ms,1.66845ms,1.668499ms,1.6685ms,1.668549ms,1.66855ms,1.668599ms,1.6686ms,1.668649ms,1.66865ms,1.668699ms,1.6687ms,1.668749ms,1.66875ms,1.668799ms,1.6688ms,1.668849ms,1.66885ms,1.668899ms,1.6689ms,1.668949ms,1.66895ms,1.668999ms,1.669ms,1.669049ms,1.66905ms,1.669099ms,1.6691ms,1.669149ms,1.66915ms,1.669199ms,1.6692ms,1.669249ms,1.66925ms,1.669299ms,1.6693ms,1.669349ms,1.66935ms,1.669399ms,1.6694ms,1.669449ms,1.66945ms,1.669499ms,1.6695ms,1.669549ms,1.66955ms,1.669599ms,1.6696ms,1.669649ms,1.66965ms,1.669699ms,1.6697ms,1.669749ms,1.66975ms,1.669799ms,1.6698ms,1.669849ms,1.66985ms,1.669899ms,1.6699ms,1.669949ms,1.66995ms,1.669999ms,1.67ms,1.670049ms,1.67005ms,1.670099ms,1.6701ms,1.670149ms,1.67015ms,1.670199ms,1.6702ms,1.670249ms,1.67025ms,1.670299ms,1.6703ms,1.670349ms,1.67035ms,1.670399ms,1.6704ms,1.670449ms,1.67045ms,1.670499ms,1.6705ms,1.670549ms,1.67055ms,1.670599ms,1.6706ms,1.670649ms,1.67065ms,1.670699ms,1.6707ms,1.670749ms,1.67075ms,1.670799ms,1.6708ms,1.670849ms,1.67085ms,1.670899ms,1.6709ms,1.670949ms,1.67095ms,1.670999ms,1.671ms,1.671049ms,1.67105ms,1.671099ms,1.6711ms,1.671149ms,1.67115ms,1.671199ms,1.6712ms,1.671249ms,1.67125ms,1.671299ms,1.6713ms,1.671349ms,1.67135ms,1.671399ms,1.6714ms,1.671449ms,1.67145ms,1.671499ms,1.6715ms,1.671549ms,1.67155ms,1.671599ms,1.6716ms,1.671649ms,1.67165ms,1.671699ms,1.6717ms,1.671749ms,1.67175ms,1.671799ms,1.6718ms,1.671849ms,1.67185ms,1.671899ms,1.6719ms,1.671949ms,1.67195ms,1.671999ms,1.672ms,1.672049ms,1.67205ms,1.672099ms,1.6721ms,1.672149ms,1.67215ms,1.672199ms,1.6722ms,1.672249ms,1.67225ms,1.672299ms,1.6723ms,1.672349ms,1.67235ms,1.672399ms,1.6724ms,1.672449ms,1.67245ms,1.672499ms,1.6725ms,1.672549ms,1.67255ms,1.672599ms,1.6726ms,1.672649ms,1.67265ms,1.672699ms,1.6727ms,1.672749ms,1.67275ms,1.672799ms,1.6728ms,1.672849ms,1.67285ms,1.672899ms,1.6729ms,1.672949ms,1.67295ms,1.672999ms,1.673ms,1.673049ms,1.67305ms,1.673099ms,1.6731ms,1.673149ms,1.67315ms,1.673199ms,1.6732ms,1.673249ms,1.67325ms,1.673299ms,1.6733ms,1.673349ms,1.67335ms,1.673399ms,1.6734ms,1.673449ms,1.67345ms,1.673499ms,1.6735ms,1.673549ms,1.67355ms,1.673599ms,1.6736ms,1.673649ms,1.67365ms,1.673699ms,1.6737ms,1.673749ms,1.67375ms,1.673799ms,1.6738ms,1.673849ms,1.67385ms,1.673899ms,1.6739ms,1.673949ms,1.67395ms,1.673999ms,1.674ms,1.674049ms,1.67405ms,1.674099ms,1.6741ms,1.674149ms,1.67415ms,1.674199ms,1.6742ms,1.674249ms,1.67425ms,1.674299ms,1.6743ms,1.674349ms,1.67435ms,1.674399ms,1.6744ms,1.674449ms,1.67445ms,1.674499ms,1.6745ms,1.674549ms,1.67455ms,1.674599ms,1.6746ms,1.674649ms,1.67465ms,1.674699ms,1.6747ms,1.674749ms,1.67475ms,1.674799ms,1.6748ms,1.674849ms,1.67485ms,1.674899ms,1.6749ms,1.674949ms,1.67495ms,1.674999ms,1.675ms,1.675049ms,1.67505ms,1.675099ms,1.6751ms,1.675149ms,1.67515ms,1.675199ms,1.6752ms,1.675249ms,1.67525ms,1.675299ms,1.6753ms,1.675349ms,1.67535ms,1.675399ms,1.6754ms,1.675449ms,1.67545ms,1.675499ms,1.6755ms,1.675549ms,1.67555ms,1.675599ms,1.6756ms,1.675649ms,1.67565ms,1.675699ms,1.6757ms,1.675749ms,1.67575ms,1.675799ms,1.6758ms,1.675849ms,1.67585ms,1.675899ms,1.6759ms,1.675949ms,1.67595ms,1.675999ms,1.676ms,1.676049ms,1.67605ms,1.676099ms,1.6761ms,1.676149ms,1.67615ms,1.676199ms,1.6762ms,1.676249ms,1.67625ms,1.676299ms,1.6763ms,1.676349ms,1.67635ms,1.676399ms,1.6764ms,1.676449ms,1.67645ms,1.676499ms,1.6765ms,1.676549ms,1.67655ms,1.676599ms,1.6766ms,1.676649ms,1.67665ms,1.676699ms,1.6767ms,1.676749ms,1.67675ms,1.676799ms,1.6768ms,1.676849ms,1.67685ms,1.676899ms,1.6769ms,1.676949ms,1.67695ms,1.676999ms,1.677ms,1.677049ms,1.67705ms,1.677099ms,1.6771ms,1.677149ms,1.67715ms,1.677199ms,1.6772ms,1.677249ms,1.67725ms,1.677299ms,1.6773ms,1.677349ms,1.67735ms,1.677399ms,1.6774ms,1.677449ms,1.67745ms,1.677499ms,1.6775ms,1.677549ms,1.67755ms,1.677599ms,1.6776ms,1.677649ms,1.67765ms,1.677699ms,1.6777ms,1.677749ms,1.67775ms,1.677799ms,1.6778ms,1.677849ms,1.67785ms,1.677899ms,1.6779ms,1.677949ms,1.67795ms,1.677999ms,1.678ms,1.678049ms,1.67805ms,1.678099ms,1.6781ms,1.678149ms,1.67815ms,1.678199ms,1.6782ms,1.678249ms,1.67825ms,1.678299ms,1.6783ms,1.678349ms,1.67835ms,1.678399ms,1.6784ms,1.678449ms,1.67845ms,1.678499ms,1.6785ms,1.678549ms,1.67855ms,1.678599ms,1.6786ms,1.678649ms,1.67865ms,1.678699ms,1.6787ms,1.678749ms,1.67875ms,1.678799ms,1.6788ms,1.678849ms,1.67885ms,1.678899ms,1.6789ms,1.678949ms,1.67895ms,1.678999ms,1.679ms,1.679049ms,1.67905ms,1.679099ms,1.6791ms,1.679149ms,1.67915ms,1.679199ms,1.6792ms,1.679249ms,1.67925ms,1.679299ms,1.6793ms,1.679349ms,1.67935ms,1.679399ms,1.6794ms,1.679449ms,1.67945ms,1.679499ms,1.6795ms,1.679549ms,1.67955ms,1.679599ms,1.6796ms,1.679649ms,1.67965ms,1.679699ms,1.6797ms,1.679749ms,1.67975ms,1.679799ms,1.6798ms,1.679849ms,1.67985ms,1.679899ms,1.6799ms,1.679949ms,1.67995ms,1.679999ms,1.68ms,1.680049ms,1.68005ms,1.680099ms,1.6801ms,1.680149ms,1.68015ms,1.680199ms,1.6802ms,1.680249ms,1.68025ms,1.680299ms,1.6803ms,1.680349ms,1.68035ms,1.680399ms,1.6804ms,1.680449ms,1.68045ms,1.680499ms,1.6805ms,1.680549ms,1.68055ms,1.680599ms,1.6806ms,1.680649ms,1.68065ms,1.680699ms,1.6807ms,1.680749ms,1.68075ms,1.680799ms,1.6808ms,1.680849ms,1.68085ms,1.680899ms,1.6809ms,1.680949ms,1.68095ms,1.680999ms,1.681ms,1.681049ms,1.68105ms,1.681099ms,1.6811ms,1.681149ms,1.68115ms,1.681199ms,1.6812ms,1.681249ms,1.68125ms,1.681299ms,1.6813ms,1.681349ms,1.68135ms,1.681399ms,1.6814ms,1.681449ms,1.68145ms,1.681499ms,1.6815ms,1.681549ms,1.68155ms,1.681599ms,1.6816ms,1.681649ms,1.68165ms,1.681699ms,1.6817ms,1.681749ms,1.68175ms,1.681799ms,1.6818ms,1.681849ms,1.68185ms,1.681899ms,1.6819ms,1.681949ms,1.68195ms,1.681999ms,1.682ms,1.682049ms,1.68205ms,1.682099ms,1.6821ms,1.682149ms,1.68215ms,1.682199ms,1.6822ms,1.682249ms,1.68225ms,1.682299ms,1.6823ms,1.682349ms,1.68235ms,1.682399ms,1.6824ms,1.682449ms,1.68245ms,1.682499ms,1.6825ms,1.682549ms,1.68255ms,1.682599ms,1.6826ms,1.682649ms,1.68265ms,1.682699ms,1.6827ms,1.682749ms,1.68275ms,1.682799ms,1.6828ms,1.682849ms,1.68285ms,1.682899ms,1.6829ms,1.682949ms,1.68295ms,1.682999ms,1.683ms,1.683049ms,1.68305ms,1.683099ms,1.6831ms,1.683149ms,1.68315ms,1.683199ms,1.6832ms,1.683249ms,1.68325ms,1.683299ms,1.6833ms,1.683349ms,1.68335ms,1.683399ms,1.6834ms,1.683449ms,1.68345ms,1.683499ms,1.6835ms,1.683549ms,1.68355ms,1.683599ms,1.6836ms,1.683649ms,1.68365ms,1.683699ms,1.6837ms,1.683749ms,1.68375ms,1.683799ms,1.6838ms,1.683849ms,1.68385ms,1.683899ms,1.6839ms,1.683949ms,1.68395ms,1.683999ms,1.684ms,1.684049ms,1.68405ms,1.684099ms,1.6841ms,1.684149ms,1.68415ms,1.684199ms,1.6842ms,1.684249ms,1.68425ms,1.684299ms,1.6843ms,1.684349ms,1.68435ms,1.684399ms,1.6844ms,1.684449ms,1.68445ms,1.684499ms,1.6845ms,1.684549ms,1.68455ms,1.684599ms,1.6846ms,1.684649ms,1.68465ms,1.684699ms,1.6847ms,1.684749ms,1.68475ms,1.684799ms,1.6848ms,1.684849ms,1.68485ms,1.684899ms,1.6849ms,1.684949ms,1.68495ms,1.684999ms,1.685ms,1.685049ms,1.68505ms,1.685099ms,1.6851ms,1.685149ms,1.68515ms,1.685199ms,1.6852ms,1.685249ms,1.68525ms,1.685299ms,1.6853ms,1.685349ms,1.68535ms,1.685399ms,1.6854ms,1.685449ms,1.68545ms,1.685499ms,1.6855ms,1.685549ms,1.68555ms,1.685599ms,1.6856ms,1.685649ms,1.68565ms,1.685699ms,1.6857ms,1.685749ms,1.68575ms,1.685799ms,1.6858ms,1.685849ms,1.68585ms,1.685899ms,1.6859ms,1.685949ms,1.68595ms,1.685999ms,1.686ms,1.686049ms,1.68605ms,1.686099ms,1.6861ms,1.686149ms,1.68615ms,1.686199ms,1.6862ms,1.686249ms,1.68625ms,1.686299ms,1.6863ms,1.686349ms,1.68635ms,1.686399ms,1.6864ms,1.686449ms,1.68645ms,1.686499ms,1.6865ms,1.686549ms,1.68655ms,1.686599ms,1.6866ms,1.686649ms,1.68665ms,1.686699ms,1.6867ms,1.686749ms,1.68675ms,1.686799ms,1.6868ms,1.686849ms,1.68685ms,1.686899ms,1.6869ms,1.686949ms,1.68695ms,1.686999ms,1.687ms,1.687049ms,1.68705ms,1.687099ms,1.6871ms,1.687149ms,1.68715ms,1.687199ms,1.6872ms,1.687249ms,1.68725ms,1.687299ms,1.6873ms,1.687349ms,1.68735ms,1.687399ms,1.6874ms,1.687449ms,1.68745ms,1.687499ms,1.6875ms,1.687549ms,1.68755ms,1.687599ms,1.6876ms,1.687649ms,1.68765ms,1.687699ms,1.6877ms,1.687749ms,1.68775ms,1.687799ms,1.6878ms,1.687849ms,1.68785ms,1.687899ms,1.6879ms,1.687949ms,1.68795ms,1.687999ms,1.688ms,1.688049ms,1.68805ms,1.688099ms,1.6881ms,1.688149ms,1.68815ms,1.688199ms,1.6882ms,1.688249ms,1.68825ms,1.688299ms,1.6883ms,1.688349ms,1.68835ms,1.688399ms,1.6884ms,1.688449ms,1.68845ms,1.688499ms,1.6885ms,1.688549ms,1.68855ms,1.688599ms,1.6886ms,1.688649ms,1.68865ms,1.688699ms,1.6887ms,1.688749ms,1.68875ms,1.688799ms,1.6888ms,1.688849ms,1.68885ms,1.688899ms,1.6889ms,1.688949ms,1.68895ms,1.688999ms,1.689ms,1.689049ms,1.68905ms,1.689099ms,1.6891ms,1.689149ms,1.68915ms,1.689199ms,1.6892ms,1.689249ms,1.68925ms,1.689299ms,1.6893ms,1.689349ms,1.68935ms,1.689399ms,1.6894ms,1.689449ms,1.68945ms,1.689499ms,1.6895ms,1.689549ms,1.68955ms,1.689599ms,1.6896ms,1.689649ms,1.68965ms,1.689699ms,1.6897ms,1.689749ms,1.68975ms,1.689799ms,1.6898ms,1.689849ms,1.68985ms,1.689899ms,1.6899ms,1.689949ms,1.68995ms,1.689999ms,1.69ms,1.690049ms,1.69005ms,1.690099ms,1.6901ms,1.690149ms,1.69015ms,1.690199ms,1.6902ms,1.690249ms,1.69025ms,1.690299ms,1.6903ms,1.690349ms,1.69035ms,1.690399ms,1.6904ms,1.690449ms,1.69045ms,1.690499ms,1.6905ms,1.690549ms,1.69055ms,1.690599ms,1.6906ms,1.690649ms,1.69065ms,1.690699ms,1.6907ms,1.690749ms,1.69075ms,1.690799ms,1.6908ms,1.690849ms,1.69085ms,1.690899ms,1.6909ms,1.690949ms,1.69095ms,1.690999ms,1.691ms,1.691049ms,1.69105ms,1.691099ms,1.6911ms,1.691149ms,1.69115ms,1.691199ms,1.6912ms,1.691249ms,1.69125ms,1.691299ms,1.6913ms,1.691349ms,1.69135ms,1.691399ms,1.6914ms,1.691449ms,1.69145ms,1.691499ms,1.6915ms,1.691549ms,1.69155ms,1.691599ms,1.6916ms,1.691649ms,1.69165ms,1.691699ms,1.6917ms,1.691749ms,1.69175ms,1.691799ms,1.6918ms,1.691849ms,1.69185ms,1.691899ms,1.6919ms,1.691949ms,1.69195ms,1.691999ms,1.692ms,1.692049ms,1.69205ms,1.692099ms,1.6921ms,1.692149ms,1.69215ms,1.692199ms,1.6922ms,1.692249ms,1.69225ms,1.692299ms,1.6923ms,1.692349ms,1.69235ms,1.692399ms,1.6924ms,1.692449ms,1.69245ms,1.692499ms,1.6925ms,1.692549ms,1.69255ms,1.692599ms,1.6926ms,1.692649ms,1.69265ms,1.692699ms,1.6927ms,1.692749ms,1.69275ms,1.692799ms,1.6928ms,1.692849ms,1.69285ms,1.692899ms,1.6929ms,1.692949ms,1.69295ms,1.692999ms,1.693ms,1.693049ms,1.69305ms,1.693099ms,1.6931ms,1.693149ms,1.69315ms,1.693199ms,1.6932ms,1.693249ms,1.69325ms,1.693299ms,1.6933ms,1.693349ms,1.69335ms,1.693399ms,1.6934ms,1.693449ms,1.69345ms,1.693499ms,1.6935ms,1.693549ms,1.69355ms,1.693599ms,1.6936ms,1.693649ms,1.69365ms,1.693699ms,1.6937ms,1.693749ms,1.69375ms,1.693799ms,1.6938ms,1.693849ms,1.69385ms,1.693899ms,1.6939ms,1.693949ms,1.69395ms,1.693999ms,1.694ms,1.694049ms,1.69405ms,1.694099ms,1.6941ms,1.694149ms,1.69415ms,1.694199ms,1.6942ms,1.694249ms,1.69425ms,1.694299ms,1.6943ms,1.694349ms,1.69435ms,1.694399ms,1.6944ms,1.694449ms,1.69445ms,1.694499ms,1.6945ms,1.694549ms,1.69455ms,1.694599ms,1.6946ms,1.694649ms,1.69465ms,1.694699ms,1.6947ms,1.694749ms,1.69475ms,1.694799ms,1.6948ms,1.694849ms,1.69485ms,1.694899ms,1.6949ms,1.694949ms,1.69495ms,1.694999ms,1.695ms,1.695049ms,1.69505ms,1.695099ms,1.6951ms,1.695149ms,1.69515ms,1.695199ms,1.6952ms,1.695249ms,1.69525ms,1.695299ms,1.6953ms,1.695349ms,1.69535ms,1.695399ms,1.6954ms,1.695449ms,1.69545ms,1.695499ms,1.6955ms,1.695549ms,1.69555ms,1.695599ms,1.6956ms,1.695649ms,1.69565ms,1.695699ms,1.6957ms,1.695749ms,1.69575ms,1.695799ms,1.6958ms,1.695849ms,1.69585ms,1.695899ms,1.6959ms,1.695949ms,1.69595ms,1.695999ms,1.696ms,1.696049ms,1.69605ms,1.696099ms,1.6961ms,1.696149ms,1.69615ms,1.696199ms,1.6962ms,1.696249ms,1.69625ms,1.696299ms,1.6963ms,1.696349ms,1.69635ms,1.696399ms,1.6964ms,1.696449ms,1.69645ms,1.696499ms,1.6965ms,1.696549ms,1.69655ms,1.696599ms,1.6966ms,1.696649ms,1.69665ms,1.696699ms,1.6967ms,1.696749ms,1.69675ms,1.696799ms,1.6968ms,1.696849ms,1.69685ms,1.696899ms,1.6969ms,1.696949ms,1.69695ms,1.696999ms,1.697ms,1.697049ms,1.69705ms,1.697099ms,1.6971ms,1.697149ms,1.69715ms,1.697199ms,1.6972ms,1.697249ms,1.69725ms,1.697299ms,1.6973ms,1.697349ms,1.69735ms,1.697399ms,1.6974ms,1.697449ms,1.69745ms,1.697499ms,1.6975ms,1.697549ms,1.69755ms,1.697599ms,1.6976ms,1.697649ms,1.69765ms,1.697699ms,1.6977ms,1.697749ms,1.69775ms,1.697799ms,1.6978ms,1.697849ms,1.69785ms,1.697899ms,1.6979ms,1.697949ms,1.69795ms,1.697999ms,1.698ms,1.698049ms,1.69805ms,1.698099ms,1.6981ms,1.698149ms,1.69815ms,1.698199ms,1.6982ms,1.698249ms,1.69825ms,1.698299ms,1.6983ms,1.698349ms,1.69835ms,1.698399ms,1.6984ms,1.698449ms,1.69845ms,1.698499ms,1.6985ms,1.698549ms,1.69855ms,1.698599ms,1.6986ms,1.698649ms,1.69865ms,1.698699ms,1.6987ms,1.698749ms,1.69875ms,1.698799ms,1.6988ms,1.698849ms,1.69885ms,1.698899ms,1.6989ms,1.698949ms,1.69895ms,1.698999ms,1.699ms,1.699049ms,1.69905ms,1.699099ms,1.6991ms,1.699149ms,1.69915ms,1.699199ms,1.6992ms,1.699249ms,1.69925ms,1.699299ms,1.6993ms,1.699349ms,1.69935ms,1.699399ms,1.6994ms,1.699449ms,1.69945ms,1.699499ms,1.6995ms,1.699549ms,1.69955ms,1.699599ms,1.6996ms,1.699649ms,1.69965ms,1.699699ms,1.6997ms,1.699749ms,1.69975ms,1.699799ms,1.6998ms,1.699849ms,1.69985ms,1.699899ms,1.6999ms,1.699949ms,1.69995ms,1.699999ms,1.7ms,1.700049ms,1.70005ms,1.700099ms,1.7001ms,1.700149ms,1.70015ms,1.700199ms,1.7002ms,1.700249ms,1.70025ms,1.700299ms,1.7003ms,1.700349ms,1.70035ms,1.700399ms,1.7004ms,1.700449ms,1.70045ms,1.700499ms,1.7005ms,1.700549ms,1.70055ms,1.700599ms,1.7006ms,1.700649ms,1.70065ms,1.700699ms,1.7007ms,1.700749ms,1.70075ms,1.700799ms,1.7008ms,1.700849ms,1.70085ms,1.700899ms,1.7009ms,1.700949ms,1.70095ms,1.700999ms,1.701ms,1.701049ms,1.70105ms,1.701099ms,1.7011ms,1.701149ms,1.70115ms,1.701199ms,1.7012ms,1.701249ms,1.70125ms,1.701299ms,1.7013ms,1.701349ms,1.70135ms,1.701399ms,1.7014ms,1.701449ms,1.70145ms,1.701499ms,1.7015ms,1.701549ms,1.70155ms,1.701599ms,1.7016ms,1.701649ms,1.70165ms,1.701699ms,1.7017ms,1.701749ms,1.70175ms,1.701799ms,1.7018ms,1.701849ms,1.70185ms,1.701899ms,1.7019ms,1.701949ms,1.70195ms,1.701999ms,1.702ms,1.702049ms,1.70205ms,1.702099ms,1.7021ms,1.702149ms,1.70215ms,1.702199ms,1.7022ms,1.702249ms,1.70225ms,1.702299ms,1.7023ms,1.702349ms,1.70235ms,1.702399ms,1.7024ms,1.702449ms,1.70245ms,1.702499ms,1.7025ms,1.702549ms,1.70255ms,1.702599ms,1.7026ms,1.702649ms,1.70265ms,1.702699ms,1.7027ms,1.702749ms,1.70275ms,1.702799ms,1.7028ms,1.702849ms,1.70285ms,1.702899ms,1.7029ms,1.702949ms,1.70295ms,1.702999ms,1.703ms,1.703049ms,1.70305ms,1.703099ms,1.7031ms,1.703149ms,1.70315ms,1.703199ms,1.7032ms,1.703249ms,1.70325ms,1.703299ms,1.7033ms,1.703349ms,1.70335ms,1.703399ms,1.7034ms,1.703449ms,1.70345ms,1.703499ms,1.7035ms,1.703549ms,1.70355ms,1.703599ms,1.7036ms,1.703649ms,1.70365ms,1.703699ms,1.7037ms,1.703749ms,1.70375ms,1.703799ms,1.7038ms,1.703849ms,1.70385ms,1.703899ms,1.7039ms,1.703949ms,1.70395ms,1.703999ms,1.704ms,1.704049ms,1.70405ms,1.704099ms,1.7041ms,1.704149ms,1.70415ms,1.704199ms,1.7042ms,1.704249ms,1.70425ms,1.704299ms,1.7043ms,1.704349ms,1.70435ms,1.704399ms,1.7044ms,1.704449ms,1.70445ms,1.704499ms,1.7045ms,1.704549ms,1.70455ms,1.704599ms,1.7046ms,1.704649ms,1.70465ms,1.704699ms,1.7047ms,1.704749ms,1.70475ms,1.704799ms,1.7048ms,1.704849ms,1.70485ms,1.704899ms,1.7049ms,1.704949ms,1.70495ms,1.704999ms,1.705ms,1.705049ms,1.70505ms,1.705099ms,1.7051ms,1.705149ms,1.70515ms,1.705199ms,1.7052ms,1.705249ms,1.70525ms,1.705299ms,1.7053ms,1.705349ms,1.70535ms,1.705399ms,1.7054ms,1.705449ms,1.70545ms,1.705499ms,1.7055ms,1.705549ms,1.70555ms,1.705599ms,1.7056ms,1.705649ms,1.70565ms,1.705699ms,1.7057ms,1.705749ms,1.70575ms,1.705799ms,1.7058ms,1.705849ms,1.70585ms,1.705899ms,1.7059ms,1.705949ms,1.70595ms,1.705999ms,1.706ms,1.706049ms,1.70605ms,1.706099ms,1.7061ms,1.706149ms,1.70615ms,1.706199ms,1.7062ms,1.706249ms,1.70625ms,1.706299ms,1.7063ms,1.706349ms,1.70635ms,1.706399ms,1.7064ms,1.706449ms,1.70645ms,1.706499ms,1.7065ms,1.706549ms,1.70655ms,1.706599ms,1.7066ms,1.706649ms,1.70665ms,1.706699ms,1.7067ms,1.706749ms,1.70675ms,1.706799ms,1.7068ms,1.706849ms,1.70685ms,1.706899ms,1.7069ms,1.706949ms,1.70695ms,1.706999ms,1.707ms,1.707049ms,1.70705ms,1.707099ms,1.7071ms,1.707149ms,1.70715ms,1.707199ms,1.7072ms,1.707249ms,1.70725ms,1.707299ms,1.7073ms,1.707349ms,1.70735ms,1.707399ms,1.7074ms,1.707449ms,1.70745ms,1.707499ms,1.7075ms,1.707549ms,1.70755ms,1.707599ms,1.7076ms,1.707649ms,1.70765ms,1.707699ms,1.7077ms,1.707749ms,1.70775ms,1.707799ms,1.7078ms,1.707849ms,1.70785ms,1.707899ms,1.7079ms,1.707949ms,1.70795ms,1.707999ms,1.708ms,1.708049ms,1.70805ms,1.708099ms,1.7081ms,1.708149ms,1.70815ms,1.708199ms,1.7082ms,1.708249ms,1.70825ms,1.708299ms,1.7083ms,1.708349ms,1.70835ms,1.708399ms,1.7084ms,1.708449ms,1.70845ms,1.708499ms,1.7085ms,1.708549ms,1.70855ms,1.708599ms,1.7086ms,1.708649ms,1.70865ms,1.708699ms,1.7087ms,1.708749ms,1.70875ms,1.708799ms,1.7088ms,1.708849ms,1.70885ms,1.708899ms,1.7089ms,1.708949ms,1.70895ms,1.708999ms,1.709ms,1.709049ms,1.70905ms,1.709099ms,1.7091ms,1.709149ms,1.70915ms,1.709199ms,1.7092ms,1.709249ms,1.70925ms,1.709299ms,1.7093ms,1.709349ms,1.70935ms,1.709399ms,1.7094ms,1.709449ms,1.70945ms,1.709499ms,1.7095ms,1.709549ms,1.70955ms,1.709599ms,1.7096ms,1.709649ms,1.70965ms,1.709699ms,1.7097ms,1.709749ms,1.70975ms,1.709799ms,1.7098ms,1.709849ms,1.70985ms,1.709899ms,1.7099ms,1.709949ms,1.70995ms,1.709999ms,1.71ms,1.710049ms,1.71005ms,1.710099ms,1.7101ms,1.710149ms,1.71015ms,1.710199ms,1.7102ms,1.710249ms,1.71025ms,1.710299ms,1.7103ms,1.710349ms,1.71035ms,1.710399ms,1.7104ms,1.710449ms,1.71045ms,1.710499ms,1.7105ms,1.710549ms,1.71055ms,1.710599ms,1.7106ms,1.710649ms,1.71065ms,1.710699ms,1.7107ms,1.710749ms,1.71075ms,1.710799ms,1.7108ms,1.710849ms,1.71085ms,1.710899ms,1.7109ms,1.710949ms,1.71095ms,1.710999ms,1.711ms,1.711049ms,1.71105ms,1.711099ms,1.7111ms,1.711149ms,1.71115ms,1.711199ms,1.7112ms,1.711249ms,1.71125ms,1.711299ms,1.7113ms,1.711349ms,1.71135ms,1.711399ms,1.7114ms,1.711449ms,1.71145ms,1.711499ms,1.7115ms,1.711549ms,1.71155ms,1.711599ms,1.7116ms,1.711649ms,1.71165ms,1.711699ms,1.7117ms,1.711749ms,1.71175ms,1.711799ms,1.7118ms,1.711849ms,1.71185ms,1.711899ms,1.7119ms,1.711949ms,1.71195ms,1.711999ms,1.712ms,1.712049ms,1.71205ms,1.712099ms,1.7121ms,1.712149ms,1.71215ms,1.712199ms,1.7122ms,1.712249ms,1.71225ms,1.712299ms,1.7123ms,1.712349ms,1.71235ms,1.712399ms,1.7124ms,1.712449ms,1.71245ms,1.712499ms,1.7125ms,1.712549ms,1.71255ms,1.712599ms,1.7126ms,1.712649ms,1.71265ms,1.712699ms,1.7127ms,1.712749ms,1.71275ms,1.712799ms,1.7128ms,1.712849ms,1.71285ms,1.712899ms,1.7129ms,1.712949ms,1.71295ms,1.712999ms,1.713ms,1.713049ms,1.71305ms,1.713099ms,1.7131ms,1.713149ms,1.71315ms,1.713199ms,1.7132ms,1.713249ms,1.71325ms,1.713299ms,1.7133ms,1.713349ms,1.71335ms,1.713399ms,1.7134ms,1.713449ms,1.71345ms,1.713499ms,1.7135ms,1.713549ms,1.71355ms,1.713599ms,1.7136ms,1.713649ms,1.71365ms,1.713699ms,1.7137ms,1.713749ms,1.71375ms,1.713799ms,1.7138ms,1.713849ms,1.71385ms,1.713899ms,1.7139ms,1.713949ms,1.71395ms,1.713999ms,1.714ms,1.714049ms,1.71405ms,1.714099ms,1.7141ms,1.714149ms,1.71415ms,1.714199ms,1.7142ms,1.714249ms,1.71425ms,1.714299ms,1.7143ms,1.714349ms,1.71435ms,1.714399ms,1.7144ms,1.714449ms,1.71445ms,1.714499ms,1.7145ms,1.714549ms,1.71455ms,1.714599ms,1.7146ms,1.714649ms,1.71465ms,1.714699ms,1.7147ms,1.714749ms,1.71475ms,1.714799ms,1.7148ms,1.714849ms,1.71485ms,1.714899ms,1.7149ms,1.714949ms,1.71495ms,1.714999ms,1.715ms,1.715049ms,1.71505ms,1.715099ms,1.7151ms,1.715149ms,1.71515ms,1.715199ms,1.7152ms,1.715249ms,1.71525ms,1.715299ms,1.7153ms,1.715349ms,1.71535ms,1.715399ms,1.7154ms,1.715449ms,1.71545ms,1.715499ms,1.7155ms,1.715549ms,1.71555ms,1.715599ms,1.7156ms,1.715649ms,1.71565ms,1.715699ms,1.7157ms,1.715749ms,1.71575ms,1.715799ms,1.7158ms,1.715849ms,1.71585ms,1.715899ms,1.7159ms,1.715949ms,1.71595ms,1.715999ms,1.716ms,1.716049ms,1.71605ms,1.716099ms,1.7161ms,1.716149ms,1.71615ms,1.716199ms,1.7162ms,1.716249ms,1.71625ms,1.716299ms,1.7163ms,1.716349ms,1.71635ms,1.716399ms,1.7164ms,1.716449ms,1.71645ms,1.716499ms,1.7165ms,1.716549ms,1.71655ms,1.716599ms,1.7166ms,1.716649ms,1.71665ms,1.716699ms,1.7167ms,1.716749ms,1.71675ms,1.716799ms,1.7168ms,1.716849ms,1.71685ms,1.716899ms,1.7169ms,1.716949ms,1.71695ms,1.716999ms,1.717ms,1.717049ms,1.71705ms,1.717099ms,1.7171ms,1.717149ms,1.71715ms,1.717199ms,1.7172ms,1.717249ms,1.71725ms,1.717299ms,1.7173ms,1.717349ms,1.71735ms,1.717399ms,1.7174ms,1.717449ms,1.71745ms,1.717499ms,1.7175ms,1.717549ms,1.71755ms,1.717599ms,1.7176ms,1.717649ms,1.71765ms,1.717699ms,1.7177ms,1.717749ms,1.71775ms,1.717799ms,1.7178ms,1.717849ms,1.71785ms,1.717899ms,1.7179ms,1.717949ms,1.71795ms,1.717999ms,1.718ms,1.718049ms,1.71805ms,1.718099ms,1.7181ms,1.718149ms,1.71815ms,1.718199ms,1.7182ms,1.718249ms,1.71825ms,1.718299ms,1.7183ms,1.718349ms,1.71835ms,1.718399ms,1.7184ms,1.718449ms,1.71845ms,1.718499ms,1.7185ms,1.718549ms,1.71855ms,1.718599ms,1.7186ms,1.718649ms,1.71865ms,1.718699ms,1.7187ms,1.718749ms,1.71875ms,1.718799ms,1.7188ms,1.718849ms,1.71885ms,1.718899ms,1.7189ms,1.718949ms,1.71895ms,1.718999ms,1.719ms,1.719049ms,1.71905ms,1.719099ms,1.7191ms,1.719149ms,1.71915ms,1.719199ms,1.7192ms,1.719249ms,1.71925ms,1.719299ms,1.7193ms,1.719349ms,1.71935ms,1.719399ms,1.7194ms,1.719449ms,1.71945ms,1.719499ms,1.7195ms,1.719549ms,1.71955ms,1.719599ms,1.7196ms,1.719649ms,1.71965ms,1.719699ms,1.7197ms,1.719749ms,1.71975ms,1.719799ms,1.7198ms,1.719849ms,1.71985ms,1.719899ms,1.7199ms,1.719949ms,1.71995ms,1.719999ms,1.72ms,1.720049ms,1.72005ms,1.720099ms,1.7201ms,1.720149ms,1.72015ms,1.720199ms,1.7202ms,1.720249ms,1.72025ms,1.720299ms,1.7203ms,1.720349ms,1.72035ms,1.720399ms,1.7204ms,1.720449ms,1.72045ms,1.720499ms,1.7205ms,1.720549ms,1.72055ms,1.720599ms,1.7206ms,1.720649ms,1.72065ms,1.720699ms,1.7207ms,1.720749ms,1.72075ms,1.720799ms,1.7208ms,1.720849ms,1.72085ms,1.720899ms,1.7209ms,1.720949ms,1.72095ms,1.720999ms,1.721ms,1.721049ms,1.72105ms,1.721099ms,1.7211ms,1.721149ms,1.72115ms,1.721199ms,1.7212ms,1.721249ms,1.72125ms,1.721299ms,1.7213ms,1.721349ms,1.72135ms,1.721399ms,1.7214ms,1.721449ms,1.72145ms,1.721499ms,1.7215ms,1.721549ms,1.72155ms,1.721599ms,1.7216ms,1.721649ms,1.72165ms,1.721699ms,1.7217ms,1.721749ms,1.72175ms,1.721799ms,1.7218ms,1.721849ms,1.72185ms,1.721899ms,1.7219ms,1.721949ms,1.72195ms,1.721999ms,1.722ms,1.722049ms,1.72205ms,1.722099ms,1.7221ms,1.722149ms,1.72215ms,1.722199ms,1.7222ms,1.722249ms,1.72225ms,1.722299ms,1.7223ms,1.722349ms,1.72235ms,1.722399ms,1.7224ms,1.722449ms,1.72245ms,1.722499ms,1.7225ms,1.722549ms,1.72255ms,1.722599ms,1.7226ms,1.722649ms,1.72265ms,1.722699ms,1.7227ms,1.722749ms,1.72275ms,1.722799ms,1.7228ms,1.722849ms,1.72285ms,1.722899ms,1.7229ms,1.722949ms,1.72295ms,1.722999ms,1.723ms,1.723049ms,1.72305ms,1.723099ms,1.7231ms,1.723149ms,1.72315ms,1.723199ms,1.7232ms,1.723249ms,1.72325ms,1.723299ms,1.7233ms,1.723349ms,1.72335ms,1.723399ms,1.7234ms,1.723449ms,1.72345ms,1.723499ms,1.7235ms,1.723549ms,1.72355ms,1.723599ms,1.7236ms,1.723649ms,1.72365ms,1.723699ms,1.7237ms,1.723749ms,1.72375ms,1.723799ms,1.7238ms,1.723849ms,1.72385ms,1.723899ms,1.7239ms,1.723949ms,1.72395ms,1.723999ms,1.724ms,1.724049ms,1.72405ms,1.724099ms,1.7241ms,1.724149ms,1.72415ms,1.724199ms,1.7242ms,1.724249ms,1.72425ms,1.724299ms,1.7243ms,1.724349ms,1.72435ms,1.724399ms,1.7244ms,1.724449ms,1.72445ms,1.724499ms,1.7245ms,1.724549ms,1.72455ms,1.724599ms,1.7246ms,1.724649ms,1.72465ms,1.724699ms,1.7247ms,1.724749ms,1.72475ms,1.724799ms,1.7248ms,1.724849ms,1.72485ms,1.724899ms,1.7249ms,1.724949ms,1.72495ms,1.724999ms,1.725ms,1.725049ms,1.72505ms,1.725099ms,1.7251ms,1.725149ms,1.72515ms,1.725199ms,1.7252ms,1.725249ms,1.72525ms,1.725299ms,1.7253ms,1.725349ms,1.72535ms,1.725399ms,1.7254ms,1.725449ms,1.72545ms,1.725499ms,1.7255ms,1.725549ms,1.72555ms,1.725599ms,1.7256ms,1.725649ms,1.72565ms,1.725699ms,1.7257ms,1.725749ms,1.72575ms,1.725799ms,1.7258ms,1.725849ms,1.72585ms,1.725899ms,1.7259ms,1.725949ms,1.72595ms,1.725999ms,1.726ms,1.726049ms,1.72605ms,1.726099ms,1.7261ms,1.726149ms,1.72615ms,1.726199ms,1.7262ms,1.726249ms,1.72625ms,1.726299ms,1.7263ms,1.726349ms,1.72635ms,1.726399ms,1.7264ms,1.726449ms,1.72645ms,1.726499ms,1.7265ms,1.726549ms,1.72655ms,1.726599ms,1.7266ms,1.726649ms,1.72665ms,1.726699ms,1.7267ms,1.726749ms,1.72675ms,1.726799ms,1.7268ms,1.726849ms,1.72685ms,1.726899ms,1.7269ms,1.726949ms,1.72695ms,1.726999ms,1.727ms,1.727049ms,1.72705ms,1.727099ms,1.7271ms,1.727149ms,1.72715ms,1.727199ms,1.7272ms,1.727249ms,1.72725ms,1.727299ms,1.7273ms,1.727349ms,1.72735ms,1.727399ms,1.7274ms,1.727449ms,1.72745ms,1.727499ms,1.7275ms,1.727549ms,1.72755ms,1.727599ms,1.7276ms,1.727649ms,1.72765ms,1.727699ms,1.7277ms,1.727749ms,1.72775ms,1.727799ms,1.7278ms,1.727849ms,1.72785ms,1.727899ms,1.7279ms,1.727949ms,1.72795ms,1.727999ms,1.728ms,1.728049ms,1.72805ms,1.728099ms,1.7281ms,1.728149ms,1.72815ms,1.728199ms,1.7282ms,1.728249ms,1.72825ms,1.728299ms,1.7283ms,1.728349ms,1.72835ms,1.728399ms,1.7284ms,1.728449ms,1.72845ms,1.728499ms,1.7285ms,1.728549ms,1.72855ms,1.728599ms,1.7286ms,1.728649ms,1.72865ms,1.728699ms,1.7287ms,1.728749ms,1.72875ms,1.728799ms,1.7288ms,1.728849ms,1.72885ms,1.728899ms,1.7289ms,1.728949ms,1.72895ms,1.728999ms,1.729ms,1.729049ms,1.72905ms,1.729099ms,1.7291ms,1.729149ms,1.72915ms,1.729199ms,1.7292ms,1.729249ms,1.72925ms,1.729299ms,1.7293ms,1.729349ms,1.72935ms,1.729399ms,1.7294ms,1.729449ms,1.72945ms,1.729499ms,1.7295ms,1.729549ms,1.72955ms,1.729599ms,1.7296ms,1.729649ms,1.72965ms,1.729699ms,1.7297ms,1.729749ms,1.72975ms,1.729799ms,1.7298ms,1.729849ms,1.72985ms,1.729899ms,1.7299ms,1.729949ms,1.72995ms,1.729999ms,1.73ms,1.730049ms,1.73005ms,1.730099ms,1.7301ms,1.730149ms,1.73015ms,1.730199ms,1.7302ms,1.730249ms,1.73025ms,1.730299ms,1.7303ms,1.730349ms,1.73035ms,1.730399ms,1.7304ms,1.730449ms,1.73045ms,1.730499ms,1.7305ms,1.730549ms,1.73055ms,1.730599ms,1.7306ms,1.730649ms,1.73065ms,1.730699ms,1.7307ms,1.730749ms,1.73075ms,1.730799ms,1.7308ms,1.730849ms,1.73085ms,1.730899ms,1.7309ms,1.730949ms,1.73095ms,1.730999ms,1.731ms,1.731049ms,1.73105ms,1.731099ms,1.7311ms,1.731149ms,1.73115ms,1.731199ms,1.7312ms,1.731249ms,1.73125ms,1.731299ms,1.7313ms,1.731349ms,1.73135ms,1.731399ms,1.7314ms,1.731449ms,1.73145ms,1.731499ms,1.7315ms,1.731549ms,1.73155ms,1.731599ms,1.7316ms,1.731649ms,1.73165ms,1.731699ms,1.7317ms,1.731749ms,1.73175ms,1.731799ms,1.7318ms,1.731849ms,1.73185ms,1.731899ms,1.7319ms,1.731949ms,1.73195ms,1.731999ms,1.732ms,1.732049ms,1.73205ms,1.732099ms,1.7321ms,1.732149ms,1.73215ms,1.732199ms,1.7322ms,1.732249ms,1.73225ms,1.732299ms,1.7323ms,1.732349ms,1.73235ms,1.732399ms,1.7324ms,1.732449ms,1.73245ms,1.732499ms,1.7325ms,1.732549ms,1.73255ms,1.732599ms,1.7326ms,1.732649ms,1.73265ms,1.732699ms,1.7327ms,1.732749ms,1.73275ms,1.732799ms,1.7328ms,1.732849ms,1.73285ms,1.732899ms,1.7329ms,1.732949ms,1.73295ms,1.732999ms,1.733ms,1.733049ms,1.73305ms,1.733099ms,1.7331ms,1.733149ms,1.73315ms,1.733199ms,1.7332ms,1.733249ms,1.73325ms,1.733299ms,1.7333ms,1.733349ms,1.73335ms,1.733399ms,1.7334ms,1.733449ms,1.73345ms,1.733499ms,1.7335ms,1.733549ms,1.73355ms,1.733599ms,1.7336ms,1.733649ms,1.73365ms,1.733699ms,1.7337ms,1.733749ms,1.73375ms,1.733799ms,1.7338ms,1.733849ms,1.73385ms,1.733899ms,1.7339ms,1.733949ms,1.73395ms,1.733999ms,1.734ms,1.734049ms,1.73405ms,1.734099ms,1.7341ms,1.734149ms,1.73415ms,1.734199ms,1.7342ms,1.734249ms,1.73425ms,1.734299ms,1.7343ms,1.734349ms,1.73435ms,1.734399ms,1.7344ms,1.734449ms,1.73445ms,1.734499ms,1.7345ms,1.734549ms,1.73455ms,1.734599ms,1.7346ms,1.734649ms,1.73465ms,1.734699ms,1.7347ms,1.734749ms,1.73475ms,1.734799ms,1.7348ms,1.734849ms,1.73485ms,1.734899ms,1.7349ms,1.734949ms,1.73495ms,1.734999ms,1.735ms,1.735049ms,1.73505ms,1.735099ms,1.7351ms,1.735149ms,1.73515ms,1.735199ms,1.7352ms,1.735249ms,1.73525ms,1.735299ms,1.7353ms,1.735349ms,1.73535ms,1.735399ms,1.7354ms,1.735449ms,1.73545ms,1.735499ms,1.7355ms,1.735549ms,1.73555ms,1.735599ms,1.7356ms,1.735649ms,1.73565ms,1.735699ms,1.7357ms,1.735749ms,1.73575ms,1.735799ms,1.7358ms,1.735849ms,1.73585ms,1.735899ms,1.7359ms,1.735949ms,1.73595ms,1.735999ms,1.736ms,1.736049ms,1.73605ms,1.736099ms,1.7361ms,1.736149ms,1.73615ms,1.736199ms,1.7362ms,1.736249ms,1.73625ms,1.736299ms,1.7363ms,1.736349ms,1.73635ms,1.736399ms,1.7364ms,1.736449ms,1.73645ms,1.736499ms,1.7365ms,1.736549ms,1.73655ms,1.736599ms,1.7366ms,1.736649ms,1.73665ms,1.736699ms,1.7367ms,1.736749ms,1.73675ms,1.736799ms,1.7368ms,1.736849ms,1.73685ms,1.736899ms,1.7369ms,1.736949ms,1.73695ms,1.736999ms,1.737ms,1.737049ms,1.73705ms,1.737099ms,1.7371ms,1.737149ms,1.73715ms,1.737199ms,1.7372ms,1.737249ms,1.73725ms,1.737299ms,1.7373ms,1.737349ms,1.73735ms,1.737399ms,1.7374ms,1.737449ms,1.73745ms,1.737499ms,1.7375ms,1.737549ms,1.73755ms,1.737599ms,1.7376ms,1.737649ms,1.73765ms,1.737699ms,1.7377ms,1.737749ms,1.73775ms,1.737799ms,1.7378ms,1.737849ms,1.73785ms,1.737899ms,1.7379ms,1.737949ms,1.73795ms,1.737999ms,1.738ms,1.738049ms,1.73805ms,1.738099ms,1.7381ms,1.738149ms,1.73815ms,1.738199ms,1.7382ms,1.738249ms,1.73825ms,1.738299ms,1.7383ms,1.738349ms,1.73835ms,1.738399ms,1.7384ms,1.738449ms,1.73845ms,1.738499ms,1.7385ms,1.738549ms,1.73855ms,1.738599ms,1.7386ms,1.738649ms,1.73865ms,1.738699ms,1.7387ms,1.738749ms,1.73875ms,1.738799ms,1.7388ms,1.738849ms,1.73885ms,1.738899ms,1.7389ms,1.738949ms,1.73895ms,1.738999ms,1.739ms,1.739049ms,1.73905ms,1.739099ms,1.7391ms,1.739149ms,1.73915ms,1.739199ms,1.7392ms,1.739249ms,1.73925ms,1.739299ms,1.7393ms,1.739349ms,1.73935ms,1.739399ms,1.7394ms,1.739449ms,1.73945ms,1.739499ms,1.7395ms,1.739549ms,1.73955ms,1.739599ms,1.7396ms,1.739649ms,1.73965ms,1.739699ms,1.7397ms,1.739749ms,1.73975ms,1.739799ms,1.7398ms,1.739849ms,1.73985ms,1.739899ms,1.7399ms,1.739949ms,1.73995ms,1.739999ms,1.74ms,1.740049ms,1.74005ms,1.740099ms,1.7401ms,1.740149ms,1.74015ms,1.740199ms,1.7402ms,1.740249ms,1.74025ms,1.740299ms,1.7403ms,1.740349ms,1.74035ms,1.740399ms,1.7404ms,1.740449ms,1.74045ms,1.740499ms,1.7405ms,1.740549ms,1.74055ms,1.740599ms,1.7406ms,1.740649ms,1.74065ms,1.740699ms,1.7407ms,1.740749ms,1.74075ms,1.740799ms,1.7408ms,1.740849ms,1.74085ms,1.740899ms,1.7409ms,1.740949ms,1.74095ms,1.740999ms,1.741ms,1.741049ms,1.74105ms,1.741099ms,1.7411ms,1.741149ms,1.74115ms,1.741199ms,1.7412ms,1.741249ms,1.74125ms,1.741299ms,1.7413ms,1.741349ms,1.74135ms,1.741399ms,1.7414ms,1.741449ms,1.74145ms,1.741499ms,1.7415ms,1.741549ms,1.74155ms,1.741599ms,1.7416ms,1.741649ms,1.74165ms,1.741699ms,1.7417ms,1.741749ms,1.74175ms,1.741799ms,1.7418ms,1.741849ms,1.74185ms,1.741899ms,1.7419ms,1.741949ms,1.74195ms,1.741999ms,1.742ms,1.742049ms,1.74205ms,1.742099ms,1.7421ms,1.742149ms,1.74215ms,1.742199ms,1.7422ms,1.742249ms,1.74225ms,1.742299ms,1.7423ms,1.742349ms,1.74235ms,1.742399ms,1.7424ms,1.742449ms,1.74245ms,1.742499ms,1.7425ms,1.742549ms,1.74255ms,1.742599ms,1.7426ms,1.742649ms,1.74265ms,1.742699ms,1.7427ms,1.742749ms,1.74275ms,1.742799ms,1.7428ms,1.742849ms,1.74285ms,1.742899ms,1.7429ms,1.742949ms,1.74295ms,1.742999ms,1.743ms,1.743049ms,1.74305ms,1.743099ms,1.7431ms,1.743149ms,1.74315ms,1.743199ms,1.7432ms,1.743249ms,1.74325ms,1.743299ms,1.7433ms,1.743349ms,1.74335ms,1.743399ms,1.7434ms,1.743449ms,1.74345ms,1.743499ms,1.7435ms,1.743549ms,1.74355ms,1.743599ms,1.7436ms,1.743649ms,1.74365ms,1.743699ms,1.7437ms,1.743749ms,1.74375ms,1.743799ms,1.7438ms,1.743849ms,1.74385ms,1.743899ms,1.7439ms,1.743949ms,1.74395ms,1.743999ms,1.744ms,1.744049ms,1.74405ms,1.744099ms,1.7441ms,1.744149ms,1.74415ms,1.744199ms,1.7442ms,1.744249ms,1.74425ms,1.744299ms,1.7443ms,1.744349ms,1.74435ms,1.744399ms,1.7444ms,1.744449ms,1.74445ms,1.744499ms,1.7445ms,1.744549ms,1.74455ms,1.744599ms,1.7446ms,1.744649ms,1.74465ms,1.744699ms,1.7447ms,1.744749ms,1.74475ms,1.744799ms,1.7448ms,1.744849ms,1.74485ms,1.744899ms,1.7449ms,1.744949ms,1.74495ms,1.744999ms,1.745ms,1.745049ms,1.74505ms,1.745099ms,1.7451ms,1.745149ms,1.74515ms,1.745199ms,1.7452ms,1.745249ms,1.74525ms,1.745299ms,1.7453ms,1.745349ms,1.74535ms,1.745399ms,1.7454ms,1.745449ms,1.74545ms,1.745499ms,1.7455ms,1.745549ms,1.74555ms,1.745599ms,1.7456ms,1.745649ms,1.74565ms,1.745699ms,1.7457ms,1.745749ms,1.74575ms,1.745799ms,1.7458ms,1.745849ms,1.74585ms,1.745899ms,1.7459ms,1.745949ms,1.74595ms,1.745999ms,1.746ms,1.746049ms,1.74605ms,1.746099ms,1.7461ms,1.746149ms,1.74615ms,1.746199ms,1.7462ms,1.746249ms,1.74625ms,1.746299ms,1.7463ms,1.746349ms,1.74635ms,1.746399ms,1.7464ms,1.746449ms,1.74645ms,1.746499ms,1.7465ms,1.746549ms,1.74655ms,1.746599ms,1.7466ms,1.746649ms,1.74665ms,1.746699ms,1.7467ms,1.746749ms,1.74675ms,1.746799ms,1.7468ms,1.746849ms,1.74685ms,1.746899ms,1.7469ms,1.746949ms,1.74695ms,1.746999ms,1.747ms,1.747049ms,1.74705ms,1.747099ms,1.7471ms,1.747149ms,1.74715ms,1.747199ms,1.7472ms,1.747249ms,1.74725ms,1.747299ms,1.7473ms,1.747349ms,1.74735ms,1.747399ms,1.7474ms,1.747449ms,1.74745ms,1.747499ms,1.7475ms,1.747549ms,1.74755ms,1.747599ms,1.7476ms,1.747649ms,1.74765ms,1.747699ms,1.7477ms,1.747749ms,1.74775ms,1.747799ms,1.7478ms,1.747849ms,1.74785ms,1.747899ms,1.7479ms,1.747949ms,1.74795ms,1.747999ms,1.748ms,1.748049ms,1.74805ms,1.748099ms,1.7481ms,1.748149ms,1.74815ms,1.748199ms,1.7482ms,1.748249ms,1.74825ms,1.748299ms,1.7483ms,1.748349ms,1.74835ms,1.748399ms,1.7484ms,1.748449ms,1.74845ms,1.748499ms,1.7485ms,1.748549ms,1.74855ms,1.748599ms,1.7486ms,1.748649ms,1.74865ms,1.748699ms,1.7487ms,1.748749ms,1.74875ms,1.748799ms,1.7488ms,1.748849ms,1.74885ms,1.748899ms,1.7489ms,1.748949ms,1.74895ms,1.748999ms,1.749ms,1.749049ms,1.74905ms,1.749099ms,1.7491ms,1.749149ms,1.74915ms,1.749199ms,1.7492ms,1.749249ms,1.74925ms,1.749299ms,1.7493ms,1.749349ms,1.74935ms,1.749399ms,1.7494ms,1.749449ms,1.74945ms,1.749499ms,1.7495ms,1.749549ms,1.74955ms,1.749599ms,1.7496ms,1.749649ms,1.74965ms,1.749699ms,1.7497ms,1.749749ms,1.74975ms,1.749799ms,1.7498ms,1.749849ms,1.74985ms,1.749899ms,1.7499ms,1.749949ms,1.74995ms,1.749999ms,1.75ms,1.750049ms,1.75005ms,1.750099ms,1.7501ms,1.750149ms,1.75015ms,1.750199ms,1.7502ms,1.750249ms,1.75025ms,1.750299ms,1.7503ms,1.750349ms,1.75035ms,1.750399ms,1.7504ms,1.750449ms,1.75045ms,1.750499ms,1.7505ms,1.750549ms,1.75055ms,1.750599ms,1.7506ms,1.750649ms,1.75065ms,1.750699ms,1.7507ms,1.750749ms,1.75075ms,1.750799ms,1.7508ms,1.750849ms,1.75085ms,1.750899ms,1.7509ms,1.750949ms,1.75095ms,1.750999ms,1.751ms,1.751049ms,1.75105ms,1.751099ms,1.7511ms,1.751149ms,1.75115ms,1.751199ms,1.7512ms,1.751249ms,1.75125ms,1.751299ms,1.7513ms,1.751349ms,1.75135ms,1.751399ms,1.7514ms,1.751449ms,1.75145ms,1.751499ms,1.7515ms,1.751549ms,1.75155ms,1.751599ms,1.7516ms,1.751649ms,1.75165ms,1.751699ms,1.7517ms,1.751749ms,1.75175ms,1.751799ms,1.7518ms,1.751849ms,1.75185ms,1.751899ms,1.7519ms,1.751949ms,1.75195ms,1.751999ms,1.752ms,1.752049ms,1.75205ms,1.752099ms,1.7521ms,1.752149ms,1.75215ms,1.752199ms,1.7522ms,1.752249ms,1.75225ms,1.752299ms,1.7523ms,1.752349ms,1.75235ms,1.752399ms,1.7524ms,1.752449ms,1.75245ms,1.752499ms,1.7525ms,1.752549ms,1.75255ms,1.752599ms,1.7526ms,1.752649ms,1.75265ms,1.752699ms,1.7527ms,1.752749ms,1.75275ms,1.752799ms,1.7528ms,1.752849ms,1.75285ms,1.752899ms,1.7529ms,1.752949ms,1.75295ms,1.752999ms,1.753ms,1.753049ms,1.75305ms,1.753099ms,1.7531ms,1.753149ms,1.75315ms,1.753199ms,1.7532ms,1.753249ms,1.75325ms,1.753299ms,1.7533ms,1.753349ms,1.75335ms,1.753399ms,1.7534ms,1.753449ms,1.75345ms,1.753499ms,1.7535ms,1.753549ms,1.75355ms,1.753599ms,1.7536ms,1.753649ms,1.75365ms,1.753699ms,1.7537ms,1.753749ms,1.75375ms,1.753799ms,1.7538ms,1.753849ms,1.75385ms,1.753899ms,1.7539ms,1.753949ms,1.75395ms,1.753999ms,1.754ms,1.754049ms,1.75405ms,1.754099ms,1.7541ms,1.754149ms,1.75415ms,1.754199ms,1.7542ms,1.754249ms,1.75425ms,1.754299ms,1.7543ms,1.754349ms,1.75435ms,1.754399ms,1.7544ms,1.754449ms,1.75445ms,1.754499ms,1.7545ms,1.754549ms,1.75455ms,1.754599ms,1.7546ms,1.754649ms,1.75465ms,1.754699ms,1.7547ms,1.754749ms,1.75475ms,1.754799ms,1.7548ms,1.754849ms,1.75485ms,1.754899ms,1.7549ms,1.754949ms,1.75495ms,1.754999ms,1.755ms,1.755049ms,1.75505ms,1.755099ms,1.7551ms,1.755149ms,1.75515ms,1.755199ms,1.7552ms,1.755249ms,1.75525ms,1.755299ms,1.7553ms,1.755349ms,1.75535ms,1.755399ms,1.7554ms,1.755449ms,1.75545ms,1.755499ms,1.7555ms,1.755549ms,1.75555ms,1.755599ms,1.7556ms,1.755649ms,1.75565ms,1.755699ms,1.7557ms,1.755749ms,1.75575ms,1.755799ms,1.7558ms,1.755849ms,1.75585ms,1.755899ms,1.7559ms,1.755949ms,1.75595ms,1.755999ms,1.756ms,1.756049ms,1.75605ms,1.756099ms,1.7561ms,1.756149ms,1.75615ms,1.756199ms,1.7562ms,1.756249ms,1.75625ms,1.756299ms,1.7563ms,1.756349ms,1.75635ms,1.756399ms,1.7564ms,1.756449ms,1.75645ms,1.756499ms,1.7565ms,1.756549ms,1.75655ms,1.756599ms,1.7566ms,1.756649ms,1.75665ms,1.756699ms,1.7567ms,1.756749ms,1.75675ms,1.756799ms,1.7568ms,1.756849ms,1.75685ms,1.756899ms,1.7569ms,1.756949ms,1.75695ms,1.756999ms,1.757ms,1.757049ms,1.75705ms,1.757099ms,1.7571ms,1.757149ms,1.75715ms,1.757199ms,1.7572ms,1.757249ms,1.75725ms,1.757299ms,1.7573ms,1.757349ms,1.75735ms,1.757399ms,1.7574ms,1.757449ms,1.75745ms,1.757499ms,1.7575ms,1.757549ms,1.75755ms,1.757599ms,1.7576ms,1.757649ms,1.75765ms,1.757699ms,1.7577ms,1.757749ms,1.75775ms,1.757799ms,1.7578ms,1.757849ms,1.75785ms,1.757899ms,1.7579ms,1.757949ms,1.75795ms,1.757999ms,1.758ms,1.758049ms,1.75805ms,1.758099ms,1.7581ms,1.758149ms,1.75815ms,1.758199ms,1.7582ms,1.758249ms,1.75825ms,1.758299ms,1.7583ms,1.758349ms,1.75835ms,1.758399ms,1.7584ms,1.758449ms,1.75845ms,1.758499ms,1.7585ms,1.758549ms,1.75855ms,1.758599ms,1.7586ms,1.758649ms,1.75865ms,1.758699ms,1.7587ms,1.758749ms,1.75875ms,1.758799ms,1.7588ms,1.758849ms,1.75885ms,1.758899ms,1.7589ms,1.758949ms,1.75895ms,1.758999ms,1.759ms,1.759049ms,1.75905ms,1.759099ms,1.7591ms,1.759149ms,1.75915ms,1.759199ms,1.7592ms,1.759249ms,1.75925ms,1.759299ms,1.7593ms,1.759349ms,1.75935ms,1.759399ms,1.7594ms,1.759449ms,1.75945ms,1.759499ms,1.7595ms,1.759549ms,1.75955ms,1.759599ms,1.7596ms,1.759649ms,1.75965ms,1.759699ms,1.7597ms,1.759749ms,1.75975ms,1.759799ms,1.7598ms,1.759849ms,1.75985ms,1.759899ms,1.7599ms,1.759949ms,1.75995ms,1.759999ms,1.76ms,1.760049ms,1.76005ms,1.760099ms,1.7601ms,1.760149ms,1.76015ms,1.760199ms,1.7602ms,1.760249ms,1.76025ms,1.760299ms,1.7603ms,1.760349ms,1.76035ms,1.760399ms,1.7604ms,1.760449ms,1.76045ms,1.760499ms,1.7605ms,1.760549ms,1.76055ms,1.760599ms,1.7606ms,1.760649ms,1.76065ms,1.760699ms,1.7607ms,1.760749ms,1.76075ms,1.760799ms,1.7608ms,1.760849ms,1.76085ms,1.760899ms,1.7609ms,1.760949ms,1.76095ms,1.760999ms,1.761ms,1.761049ms,1.76105ms,1.761099ms,1.7611ms,1.761149ms,1.76115ms,1.761199ms,1.7612ms,1.761249ms,1.76125ms,1.761299ms,1.7613ms,1.761349ms,1.76135ms,1.761399ms,1.7614ms,1.761449ms,1.76145ms,1.761499ms,1.7615ms,1.761549ms,1.76155ms,1.761599ms,1.7616ms,1.761649ms,1.76165ms,1.761699ms,1.7617ms,1.761749ms,1.76175ms,1.761799ms,1.7618ms,1.761849ms,1.76185ms,1.761899ms,1.7619ms,1.761949ms,1.76195ms,1.761999ms,1.762ms,1.762049ms,1.76205ms,1.762099ms,1.7621ms,1.762149ms,1.76215ms,1.762199ms,1.7622ms,1.762249ms,1.76225ms,1.762299ms,1.7623ms,1.762349ms,1.76235ms,1.762399ms,1.7624ms,1.762449ms,1.76245ms,1.762499ms,1.7625ms,1.762549ms,1.76255ms,1.762599ms,1.7626ms,1.762649ms,1.76265ms,1.762699ms,1.7627ms,1.762749ms,1.76275ms,1.762799ms,1.7628ms,1.762849ms,1.76285ms,1.762899ms,1.7629ms,1.762949ms,1.76295ms,1.762999ms,1.763ms,1.763049ms,1.76305ms,1.763099ms,1.7631ms,1.763149ms,1.76315ms,1.763199ms,1.7632ms,1.763249ms,1.76325ms,1.763299ms,1.7633ms,1.763349ms,1.76335ms,1.763399ms,1.7634ms,1.763449ms,1.76345ms,1.763499ms,1.7635ms,1.763549ms,1.76355ms,1.763599ms,1.7636ms,1.763649ms,1.76365ms,1.763699ms,1.7637ms,1.763749ms,1.76375ms,1.763799ms,1.7638ms,1.763849ms,1.76385ms,1.763899ms,1.7639ms,1.763949ms,1.76395ms,1.763999ms,1.764ms,1.764049ms,1.76405ms,1.764099ms,1.7641ms,1.764149ms,1.76415ms,1.764199ms,1.7642ms,1.764249ms,1.76425ms,1.764299ms,1.7643ms,1.764349ms,1.76435ms,1.764399ms,1.7644ms,1.764449ms,1.76445ms,1.764499ms,1.7645ms,1.764549ms,1.76455ms,1.764599ms,1.7646ms,1.764649ms,1.76465ms,1.764699ms,1.7647ms,1.764749ms,1.76475ms,1.764799ms,1.7648ms,1.764849ms,1.76485ms,1.764899ms,1.7649ms,1.764949ms,1.76495ms,1.764999ms,1.765ms,1.765049ms,1.76505ms,1.765099ms,1.7651ms,1.765149ms,1.76515ms,1.765199ms,1.7652ms,1.765249ms,1.76525ms,1.765299ms,1.7653ms,1.765349ms,1.76535ms,1.765399ms,1.7654ms,1.765449ms,1.76545ms,1.765499ms,1.7655ms,1.765549ms,1.76555ms,1.765599ms,1.7656ms,1.765649ms,1.76565ms,1.765699ms,1.7657ms,1.765749ms,1.76575ms,1.765799ms,1.7658ms,1.765849ms,1.76585ms,1.765899ms,1.7659ms,1.765949ms,1.76595ms,1.765999ms,1.766ms,1.766049ms,1.76605ms,1.766099ms,1.7661ms,1.766149ms,1.76615ms,1.766199ms,1.7662ms,1.766249ms,1.76625ms,1.766299ms,1.7663ms,1.766349ms,1.76635ms,1.766399ms,1.7664ms,1.766449ms,1.76645ms,1.766499ms,1.7665ms,1.766549ms,1.76655ms,1.766599ms,1.7666ms,1.766649ms,1.76665ms,1.766699ms,1.7667ms,1.766749ms,1.76675ms,1.766799ms,1.7668ms,1.766849ms,1.76685ms,1.766899ms,1.7669ms,1.766949ms,1.76695ms,1.766999ms,1.767ms,1.767049ms,1.76705ms,1.767099ms,1.7671ms,1.767149ms,1.76715ms,1.767199ms,1.7672ms,1.767249ms,1.76725ms,1.767299ms,1.7673ms,1.767349ms,1.76735ms,1.767399ms,1.7674ms,1.767449ms,1.76745ms,1.767499ms,1.7675ms,1.767549ms,1.76755ms,1.767599ms,1.7676ms,1.767649ms,1.76765ms,1.767699ms,1.7677ms,1.767749ms,1.76775ms,1.767799ms,1.7678ms,1.767849ms,1.76785ms,1.767899ms,1.7679ms,1.767949ms,1.76795ms,1.767999ms,1.768ms,1.768049ms,1.76805ms,1.768099ms,1.7681ms,1.768149ms,1.76815ms,1.768199ms,1.7682ms,1.768249ms,1.76825ms,1.768299ms,1.7683ms,1.768349ms,1.76835ms,1.768399ms,1.7684ms,1.768449ms,1.76845ms,1.768499ms,1.7685ms,1.768549ms,1.76855ms,1.768599ms,1.7686ms,1.768649ms,1.76865ms,1.768699ms,1.7687ms,1.768749ms,1.76875ms,1.768799ms,1.7688ms,1.768849ms,1.76885ms,1.768899ms,1.7689ms,1.768949ms,1.76895ms,1.768999ms,1.769ms,1.769049ms,1.76905ms,1.769099ms,1.7691ms,1.769149ms,1.76915ms,1.769199ms,1.7692ms,1.769249ms,1.76925ms,1.769299ms,1.7693ms,1.769349ms,1.76935ms,1.769399ms,1.7694ms,1.769449ms,1.76945ms,1.769499ms,1.7695ms,1.769549ms,1.76955ms,1.769599ms,1.7696ms,1.769649ms,1.76965ms,1.769699ms,1.7697ms,1.769749ms,1.76975ms,1.769799ms,1.7698ms,1.769849ms,1.76985ms,1.769899ms,1.7699ms,1.769949ms,1.76995ms,1.769999ms,1.77ms,1.770049ms,1.77005ms,1.770099ms,1.7701ms,1.770149ms,1.77015ms,1.770199ms,1.7702ms,1.770249ms,1.77025ms,1.770299ms,1.7703ms,1.770349ms,1.77035ms,1.770399ms,1.7704ms,1.770449ms,1.77045ms,1.770499ms,1.7705ms,1.770549ms,1.77055ms,1.770599ms,1.7706ms,1.770649ms,1.77065ms,1.770699ms,1.7707ms,1.770749ms,1.77075ms,1.770799ms,1.7708ms,1.770849ms,1.77085ms,1.770899ms,1.7709ms,1.770949ms,1.77095ms,1.770999ms,1.771ms,1.771049ms,1.77105ms,1.771099ms,1.7711ms,1.771149ms,1.77115ms,1.771199ms,1.7712ms,1.771249ms,1.77125ms,1.771299ms,1.7713ms,1.771349ms,1.77135ms,1.771399ms,1.7714ms,1.771449ms,1.77145ms,1.771499ms,1.7715ms,1.771549ms,1.77155ms,1.771599ms,1.7716ms,1.771649ms,1.77165ms,1.771699ms,1.7717ms,1.771749ms,1.77175ms,1.771799ms,1.7718ms,1.771849ms,1.77185ms,1.771899ms,1.7719ms,1.771949ms,1.77195ms,1.771999ms,1.772ms,1.772049ms,1.77205ms,1.772099ms,1.7721ms,1.772149ms,1.77215ms,1.772199ms,1.7722ms,1.772249ms,1.77225ms,1.772299ms,1.7723ms,1.772349ms,1.77235ms,1.772399ms,1.7724ms,1.772449ms,1.77245ms,1.772499ms,1.7725ms,1.772549ms,1.77255ms,1.772599ms,1.7726ms,1.772649ms,1.77265ms,1.772699ms,1.7727ms,1.772749ms,1.77275ms,1.772799ms,1.7728ms,1.772849ms,1.77285ms,1.772899ms,1.7729ms,1.772949ms,1.77295ms,1.772999ms,1.773ms,1.773049ms,1.77305ms,1.773099ms,1.7731ms,1.773149ms,1.77315ms,1.773199ms,1.7732ms,1.773249ms,1.77325ms,1.773299ms,1.7733ms,1.773349ms,1.77335ms,1.773399ms,1.7734ms,1.773449ms,1.77345ms,1.773499ms,1.7735ms,1.773549ms,1.77355ms,1.773599ms,1.7736ms,1.773649ms,1.77365ms,1.773699ms,1.7737ms,1.773749ms,1.77375ms,1.773799ms,1.7738ms,1.773849ms,1.77385ms,1.773899ms,1.7739ms,1.773949ms,1.77395ms,1.773999ms,1.774ms,1.774049ms,1.77405ms,1.774099ms,1.7741ms,1.774149ms,1.77415ms,1.774199ms,1.7742ms,1.774249ms,1.77425ms,1.774299ms,1.7743ms,1.774349ms,1.77435ms,1.774399ms,1.7744ms,1.774449ms,1.77445ms,1.774499ms,1.7745ms,1.774549ms,1.77455ms,1.774599ms,1.7746ms,1.774649ms,1.77465ms,1.774699ms,1.7747ms,1.774749ms,1.77475ms,1.774799ms,1.7748ms,1.774849ms,1.77485ms,1.774899ms,1.7749ms,1.774949ms,1.77495ms,1.774999ms,1.775ms,1.775049ms,1.77505ms,1.775099ms,1.7751ms,1.775149ms,1.77515ms,1.775199ms,1.7752ms,1.775249ms,1.77525ms,1.775299ms,1.7753ms,1.775349ms,1.77535ms,1.775399ms,1.7754ms,1.775449ms,1.77545ms,1.775499ms,1.7755ms,1.775549ms,1.77555ms,1.775599ms,1.7756ms,1.775649ms,1.77565ms,1.775699ms,1.7757ms,1.775749ms,1.77575ms,1.775799ms,1.7758ms,1.775849ms,1.77585ms,1.775899ms,1.7759ms,1.775949ms,1.77595ms,1.775999ms,1.776ms,1.776049ms,1.77605ms,1.776099ms,1.7761ms,1.776149ms,1.77615ms,1.776199ms,1.7762ms,1.776249ms,1.77625ms,1.776299ms,1.7763ms,1.776349ms,1.77635ms,1.776399ms,1.7764ms,1.776449ms,1.77645ms,1.776499ms,1.7765ms,1.776549ms,1.77655ms,1.776599ms,1.7766ms,1.776649ms,1.77665ms,1.776699ms,1.7767ms,1.776749ms,1.77675ms,1.776799ms,1.7768ms,1.776849ms,1.77685ms,1.776899ms,1.7769ms,1.776949ms,1.77695ms,1.776999ms,1.777ms,1.777049ms,1.77705ms,1.777099ms,1.7771ms,1.777149ms,1.77715ms,1.777199ms,1.7772ms,1.777249ms,1.77725ms,1.777299ms,1.7773ms,1.777349ms,1.77735ms,1.777399ms,1.7774ms,1.777449ms,1.77745ms,1.777499ms,1.7775ms,1.777549ms,1.77755ms,1.777599ms,1.7776ms,1.777649ms,1.77765ms,1.777699ms,1.7777ms,1.777749ms,1.77775ms,1.777799ms,1.7778ms,1.777849ms,1.77785ms,1.777899ms,1.7779ms,1.777949ms,1.77795ms,1.777999ms,1.778ms,1.778049ms,1.77805ms,1.778099ms,1.7781ms,1.778149ms,1.77815ms,1.778199ms,1.7782ms,1.778249ms,1.77825ms,1.778299ms,1.7783ms,1.778349ms,1.77835ms,1.778399ms,1.7784ms,1.778449ms,1.77845ms,1.778499ms,1.7785ms,1.778549ms,1.77855ms,1.778599ms,1.7786ms,1.778649ms,1.77865ms,1.778699ms,1.7787ms,1.778749ms,1.77875ms,1.778799ms,1.7788ms,1.778849ms,1.77885ms,1.778899ms,1.7789ms,1.778949ms,1.77895ms,1.778999ms,1.779ms,1.779049ms,1.77905ms,1.779099ms,1.7791ms,1.779149ms,1.77915ms,1.779199ms,1.7792ms,1.779249ms,1.77925ms,1.779299ms,1.7793ms,1.779349ms,1.77935ms,1.779399ms,1.7794ms,1.779449ms,1.77945ms,1.779499ms,1.7795ms,1.779549ms,1.77955ms,1.779599ms,1.7796ms,1.779649ms,1.77965ms,1.779699ms,1.7797ms,1.779749ms,1.77975ms,1.779799ms,1.7798ms,1.779849ms,1.77985ms,1.779899ms,1.7799ms,1.779949ms,1.77995ms,1.779999ms,1.78ms,1.780049ms,1.78005ms,1.780099ms,1.7801ms,1.780149ms,1.78015ms,1.780199ms,1.7802ms,1.780249ms,1.78025ms,1.780299ms,1.7803ms,1.780349ms,1.78035ms,1.780399ms,1.7804ms,1.780449ms,1.78045ms,1.780499ms,1.7805ms,1.780549ms,1.78055ms,1.780599ms,1.7806ms,1.780649ms,1.78065ms,1.780699ms,1.7807ms,1.780749ms,1.78075ms,1.780799ms,1.7808ms,1.780849ms,1.78085ms,1.780899ms,1.7809ms,1.780949ms,1.78095ms,1.780999ms,1.781ms,1.781049ms,1.78105ms,1.781099ms,1.7811ms,1.781149ms,1.78115ms,1.781199ms,1.7812ms,1.781249ms,1.78125ms,1.781299ms,1.7813ms,1.781349ms,1.78135ms,1.781399ms,1.7814ms,1.781449ms,1.78145ms,1.781499ms,1.7815ms,1.781549ms,1.78155ms,1.781599ms,1.7816ms,1.781649ms,1.78165ms,1.781699ms,1.7817ms,1.781749ms,1.78175ms,1.781799ms,1.7818ms,1.781849ms,1.78185ms,1.781899ms,1.7819ms,1.781949ms,1.78195ms,1.781999ms,1.782ms,1.782049ms,1.78205ms,1.782099ms,1.7821ms,1.782149ms,1.78215ms,1.782199ms,1.7822ms,1.782249ms,1.78225ms,1.782299ms,1.7823ms,1.782349ms,1.78235ms,1.782399ms,1.7824ms,1.782449ms,1.78245ms,1.782499ms,1.7825ms,1.782549ms,1.78255ms,1.782599ms,1.7826ms,1.782649ms,1.78265ms,1.782699ms,1.7827ms,1.782749ms,1.78275ms,1.782799ms,1.7828ms,1.782849ms,1.78285ms,1.782899ms,1.7829ms,1.782949ms,1.78295ms,1.782999ms,1.783ms,1.783049ms,1.78305ms,1.783099ms,1.7831ms,1.783149ms,1.78315ms,1.783199ms,1.7832ms,1.783249ms,1.78325ms,1.783299ms,1.7833ms,1.783349ms,1.78335ms,1.783399ms,1.7834ms,1.783449ms,1.78345ms,1.783499ms,1.7835ms,1.783549ms,1.78355ms,1.783599ms,1.7836ms,1.783649ms,1.78365ms,1.783699ms,1.7837ms,1.783749ms,1.78375ms,1.783799ms,1.7838ms,1.783849ms,1.78385ms,1.783899ms,1.7839ms,1.783949ms,1.78395ms,1.783999ms,1.784ms,1.784049ms,1.78405ms,1.784099ms,1.7841ms,1.784149ms,1.78415ms,1.784199ms,1.7842ms,1.784249ms,1.78425ms,1.784299ms,1.7843ms,1.784349ms,1.78435ms,1.784399ms,1.7844ms,1.784449ms,1.78445ms,1.784499ms,1.7845ms,1.784549ms,1.78455ms,1.784599ms,1.7846ms,1.784649ms,1.78465ms,1.784699ms,1.7847ms,1.784749ms,1.78475ms,1.784799ms,1.7848ms,1.784849ms,1.78485ms,1.784899ms,1.7849ms,1.784949ms,1.78495ms,1.784999ms,1.785ms,1.785049ms,1.78505ms,1.785099ms,1.7851ms,1.785149ms,1.78515ms,1.785199ms,1.7852ms,1.785249ms,1.78525ms,1.785299ms,1.7853ms,1.785349ms,1.78535ms,1.785399ms,1.7854ms,1.785449ms,1.78545ms,1.785499ms,1.7855ms,1.785549ms,1.78555ms,1.785599ms,1.7856ms,1.785649ms,1.78565ms,1.785699ms,1.7857ms,1.785749ms,1.78575ms,1.785799ms,1.7858ms,1.785849ms,1.78585ms,1.785899ms,1.7859ms,1.785949ms,1.78595ms,1.785999ms,1.786ms,1.786049ms,1.78605ms,1.786099ms,1.7861ms,1.786149ms,1.78615ms,1.786199ms,1.7862ms,1.786249ms,1.78625ms,1.786299ms,1.7863ms,1.786349ms,1.78635ms,1.786399ms,1.7864ms,1.786449ms,1.78645ms,1.786499ms,1.7865ms,1.786549ms,1.78655ms,1.786599ms,1.7866ms,1.786649ms,1.78665ms,1.786699ms,1.7867ms,1.786749ms,1.78675ms,1.786799ms,1.7868ms,1.786849ms,1.78685ms,1.786899ms,1.7869ms,1.786949ms,1.78695ms,1.786999ms,1.787ms,1.787049ms,1.78705ms,1.787099ms,1.7871ms,1.787149ms,1.78715ms,1.787199ms,1.7872ms,1.787249ms,1.78725ms,1.787299ms,1.7873ms,1.787349ms,1.78735ms,1.787399ms,1.7874ms,1.787449ms,1.78745ms,1.787499ms,1.7875ms,1.787549ms,1.78755ms,1.787599ms,1.7876ms,1.787649ms,1.78765ms,1.787699ms,1.7877ms,1.787749ms,1.78775ms,1.787799ms,1.7878ms,1.787849ms,1.78785ms,1.787899ms,1.7879ms,1.787949ms,1.78795ms,1.787999ms,1.788ms,1.788049ms,1.78805ms,1.788099ms,1.7881ms,1.788149ms,1.78815ms,1.788199ms,1.7882ms,1.788249ms,1.78825ms,1.788299ms,1.7883ms,1.788349ms,1.78835ms,1.788399ms,1.7884ms,1.788449ms,1.78845ms,1.788499ms,1.7885ms,1.788549ms,1.78855ms,1.788599ms,1.7886ms,1.788649ms,1.78865ms,1.788699ms,1.7887ms,1.788749ms,1.78875ms,1.788799ms,1.7888ms,1.788849ms,1.78885ms,1.788899ms,1.7889ms,1.788949ms,1.78895ms,1.788999ms,1.789ms,1.789049ms,1.78905ms,1.789099ms,1.7891ms,1.789149ms,1.78915ms,1.789199ms,1.7892ms,1.789249ms,1.78925ms,1.789299ms,1.7893ms,1.789349ms,1.78935ms,1.789399ms,1.7894ms,1.789449ms,1.78945ms,1.789499ms,1.7895ms,1.789549ms,1.78955ms,1.789599ms,1.7896ms,1.789649ms,1.78965ms,1.789699ms,1.7897ms,1.789749ms,1.78975ms,1.789799ms,1.7898ms,1.789849ms,1.78985ms,1.789899ms,1.7899ms,1.789949ms,1.78995ms,1.789999ms,1.79ms,1.790049ms,1.79005ms,1.790099ms,1.7901ms,1.790149ms,1.79015ms,1.790199ms,1.7902ms,1.790249ms,1.79025ms,1.790299ms,1.7903ms,1.790349ms,1.79035ms,1.790399ms,1.7904ms,1.790449ms,1.79045ms,1.790499ms,1.7905ms,1.790549ms,1.79055ms,1.790599ms,1.7906ms,1.790649ms,1.79065ms,1.790699ms,1.7907ms,1.790749ms,1.79075ms,1.790799ms,1.7908ms,1.790849ms,1.79085ms,1.790899ms,1.7909ms,1.790949ms,1.79095ms,1.790999ms,1.791ms,1.791049ms,1.79105ms,1.791099ms,1.7911ms,1.791149ms,1.79115ms,1.791199ms,1.7912ms,1.791249ms,1.79125ms,1.791299ms,1.7913ms,1.791349ms,1.79135ms,1.791399ms,1.7914ms,1.791449ms,1.79145ms,1.791499ms,1.7915ms,1.791549ms,1.79155ms,1.791599ms,1.7916ms,1.791649ms,1.79165ms,1.791699ms,1.7917ms,1.791749ms,1.79175ms,1.791799ms,1.7918ms,1.791849ms,1.79185ms,1.791899ms,1.7919ms,1.791949ms,1.79195ms,1.791999ms,1.792ms,1.792049ms,1.79205ms,1.792099ms,1.7921ms,1.792149ms,1.79215ms,1.792199ms,1.7922ms,1.792249ms,1.79225ms,1.792299ms,1.7923ms,1.792349ms,1.79235ms,1.792399ms,1.7924ms,1.792449ms,1.79245ms,1.792499ms,1.7925ms,1.792549ms,1.79255ms,1.792599ms,1.7926ms,1.792649ms,1.79265ms,1.792699ms,1.7927ms,1.792749ms,1.79275ms,1.792799ms,1.7928ms,1.792849ms,1.79285ms,1.792899ms,1.7929ms,1.792949ms,1.79295ms,1.792999ms,1.793ms,1.793049ms,1.79305ms,1.793099ms,1.7931ms,1.793149ms,1.79315ms,1.793199ms,1.7932ms,1.793249ms,1.79325ms,1.793299ms,1.7933ms,1.793349ms,1.79335ms,1.793399ms,1.7934ms,1.793449ms,1.79345ms,1.793499ms,1.7935ms,1.793549ms,1.79355ms,1.793599ms,1.7936ms,1.793649ms,1.79365ms,1.793699ms,1.7937ms,1.793749ms,1.79375ms,1.793799ms,1.7938ms,1.793849ms,1.79385ms,1.793899ms,1.7939ms,1.793949ms,1.79395ms,1.793999ms,1.794ms,1.794049ms,1.79405ms,1.794099ms,1.7941ms,1.794149ms,1.79415ms,1.794199ms,1.7942ms,1.794249ms,1.79425ms,1.794299ms,1.7943ms,1.794349ms,1.79435ms,1.794399ms,1.7944ms,1.794449ms,1.79445ms,1.794499ms,1.7945ms,1.794549ms,1.79455ms,1.794599ms,1.7946ms,1.794649ms,1.79465ms,1.794699ms,1.7947ms,1.794749ms,1.79475ms,1.794799ms,1.7948ms,1.794849ms,1.79485ms,1.794899ms,1.7949ms,1.794949ms,1.79495ms,1.794999ms,1.795ms,1.795049ms,1.79505ms,1.795099ms,1.7951ms,1.795149ms,1.79515ms,1.795199ms,1.7952ms,1.795249ms,1.79525ms,1.795299ms,1.7953ms,1.795349ms,1.79535ms,1.795399ms,1.7954ms,1.795449ms,1.79545ms,1.795499ms,1.7955ms,1.795549ms,1.79555ms,1.795599ms,1.7956ms,1.795649ms,1.79565ms,1.795699ms,1.7957ms,1.795749ms,1.79575ms,1.795799ms,1.7958ms,1.795849ms,1.79585ms,1.795899ms,1.7959ms,1.795949ms,1.79595ms,1.795999ms,1.796ms,1.796049ms,1.79605ms,1.796099ms,1.7961ms,1.796149ms,1.79615ms,1.796199ms,1.7962ms,1.796249ms,1.79625ms,1.796299ms,1.7963ms,1.796349ms,1.79635ms,1.796399ms,1.7964ms,1.796449ms,1.79645ms,1.796499ms,1.7965ms,1.796549ms,1.79655ms,1.796599ms,1.7966ms,1.796649ms,1.79665ms,1.796699ms,1.7967ms,1.796749ms,1.79675ms,1.796799ms,1.7968ms,1.796849ms,1.79685ms,1.796899ms,1.7969ms,1.796949ms,1.79695ms,1.796999ms,1.797ms,1.797049ms,1.79705ms,1.797099ms,1.7971ms,1.797149ms,1.79715ms,1.797199ms,1.7972ms,1.797249ms,1.79725ms,1.797299ms,1.7973ms,1.797349ms,1.79735ms,1.797399ms,1.7974ms,1.797449ms,1.79745ms,1.797499ms,1.7975ms,1.797549ms,1.79755ms,1.797599ms,1.7976ms,1.797649ms,1.79765ms,1.797699ms,1.7977ms,1.797749ms,1.79775ms,1.797799ms,1.7978ms,1.797849ms,1.79785ms,1.797899ms,1.7979ms,1.797949ms,1.79795ms,1.797999ms,1.798ms,1.798049ms,1.79805ms,1.798099ms,1.7981ms,1.798149ms,1.79815ms,1.798199ms,1.7982ms,1.798249ms,1.79825ms,1.798299ms,1.7983ms,1.798349ms,1.79835ms,1.798399ms,1.7984ms,1.798449ms,1.79845ms,1.798499ms,1.7985ms,1.798549ms,1.79855ms,1.798599ms,1.7986ms,1.798649ms,1.79865ms,1.798699ms,1.7987ms,1.798749ms,1.79875ms,1.798799ms,1.7988ms,1.798849ms,1.79885ms,1.798899ms,1.7989ms,1.798949ms,1.79895ms,1.798999ms,1.799ms,1.799049ms,1.79905ms,1.799099ms,1.7991ms,1.799149ms,1.79915ms,1.799199ms,1.7992ms,1.799249ms,1.79925ms,1.799299ms,1.7993ms,1.799349ms,1.79935ms,1.799399ms,1.7994ms,1.799449ms,1.79945ms,1.799499ms,1.7995ms,1.799549ms,1.79955ms,1.799599ms,1.7996ms,1.799649ms,1.79965ms,1.799699ms,1.7997ms,1.799749ms,1.79975ms,1.799799ms,1.7998ms,1.799849ms,1.79985ms,1.799899ms,1.7999ms,1.799949ms,1.79995ms,1.799999ms,1.8ms,1.800049ms,1.80005ms,1.800099ms,1.8001ms,1.800149ms,1.80015ms,1.800199ms,1.8002ms,1.800249ms,1.80025ms,1.800299ms,1.8003ms,1.800349ms,1.80035ms,1.800399ms,1.8004ms,1.800449ms,1.80045ms,1.800499ms,1.8005ms,1.800549ms,1.80055ms,1.800599ms,1.8006ms,1.800649ms,1.80065ms,1.800699ms,1.8007ms,1.800749ms,1.80075ms,1.800799ms,1.8008ms,1.800849ms,1.80085ms,1.800899ms,1.8009ms,1.800949ms,1.80095ms,1.800999ms,1.801ms,1.801049ms,1.80105ms,1.801099ms,1.8011ms,1.801149ms,1.80115ms,1.801199ms,1.8012ms,1.801249ms,1.80125ms,1.801299ms,1.8013ms,1.801349ms,1.80135ms,1.801399ms,1.8014ms,1.801449ms,1.80145ms,1.801499ms,1.8015ms,1.801549ms,1.80155ms,1.801599ms,1.8016ms,1.801649ms,1.80165ms,1.801699ms,1.8017ms,1.801749ms,1.80175ms,1.801799ms,1.8018ms,1.801849ms,1.80185ms,1.801899ms,1.8019ms,1.801949ms,1.80195ms,1.801999ms,1.802ms,1.802049ms,1.80205ms,1.802099ms,1.8021ms,1.802149ms,1.80215ms,1.802199ms,1.8022ms,1.802249ms,1.80225ms,1.802299ms,1.8023ms,1.802349ms,1.80235ms,1.802399ms,1.8024ms,1.802449ms,1.80245ms,1.802499ms,1.8025ms,1.802549ms,1.80255ms,1.802599ms,1.8026ms,1.802649ms,1.80265ms,1.802699ms,1.8027ms,1.802749ms,1.80275ms,1.802799ms,1.8028ms,1.802849ms,1.80285ms,1.802899ms,1.8029ms,1.802949ms,1.80295ms,1.802999ms,1.803ms,1.803049ms,1.80305ms,1.803099ms,1.8031ms,1.803149ms,1.80315ms,1.803199ms,1.8032ms,1.803249ms,1.80325ms,1.803299ms,1.8033ms,1.803349ms,1.80335ms,1.803399ms,1.8034ms,1.803449ms,1.80345ms,1.803499ms,1.8035ms,1.803549ms,1.80355ms,1.803599ms,1.8036ms,1.803649ms,1.80365ms,1.803699ms,1.8037ms,1.803749ms,1.80375ms,1.803799ms,1.8038ms,1.803849ms,1.80385ms,1.803899ms,1.8039ms,1.803949ms,1.80395ms,1.803999ms,1.804ms,1.804049ms,1.80405ms,1.804099ms,1.8041ms,1.804149ms,1.80415ms,1.804199ms,1.8042ms,1.804249ms,1.80425ms,1.804299ms,1.8043ms,1.804349ms,1.80435ms,1.804399ms,1.8044ms,1.804449ms,1.80445ms,1.804499ms,1.8045ms,1.804549ms,1.80455ms,1.804599ms,1.8046ms,1.804649ms,1.80465ms,1.804699ms,1.8047ms,1.804749ms,1.80475ms,1.804799ms,1.8048ms,1.804849ms,1.80485ms,1.804899ms,1.8049ms,1.804949ms,1.80495ms,1.804999ms,1.805ms,1.805049ms,1.80505ms,1.805099ms,1.8051ms,1.805149ms,1.80515ms,1.805199ms,1.8052ms,1.805249ms,1.80525ms,1.805299ms,1.8053ms,1.805349ms,1.80535ms,1.805399ms,1.8054ms,1.805449ms,1.80545ms,1.805499ms,1.8055ms,1.805549ms,1.80555ms,1.805599ms,1.8056ms,1.805649ms,1.80565ms,1.805699ms,1.8057ms,1.805749ms,1.80575ms,1.805799ms,1.8058ms,1.805849ms,1.80585ms,1.805899ms,1.8059ms,1.805949ms,1.80595ms,1.805999ms,1.806ms,1.806049ms,1.80605ms,1.806099ms,1.8061ms,1.806149ms,1.80615ms,1.806199ms,1.8062ms,1.806249ms,1.80625ms,1.806299ms,1.8063ms,1.806349ms,1.80635ms,1.806399ms,1.8064ms,1.806449ms,1.80645ms,1.806499ms,1.8065ms,1.806549ms,1.80655ms,1.806599ms,1.8066ms,1.806649ms,1.80665ms,1.806699ms,1.8067ms,1.806749ms,1.80675ms,1.806799ms,1.8068ms,1.806849ms,1.80685ms,1.806899ms,1.8069ms,1.806949ms,1.80695ms,1.806999ms,1.807ms,1.807049ms,1.80705ms,1.807099ms,1.8071ms,1.807149ms,1.80715ms,1.807199ms,1.8072ms,1.807249ms,1.80725ms,1.807299ms,1.8073ms,1.807349ms,1.80735ms,1.807399ms,1.8074ms,1.807449ms,1.80745ms,1.807499ms,1.8075ms,1.807549ms,1.80755ms,1.807599ms,1.8076ms,1.807649ms,1.80765ms,1.807699ms,1.8077ms,1.807749ms,1.80775ms,1.807799ms,1.8078ms,1.807849ms,1.80785ms,1.807899ms,1.8079ms,1.807949ms,1.80795ms,1.807999ms,1.808ms,1.808049ms,1.80805ms,1.808099ms,1.8081ms,1.808149ms,1.80815ms,1.808199ms,1.8082ms,1.808249ms,1.80825ms,1.808299ms,1.8083ms,1.808349ms,1.80835ms,1.808399ms,1.8084ms,1.808449ms,1.80845ms,1.808499ms,1.8085ms,1.808549ms,1.80855ms,1.808599ms,1.8086ms,1.808649ms,1.80865ms,1.808699ms,1.8087ms,1.808749ms,1.80875ms,1.808799ms,1.8088ms,1.808849ms,1.80885ms,1.808899ms,1.8089ms,1.808949ms,1.80895ms,1.808999ms,1.809ms,1.809049ms,1.80905ms,1.809099ms,1.8091ms,1.809149ms,1.80915ms,1.809199ms,1.8092ms,1.809249ms,1.80925ms,1.809299ms,1.8093ms,1.809349ms,1.80935ms,1.809399ms,1.8094ms,1.809449ms,1.80945ms,1.809499ms,1.8095ms,1.809549ms,1.80955ms,1.809599ms,1.8096ms,1.809649ms,1.80965ms,1.809699ms,1.8097ms,1.809749ms,1.80975ms,1.809799ms,1.8098ms,1.809849ms,1.80985ms,1.809899ms,1.8099ms,1.809949ms,1.80995ms,1.809999ms,1.81ms,1.810049ms,1.81005ms,1.810099ms,1.8101ms,1.810149ms,1.81015ms,1.810199ms,1.8102ms,1.810249ms,1.81025ms,1.810299ms,1.8103ms,1.810349ms,1.81035ms,1.810399ms,1.8104ms,1.810449ms,1.81045ms,1.810499ms,1.8105ms,1.810549ms,1.81055ms,1.810599ms,1.8106ms,1.810649ms,1.81065ms,1.810699ms,1.8107ms,1.810749ms,1.81075ms,1.810799ms,1.8108ms,1.810849ms,1.81085ms,1.810899ms,1.8109ms,1.810949ms,1.81095ms,1.810999ms,1.811ms,1.811049ms,1.81105ms,1.811099ms,1.8111ms,1.811149ms,1.81115ms,1.811199ms,1.8112ms,1.811249ms,1.81125ms,1.811299ms,1.8113ms,1.811349ms,1.81135ms,1.811399ms,1.8114ms,1.811449ms,1.81145ms,1.811499ms,1.8115ms,1.811549ms,1.81155ms,1.811599ms,1.8116ms,1.811649ms,1.81165ms,1.811699ms,1.8117ms,1.811749ms,1.81175ms,1.811799ms,1.8118ms,1.811849ms,1.81185ms,1.811899ms,1.8119ms,1.811949ms,1.81195ms,1.811999ms,1.812ms,1.812049ms,1.81205ms,1.812099ms,1.8121ms,1.812149ms,1.81215ms,1.812199ms,1.8122ms,1.812249ms,1.81225ms,1.812299ms,1.8123ms,1.812349ms,1.81235ms,1.812399ms,1.8124ms,1.812449ms,1.81245ms,1.812499ms,1.8125ms,1.812549ms,1.81255ms,1.812599ms,1.8126ms,1.812649ms,1.81265ms,1.812699ms,1.8127ms,1.812749ms,1.81275ms,1.812799ms,1.8128ms,1.812849ms,1.81285ms,1.812899ms,1.8129ms,1.812949ms,1.81295ms,1.812999ms,1.813ms,1.813049ms,1.81305ms,1.813099ms,1.8131ms,1.813149ms,1.81315ms,1.813199ms,1.8132ms,1.813249ms,1.81325ms,1.813299ms,1.8133ms,1.813349ms,1.81335ms,1.813399ms,1.8134ms,1.813449ms,1.81345ms,1.813499ms,1.8135ms,1.813549ms,1.81355ms,1.813599ms,1.8136ms,1.813649ms,1.81365ms,1.813699ms,1.8137ms,1.813749ms,1.81375ms,1.813799ms,1.8138ms,1.813849ms,1.81385ms,1.813899ms,1.8139ms,1.813949ms,1.81395ms,1.813999ms,1.814ms,1.814049ms,1.81405ms,1.814099ms,1.8141ms,1.814149ms,1.81415ms,1.814199ms,1.8142ms,1.814249ms,1.81425ms,1.814299ms,1.8143ms,1.814349ms,1.81435ms,1.814399ms,1.8144ms,1.814449ms,1.81445ms,1.814499ms,1.8145ms,1.814549ms,1.81455ms,1.814599ms,1.8146ms,1.814649ms,1.81465ms,1.814699ms,1.8147ms,1.814749ms,1.81475ms,1.814799ms,1.8148ms,1.814849ms,1.81485ms,1.814899ms,1.8149ms,1.814949ms,1.81495ms,1.814999ms,1.815ms,1.815049ms,1.81505ms,1.815099ms,1.8151ms,1.815149ms,1.81515ms,1.815199ms,1.8152ms,1.815249ms,1.81525ms,1.815299ms,1.8153ms,1.815349ms,1.81535ms,1.815399ms,1.8154ms,1.815449ms,1.81545ms,1.815499ms,1.8155ms,1.815549ms,1.81555ms,1.815599ms,1.8156ms,1.815649ms,1.81565ms,1.815699ms,1.8157ms,1.815749ms,1.81575ms,1.815799ms,1.8158ms,1.815849ms,1.81585ms,1.815899ms,1.8159ms,1.815949ms,1.81595ms,1.815999ms,1.816ms,1.816049ms,1.81605ms,1.816099ms,1.8161ms,1.816149ms,1.81615ms,1.816199ms,1.8162ms,1.816249ms,1.81625ms,1.816299ms,1.8163ms,1.816349ms,1.81635ms,1.816399ms,1.8164ms,1.816449ms,1.81645ms,1.816499ms,1.8165ms,1.816549ms,1.81655ms,1.816599ms,1.8166ms,1.816649ms,1.81665ms,1.816699ms,1.8167ms,1.816749ms,1.81675ms,1.816799ms,1.8168ms,1.816849ms,1.81685ms,1.816899ms,1.8169ms,1.816949ms,1.81695ms,1.816999ms,1.817ms,1.817049ms,1.81705ms,1.817099ms,1.8171ms,1.817149ms,1.81715ms,1.817199ms,1.8172ms,1.817249ms,1.81725ms,1.817299ms,1.8173ms,1.817349ms,1.81735ms,1.817399ms,1.8174ms,1.817449ms,1.81745ms,1.817499ms,1.8175ms,1.817549ms,1.81755ms,1.817599ms,1.8176ms,1.817649ms,1.81765ms,1.817699ms,1.8177ms,1.817749ms,1.81775ms,1.817799ms,1.8178ms,1.817849ms,1.81785ms,1.817899ms,1.8179ms,1.817949ms,1.81795ms,1.817999ms,1.818ms,1.818049ms,1.81805ms,1.818099ms,1.8181ms,1.818149ms,1.81815ms,1.818199ms,1.8182ms,1.818249ms,1.81825ms,1.818299ms,1.8183ms,1.818349ms,1.81835ms,1.818399ms,1.8184ms,1.818449ms,1.81845ms,1.818499ms,1.8185ms,1.818549ms,1.81855ms,1.818599ms,1.8186ms,1.818649ms,1.81865ms,1.818699ms,1.8187ms,1.818749ms,1.81875ms,1.818799ms,1.8188ms,1.818849ms,1.81885ms,1.818899ms,1.8189ms,1.818949ms,1.81895ms,1.818999ms,1.819ms,1.819049ms,1.81905ms,1.819099ms,1.8191ms,1.819149ms,1.81915ms,1.819199ms,1.8192ms,1.819249ms,1.81925ms,1.819299ms,1.8193ms,1.819349ms,1.81935ms,1.819399ms,1.8194ms,1.819449ms,1.81945ms,1.819499ms,1.8195ms,1.819549ms,1.81955ms,1.819599ms,1.8196ms,1.819649ms,1.81965ms,1.819699ms,1.8197ms,1.819749ms,1.81975ms,1.819799ms,1.8198ms,1.819849ms,1.81985ms,1.819899ms,1.8199ms,1.819949ms,1.81995ms,1.819999ms,1.82ms,1.820049ms,1.82005ms,1.820099ms,1.8201ms,1.820149ms,1.82015ms,1.820199ms,1.8202ms,1.820249ms,1.82025ms,1.820299ms,1.8203ms,1.820349ms,1.82035ms,1.820399ms,1.8204ms,1.820449ms,1.82045ms,1.820499ms,1.8205ms,1.820549ms,1.82055ms,1.820599ms,1.8206ms,1.820649ms,1.82065ms,1.820699ms,1.8207ms,1.820749ms,1.82075ms,1.820799ms,1.8208ms,1.820849ms,1.82085ms,1.820899ms,1.8209ms,1.820949ms,1.82095ms,1.820999ms,1.821ms,1.821049ms,1.82105ms,1.821099ms,1.8211ms,1.821149ms,1.82115ms,1.821199ms,1.8212ms,1.821249ms,1.82125ms,1.821299ms,1.8213ms,1.821349ms,1.82135ms,1.821399ms,1.8214ms,1.821449ms,1.82145ms,1.821499ms,1.8215ms,1.821549ms,1.82155ms,1.821599ms,1.8216ms,1.821649ms,1.82165ms,1.821699ms,1.8217ms,1.821749ms,1.82175ms,1.821799ms,1.8218ms,1.821849ms,1.82185ms,1.821899ms,1.8219ms,1.821949ms,1.82195ms,1.821999ms,1.822ms,1.822049ms,1.82205ms,1.822099ms,1.8221ms,1.822149ms,1.82215ms,1.822199ms,1.8222ms,1.822249ms,1.82225ms,1.822299ms,1.8223ms,1.822349ms,1.82235ms,1.822399ms,1.8224ms,1.822449ms,1.82245ms,1.822499ms,1.8225ms,1.822549ms,1.82255ms,1.822599ms,1.8226ms,1.822649ms,1.82265ms,1.822699ms,1.8227ms,1.822749ms,1.82275ms,1.822799ms,1.8228ms,1.822849ms,1.82285ms,1.822899ms,1.8229ms,1.822949ms,1.82295ms,1.822999ms,1.823ms,1.823049ms,1.82305ms,1.823099ms,1.8231ms,1.823149ms,1.82315ms,1.823199ms,1.8232ms,1.823249ms,1.82325ms,1.823299ms,1.8233ms,1.823349ms,1.82335ms,1.823399ms,1.8234ms,1.823449ms,1.82345ms,1.823499ms,1.8235ms,1.823549ms,1.82355ms,1.823599ms,1.8236ms,1.823649ms,1.82365ms,1.823699ms,1.8237ms,1.823749ms,1.82375ms,1.823799ms,1.8238ms,1.823849ms,1.82385ms,1.823899ms,1.8239ms,1.823949ms,1.82395ms,1.823999ms,1.824ms,1.824049ms,1.82405ms,1.824099ms,1.8241ms,1.824149ms,1.82415ms,1.824199ms,1.8242ms,1.824249ms,1.82425ms,1.824299ms,1.8243ms,1.824349ms,1.82435ms,1.824399ms,1.8244ms,1.824449ms,1.82445ms,1.824499ms,1.8245ms,1.824549ms,1.82455ms,1.824599ms,1.8246ms,1.824649ms,1.82465ms,1.824699ms,1.8247ms,1.824749ms,1.82475ms,1.824799ms,1.8248ms,1.824849ms,1.82485ms,1.824899ms,1.8249ms,1.824949ms,1.82495ms,1.824999ms,1.825ms,1.825049ms,1.82505ms,1.825099ms,1.8251ms,1.825149ms,1.82515ms,1.825199ms,1.8252ms,1.825249ms,1.82525ms,1.825299ms,1.8253ms,1.825349ms,1.82535ms,1.825399ms,1.8254ms,1.825449ms,1.82545ms,1.825499ms,1.8255ms,1.825549ms,1.82555ms,1.825599ms,1.8256ms,1.825649ms,1.82565ms,1.825699ms,1.8257ms,1.825749ms,1.82575ms,1.825799ms,1.8258ms,1.825849ms,1.82585ms,1.825899ms,1.8259ms,1.825949ms,1.82595ms,1.825999ms,1.826ms,1.826049ms,1.82605ms,1.826099ms,1.8261ms,1.826149ms,1.82615ms,1.826199ms,1.8262ms,1.826249ms,1.82625ms,1.826299ms,1.8263ms,1.826349ms,1.82635ms,1.826399ms,1.8264ms,1.826449ms,1.82645ms,1.826499ms,1.8265ms,1.826549ms,1.82655ms,1.826599ms,1.8266ms,1.826649ms,1.82665ms,1.826699ms,1.8267ms,1.826749ms,1.82675ms,1.826799ms,1.8268ms,1.826849ms,1.82685ms,1.826899ms,1.8269ms,1.826949ms,1.82695ms,1.826999ms,1.827ms,1.827049ms,1.82705ms,1.827099ms,1.8271ms,1.827149ms,1.82715ms,1.827199ms,1.8272ms,1.827249ms,1.82725ms,1.827299ms,1.8273ms,1.827349ms,1.82735ms,1.827399ms,1.8274ms,1.827449ms,1.82745ms,1.827499ms,1.8275ms,1.827549ms,1.82755ms,1.827599ms,1.8276ms,1.827649ms,1.82765ms,1.827699ms,1.8277ms,1.827749ms,1.82775ms,1.827799ms,1.8278ms,1.827849ms,1.82785ms,1.827899ms,1.8279ms,1.827949ms,1.82795ms,1.827999ms,1.828ms,1.828049ms,1.82805ms,1.828099ms,1.8281ms,1.828149ms,1.82815ms,1.828199ms,1.8282ms,1.828249ms,1.82825ms,1.828299ms,1.8283ms,1.828349ms,1.82835ms,1.828399ms,1.8284ms,1.828449ms,1.82845ms,1.828499ms,1.8285ms,1.828549ms,1.82855ms,1.828599ms,1.8286ms,1.828649ms,1.82865ms,1.828699ms,1.8287ms,1.828749ms,1.82875ms,1.828799ms,1.8288ms,1.828849ms,1.82885ms,1.828899ms,1.8289ms,1.828949ms,1.82895ms,1.828999ms,1.829ms,1.829049ms,1.82905ms,1.829099ms,1.8291ms,1.829149ms,1.82915ms,1.829199ms,1.8292ms,1.829249ms,1.82925ms,1.829299ms,1.8293ms,1.829349ms,1.82935ms,1.829399ms,1.8294ms,1.829449ms,1.82945ms,1.829499ms,1.8295ms,1.829549ms,1.82955ms,1.829599ms,1.8296ms,1.829649ms,1.82965ms,1.829699ms,1.8297ms,1.829749ms,1.82975ms,1.829799ms,1.8298ms,1.829849ms,1.82985ms,1.829899ms,1.8299ms,1.829949ms,1.82995ms,1.829999ms,1.83ms,1.830049ms,1.83005ms,1.830099ms,1.8301ms,1.830149ms,1.83015ms,1.830199ms,1.8302ms,1.830249ms,1.83025ms,1.830299ms,1.8303ms,1.830349ms,1.83035ms,1.830399ms,1.8304ms,1.830449ms,1.83045ms,1.830499ms,1.8305ms,1.830549ms,1.83055ms,1.830599ms,1.8306ms,1.830649ms,1.83065ms,1.830699ms,1.8307ms,1.830749ms,1.83075ms,1.830799ms,1.8308ms,1.830849ms,1.83085ms,1.830899ms,1.8309ms,1.830949ms,1.83095ms,1.830999ms,1.831ms,1.831049ms,1.83105ms,1.831099ms,1.8311ms,1.831149ms,1.83115ms,1.831199ms,1.8312ms,1.831249ms,1.83125ms,1.831299ms,1.8313ms,1.831349ms,1.83135ms,1.831399ms,1.8314ms,1.831449ms,1.83145ms,1.831499ms,1.8315ms,1.831549ms,1.83155ms,1.831599ms,1.8316ms,1.831649ms,1.83165ms,1.831699ms,1.8317ms,1.831749ms,1.83175ms,1.831799ms,1.8318ms,1.831849ms,1.83185ms,1.831899ms,1.8319ms,1.831949ms,1.83195ms,1.831999ms,1.832ms,1.832049ms,1.83205ms,1.832099ms,1.8321ms,1.832149ms,1.83215ms,1.832199ms,1.8322ms,1.832249ms,1.83225ms,1.832299ms,1.8323ms,1.832349ms,1.83235ms,1.832399ms,1.8324ms,1.832449ms,1.83245ms,1.832499ms,1.8325ms,1.832549ms,1.83255ms,1.832599ms,1.8326ms,1.832649ms,1.83265ms,1.832699ms,1.8327ms,1.832749ms,1.83275ms,1.832799ms,1.8328ms,1.832849ms,1.83285ms,1.832899ms,1.8329ms,1.832949ms,1.83295ms,1.832999ms,1.833ms,1.833049ms,1.83305ms,1.833099ms,1.8331ms,1.833149ms,1.83315ms,1.833199ms,1.8332ms,1.833249ms,1.83325ms,1.833299ms,1.8333ms,1.833349ms,1.83335ms,1.833399ms,1.8334ms,1.833449ms,1.83345ms,1.833499ms,1.8335ms,1.833549ms,1.83355ms,1.833599ms,1.8336ms,1.833649ms,1.83365ms,1.833699ms,1.8337ms,1.833749ms,1.83375ms,1.833799ms,1.8338ms,1.833849ms,1.83385ms,1.833899ms,1.8339ms,1.833949ms,1.83395ms,1.833999ms,1.834ms,1.834049ms,1.83405ms,1.834099ms,1.8341ms,1.834149ms,1.83415ms,1.834199ms,1.8342ms,1.834249ms,1.83425ms,1.834299ms,1.8343ms,1.834349ms,1.83435ms,1.834399ms,1.8344ms,1.834449ms,1.83445ms,1.834499ms,1.8345ms,1.834549ms,1.83455ms,1.834599ms,1.8346ms,1.834649ms,1.83465ms,1.834699ms,1.8347ms,1.834749ms,1.83475ms,1.834799ms,1.8348ms,1.834849ms,1.83485ms,1.834899ms,1.8349ms,1.834949ms,1.83495ms,1.834999ms,1.835ms,1.835049ms,1.83505ms,1.835099ms,1.8351ms,1.835149ms,1.83515ms,1.835199ms,1.8352ms,1.835249ms,1.83525ms,1.835299ms,1.8353ms,1.835349ms,1.83535ms,1.835399ms,1.8354ms,1.835449ms,1.83545ms,1.835499ms,1.8355ms,1.835549ms,1.83555ms,1.835599ms,1.8356ms,1.835649ms,1.83565ms,1.835699ms,1.8357ms,1.835749ms,1.83575ms,1.835799ms,1.8358ms,1.835849ms,1.83585ms,1.835899ms,1.8359ms,1.835949ms,1.83595ms,1.835999ms,1.836ms,1.836049ms,1.83605ms,1.836099ms,1.8361ms,1.836149ms,1.83615ms,1.836199ms,1.8362ms,1.836249ms,1.83625ms,1.836299ms,1.8363ms,1.836349ms,1.83635ms,1.836399ms,1.8364ms,1.836449ms,1.83645ms,1.836499ms,1.8365ms,1.836549ms,1.83655ms,1.836599ms,1.8366ms,1.836649ms,1.83665ms,1.836699ms,1.8367ms,1.836749ms,1.83675ms,1.836799ms,1.8368ms,1.836849ms,1.83685ms,1.836899ms,1.8369ms,1.836949ms,1.83695ms,1.836999ms,1.837ms,1.837049ms,1.83705ms,1.837099ms,1.8371ms,1.837149ms,1.83715ms,1.837199ms,1.8372ms,1.837249ms,1.83725ms,1.837299ms,1.8373ms,1.837349ms,1.83735ms,1.837399ms,1.8374ms,1.837449ms,1.83745ms,1.837499ms,1.8375ms,1.837549ms,1.83755ms,1.837599ms,1.8376ms,1.837649ms,1.83765ms,1.837699ms,1.8377ms,1.837749ms,1.83775ms,1.837799ms,1.8378ms,1.837849ms,1.83785ms,1.837899ms,1.8379ms,1.837949ms,1.83795ms,1.837999ms,1.838ms,1.838049ms,1.83805ms,1.838099ms,1.8381ms,1.838149ms,1.83815ms,1.838199ms,1.8382ms,1.838249ms,1.83825ms,1.838299ms,1.8383ms,1.838349ms,1.83835ms,1.838399ms,1.8384ms,1.838449ms,1.83845ms,1.838499ms,1.8385ms,1.838549ms,1.83855ms,1.838599ms,1.8386ms,1.838649ms,1.83865ms,1.838699ms,1.8387ms,1.838749ms,1.83875ms,1.838799ms,1.8388ms,1.838849ms,1.83885ms,1.838899ms,1.8389ms,1.838949ms,1.83895ms,1.838999ms,1.839ms,1.839049ms,1.83905ms,1.839099ms,1.8391ms,1.839149ms,1.83915ms,1.839199ms,1.8392ms,1.839249ms,1.83925ms,1.839299ms,1.8393ms,1.839349ms,1.83935ms,1.839399ms,1.8394ms,1.839449ms,1.83945ms,1.839499ms,1.8395ms,1.839549ms,1.83955ms,1.839599ms,1.8396ms,1.839649ms,1.83965ms,1.839699ms,1.8397ms,1.839749ms,1.83975ms,1.839799ms,1.8398ms,1.839849ms,1.83985ms,1.839899ms,1.8399ms,1.839949ms,1.83995ms,1.839999ms,1.84ms,1.840049ms,1.84005ms,1.840099ms,1.8401ms,1.840149ms,1.84015ms,1.840199ms,1.8402ms,1.840249ms,1.84025ms,1.840299ms,1.8403ms,1.840349ms,1.84035ms,1.840399ms,1.8404ms,1.840449ms,1.84045ms,1.840499ms,1.8405ms,1.840549ms,1.84055ms,1.840599ms,1.8406ms,1.840649ms,1.84065ms,1.840699ms,1.8407ms,1.840749ms,1.84075ms,1.840799ms,1.8408ms,1.840849ms,1.84085ms,1.840899ms,1.8409ms,1.840949ms,1.84095ms,1.840999ms,1.841ms,1.841049ms,1.84105ms,1.841099ms,1.8411ms,1.841149ms,1.84115ms,1.841199ms,1.8412ms,1.841249ms,1.84125ms,1.841299ms,1.8413ms,1.841349ms,1.84135ms,1.841399ms,1.8414ms,1.841449ms,1.84145ms,1.841499ms,1.8415ms,1.841549ms,1.84155ms,1.841599ms,1.8416ms,1.841649ms,1.84165ms,1.841699ms,1.8417ms,1.841749ms,1.84175ms,1.841799ms,1.8418ms,1.841849ms,1.84185ms,1.841899ms,1.8419ms,1.841949ms,1.84195ms,1.841999ms,1.842ms,1.842049ms,1.84205ms,1.842099ms,1.8421ms,1.842149ms,1.84215ms,1.842199ms,1.8422ms,1.842249ms,1.84225ms,1.842299ms,1.8423ms,1.842349ms,1.84235ms,1.842399ms,1.8424ms,1.842449ms,1.84245ms,1.842499ms,1.8425ms,1.842549ms,1.84255ms,1.842599ms,1.8426ms,1.842649ms,1.84265ms,1.842699ms,1.8427ms,1.842749ms,1.84275ms,1.842799ms,1.8428ms,1.842849ms,1.84285ms,1.842899ms,1.8429ms,1.842949ms,1.84295ms,1.842999ms,1.843ms,1.843049ms,1.84305ms,1.843099ms,1.8431ms,1.843149ms,1.84315ms,1.843199ms,1.8432ms,1.843249ms,1.84325ms,1.843299ms,1.8433ms,1.843349ms,1.84335ms,1.843399ms,1.8434ms,1.843449ms,1.84345ms,1.843499ms,1.8435ms,1.843549ms,1.84355ms,1.843599ms,1.8436ms,1.843649ms,1.84365ms,1.843699ms,1.8437ms,1.843749ms,1.84375ms,1.843799ms,1.8438ms,1.843849ms,1.84385ms,1.843899ms,1.8439ms,1.843949ms,1.84395ms,1.843999ms,1.844ms,1.844049ms,1.84405ms,1.844099ms,1.8441ms,1.844149ms,1.84415ms,1.844199ms,1.8442ms,1.844249ms,1.84425ms,1.844299ms,1.8443ms,1.844349ms,1.84435ms,1.844399ms,1.8444ms,1.844449ms,1.84445ms,1.844499ms,1.8445ms,1.844549ms,1.84455ms,1.844599ms,1.8446ms,1.844649ms,1.84465ms,1.844699ms,1.8447ms,1.844749ms,1.84475ms,1.844799ms,1.8448ms,1.844849ms,1.84485ms,1.844899ms,1.8449ms,1.844949ms,1.84495ms,1.844999ms,1.845ms,1.845049ms,1.84505ms,1.845099ms,1.8451ms,1.845149ms,1.84515ms,1.845199ms,1.8452ms,1.845249ms,1.84525ms,1.845299ms,1.8453ms,1.845349ms,1.84535ms,1.845399ms,1.8454ms,1.845449ms,1.84545ms,1.845499ms,1.8455ms,1.845549ms,1.84555ms,1.845599ms,1.8456ms,1.845649ms,1.84565ms,1.845699ms,1.8457ms,1.845749ms,1.84575ms,1.845799ms,1.8458ms,1.845849ms,1.84585ms,1.845899ms,1.8459ms,1.845949ms,1.84595ms,1.845999ms,1.846ms,1.846049ms,1.84605ms,1.846099ms,1.8461ms,1.846149ms,1.84615ms,1.846199ms,1.8462ms,1.846249ms,1.84625ms,1.846299ms,1.8463ms,1.846349ms,1.84635ms,1.846399ms,1.8464ms,1.846449ms,1.84645ms,1.846499ms,1.8465ms,1.846549ms,1.84655ms,1.846599ms,1.8466ms,1.846649ms,1.84665ms,1.846699ms,1.8467ms,1.846749ms,1.84675ms,1.846799ms,1.8468ms,1.846849ms,1.84685ms,1.846899ms,1.8469ms,1.846949ms,1.84695ms,1.846999ms,1.847ms,1.847049ms,1.84705ms,1.847099ms,1.8471ms,1.847149ms,1.84715ms,1.847199ms,1.8472ms,1.847249ms,1.84725ms,1.847299ms,1.8473ms,1.847349ms,1.84735ms,1.847399ms,1.8474ms,1.847449ms,1.84745ms,1.847499ms,1.8475ms,1.847549ms,1.84755ms,1.847599ms,1.8476ms,1.847649ms,1.84765ms,1.847699ms,1.8477ms,1.847749ms,1.84775ms,1.847799ms,1.8478ms,1.847849ms,1.84785ms,1.847899ms,1.8479ms,1.847949ms,1.84795ms,1.847999ms,1.848ms,1.848049ms,1.84805ms,1.848099ms,1.8481ms,1.848149ms,1.84815ms,1.848199ms,1.8482ms,1.848249ms,1.84825ms,1.848299ms,1.8483ms,1.848349ms,1.84835ms,1.848399ms,1.8484ms,1.848449ms,1.84845ms,1.848499ms,1.8485ms,1.848549ms,1.84855ms,1.848599ms,1.8486ms,1.848649ms,1.84865ms,1.848699ms,1.8487ms,1.848749ms,1.84875ms,1.848799ms,1.8488ms,1.848849ms,1.84885ms,1.848899ms,1.8489ms,1.848949ms,1.84895ms,1.848999ms,1.849ms,1.849049ms,1.84905ms,1.849099ms,1.8491ms,1.849149ms,1.84915ms,1.849199ms,1.8492ms,1.849249ms,1.84925ms,1.849299ms,1.8493ms,1.849349ms,1.84935ms,1.849399ms,1.8494ms,1.849449ms,1.84945ms,1.849499ms,1.8495ms,1.849549ms,1.84955ms,1.849599ms,1.8496ms,1.849649ms,1.84965ms,1.849699ms,1.8497ms,1.849749ms,1.84975ms,1.849799ms,1.8498ms,1.849849ms,1.84985ms,1.849899ms,1.8499ms,1.849949ms,1.84995ms,1.849999ms,1.85ms,1.850049ms,1.85005ms,1.850099ms,1.8501ms,1.850149ms,1.85015ms,1.850199ms,1.8502ms,1.850249ms,1.85025ms,1.850299ms,1.8503ms,1.850349ms,1.85035ms,1.850399ms,1.8504ms,1.850449ms,1.85045ms,1.850499ms,1.8505ms,1.850549ms,1.85055ms,1.850599ms,1.8506ms,1.850649ms,1.85065ms,1.850699ms,1.8507ms,1.850749ms,1.85075ms,1.850799ms,1.8508ms,1.850849ms,1.85085ms,1.850899ms,1.8509ms,1.850949ms,1.85095ms,1.850999ms,1.851ms,1.851049ms,1.85105ms,1.851099ms,1.8511ms,1.851149ms,1.85115ms,1.851199ms,1.8512ms,1.851249ms,1.85125ms,1.851299ms,1.8513ms,1.851349ms,1.85135ms,1.851399ms,1.8514ms,1.851449ms,1.85145ms,1.851499ms,1.8515ms,1.851549ms,1.85155ms,1.851599ms,1.8516ms,1.851649ms,1.85165ms,1.851699ms,1.8517ms,1.851749ms,1.85175ms,1.851799ms,1.8518ms,1.851849ms,1.85185ms,1.851899ms,1.8519ms,1.851949ms,1.85195ms,1.851999ms,1.852ms,1.852049ms,1.85205ms,1.852099ms,1.8521ms,1.852149ms,1.85215ms,1.852199ms,1.8522ms,1.852249ms,1.85225ms,1.852299ms,1.8523ms,1.852349ms,1.85235ms,1.852399ms,1.8524ms,1.852449ms,1.85245ms,1.852499ms,1.8525ms,1.852549ms,1.85255ms,1.852599ms,1.8526ms,1.852649ms,1.85265ms,1.852699ms,1.8527ms,1.852749ms,1.85275ms,1.852799ms,1.8528ms,1.852849ms,1.85285ms,1.852899ms,1.8529ms,1.852949ms,1.85295ms,1.852999ms,1.853ms,1.853049ms,1.85305ms,1.853099ms,1.8531ms,1.853149ms,1.85315ms,1.853199ms,1.8532ms,1.853249ms,1.85325ms,1.853299ms,1.8533ms,1.853349ms,1.85335ms,1.853399ms,1.8534ms,1.853449ms,1.85345ms,1.853499ms,1.8535ms,1.853549ms,1.85355ms,1.853599ms,1.8536ms,1.853649ms,1.85365ms,1.853699ms,1.8537ms,1.853749ms,1.85375ms,1.853799ms,1.8538ms,1.853849ms,1.85385ms,1.853899ms,1.8539ms,1.853949ms,1.85395ms,1.853999ms,1.854ms,1.854049ms,1.85405ms,1.854099ms,1.8541ms,1.854149ms,1.85415ms,1.854199ms,1.8542ms,1.854249ms,1.85425ms,1.854299ms,1.8543ms,1.854349ms,1.85435ms,1.854399ms,1.8544ms,1.854449ms,1.85445ms,1.854499ms,1.8545ms,1.854549ms,1.85455ms,1.854599ms,1.8546ms,1.854649ms,1.85465ms,1.854699ms,1.8547ms,1.854749ms,1.85475ms,1.854799ms,1.8548ms,1.854849ms,1.85485ms,1.854899ms,1.8549ms,1.854949ms,1.85495ms,1.854999ms,1.855ms,1.855049ms,1.85505ms,1.855099ms,1.8551ms,1.855149ms,1.85515ms,1.855199ms,1.8552ms,1.855249ms,1.85525ms,1.855299ms,1.8553ms,1.855349ms,1.85535ms,1.855399ms,1.8554ms,1.855449ms,1.85545ms,1.855499ms,1.8555ms,1.855549ms,1.85555ms,1.855599ms,1.8556ms,1.855649ms,1.85565ms,1.855699ms,1.8557ms,1.855749ms,1.85575ms,1.855799ms,1.8558ms,1.855849ms,1.85585ms,1.855899ms,1.8559ms,1.855949ms,1.85595ms,1.855999ms,1.856ms,1.856049ms,1.85605ms,1.856099ms,1.8561ms,1.856149ms,1.85615ms,1.856199ms,1.8562ms,1.856249ms,1.85625ms,1.856299ms,1.8563ms,1.856349ms,1.85635ms,1.856399ms,1.8564ms,1.856449ms,1.85645ms,1.856499ms,1.8565ms,1.856549ms,1.85655ms,1.856599ms,1.8566ms,1.856649ms,1.85665ms,1.856699ms,1.8567ms,1.856749ms,1.85675ms,1.856799ms,1.8568ms,1.856849ms,1.85685ms,1.856899ms,1.8569ms,1.856949ms,1.85695ms,1.856999ms,1.857ms,1.857049ms,1.85705ms,1.857099ms,1.8571ms,1.857149ms,1.85715ms,1.857199ms,1.8572ms,1.857249ms,1.85725ms,1.857299ms,1.8573ms,1.857349ms,1.85735ms,1.857399ms,1.8574ms,1.857449ms,1.85745ms,1.857499ms,1.8575ms,1.857549ms,1.85755ms,1.857599ms,1.8576ms,1.857649ms,1.85765ms,1.857699ms,1.8577ms,1.857749ms,1.85775ms,1.857799ms,1.8578ms,1.857849ms,1.85785ms,1.857899ms,1.8579ms,1.857949ms,1.85795ms,1.857999ms,1.858ms,1.858049ms,1.85805ms,1.858099ms,1.8581ms,1.858149ms,1.85815ms,1.858199ms,1.8582ms,1.858249ms,1.85825ms,1.858299ms,1.8583ms,1.858349ms,1.85835ms,1.858399ms,1.8584ms,1.858449ms,1.85845ms,1.858499ms,1.8585ms,1.858549ms,1.85855ms,1.858599ms,1.8586ms,1.858649ms,1.85865ms,1.858699ms,1.8587ms,1.858749ms,1.85875ms,1.858799ms,1.8588ms,1.858849ms,1.85885ms,1.858899ms,1.8589ms,1.858949ms,1.85895ms,1.858999ms,1.859ms,1.859049ms,1.85905ms,1.859099ms,1.8591ms,1.859149ms,1.85915ms,1.859199ms,1.8592ms,1.859249ms,1.85925ms,1.859299ms,1.8593ms,1.859349ms,1.85935ms,1.859399ms,1.8594ms,1.859449ms,1.85945ms,1.859499ms,1.8595ms,1.859549ms,1.85955ms,1.859599ms,1.8596ms,1.859649ms,1.85965ms,1.859699ms,1.8597ms,1.859749ms,1.85975ms,1.859799ms,1.8598ms,1.859849ms,1.85985ms,1.859899ms,1.8599ms,1.859949ms,1.85995ms,1.859999ms,1.86ms,1.860049ms,1.86005ms,1.860099ms,1.8601ms,1.860149ms,1.86015ms,1.860199ms,1.8602ms,1.860249ms,1.86025ms,1.860299ms,1.8603ms,1.860349ms,1.86035ms,1.860399ms,1.8604ms,1.860449ms,1.86045ms,1.860499ms,1.8605ms,1.860549ms,1.86055ms,1.860599ms,1.8606ms,1.860649ms,1.86065ms,1.860699ms,1.8607ms,1.860749ms,1.86075ms,1.860799ms,1.8608ms,1.860849ms,1.86085ms,1.860899ms,1.8609ms,1.860949ms,1.86095ms,1.860999ms,1.861ms,1.861049ms,1.86105ms,1.861099ms,1.8611ms,1.861149ms,1.86115ms,1.861199ms,1.8612ms,1.861249ms,1.86125ms,1.861299ms,1.8613ms,1.861349ms,1.86135ms,1.861399ms,1.8614ms,1.861449ms,1.86145ms,1.861499ms,1.8615ms,1.861549ms,1.86155ms,1.861599ms,1.8616ms,1.861649ms,1.86165ms,1.861699ms,1.8617ms,1.861749ms,1.86175ms,1.861799ms,1.8618ms,1.861849ms,1.86185ms,1.861899ms,1.8619ms,1.861949ms,1.86195ms,1.861999ms,1.862ms,1.862049ms,1.86205ms,1.862099ms,1.8621ms,1.862149ms,1.86215ms,1.862199ms,1.8622ms,1.862249ms,1.86225ms,1.862299ms,1.8623ms,1.862349ms,1.86235ms,1.862399ms,1.8624ms,1.862449ms,1.86245ms,1.862499ms,1.8625ms,1.862549ms,1.86255ms,1.862599ms,1.8626ms,1.862649ms,1.86265ms,1.862699ms,1.8627ms,1.862749ms,1.86275ms,1.862799ms,1.8628ms,1.862849ms,1.86285ms,1.862899ms,1.8629ms,1.862949ms,1.86295ms,1.862999ms,1.863ms,1.863049ms,1.86305ms,1.863099ms,1.8631ms,1.863149ms,1.86315ms,1.863199ms,1.8632ms,1.863249ms,1.86325ms,1.863299ms,1.8633ms,1.863349ms,1.86335ms,1.863399ms,1.8634ms,1.863449ms,1.86345ms,1.863499ms,1.8635ms,1.863549ms,1.86355ms,1.863599ms,1.8636ms,1.863649ms,1.86365ms,1.863699ms,1.8637ms,1.863749ms,1.86375ms,1.863799ms,1.8638ms,1.863849ms,1.86385ms,1.863899ms,1.8639ms,1.863949ms,1.86395ms,1.863999ms,1.864ms,1.864049ms,1.86405ms,1.864099ms,1.8641ms,1.864149ms,1.86415ms,1.864199ms,1.8642ms,1.864249ms,1.86425ms,1.864299ms,1.8643ms,1.864349ms,1.86435ms,1.864399ms,1.8644ms,1.864449ms,1.86445ms,1.864499ms,1.8645ms,1.864549ms,1.86455ms,1.864599ms,1.8646ms,1.864649ms,1.86465ms,1.864699ms,1.8647ms,1.864749ms,1.86475ms,1.864799ms,1.8648ms,1.864849ms,1.86485ms,1.864899ms,1.8649ms,1.864949ms,1.86495ms,1.864999ms,1.865ms,1.865049ms,1.86505ms,1.865099ms,1.8651ms,1.865149ms,1.86515ms,1.865199ms,1.8652ms,1.865249ms,1.86525ms,1.865299ms,1.8653ms,1.865349ms,1.86535ms,1.865399ms,1.8654ms,1.865449ms,1.86545ms,1.865499ms,1.8655ms,1.865549ms,1.86555ms,1.865599ms,1.8656ms,1.865649ms,1.86565ms,1.865699ms,1.8657ms,1.865749ms,1.86575ms,1.865799ms,1.8658ms,1.865849ms,1.86585ms,1.865899ms,1.8659ms,1.865949ms,1.86595ms,1.865999ms,1.866ms,1.866049ms,1.86605ms,1.866099ms,1.8661ms,1.866149ms,1.86615ms,1.866199ms,1.8662ms,1.866249ms,1.86625ms,1.866299ms,1.8663ms,1.866349ms,1.86635ms,1.866399ms,1.8664ms,1.866449ms,1.86645ms,1.866499ms,1.8665ms,1.866549ms,1.86655ms,1.866599ms,1.8666ms,1.866649ms,1.86665ms,1.866699ms,1.8667ms,1.866749ms,1.86675ms,1.866799ms,1.8668ms,1.866849ms,1.86685ms,1.866899ms,1.8669ms,1.866949ms,1.86695ms,1.866999ms,1.867ms,1.867049ms,1.86705ms,1.867099ms,1.8671ms,1.867149ms,1.86715ms,1.867199ms,1.8672ms,1.867249ms,1.86725ms,1.867299ms,1.8673ms,1.867349ms,1.86735ms,1.867399ms,1.8674ms,1.867449ms,1.86745ms,1.867499ms,1.8675ms,1.867549ms,1.86755ms,1.867599ms,1.8676ms,1.867649ms,1.86765ms,1.867699ms,1.8677ms,1.867749ms,1.86775ms,1.867799ms,1.8678ms,1.867849ms,1.86785ms,1.867899ms,1.8679ms,1.867949ms,1.86795ms,1.867999ms,1.868ms,1.868049ms,1.86805ms,1.868099ms,1.8681ms,1.868149ms,1.86815ms,1.868199ms,1.8682ms,1.868249ms,1.86825ms,1.868299ms,1.8683ms,1.868349ms,1.86835ms,1.868399ms,1.8684ms,1.868449ms,1.86845ms,1.868499ms,1.8685ms,1.868549ms,1.86855ms,1.868599ms,1.8686ms,1.868649ms,1.86865ms,1.868699ms,1.8687ms,1.868749ms,1.86875ms,1.868799ms,1.8688ms,1.868849ms,1.86885ms,1.868899ms,1.8689ms,1.868949ms,1.86895ms,1.868999ms,1.869ms,1.869049ms,1.86905ms,1.869099ms,1.8691ms,1.869149ms,1.86915ms,1.869199ms,1.8692ms,1.869249ms,1.86925ms,1.869299ms,1.8693ms,1.869349ms,1.86935ms,1.869399ms,1.8694ms,1.869449ms,1.86945ms,1.869499ms,1.8695ms,1.869549ms,1.86955ms,1.869599ms,1.8696ms,1.869649ms,1.86965ms,1.869699ms,1.8697ms,1.869749ms,1.86975ms,1.869799ms,1.8698ms,1.869849ms,1.86985ms,1.869899ms,1.8699ms,1.869949ms,1.86995ms,1.869999ms,1.87ms,1.870049ms,1.87005ms,1.870099ms,1.8701ms,1.870149ms,1.87015ms,1.870199ms,1.8702ms,1.870249ms,1.87025ms,1.870299ms,1.8703ms,1.870349ms,1.87035ms,1.870399ms,1.8704ms,1.870449ms,1.87045ms,1.870499ms,1.8705ms,1.870549ms,1.87055ms,1.870599ms,1.8706ms,1.870649ms,1.87065ms,1.870699ms,1.8707ms,1.870749ms,1.87075ms,1.870799ms,1.8708ms,1.870849ms,1.87085ms,1.870899ms,1.8709ms,1.870949ms,1.87095ms,1.870999ms,1.871ms,1.871049ms,1.87105ms,1.871099ms,1.8711ms,1.871149ms,1.87115ms,1.871199ms,1.8712ms,1.871249ms,1.87125ms,1.871299ms,1.8713ms,1.871349ms,1.87135ms,1.871399ms,1.8714ms,1.871449ms,1.87145ms,1.871499ms,1.8715ms,1.871549ms,1.87155ms,1.871599ms,1.8716ms,1.871649ms,1.87165ms,1.871699ms,1.8717ms,1.871749ms,1.87175ms,1.871799ms,1.8718ms,1.871849ms,1.87185ms,1.871899ms,1.8719ms,1.871949ms,1.87195ms,1.871999ms,1.872ms,1.872049ms,1.87205ms,1.872099ms,1.8721ms,1.872149ms,1.87215ms,1.872199ms,1.8722ms,1.872249ms,1.87225ms,1.872299ms,1.8723ms,1.872349ms,1.87235ms,1.872399ms,1.8724ms,1.872449ms,1.87245ms,1.872499ms,1.8725ms,1.872549ms,1.87255ms,1.872599ms,1.8726ms,1.872649ms,1.87265ms,1.872699ms,1.8727ms,1.872749ms,1.87275ms,1.872799ms,1.8728ms,1.872849ms,1.87285ms,1.872899ms,1.8729ms,1.872949ms,1.87295ms,1.872999ms,1.873ms,1.873049ms,1.87305ms,1.873099ms,1.8731ms,1.873149ms,1.87315ms,1.873199ms,1.8732ms,1.873249ms,1.87325ms,1.873299ms,1.8733ms,1.873349ms,1.87335ms,1.873399ms,1.8734ms,1.873449ms,1.87345ms,1.873499ms,1.8735ms,1.873549ms,1.87355ms,1.873599ms,1.8736ms,1.873649ms,1.87365ms,1.873699ms,1.8737ms,1.873749ms,1.87375ms,1.873799ms,1.8738ms,1.873849ms,1.87385ms,1.873899ms,1.8739ms,1.873949ms,1.87395ms,1.873999ms,1.874ms,1.874049ms,1.87405ms,1.874099ms,1.8741ms,1.874149ms,1.87415ms,1.874199ms,1.8742ms,1.874249ms,1.87425ms,1.874299ms,1.8743ms,1.874349ms,1.87435ms,1.874399ms,1.8744ms,1.874449ms,1.87445ms,1.874499ms,1.8745ms,1.874549ms,1.87455ms,1.874599ms,1.8746ms,1.874649ms,1.87465ms,1.874699ms,1.8747ms,1.874749ms,1.87475ms,1.874799ms,1.8748ms,1.874849ms,1.87485ms,1.874899ms,1.8749ms,1.874949ms,1.87495ms,1.874999ms,1.875ms,1.875049ms,1.87505ms,1.875099ms,1.8751ms,1.875149ms,1.87515ms,1.875199ms,1.8752ms,1.875249ms,1.87525ms,1.875299ms,1.8753ms,1.875349ms,1.87535ms,1.875399ms,1.8754ms,1.875449ms,1.87545ms,1.875499ms,1.8755ms,1.875549ms,1.87555ms,1.875599ms,1.8756ms,1.875649ms,1.87565ms,1.875699ms,1.8757ms,1.875749ms,1.87575ms,1.875799ms,1.8758ms,1.875849ms,1.87585ms,1.875899ms,1.8759ms,1.875949ms,1.87595ms,1.875999ms,1.876ms,1.876049ms,1.87605ms,1.876099ms,1.8761ms,1.876149ms,1.87615ms,1.876199ms,1.8762ms,1.876249ms,1.87625ms,1.876299ms,1.8763ms,1.876349ms,1.87635ms,1.876399ms,1.8764ms,1.876449ms,1.87645ms,1.876499ms,1.8765ms,1.876549ms,1.87655ms,1.876599ms,1.8766ms,1.876649ms,1.87665ms,1.876699ms,1.8767ms,1.876749ms,1.87675ms,1.876799ms,1.8768ms,1.876849ms,1.87685ms,1.876899ms,1.8769ms,1.876949ms,1.87695ms,1.876999ms,1.877ms,1.877049ms,1.87705ms,1.877099ms,1.8771ms,1.877149ms,1.87715ms,1.877199ms,1.8772ms,1.877249ms,1.87725ms,1.877299ms,1.8773ms,1.877349ms,1.87735ms,1.877399ms,1.8774ms,1.877449ms,1.87745ms,1.877499ms,1.8775ms,1.877549ms,1.87755ms,1.877599ms,1.8776ms,1.877649ms,1.87765ms,1.877699ms,1.8777ms,1.877749ms,1.87775ms,1.877799ms,1.8778ms,1.877849ms,1.87785ms,1.877899ms,1.8779ms,1.877949ms,1.87795ms,1.877999ms,1.878ms,1.878049ms,1.87805ms,1.878099ms,1.8781ms,1.878149ms,1.87815ms,1.878199ms,1.8782ms,1.878249ms,1.87825ms,1.878299ms,1.8783ms,1.878349ms,1.87835ms,1.878399ms,1.8784ms,1.878449ms,1.87845ms,1.878499ms,1.8785ms,1.878549ms,1.87855ms,1.878599ms,1.8786ms,1.878649ms,1.87865ms,1.878699ms,1.8787ms,1.878749ms,1.87875ms,1.878799ms,1.8788ms,1.878849ms,1.87885ms,1.878899ms,1.8789ms,1.878949ms,1.87895ms,1.878999ms,1.879ms,1.879049ms,1.87905ms,1.879099ms,1.8791ms,1.879149ms,1.87915ms,1.879199ms,1.8792ms,1.879249ms,1.87925ms,1.879299ms,1.8793ms,1.879349ms,1.87935ms,1.879399ms,1.8794ms,1.879449ms,1.87945ms,1.879499ms,1.8795ms,1.879549ms,1.87955ms,1.879599ms,1.8796ms,1.879649ms,1.87965ms,1.879699ms,1.8797ms,1.879749ms,1.87975ms,1.879799ms,1.8798ms,1.879849ms,1.87985ms,1.879899ms,1.8799ms,1.879949ms,1.87995ms,1.879999ms,1.88ms,1.880049ms,1.88005ms,1.880099ms,1.8801ms,1.880149ms,1.88015ms,1.880199ms,1.8802ms,1.880249ms,1.88025ms,1.880299ms,1.8803ms,1.880349ms,1.88035ms,1.880399ms,1.8804ms,1.880449ms,1.88045ms,1.880499ms,1.8805ms,1.880549ms,1.88055ms,1.880599ms,1.8806ms,1.880649ms,1.88065ms,1.880699ms,1.8807ms,1.880749ms,1.88075ms,1.880799ms,1.8808ms,1.880849ms,1.88085ms,1.880899ms,1.8809ms,1.880949ms,1.88095ms,1.880999ms,1.881ms,1.881049ms,1.88105ms,1.881099ms,1.8811ms,1.881149ms,1.88115ms,1.881199ms,1.8812ms,1.881249ms,1.88125ms,1.881299ms,1.8813ms,1.881349ms,1.88135ms,1.881399ms,1.8814ms,1.881449ms,1.88145ms,1.881499ms,1.8815ms,1.881549ms,1.88155ms,1.881599ms,1.8816ms,1.881649ms,1.88165ms,1.881699ms,1.8817ms,1.881749ms,1.88175ms,1.881799ms,1.8818ms,1.881849ms,1.88185ms,1.881899ms,1.8819ms,1.881949ms,1.88195ms,1.881999ms,1.882ms,1.882049ms,1.88205ms,1.882099ms,1.8821ms,1.882149ms,1.88215ms,1.882199ms,1.8822ms,1.882249ms,1.88225ms,1.882299ms,1.8823ms,1.882349ms,1.88235ms,1.882399ms,1.8824ms,1.882449ms,1.88245ms,1.882499ms,1.8825ms,1.882549ms,1.88255ms,1.882599ms,1.8826ms,1.882649ms,1.88265ms,1.882699ms,1.8827ms,1.882749ms,1.88275ms,1.882799ms,1.8828ms,1.882849ms,1.88285ms,1.882899ms,1.8829ms,1.882949ms,1.88295ms,1.882999ms,1.883ms,1.883049ms,1.88305ms,1.883099ms,1.8831ms,1.883149ms,1.88315ms,1.883199ms,1.8832ms,1.883249ms,1.88325ms,1.883299ms,1.8833ms,1.883349ms,1.88335ms,1.883399ms,1.8834ms,1.883449ms,1.88345ms,1.883499ms,1.8835ms,1.883549ms,1.88355ms,1.883599ms,1.8836ms,1.883649ms,1.88365ms,1.883699ms,1.8837ms,1.883749ms,1.88375ms,1.883799ms,1.8838ms,1.883849ms,1.88385ms,1.883899ms,1.8839ms,1.883949ms,1.88395ms,1.883999ms,1.884ms,1.884049ms,1.88405ms,1.884099ms,1.8841ms,1.884149ms,1.88415ms,1.884199ms,1.8842ms,1.884249ms,1.88425ms,1.884299ms,1.8843ms,1.884349ms,1.88435ms,1.884399ms,1.8844ms,1.884449ms,1.88445ms,1.884499ms,1.8845ms,1.884549ms,1.88455ms,1.884599ms,1.8846ms,1.884649ms,1.88465ms,1.884699ms,1.8847ms,1.884749ms,1.88475ms,1.884799ms,1.8848ms,1.884849ms,1.88485ms,1.884899ms,1.8849ms,1.884949ms,1.88495ms,1.884999ms,1.885ms,1.885049ms,1.88505ms,1.885099ms,1.8851ms,1.885149ms,1.88515ms,1.885199ms,1.8852ms,1.885249ms,1.88525ms,1.885299ms,1.8853ms,1.885349ms,1.88535ms,1.885399ms,1.8854ms,1.885449ms,1.88545ms,1.885499ms,1.8855ms,1.885549ms,1.88555ms,1.885599ms,1.8856ms,1.885649ms,1.88565ms,1.885699ms,1.8857ms,1.885749ms,1.88575ms,1.885799ms,1.8858ms,1.885849ms,1.88585ms,1.885899ms,1.8859ms,1.885949ms,1.88595ms,1.885999ms,1.886ms,1.886049ms,1.88605ms,1.886099ms,1.8861ms,1.886149ms,1.88615ms,1.886199ms,1.8862ms,1.886249ms,1.88625ms,1.886299ms,1.8863ms,1.886349ms,1.88635ms,1.886399ms,1.8864ms,1.886449ms,1.88645ms,1.886499ms,1.8865ms,1.886549ms,1.88655ms,1.886599ms,1.8866ms,1.886649ms,1.88665ms,1.886699ms,1.8867ms,1.886749ms,1.88675ms,1.886799ms,1.8868ms,1.886849ms,1.88685ms,1.886899ms,1.8869ms,1.886949ms,1.88695ms,1.886999ms,1.887ms,1.887049ms,1.88705ms,1.887099ms,1.8871ms,1.887149ms,1.88715ms,1.887199ms,1.8872ms,1.887249ms,1.88725ms,1.887299ms,1.8873ms,1.887349ms,1.88735ms,1.887399ms,1.8874ms,1.887449ms,1.88745ms,1.887499ms,1.8875ms,1.887549ms,1.88755ms,1.887599ms,1.8876ms,1.887649ms,1.88765ms,1.887699ms,1.8877ms,1.887749ms,1.88775ms,1.887799ms,1.8878ms,1.887849ms,1.88785ms,1.887899ms,1.8879ms,1.887949ms,1.88795ms,1.887999ms,1.888ms,1.888049ms,1.88805ms,1.888099ms,1.8881ms,1.888149ms,1.88815ms,1.888199ms,1.8882ms,1.888249ms,1.88825ms,1.888299ms,1.8883ms,1.888349ms,1.88835ms,1.888399ms,1.8884ms,1.888449ms,1.88845ms,1.888499ms,1.8885ms,1.888549ms,1.88855ms,1.888599ms,1.8886ms,1.888649ms,1.88865ms,1.888699ms,1.8887ms,1.888749ms,1.88875ms,1.888799ms,1.8888ms,1.888849ms,1.88885ms,1.888899ms,1.8889ms,1.888949ms,1.88895ms,1.888999ms,1.889ms,1.889049ms,1.88905ms,1.889099ms,1.8891ms,1.889149ms,1.88915ms,1.889199ms,1.8892ms,1.889249ms,1.88925ms,1.889299ms,1.8893ms,1.889349ms,1.88935ms,1.889399ms,1.8894ms,1.889449ms,1.88945ms,1.889499ms,1.8895ms,1.889549ms,1.88955ms,1.889599ms,1.8896ms,1.889649ms,1.88965ms,1.889699ms,1.8897ms,1.889749ms,1.88975ms,1.889799ms,1.8898ms,1.889849ms,1.88985ms,1.889899ms,1.8899ms,1.889949ms,1.88995ms,1.889999ms,1.89ms,1.890049ms,1.89005ms,1.890099ms,1.8901ms,1.890149ms,1.89015ms,1.890199ms,1.8902ms,1.890249ms,1.89025ms,1.890299ms,1.8903ms,1.890349ms,1.89035ms,1.890399ms,1.8904ms,1.890449ms,1.89045ms,1.890499ms,1.8905ms,1.890549ms,1.89055ms,1.890599ms,1.8906ms,1.890649ms,1.89065ms,1.890699ms,1.8907ms,1.890749ms,1.89075ms,1.890799ms,1.8908ms,1.890849ms,1.89085ms,1.890899ms,1.8909ms,1.890949ms,1.89095ms,1.890999ms,1.891ms,1.891049ms,1.89105ms,1.891099ms,1.8911ms,1.891149ms,1.89115ms,1.891199ms,1.8912ms,1.891249ms,1.89125ms,1.891299ms,1.8913ms,1.891349ms,1.89135ms,1.891399ms,1.8914ms,1.891449ms,1.89145ms,1.891499ms,1.8915ms,1.891549ms,1.89155ms,1.891599ms,1.8916ms,1.891649ms,1.89165ms,1.891699ms,1.8917ms,1.891749ms,1.89175ms,1.891799ms,1.8918ms,1.891849ms,1.89185ms,1.891899ms,1.8919ms,1.891949ms,1.89195ms,1.891999ms,1.892ms,1.892049ms,1.89205ms,1.892099ms,1.8921ms,1.892149ms,1.89215ms,1.892199ms,1.8922ms,1.892249ms,1.89225ms,1.892299ms,1.8923ms,1.892349ms,1.89235ms,1.892399ms,1.8924ms,1.892449ms,1.89245ms,1.892499ms,1.8925ms,1.892549ms,1.89255ms,1.892599ms,1.8926ms,1.892649ms,1.89265ms,1.892699ms,1.8927ms,1.892749ms,1.89275ms,1.892799ms,1.8928ms,1.892849ms,1.89285ms,1.892899ms,1.8929ms,1.892949ms,1.89295ms,1.892999ms,1.893ms,1.893049ms,1.89305ms,1.893099ms,1.8931ms,1.893149ms,1.89315ms,1.893199ms,1.8932ms,1.893249ms,1.89325ms,1.893299ms,1.8933ms,1.893349ms,1.89335ms,1.893399ms,1.8934ms,1.893449ms,1.89345ms,1.893499ms,1.8935ms,1.893549ms,1.89355ms,1.893599ms,1.8936ms,1.893649ms,1.89365ms,1.893699ms,1.8937ms,1.893749ms,1.89375ms,1.893799ms,1.8938ms,1.893849ms,1.89385ms,1.893899ms,1.8939ms,1.893949ms,1.89395ms,1.893999ms,1.894ms,1.894049ms,1.89405ms,1.894099ms,1.8941ms,1.894149ms,1.89415ms,1.894199ms,1.8942ms,1.894249ms,1.89425ms,1.894299ms,1.8943ms,1.894349ms,1.89435ms,1.894399ms,1.8944ms,1.894449ms,1.89445ms,1.894499ms,1.8945ms,1.894549ms,1.89455ms,1.894599ms,1.8946ms,1.894649ms,1.89465ms,1.894699ms,1.8947ms,1.894749ms,1.89475ms,1.894799ms,1.8948ms,1.894849ms,1.89485ms,1.894899ms,1.8949ms,1.894949ms,1.89495ms,1.894999ms,1.895ms,1.895049ms,1.89505ms,1.895099ms,1.8951ms,1.895149ms,1.89515ms,1.895199ms,1.8952ms,1.895249ms,1.89525ms,1.895299ms,1.8953ms,1.895349ms,1.89535ms,1.895399ms,1.8954ms,1.895449ms,1.89545ms,1.895499ms,1.8955ms,1.895549ms,1.89555ms,1.895599ms,1.8956ms,1.895649ms,1.89565ms,1.895699ms,1.8957ms,1.895749ms,1.89575ms,1.895799ms,1.8958ms,1.895849ms,1.89585ms,1.895899ms,1.8959ms,1.895949ms,1.89595ms,1.895999ms,1.896ms,1.896049ms,1.89605ms,1.896099ms,1.8961ms,1.896149ms,1.89615ms,1.896199ms,1.8962ms,1.896249ms,1.89625ms,1.896299ms,1.8963ms,1.896349ms,1.89635ms,1.896399ms,1.8964ms,1.896449ms,1.89645ms,1.896499ms,1.8965ms,1.896549ms,1.89655ms,1.896599ms,1.8966ms,1.896649ms,1.89665ms,1.896699ms,1.8967ms,1.896749ms,1.89675ms,1.896799ms,1.8968ms,1.896849ms,1.89685ms,1.896899ms,1.8969ms,1.896949ms,1.89695ms,1.896999ms,1.897ms,1.897049ms,1.89705ms,1.897099ms,1.8971ms,1.897149ms,1.89715ms,1.897199ms,1.8972ms,1.897249ms,1.89725ms,1.897299ms,1.8973ms,1.897349ms,1.89735ms,1.897399ms,1.8974ms,1.897449ms,1.89745ms,1.897499ms,1.8975ms,1.897549ms,1.89755ms,1.897599ms,1.8976ms,1.897649ms,1.89765ms,1.897699ms,1.8977ms,1.897749ms,1.89775ms,1.897799ms,1.8978ms,1.897849ms,1.89785ms,1.897899ms,1.8979ms,1.897949ms,1.89795ms,1.897999ms,1.898ms,1.898049ms,1.89805ms,1.898099ms,1.8981ms,1.898149ms,1.89815ms,1.898199ms,1.8982ms,1.898249ms,1.89825ms,1.898299ms,1.8983ms,1.898349ms,1.89835ms,1.898399ms,1.8984ms,1.898449ms,1.89845ms,1.898499ms,1.8985ms,1.898549ms,1.89855ms,1.898599ms,1.8986ms,1.898649ms,1.89865ms,1.898699ms,1.8987ms,1.898749ms,1.89875ms,1.898799ms,1.8988ms,1.898849ms,1.89885ms,1.898899ms,1.8989ms,1.898949ms,1.89895ms,1.898999ms,1.899ms,1.899049ms,1.89905ms,1.899099ms,1.8991ms,1.899149ms,1.89915ms,1.899199ms,1.8992ms,1.899249ms,1.89925ms,1.899299ms,1.8993ms,1.899349ms,1.89935ms,1.899399ms,1.8994ms,1.899449ms,1.89945ms,1.899499ms,1.8995ms,1.899549ms,1.89955ms,1.899599ms,1.8996ms,1.899649ms,1.89965ms,1.899699ms,1.8997ms,1.899749ms,1.89975ms,1.899799ms,1.8998ms,1.899849ms,1.89985ms,1.899899ms,1.8999ms,1.899949ms,1.89995ms,1.899999ms,1.9ms,1.900049ms,1.90005ms,1.900099ms,1.9001ms,1.900149ms,1.90015ms,1.900199ms,1.9002ms,1.900249ms,1.90025ms,1.900299ms,1.9003ms,1.900349ms,1.90035ms,1.900399ms,1.9004ms,1.900449ms,1.90045ms,1.900499ms,1.9005ms,1.900549ms,1.90055ms,1.900599ms,1.9006ms,1.900649ms,1.90065ms,1.900699ms,1.9007ms,1.900749ms,1.90075ms,1.900799ms,1.9008ms,1.900849ms,1.90085ms,1.900899ms,1.9009ms,1.900949ms,1.90095ms,1.900999ms,1.901ms,1.901049ms,1.90105ms,1.901099ms,1.9011ms,1.901149ms,1.90115ms,1.901199ms,1.9012ms,1.901249ms,1.90125ms,1.901299ms,1.9013ms,1.901349ms,1.90135ms,1.901399ms,1.9014ms,1.901449ms,1.90145ms,1.901499ms,1.9015ms,1.901549ms,1.90155ms,1.901599ms,1.9016ms,1.901649ms,1.90165ms,1.901699ms,1.9017ms,1.901749ms,1.90175ms,1.901799ms,1.9018ms,1.901849ms,1.90185ms,1.901899ms,1.9019ms,1.901949ms,1.90195ms,1.901999ms,1.902ms,1.902049ms,1.90205ms,1.902099ms,1.9021ms,1.902149ms,1.90215ms,1.902199ms,1.9022ms,1.902249ms,1.90225ms,1.902299ms,1.9023ms,1.902349ms,1.90235ms,1.902399ms,1.9024ms,1.902449ms,1.90245ms,1.902499ms,1.9025ms,1.902549ms,1.90255ms,1.902599ms,1.9026ms,1.902649ms,1.90265ms,1.902699ms,1.9027ms,1.902749ms,1.90275ms,1.902799ms,1.9028ms,1.902849ms,1.90285ms,1.902899ms,1.9029ms,1.902949ms,1.90295ms,1.902999ms,1.903ms,1.903049ms,1.90305ms,1.903099ms,1.9031ms,1.903149ms,1.90315ms,1.903199ms,1.9032ms,1.903249ms,1.90325ms,1.903299ms,1.9033ms,1.903349ms,1.90335ms,1.903399ms,1.9034ms,1.903449ms,1.90345ms,1.903499ms,1.9035ms,1.903549ms,1.90355ms,1.903599ms,1.9036ms,1.903649ms,1.90365ms,1.903699ms,1.9037ms,1.903749ms,1.90375ms,1.903799ms,1.9038ms,1.903849ms,1.90385ms,1.903899ms,1.9039ms,1.903949ms,1.90395ms,1.903999ms,1.904ms,1.904049ms,1.90405ms,1.904099ms,1.9041ms,1.904149ms,1.90415ms,1.904199ms,1.9042ms,1.904249ms,1.90425ms,1.904299ms,1.9043ms,1.904349ms,1.90435ms,1.904399ms,1.9044ms,1.904449ms,1.90445ms,1.904499ms,1.9045ms,1.904549ms,1.90455ms,1.904599ms,1.9046ms,1.904649ms,1.90465ms,1.904699ms,1.9047ms,1.904749ms,1.90475ms,1.904799ms,1.9048ms,1.904849ms,1.90485ms,1.904899ms,1.9049ms,1.904949ms,1.90495ms,1.904999ms,1.905ms,1.905049ms,1.90505ms,1.905099ms,1.9051ms,1.905149ms,1.90515ms,1.905199ms,1.9052ms,1.905249ms,1.90525ms,1.905299ms,1.9053ms,1.905349ms,1.90535ms,1.905399ms,1.9054ms,1.905449ms,1.90545ms,1.905499ms,1.9055ms,1.905549ms,1.90555ms,1.905599ms,1.9056ms,1.905649ms,1.90565ms,1.905699ms,1.9057ms,1.905749ms,1.90575ms,1.905799ms,1.9058ms,1.905849ms,1.90585ms,1.905899ms,1.9059ms,1.905949ms,1.90595ms,1.905999ms,1.906ms,1.906049ms,1.90605ms,1.906099ms,1.9061ms,1.906149ms,1.90615ms,1.906199ms,1.9062ms,1.906249ms,1.90625ms,1.906299ms,1.9063ms,1.906349ms,1.90635ms,1.906399ms,1.9064ms,1.906449ms,1.90645ms,1.906499ms,1.9065ms,1.906549ms,1.90655ms,1.906599ms,1.9066ms,1.906649ms,1.90665ms,1.906699ms,1.9067ms,1.906749ms,1.90675ms,1.906799ms,1.9068ms,1.906849ms,1.90685ms,1.906899ms,1.9069ms,1.906949ms,1.90695ms,1.906999ms,1.907ms,1.907049ms,1.90705ms,1.907099ms,1.9071ms,1.907149ms,1.90715ms,1.907199ms,1.9072ms,1.907249ms,1.90725ms,1.907299ms,1.9073ms,1.907349ms,1.90735ms,1.907399ms,1.9074ms,1.907449ms,1.90745ms,1.907499ms,1.9075ms,1.907549ms,1.90755ms,1.907599ms,1.9076ms,1.907649ms,1.90765ms,1.907699ms,1.9077ms,1.907749ms,1.90775ms,1.907799ms,1.9078ms,1.907849ms,1.90785ms,1.907899ms,1.9079ms,1.907949ms,1.90795ms,1.907999ms,1.908ms,1.908049ms,1.90805ms,1.908099ms,1.9081ms,1.908149ms,1.90815ms,1.908199ms,1.9082ms,1.908249ms,1.90825ms,1.908299ms,1.9083ms,1.908349ms,1.90835ms,1.908399ms,1.9084ms,1.908449ms,1.90845ms,1.908499ms,1.9085ms,1.908549ms,1.90855ms,1.908599ms,1.9086ms,1.908649ms,1.90865ms,1.908699ms,1.9087ms,1.908749ms,1.90875ms,1.908799ms,1.9088ms,1.908849ms,1.90885ms,1.908899ms,1.9089ms,1.908949ms,1.90895ms,1.908999ms,1.909ms,1.909049ms,1.90905ms,1.909099ms,1.9091ms,1.909149ms,1.90915ms,1.909199ms,1.9092ms,1.909249ms,1.90925ms,1.909299ms,1.9093ms,1.909349ms,1.90935ms,1.909399ms,1.9094ms,1.909449ms,1.90945ms,1.909499ms,1.9095ms,1.909549ms,1.90955ms,1.909599ms,1.9096ms,1.909649ms,1.90965ms,1.909699ms,1.9097ms,1.909749ms,1.90975ms,1.909799ms,1.9098ms,1.909849ms,1.90985ms,1.909899ms,1.9099ms,1.909949ms,1.90995ms,1.909999ms,1.91ms,1.910049ms,1.91005ms,1.910099ms,1.9101ms,1.910149ms,1.91015ms,1.910199ms,1.9102ms,1.910249ms,1.91025ms,1.910299ms,1.9103ms,1.910349ms,1.91035ms,1.910399ms,1.9104ms,1.910449ms,1.91045ms,1.910499ms,1.9105ms,1.910549ms,1.91055ms,1.910599ms,1.9106ms,1.910649ms,1.91065ms,1.910699ms,1.9107ms,1.910749ms,1.91075ms,1.910799ms,1.9108ms,1.910849ms,1.91085ms,1.910899ms,1.9109ms,1.910949ms,1.91095ms,1.910999ms,1.911ms,1.911049ms,1.91105ms,1.911099ms,1.9111ms,1.911149ms,1.91115ms,1.911199ms,1.9112ms,1.911249ms,1.91125ms,1.911299ms,1.9113ms,1.911349ms,1.91135ms,1.911399ms,1.9114ms,1.911449ms,1.91145ms,1.911499ms,1.9115ms,1.911549ms,1.91155ms,1.911599ms,1.9116ms,1.911649ms,1.91165ms,1.911699ms,1.9117ms,1.911749ms,1.91175ms,1.911799ms,1.9118ms,1.911849ms,1.91185ms,1.911899ms,1.9119ms,1.911949ms,1.91195ms,1.911999ms,1.912ms,1.912049ms,1.91205ms,1.912099ms,1.9121ms,1.912149ms,1.91215ms,1.912199ms,1.9122ms,1.912249ms,1.91225ms,1.912299ms,1.9123ms,1.912349ms,1.91235ms,1.912399ms,1.9124ms,1.912449ms,1.91245ms,1.912499ms,1.9125ms,1.912549ms,1.91255ms,1.912599ms,1.9126ms,1.912649ms,1.91265ms,1.912699ms,1.9127ms,1.912749ms,1.91275ms,1.912799ms,1.9128ms,1.912849ms,1.91285ms,1.912899ms,1.9129ms,1.912949ms,1.91295ms,1.912999ms,1.913ms,1.913049ms,1.91305ms,1.913099ms,1.9131ms,1.913149ms,1.91315ms,1.913199ms,1.9132ms,1.913249ms,1.91325ms,1.913299ms,1.9133ms,1.913349ms,1.91335ms,1.913399ms,1.9134ms,1.913449ms,1.91345ms,1.913499ms,1.9135ms,1.913549ms,1.91355ms,1.913599ms,1.9136ms,1.913649ms,1.91365ms,1.913699ms,1.9137ms,1.913749ms,1.91375ms,1.913799ms,1.9138ms,1.913849ms,1.91385ms,1.913899ms,1.9139ms,1.913949ms,1.91395ms,1.913999ms,1.914ms,1.914049ms,1.91405ms,1.914099ms,1.9141ms,1.914149ms,1.91415ms,1.914199ms,1.9142ms,1.914249ms,1.91425ms,1.914299ms,1.9143ms,1.914349ms,1.91435ms,1.914399ms,1.9144ms,1.914449ms,1.91445ms,1.914499ms,1.9145ms,1.914549ms,1.91455ms,1.914599ms,1.9146ms,1.914649ms,1.91465ms,1.914699ms,1.9147ms,1.914749ms,1.91475ms,1.914799ms,1.9148ms,1.914849ms,1.91485ms,1.914899ms,1.9149ms,1.914949ms,1.91495ms,1.914999ms,1.915ms,1.915049ms,1.91505ms,1.915099ms,1.9151ms,1.915149ms,1.91515ms,1.915199ms,1.9152ms,1.915249ms,1.91525ms,1.915299ms,1.9153ms,1.915349ms,1.91535ms,1.915399ms,1.9154ms,1.915449ms,1.91545ms,1.915499ms,1.9155ms,1.915549ms,1.91555ms,1.915599ms,1.9156ms,1.915649ms,1.91565ms,1.915699ms,1.9157ms,1.915749ms,1.91575ms,1.915799ms,1.9158ms,1.915849ms,1.91585ms,1.915899ms,1.9159ms,1.915949ms,1.91595ms,1.915999ms,1.916ms,1.916049ms,1.91605ms,1.916099ms,1.9161ms,1.916149ms,1.91615ms,1.916199ms,1.9162ms,1.916249ms,1.91625ms,1.916299ms,1.9163ms,1.916349ms,1.91635ms,1.916399ms,1.9164ms,1.916449ms,1.91645ms,1.916499ms,1.9165ms,1.916549ms,1.91655ms,1.916599ms,1.9166ms,1.916649ms,1.91665ms,1.916699ms,1.9167ms,1.916749ms,1.91675ms,1.916799ms,1.9168ms,1.916849ms,1.91685ms,1.916899ms,1.9169ms,1.916949ms,1.91695ms,1.916999ms,1.917ms,1.917049ms,1.91705ms,1.917099ms,1.9171ms,1.917149ms,1.91715ms,1.917199ms,1.9172ms,1.917249ms,1.91725ms,1.917299ms,1.9173ms,1.917349ms,1.91735ms,1.917399ms,1.9174ms,1.917449ms,1.91745ms,1.917499ms,1.9175ms,1.917549ms,1.91755ms,1.917599ms,1.9176ms,1.917649ms,1.91765ms,1.917699ms,1.9177ms,1.917749ms,1.91775ms,1.917799ms,1.9178ms,1.917849ms,1.91785ms,1.917899ms,1.9179ms,1.917949ms,1.91795ms,1.917999ms,1.918ms,1.918049ms,1.91805ms,1.918099ms,1.9181ms,1.918149ms,1.91815ms,1.918199ms,1.9182ms,1.918249ms,1.91825ms,1.918299ms,1.9183ms,1.918349ms,1.91835ms,1.918399ms,1.9184ms,1.918449ms,1.91845ms,1.918499ms,1.9185ms,1.918549ms,1.91855ms,1.918599ms,1.9186ms,1.918649ms,1.91865ms,1.918699ms,1.9187ms,1.918749ms,1.91875ms,1.918799ms,1.9188ms,1.918849ms,1.91885ms,1.918899ms,1.9189ms,1.918949ms,1.91895ms,1.918999ms,1.919ms,1.919049ms,1.91905ms,1.919099ms,1.9191ms,1.919149ms,1.91915ms,1.919199ms,1.9192ms,1.919249ms,1.91925ms,1.919299ms,1.9193ms,1.919349ms,1.91935ms,1.919399ms,1.9194ms,1.919449ms,1.91945ms,1.919499ms,1.9195ms,1.919549ms,1.91955ms,1.919599ms,1.9196ms,1.919649ms,1.91965ms,1.919699ms,1.9197ms,1.919749ms,1.91975ms,1.919799ms,1.9198ms,1.919849ms,1.91985ms,1.919899ms,1.9199ms,1.919949ms,1.91995ms,1.919999ms,1.92ms,1.920049ms,1.92005ms,1.920099ms,1.9201ms,1.920149ms,1.92015ms,1.920199ms,1.9202ms,1.920249ms,1.92025ms,1.920299ms,1.9203ms,1.920349ms,1.92035ms,1.920399ms,1.9204ms,1.920449ms,1.92045ms,1.920499ms,1.9205ms,1.920549ms,1.92055ms,1.920599ms,1.9206ms,1.920649ms,1.92065ms,1.920699ms,1.9207ms,1.920749ms,1.92075ms,1.920799ms,1.9208ms,1.920849ms,1.92085ms,1.920899ms,1.9209ms,1.920949ms,1.92095ms,1.920999ms,1.921ms,1.921049ms,1.92105ms,1.921099ms,1.9211ms,1.921149ms,1.92115ms,1.921199ms,1.9212ms,1.921249ms,1.92125ms,1.921299ms,1.9213ms,1.921349ms,1.92135ms,1.921399ms,1.9214ms,1.921449ms,1.92145ms,1.921499ms,1.9215ms,1.921549ms,1.92155ms,1.921599ms,1.9216ms,1.921649ms,1.92165ms,1.921699ms,1.9217ms,1.921749ms,1.92175ms,1.921799ms,1.9218ms,1.921849ms,1.92185ms,1.921899ms,1.9219ms,1.921949ms,1.92195ms,1.921999ms,1.922ms,1.922049ms,1.92205ms,1.922099ms,1.9221ms,1.922149ms,1.92215ms,1.922199ms,1.9222ms,1.922249ms,1.92225ms,1.922299ms,1.9223ms,1.922349ms,1.92235ms,1.922399ms,1.9224ms,1.922449ms,1.92245ms,1.922499ms,1.9225ms,1.922549ms,1.92255ms,1.922599ms,1.9226ms,1.922649ms,1.92265ms,1.922699ms,1.9227ms,1.922749ms,1.92275ms,1.922799ms,1.9228ms,1.922849ms,1.92285ms,1.922899ms,1.9229ms,1.922949ms,1.92295ms,1.922999ms,1.923ms,1.923049ms,1.92305ms,1.923099ms,1.9231ms,1.923149ms,1.92315ms,1.923199ms,1.9232ms,1.923249ms,1.92325ms,1.923299ms,1.9233ms,1.923349ms,1.92335ms,1.923399ms,1.9234ms,1.923449ms,1.92345ms,1.923499ms,1.9235ms,1.923549ms,1.92355ms,1.923599ms,1.9236ms,1.923649ms,1.92365ms,1.923699ms,1.9237ms,1.923749ms,1.92375ms,1.923799ms,1.9238ms,1.923849ms,1.92385ms,1.923899ms,1.9239ms,1.923949ms,1.92395ms,1.923999ms,1.924ms,1.924049ms,1.92405ms,1.924099ms,1.9241ms,1.924149ms,1.92415ms,1.924199ms,1.9242ms,1.924249ms,1.92425ms,1.924299ms,1.9243ms,1.924349ms,1.92435ms,1.924399ms,1.9244ms,1.924449ms,1.92445ms,1.924499ms,1.9245ms,1.924549ms,1.92455ms,1.924599ms,1.9246ms,1.924649ms,1.92465ms,1.924699ms,1.9247ms,1.924749ms,1.92475ms,1.924799ms,1.9248ms,1.924849ms,1.92485ms,1.924899ms,1.9249ms,1.924949ms,1.92495ms,1.924999ms,1.925ms,1.925049ms,1.92505ms,1.925099ms,1.9251ms,1.925149ms,1.92515ms,1.925199ms,1.9252ms,1.925249ms,1.92525ms,1.925299ms,1.9253ms,1.925349ms,1.92535ms,1.925399ms,1.9254ms,1.925449ms,1.92545ms,1.925499ms,1.9255ms,1.925549ms,1.92555ms,1.925599ms,1.9256ms,1.925649ms,1.92565ms,1.925699ms,1.9257ms,1.925749ms,1.92575ms,1.925799ms,1.9258ms,1.925849ms,1.92585ms,1.925899ms,1.9259ms,1.925949ms,1.92595ms,1.925999ms,1.926ms,1.926049ms,1.92605ms,1.926099ms,1.9261ms,1.926149ms,1.92615ms,1.926199ms,1.9262ms,1.926249ms,1.92625ms,1.926299ms,1.9263ms,1.926349ms,1.92635ms,1.926399ms,1.9264ms,1.926449ms,1.92645ms,1.926499ms,1.9265ms,1.926549ms,1.92655ms,1.926599ms,1.9266ms,1.926649ms,1.92665ms,1.926699ms,1.9267ms,1.926749ms,1.92675ms,1.926799ms,1.9268ms,1.926849ms,1.92685ms,1.926899ms,1.9269ms,1.926949ms,1.92695ms,1.926999ms,1.927ms,1.927049ms,1.92705ms,1.927099ms,1.9271ms,1.927149ms,1.92715ms,1.927199ms,1.9272ms,1.927249ms,1.92725ms,1.927299ms,1.9273ms,1.927349ms,1.92735ms,1.927399ms,1.9274ms,1.927449ms,1.92745ms,1.927499ms,1.9275ms,1.927549ms,1.92755ms,1.927599ms,1.9276ms,1.927649ms,1.92765ms,1.927699ms,1.9277ms,1.927749ms,1.92775ms,1.927799ms,1.9278ms,1.927849ms,1.92785ms,1.927899ms,1.9279ms,1.927949ms,1.92795ms,1.927999ms,1.928ms,1.928049ms,1.92805ms,1.928099ms,1.9281ms,1.928149ms,1.92815ms,1.928199ms,1.9282ms,1.928249ms,1.92825ms,1.928299ms,1.9283ms,1.928349ms,1.92835ms,1.928399ms,1.9284ms,1.928449ms,1.92845ms,1.928499ms,1.9285ms,1.928549ms,1.92855ms,1.928599ms,1.9286ms,1.928649ms,1.92865ms,1.928699ms,1.9287ms,1.928749ms,1.92875ms,1.928799ms,1.9288ms,1.928849ms,1.92885ms,1.928899ms,1.9289ms,1.928949ms,1.92895ms,1.928999ms,1.929ms,1.929049ms,1.92905ms,1.929099ms,1.9291ms,1.929149ms,1.92915ms,1.929199ms,1.9292ms,1.929249ms,1.92925ms,1.929299ms,1.9293ms,1.929349ms,1.92935ms,1.929399ms,1.9294ms,1.929449ms,1.92945ms,1.929499ms,1.9295ms,1.929549ms,1.92955ms,1.929599ms,1.9296ms,1.929649ms,1.92965ms,1.929699ms,1.9297ms,1.929749ms,1.92975ms,1.929799ms,1.9298ms,1.929849ms,1.92985ms,1.929899ms,1.9299ms,1.929949ms,1.92995ms,1.929999ms,1.93ms,1.930049ms,1.93005ms,1.930099ms,1.9301ms,1.930149ms,1.93015ms,1.930199ms,1.9302ms,1.930249ms,1.93025ms,1.930299ms,1.9303ms,1.930349ms,1.93035ms,1.930399ms,1.9304ms,1.930449ms,1.93045ms,1.930499ms,1.9305ms,1.930549ms,1.93055ms,1.930599ms,1.9306ms,1.930649ms,1.93065ms,1.930699ms,1.9307ms,1.930749ms,1.93075ms,1.930799ms,1.9308ms,1.930849ms,1.93085ms,1.930899ms,1.9309ms,1.930949ms,1.93095ms,1.930999ms,1.931ms,1.931049ms,1.93105ms,1.931099ms,1.9311ms,1.931149ms,1.93115ms,1.931199ms,1.9312ms,1.931249ms,1.93125ms,1.931299ms,1.9313ms,1.931349ms,1.93135ms,1.931399ms,1.9314ms,1.931449ms,1.93145ms,1.931499ms,1.9315ms,1.931549ms,1.93155ms,1.931599ms,1.9316ms,1.931649ms,1.93165ms,1.931699ms,1.9317ms,1.931749ms,1.93175ms,1.931799ms,1.9318ms,1.931849ms,1.93185ms,1.931899ms,1.9319ms,1.931949ms,1.93195ms,1.931999ms,1.932ms,1.932049ms,1.93205ms,1.932099ms,1.9321ms,1.932149ms,1.93215ms,1.932199ms,1.9322ms,1.932249ms,1.93225ms,1.932299ms,1.9323ms,1.932349ms,1.93235ms,1.932399ms,1.9324ms,1.932449ms,1.93245ms,1.932499ms,1.9325ms,1.932549ms,1.93255ms,1.932599ms,1.9326ms,1.932649ms,1.93265ms,1.932699ms,1.9327ms,1.932749ms,1.93275ms,1.932799ms,1.9328ms,1.932849ms,1.93285ms,1.932899ms,1.9329ms,1.932949ms,1.93295ms,1.932999ms,1.933ms,1.933049ms,1.93305ms,1.933099ms,1.9331ms,1.933149ms,1.93315ms,1.933199ms,1.9332ms,1.933249ms,1.93325ms,1.933299ms,1.9333ms,1.933349ms,1.93335ms,1.933399ms,1.9334ms,1.933449ms,1.93345ms,1.933499ms,1.9335ms,1.933549ms,1.93355ms,1.933599ms,1.9336ms,1.933649ms,1.93365ms,1.933699ms,1.9337ms,1.933749ms,1.93375ms,1.933799ms,1.9338ms,1.933849ms,1.93385ms,1.933899ms,1.9339ms,1.933949ms,1.93395ms,1.933999ms,1.934ms,1.934049ms,1.93405ms,1.934099ms,1.9341ms,1.934149ms,1.93415ms,1.934199ms,1.9342ms,1.934249ms,1.93425ms,1.934299ms,1.9343ms,1.934349ms,1.93435ms,1.934399ms,1.9344ms,1.934449ms,1.93445ms,1.934499ms,1.9345ms,1.934549ms,1.93455ms,1.934599ms,1.9346ms,1.934649ms,1.93465ms,1.934699ms,1.9347ms,1.934749ms,1.93475ms,1.934799ms,1.9348ms,1.934849ms,1.93485ms,1.934899ms,1.9349ms,1.934949ms,1.93495ms,1.934999ms,1.935ms,1.935049ms,1.93505ms,1.935099ms,1.9351ms,1.935149ms,1.93515ms,1.935199ms,1.9352ms,1.935249ms,1.93525ms,1.935299ms,1.9353ms,1.935349ms,1.93535ms,1.935399ms,1.9354ms,1.935449ms,1.93545ms,1.935499ms,1.9355ms,1.935549ms,1.93555ms,1.935599ms,1.9356ms,1.935649ms,1.93565ms,1.935699ms,1.9357ms,1.935749ms,1.93575ms,1.935799ms,1.9358ms,1.935849ms,1.93585ms,1.935899ms,1.9359ms,1.935949ms,1.93595ms,1.935999ms,1.936ms,1.936049ms,1.93605ms,1.936099ms,1.9361ms,1.936149ms,1.93615ms,1.936199ms,1.9362ms,1.936249ms,1.93625ms,1.936299ms,1.9363ms,1.936349ms,1.93635ms,1.936399ms,1.9364ms,1.936449ms,1.93645ms,1.936499ms,1.9365ms,1.936549ms,1.93655ms,1.936599ms,1.9366ms,1.936649ms,1.93665ms,1.936699ms,1.9367ms,1.936749ms,1.93675ms,1.936799ms,1.9368ms,1.936849ms,1.93685ms,1.936899ms,1.9369ms,1.936949ms,1.93695ms,1.936999ms,1.937ms,1.937049ms,1.93705ms,1.937099ms,1.9371ms,1.937149ms,1.93715ms,1.937199ms,1.9372ms,1.937249ms,1.93725ms,1.937299ms,1.9373ms,1.937349ms,1.93735ms,1.937399ms,1.9374ms,1.937449ms,1.93745ms,1.937499ms,1.9375ms,1.937549ms,1.93755ms,1.937599ms,1.9376ms,1.937649ms,1.93765ms,1.937699ms,1.9377ms,1.937749ms,1.93775ms,1.937799ms,1.9378ms,1.937849ms,1.93785ms,1.937899ms,1.9379ms,1.937949ms,1.93795ms,1.937999ms,1.938ms,1.938049ms,1.93805ms,1.938099ms,1.9381ms,1.938149ms,1.93815ms,1.938199ms,1.9382ms,1.938249ms,1.93825ms,1.938299ms,1.9383ms,1.938349ms,1.93835ms,1.938399ms,1.9384ms,1.938449ms,1.93845ms,1.938499ms,1.9385ms,1.938549ms,1.93855ms,1.938599ms,1.9386ms,1.938649ms,1.93865ms,1.938699ms,1.9387ms,1.938749ms,1.93875ms,1.938799ms,1.9388ms,1.938849ms,1.93885ms,1.938899ms,1.9389ms,1.938949ms,1.93895ms,1.938999ms,1.939ms,1.939049ms,1.93905ms,1.939099ms,1.9391ms,1.939149ms,1.93915ms,1.939199ms,1.9392ms,1.939249ms,1.93925ms,1.939299ms,1.9393ms,1.939349ms,1.93935ms,1.939399ms,1.9394ms,1.939449ms,1.93945ms,1.939499ms,1.9395ms,1.939549ms,1.93955ms,1.939599ms,1.9396ms,1.939649ms,1.93965ms,1.939699ms,1.9397ms,1.939749ms,1.93975ms,1.939799ms,1.9398ms,1.939849ms,1.93985ms,1.939899ms,1.9399ms,1.939949ms,1.93995ms,1.939999ms,1.94ms,1.940049ms,1.94005ms,1.940099ms,1.9401ms,1.940149ms,1.94015ms,1.940199ms,1.9402ms,1.940249ms,1.94025ms,1.940299ms,1.9403ms,1.940349ms,1.94035ms,1.940399ms,1.9404ms,1.940449ms,1.94045ms,1.940499ms,1.9405ms,1.940549ms,1.94055ms,1.940599ms,1.9406ms,1.940649ms,1.94065ms,1.940699ms,1.9407ms,1.940749ms,1.94075ms,1.940799ms,1.9408ms,1.940849ms,1.94085ms,1.940899ms,1.9409ms,1.940949ms,1.94095ms,1.940999ms,1.941ms,1.941049ms,1.94105ms,1.941099ms,1.9411ms,1.941149ms,1.94115ms,1.941199ms,1.9412ms,1.941249ms,1.94125ms,1.941299ms,1.9413ms,1.941349ms,1.94135ms,1.941399ms,1.9414ms,1.941449ms,1.94145ms,1.941499ms,1.9415ms,1.941549ms,1.94155ms,1.941599ms,1.9416ms,1.941649ms,1.94165ms,1.941699ms,1.9417ms,1.941749ms,1.94175ms,1.941799ms,1.9418ms,1.941849ms,1.94185ms,1.941899ms,1.9419ms,1.941949ms,1.94195ms,1.941999ms,1.942ms,1.942049ms,1.94205ms,1.942099ms,1.9421ms,1.942149ms,1.94215ms,1.942199ms,1.9422ms,1.942249ms,1.94225ms,1.942299ms,1.9423ms,1.942349ms,1.94235ms,1.942399ms,1.9424ms,1.942449ms,1.94245ms,1.942499ms,1.9425ms,1.942549ms,1.94255ms,1.942599ms,1.9426ms,1.942649ms,1.94265ms,1.942699ms,1.9427ms,1.942749ms,1.94275ms,1.942799ms,1.9428ms,1.942849ms,1.94285ms,1.942899ms,1.9429ms,1.942949ms,1.94295ms,1.942999ms,1.943ms,1.943049ms,1.94305ms,1.943099ms,1.9431ms,1.943149ms,1.94315ms,1.943199ms,1.9432ms,1.943249ms,1.94325ms,1.943299ms,1.9433ms,1.943349ms,1.94335ms,1.943399ms,1.9434ms,1.943449ms,1.94345ms,1.943499ms,1.9435ms,1.943549ms,1.94355ms,1.943599ms,1.9436ms,1.943649ms,1.94365ms,1.943699ms,1.9437ms,1.943749ms,1.94375ms,1.943799ms,1.9438ms,1.943849ms,1.94385ms,1.943899ms,1.9439ms,1.943949ms,1.94395ms,1.943999ms,1.944ms,1.944049ms,1.94405ms,1.944099ms,1.9441ms,1.944149ms,1.94415ms,1.944199ms,1.9442ms,1.944249ms,1.94425ms,1.944299ms,1.9443ms,1.944349ms,1.94435ms,1.944399ms,1.9444ms,1.944449ms,1.94445ms,1.944499ms,1.9445ms,1.944549ms,1.94455ms,1.944599ms,1.9446ms,1.944649ms,1.94465ms,1.944699ms,1.9447ms,1.944749ms,1.94475ms,1.944799ms,1.9448ms,1.944849ms,1.94485ms,1.944899ms,1.9449ms,1.944949ms,1.94495ms,1.944999ms,1.945ms,1.945049ms,1.94505ms,1.945099ms,1.9451ms,1.945149ms,1.94515ms,1.945199ms,1.9452ms,1.945249ms,1.94525ms,1.945299ms,1.9453ms,1.945349ms,1.94535ms,1.945399ms,1.9454ms,1.945449ms,1.94545ms,1.945499ms,1.9455ms,1.945549ms,1.94555ms,1.945599ms,1.9456ms,1.945649ms,1.94565ms,1.945699ms,1.9457ms,1.945749ms,1.94575ms,1.945799ms,1.9458ms,1.945849ms,1.94585ms,1.945899ms,1.9459ms,1.945949ms,1.94595ms,1.945999ms,1.946ms,1.946049ms,1.94605ms,1.946099ms,1.9461ms,1.946149ms,1.94615ms,1.946199ms,1.9462ms,1.946249ms,1.94625ms,1.946299ms,1.9463ms,1.946349ms,1.94635ms,1.946399ms,1.9464ms,1.946449ms,1.94645ms,1.946499ms,1.9465ms,1.946549ms,1.94655ms,1.946599ms,1.9466ms,1.946649ms,1.94665ms,1.946699ms,1.9467ms,1.946749ms,1.94675ms,1.946799ms,1.9468ms,1.946849ms,1.94685ms,1.946899ms,1.9469ms,1.946949ms,1.94695ms,1.946999ms,1.947ms,1.947049ms,1.94705ms,1.947099ms,1.9471ms,1.947149ms,1.94715ms,1.947199ms,1.9472ms,1.947249ms,1.94725ms,1.947299ms,1.9473ms,1.947349ms,1.94735ms,1.947399ms,1.9474ms,1.947449ms,1.94745ms,1.947499ms,1.9475ms,1.947549ms,1.94755ms,1.947599ms,1.9476ms,1.947649ms,1.94765ms,1.947699ms,1.9477ms,1.947749ms,1.94775ms,1.947799ms,1.9478ms,1.947849ms,1.94785ms,1.947899ms,1.9479ms,1.947949ms,1.94795ms,1.947999ms,1.948ms,1.948049ms,1.94805ms,1.948099ms,1.9481ms,1.948149ms,1.94815ms,1.948199ms,1.9482ms,1.948249ms,1.94825ms,1.948299ms,1.9483ms,1.948349ms,1.94835ms,1.948399ms,1.9484ms,1.948449ms,1.94845ms,1.948499ms,1.9485ms,1.948549ms,1.94855ms,1.948599ms,1.9486ms,1.948649ms,1.94865ms,1.948699ms,1.9487ms,1.948749ms,1.94875ms,1.948799ms,1.9488ms,1.948849ms,1.94885ms,1.948899ms,1.9489ms,1.948949ms,1.94895ms,1.948999ms,1.949ms,1.949049ms,1.94905ms,1.949099ms,1.9491ms,1.949149ms,1.94915ms,1.949199ms,1.9492ms,1.949249ms,1.94925ms,1.949299ms,1.9493ms,1.949349ms,1.94935ms,1.949399ms,1.9494ms,1.949449ms,1.94945ms,1.949499ms,1.9495ms,1.949549ms,1.94955ms,1.949599ms,1.9496ms,1.949649ms,1.94965ms,1.949699ms,1.9497ms,1.949749ms,1.94975ms,1.949799ms,1.9498ms,1.949849ms,1.94985ms,1.949899ms,1.9499ms,1.949949ms,1.94995ms,1.949999ms,1.95ms,1.950049ms,1.95005ms,1.950099ms,1.9501ms,1.950149ms,1.95015ms,1.950199ms,1.9502ms,1.950249ms,1.95025ms,1.950299ms,1.9503ms,1.950349ms,1.95035ms,1.950399ms,1.9504ms,1.950449ms,1.95045ms,1.950499ms,1.9505ms,1.950549ms,1.95055ms,1.950599ms,1.9506ms,1.950649ms,1.95065ms,1.950699ms,1.9507ms,1.950749ms,1.95075ms,1.950799ms,1.9508ms,1.950849ms,1.95085ms,1.950899ms,1.9509ms,1.950949ms,1.95095ms,1.950999ms,1.951ms,1.951049ms,1.95105ms,1.951099ms,1.9511ms,1.951149ms,1.95115ms,1.951199ms,1.9512ms,1.951249ms,1.95125ms,1.951299ms,1.9513ms,1.951349ms,1.95135ms,1.951399ms,1.9514ms,1.951449ms,1.95145ms,1.951499ms,1.9515ms,1.951549ms,1.95155ms,1.951599ms,1.9516ms,1.951649ms,1.95165ms,1.951699ms,1.9517ms,1.951749ms,1.95175ms,1.951799ms,1.9518ms,1.951849ms,1.95185ms,1.951899ms,1.9519ms,1.951949ms,1.95195ms,1.951999ms,1.952ms,1.952049ms,1.95205ms,1.952099ms,1.9521ms,1.952149ms,1.95215ms,1.952199ms,1.9522ms,1.952249ms,1.95225ms,1.952299ms,1.9523ms,1.952349ms,1.95235ms,1.952399ms,1.9524ms,1.952449ms,1.95245ms,1.952499ms,1.9525ms,1.952549ms,1.95255ms,1.952599ms,1.9526ms,1.952649ms,1.95265ms,1.952699ms,1.9527ms,1.952749ms,1.95275ms,1.952799ms,1.9528ms,1.952849ms,1.95285ms,1.952899ms,1.9529ms,1.952949ms,1.95295ms,1.952999ms,1.953ms,1.953049ms,1.95305ms,1.953099ms,1.9531ms,1.953149ms,1.95315ms,1.953199ms,1.9532ms,1.953249ms,1.95325ms,1.953299ms,1.9533ms,1.953349ms,1.95335ms,1.953399ms,1.9534ms,1.953449ms,1.95345ms,1.953499ms,1.9535ms,1.953549ms,1.95355ms,1.953599ms,1.9536ms,1.953649ms,1.95365ms,1.953699ms,1.9537ms,1.953749ms,1.95375ms,1.953799ms,1.9538ms,1.953849ms,1.95385ms,1.953899ms,1.9539ms,1.953949ms,1.95395ms,1.953999ms,1.954ms,1.954049ms,1.95405ms,1.954099ms,1.9541ms,1.954149ms,1.95415ms,1.954199ms,1.9542ms,1.954249ms,1.95425ms,1.954299ms,1.9543ms,1.954349ms,1.95435ms,1.954399ms,1.9544ms,1.954449ms,1.95445ms,1.954499ms,1.9545ms,1.954549ms,1.95455ms,1.954599ms,1.9546ms,1.954649ms,1.95465ms,1.954699ms,1.9547ms,1.954749ms,1.95475ms,1.954799ms,1.9548ms,1.954849ms,1.95485ms,1.954899ms,1.9549ms,1.954949ms,1.95495ms,1.954999ms,1.955ms,1.955049ms,1.95505ms,1.955099ms,1.9551ms,1.955149ms,1.95515ms,1.955199ms,1.9552ms,1.955249ms,1.95525ms,1.955299ms,1.9553ms,1.955349ms,1.95535ms,1.955399ms,1.9554ms,1.955449ms,1.95545ms,1.955499ms,1.9555ms,1.955549ms,1.95555ms,1.955599ms,1.9556ms,1.955649ms,1.95565ms,1.955699ms,1.9557ms,1.955749ms,1.95575ms,1.955799ms,1.9558ms,1.955849ms,1.95585ms,1.955899ms,1.9559ms,1.955949ms,1.95595ms,1.955999ms,1.956ms,1.956049ms,1.95605ms,1.956099ms,1.9561ms,1.956149ms,1.95615ms,1.956199ms,1.9562ms,1.956249ms,1.95625ms,1.956299ms,1.9563ms,1.956349ms,1.95635ms,1.956399ms,1.9564ms,1.956449ms,1.95645ms,1.956499ms,1.9565ms,1.956549ms,1.95655ms,1.956599ms,1.9566ms,1.956649ms,1.95665ms,1.956699ms,1.9567ms,1.956749ms,1.95675ms,1.956799ms,1.9568ms,1.956849ms,1.95685ms,1.956899ms,1.9569ms,1.956949ms,1.95695ms,1.956999ms,1.957ms,1.957049ms,1.95705ms,1.957099ms,1.9571ms,1.957149ms,1.95715ms,1.957199ms,1.9572ms,1.957249ms,1.95725ms,1.957299ms,1.9573ms,1.957349ms,1.95735ms,1.957399ms,1.9574ms,1.957449ms,1.95745ms,1.957499ms,1.9575ms,1.957549ms,1.95755ms,1.957599ms,1.9576ms,1.957649ms,1.95765ms,1.957699ms,1.9577ms,1.957749ms,1.95775ms,1.957799ms,1.9578ms,1.957849ms,1.95785ms,1.957899ms,1.9579ms,1.957949ms,1.95795ms,1.957999ms,1.958ms,1.958049ms,1.95805ms,1.958099ms,1.9581ms,1.958149ms,1.95815ms,1.958199ms,1.9582ms,1.958249ms,1.95825ms,1.958299ms,1.9583ms,1.958349ms,1.95835ms,1.958399ms,1.9584ms,1.958449ms,1.95845ms,1.958499ms,1.9585ms,1.958549ms,1.95855ms,1.958599ms,1.9586ms,1.958649ms,1.95865ms,1.958699ms,1.9587ms,1.958749ms,1.95875ms,1.958799ms,1.9588ms,1.958849ms,1.95885ms,1.958899ms,1.9589ms,1.958949ms,1.95895ms,1.958999ms,1.959ms,1.959049ms,1.95905ms,1.959099ms,1.9591ms,1.959149ms,1.95915ms,1.959199ms,1.9592ms,1.959249ms,1.95925ms,1.959299ms,1.9593ms,1.959349ms,1.95935ms,1.959399ms,1.9594ms,1.959449ms,1.95945ms,1.959499ms,1.9595ms,1.959549ms,1.95955ms,1.959599ms,1.9596ms,1.959649ms,1.95965ms,1.959699ms,1.9597ms,1.959749ms,1.95975ms,1.959799ms,1.9598ms,1.959849ms,1.95985ms,1.959899ms,1.9599ms,1.959949ms,1.95995ms,1.959999ms,1.96ms,1.960049ms,1.96005ms,1.960099ms,1.9601ms,1.960149ms,1.96015ms,1.960199ms,1.9602ms,1.960249ms,1.96025ms,1.960299ms,1.9603ms,1.960349ms,1.96035ms,1.960399ms,1.9604ms,1.960449ms,1.96045ms,1.960499ms,1.9605ms,1.960549ms,1.96055ms,1.960599ms,1.9606ms,1.960649ms,1.96065ms,1.960699ms,1.9607ms,1.960749ms,1.96075ms,1.960799ms,1.9608ms,1.960849ms,1.96085ms,1.960899ms,1.9609ms,1.960949ms,1.96095ms,1.960999ms,1.961ms,1.961049ms,1.96105ms,1.961099ms,1.9611ms,1.961149ms,1.96115ms,1.961199ms,1.9612ms,1.961249ms,1.96125ms,1.961299ms,1.9613ms,1.961349ms,1.96135ms,1.961399ms,1.9614ms,1.961449ms,1.96145ms,1.961499ms,1.9615ms,1.961549ms,1.96155ms,1.961599ms,1.9616ms,1.961649ms,1.96165ms,1.961699ms,1.9617ms,1.961749ms,1.96175ms,1.961799ms,1.9618ms,1.961849ms,1.96185ms,1.961899ms,1.9619ms,1.961949ms,1.96195ms,1.961999ms,1.962ms,1.962049ms,1.96205ms,1.962099ms,1.9621ms,1.962149ms,1.96215ms,1.962199ms,1.9622ms,1.962249ms,1.96225ms,1.962299ms,1.9623ms,1.962349ms,1.96235ms,1.962399ms,1.9624ms,1.962449ms,1.96245ms,1.962499ms,1.9625ms,1.962549ms,1.96255ms,1.962599ms,1.9626ms,1.962649ms,1.96265ms,1.962699ms,1.9627ms,1.962749ms,1.96275ms,1.962799ms,1.9628ms,1.962849ms,1.96285ms,1.962899ms,1.9629ms,1.962949ms,1.96295ms,1.962999ms,1.963ms,1.963049ms,1.96305ms,1.963099ms,1.9631ms,1.963149ms,1.96315ms,1.963199ms,1.9632ms,1.963249ms,1.96325ms,1.963299ms,1.9633ms,1.963349ms,1.96335ms,1.963399ms,1.9634ms,1.963449ms,1.96345ms,1.963499ms,1.9635ms,1.963549ms,1.96355ms,1.963599ms,1.9636ms,1.963649ms,1.96365ms,1.963699ms,1.9637ms,1.963749ms,1.96375ms,1.963799ms,1.9638ms,1.963849ms,1.96385ms,1.963899ms,1.9639ms,1.963949ms,1.96395ms,1.963999ms,1.964ms,1.964049ms,1.96405ms,1.964099ms,1.9641ms,1.964149ms,1.96415ms,1.964199ms,1.9642ms,1.964249ms,1.96425ms,1.964299ms,1.9643ms,1.964349ms,1.96435ms,1.964399ms,1.9644ms,1.964449ms,1.96445ms,1.964499ms,1.9645ms,1.964549ms,1.96455ms,1.964599ms,1.9646ms,1.964649ms,1.96465ms,1.964699ms,1.9647ms,1.964749ms,1.96475ms,1.964799ms,1.9648ms,1.964849ms,1.96485ms,1.964899ms,1.9649ms,1.964949ms,1.96495ms,1.964999ms,1.965ms,1.965049ms,1.96505ms,1.965099ms,1.9651ms,1.965149ms,1.96515ms,1.965199ms,1.9652ms,1.965249ms,1.96525ms,1.965299ms,1.9653ms,1.965349ms,1.96535ms,1.965399ms,1.9654ms,1.965449ms,1.96545ms,1.965499ms,1.9655ms,1.965549ms,1.96555ms,1.965599ms,1.9656ms,1.965649ms,1.96565ms,1.965699ms,1.9657ms,1.965749ms,1.96575ms,1.965799ms,1.9658ms,1.965849ms,1.96585ms,1.965899ms,1.9659ms,1.965949ms,1.96595ms,1.965999ms,1.966ms,1.966049ms,1.96605ms,1.966099ms,1.9661ms,1.966149ms,1.96615ms,1.966199ms,1.9662ms,1.966249ms,1.96625ms,1.966299ms,1.9663ms,1.966349ms,1.96635ms,1.966399ms,1.9664ms,1.966449ms,1.96645ms,1.966499ms,1.9665ms,1.966549ms,1.96655ms,1.966599ms,1.9666ms,1.966649ms,1.96665ms,1.966699ms,1.9667ms,1.966749ms,1.96675ms,1.966799ms,1.9668ms,1.966849ms,1.96685ms,1.966899ms,1.9669ms,1.966949ms,1.96695ms,1.966999ms,1.967ms,1.967049ms,1.96705ms,1.967099ms,1.9671ms,1.967149ms,1.96715ms,1.967199ms,1.9672ms,1.967249ms,1.96725ms,1.967299ms,1.9673ms,1.967349ms,1.96735ms,1.967399ms,1.9674ms,1.967449ms,1.96745ms,1.967499ms,1.9675ms,1.967549ms,1.96755ms,1.967599ms,1.9676ms,1.967649ms,1.96765ms,1.967699ms,1.9677ms,1.967749ms,1.96775ms,1.967799ms,1.9678ms,1.967849ms,1.96785ms,1.967899ms,1.9679ms,1.967949ms,1.96795ms,1.967999ms,1.968ms,1.968049ms,1.96805ms,1.968099ms,1.9681ms,1.968149ms,1.96815ms,1.968199ms,1.9682ms,1.968249ms,1.96825ms,1.968299ms,1.9683ms,1.968349ms,1.96835ms,1.968399ms,1.9684ms,1.968449ms,1.96845ms,1.968499ms,1.9685ms,1.968549ms,1.96855ms,1.968599ms,1.9686ms,1.968649ms,1.96865ms,1.968699ms,1.9687ms,1.968749ms,1.96875ms,1.968799ms,1.9688ms,1.968849ms,1.96885ms,1.968899ms,1.9689ms,1.968949ms,1.96895ms,1.968999ms,1.969ms,1.969049ms,1.96905ms,1.969099ms,1.9691ms,1.969149ms,1.96915ms,1.969199ms,1.9692ms,1.969249ms,1.96925ms,1.969299ms,1.9693ms,1.969349ms,1.96935ms,1.969399ms,1.9694ms,1.969449ms,1.96945ms,1.969499ms,1.9695ms,1.969549ms,1.96955ms,1.969599ms,1.9696ms,1.969649ms,1.96965ms,1.969699ms,1.9697ms,1.969749ms,1.96975ms,1.969799ms,1.9698ms,1.969849ms,1.96985ms,1.969899ms,1.9699ms,1.969949ms,1.96995ms,1.969999ms,1.97ms,1.970049ms,1.97005ms,1.970099ms,1.9701ms,1.970149ms,1.97015ms,1.970199ms,1.9702ms,1.970249ms,1.97025ms,1.970299ms,1.9703ms,1.970349ms,1.97035ms,1.970399ms,1.9704ms,1.970449ms,1.97045ms,1.970499ms,1.9705ms,1.970549ms,1.97055ms,1.970599ms,1.9706ms,1.970649ms,1.97065ms,1.970699ms,1.9707ms,1.970749ms,1.97075ms,1.970799ms,1.9708ms,1.970849ms,1.97085ms,1.970899ms,1.9709ms,1.970949ms,1.97095ms,1.970999ms,1.971ms,1.971049ms,1.97105ms,1.971099ms,1.9711ms,1.971149ms,1.97115ms,1.971199ms,1.9712ms,1.971249ms,1.97125ms,1.971299ms,1.9713ms,1.971349ms,1.97135ms,1.971399ms,1.9714ms,1.971449ms,1.97145ms,1.971499ms,1.9715ms,1.971549ms,1.97155ms,1.971599ms,1.9716ms,1.971649ms,1.97165ms,1.971699ms,1.9717ms,1.971749ms,1.97175ms,1.971799ms,1.9718ms,1.971849ms,1.97185ms,1.971899ms,1.9719ms,1.971949ms,1.97195ms,1.971999ms,1.972ms,1.972049ms,1.97205ms,1.972099ms,1.9721ms,1.972149ms,1.97215ms,1.972199ms,1.9722ms,1.972249ms,1.97225ms,1.972299ms,1.9723ms,1.972349ms,1.97235ms,1.972399ms,1.9724ms,1.972449ms,1.97245ms,1.972499ms,1.9725ms,1.972549ms,1.97255ms,1.972599ms,1.9726ms,1.972649ms,1.97265ms,1.972699ms,1.9727ms,1.972749ms,1.97275ms,1.972799ms,1.9728ms,1.972849ms,1.97285ms,1.972899ms,1.9729ms,1.972949ms,1.97295ms,1.972999ms,1.973ms,1.973049ms,1.97305ms,1.973099ms,1.9731ms,1.973149ms,1.97315ms,1.973199ms,1.9732ms,1.973249ms,1.97325ms,1.973299ms,1.9733ms,1.973349ms,1.97335ms,1.973399ms,1.9734ms,1.973449ms,1.97345ms,1.973499ms,1.9735ms,1.973549ms,1.97355ms,1.973599ms,1.9736ms,1.973649ms,1.97365ms,1.973699ms,1.9737ms,1.973749ms,1.97375ms,1.973799ms,1.9738ms,1.973849ms,1.97385ms,1.973899ms,1.9739ms,1.973949ms,1.97395ms,1.973999ms,1.974ms,1.974049ms,1.97405ms,1.974099ms,1.9741ms,1.974149ms,1.97415ms,1.974199ms,1.9742ms,1.974249ms,1.97425ms,1.974299ms,1.9743ms,1.974349ms,1.97435ms,1.974399ms,1.9744ms,1.974449ms,1.97445ms,1.974499ms,1.9745ms,1.974549ms,1.97455ms,1.974599ms,1.9746ms,1.974649ms,1.97465ms,1.974699ms,1.9747ms,1.974749ms,1.97475ms,1.974799ms,1.9748ms,1.974849ms,1.97485ms,1.974899ms,1.9749ms,1.974949ms,1.97495ms,1.974999ms,1.975ms,1.975049ms,1.97505ms,1.975099ms,1.9751ms,1.975149ms,1.97515ms,1.975199ms,1.9752ms,1.975249ms,1.97525ms,1.975299ms,1.9753ms,1.975349ms,1.97535ms,1.975399ms,1.9754ms,1.975449ms,1.97545ms,1.975499ms,1.9755ms,1.975549ms,1.97555ms,1.975599ms,1.9756ms,1.975649ms,1.97565ms,1.975699ms,1.9757ms,1.975749ms,1.97575ms,1.975799ms,1.9758ms,1.975849ms,1.97585ms,1.975899ms,1.9759ms,1.975949ms,1.97595ms,1.975999ms,1.976ms,1.976049ms,1.97605ms,1.976099ms,1.9761ms,1.976149ms,1.97615ms,1.976199ms,1.9762ms,1.976249ms,1.97625ms,1.976299ms,1.9763ms,1.976349ms,1.97635ms,1.976399ms,1.9764ms,1.976449ms,1.97645ms,1.976499ms,1.9765ms,1.976549ms,1.97655ms,1.976599ms,1.9766ms,1.976649ms,1.97665ms,1.976699ms,1.9767ms,1.976749ms,1.97675ms,1.976799ms,1.9768ms,1.976849ms,1.97685ms,1.976899ms,1.9769ms,1.976949ms,1.97695ms,1.976999ms,1.977ms,1.977049ms,1.97705ms,1.977099ms,1.9771ms,1.977149ms,1.97715ms,1.977199ms,1.9772ms,1.977249ms,1.97725ms,1.977299ms,1.9773ms,1.977349ms,1.97735ms,1.977399ms,1.9774ms,1.977449ms,1.97745ms,1.977499ms,1.9775ms,1.977549ms,1.97755ms,1.977599ms,1.9776ms,1.977649ms,1.97765ms,1.977699ms,1.9777ms,1.977749ms,1.97775ms,1.977799ms,1.9778ms,1.977849ms,1.97785ms,1.977899ms,1.9779ms,1.977949ms,1.97795ms,1.977999ms,1.978ms,1.978049ms,1.97805ms,1.978099ms,1.9781ms,1.978149ms,1.97815ms,1.978199ms,1.9782ms,1.978249ms,1.97825ms,1.978299ms,1.9783ms,1.978349ms,1.97835ms,1.978399ms,1.9784ms,1.978449ms,1.97845ms,1.978499ms,1.9785ms,1.978549ms,1.97855ms,1.978599ms,1.9786ms,1.978649ms,1.97865ms,1.978699ms,1.9787ms,1.978749ms,1.97875ms,1.978799ms,1.9788ms,1.978849ms,1.97885ms,1.978899ms,1.9789ms,1.978949ms,1.97895ms,1.978999ms,1.979ms,1.979049ms,1.97905ms,1.979099ms,1.9791ms,1.979149ms,1.97915ms,1.979199ms,1.9792ms,1.979249ms,1.97925ms,1.979299ms,1.9793ms,1.979349ms,1.97935ms,1.979399ms,1.9794ms,1.979449ms,1.97945ms,1.979499ms,1.9795ms,1.979549ms,1.97955ms,1.979599ms,1.9796ms,1.979649ms,1.97965ms,1.979699ms,1.9797ms,1.979749ms,1.97975ms,1.979799ms,1.9798ms,1.979849ms,1.97985ms,1.979899ms,1.9799ms,1.979949ms,1.97995ms,1.979999ms,1.98ms,1.980049ms,1.98005ms,1.980099ms,1.9801ms,1.980149ms,1.98015ms,1.980199ms,1.9802ms,1.980249ms,1.98025ms,1.980299ms,1.9803ms,1.980349ms,1.98035ms,1.980399ms,1.9804ms,1.980449ms,1.98045ms,1.980499ms,1.9805ms,1.980549ms,1.98055ms,1.980599ms,1.9806ms,1.980649ms,1.98065ms,1.980699ms,1.9807ms,1.980749ms,1.98075ms,1.980799ms,1.9808ms,1.980849ms,1.98085ms,1.980899ms,1.9809ms,1.980949ms,1.98095ms,1.980999ms,1.981ms,1.981049ms,1.98105ms,1.981099ms,1.9811ms,1.981149ms,1.98115ms,1.981199ms,1.9812ms,1.981249ms,1.98125ms,1.981299ms,1.9813ms,1.981349ms,1.98135ms,1.981399ms,1.9814ms,1.981449ms,1.98145ms,1.981499ms,1.9815ms,1.981549ms,1.98155ms,1.981599ms,1.9816ms,1.981649ms,1.98165ms,1.981699ms,1.9817ms,1.981749ms,1.98175ms,1.981799ms,1.9818ms,1.981849ms,1.98185ms,1.981899ms,1.9819ms,1.981949ms,1.98195ms,1.981999ms,1.982ms,1.982049ms,1.98205ms,1.982099ms,1.9821ms,1.982149ms,1.98215ms,1.982199ms,1.9822ms,1.982249ms,1.98225ms,1.982299ms,1.9823ms,1.982349ms,1.98235ms,1.982399ms,1.9824ms,1.982449ms,1.98245ms,1.982499ms,1.9825ms,1.982549ms,1.98255ms,1.982599ms,1.9826ms,1.982649ms,1.98265ms,1.982699ms,1.9827ms,1.982749ms,1.98275ms,1.982799ms,1.9828ms,1.982849ms,1.98285ms,1.982899ms,1.9829ms,1.982949ms,1.98295ms,1.982999ms,1.983ms,1.983049ms,1.98305ms,1.983099ms,1.9831ms,1.983149ms,1.98315ms,1.983199ms,1.9832ms,1.983249ms,1.98325ms,1.983299ms,1.9833ms,1.983349ms,1.98335ms,1.983399ms,1.9834ms,1.983449ms,1.98345ms,1.983499ms,1.9835ms,1.983549ms,1.98355ms,1.983599ms,1.9836ms,1.983649ms,1.98365ms,1.983699ms,1.9837ms,1.983749ms,1.98375ms,1.983799ms,1.9838ms,1.983849ms,1.98385ms,1.983899ms,1.9839ms,1.983949ms,1.98395ms,1.983999ms,1.984ms,1.984049ms,1.98405ms,1.984099ms,1.9841ms,1.984149ms,1.98415ms,1.984199ms,1.9842ms,1.984249ms,1.98425ms,1.984299ms,1.9843ms,1.984349ms,1.98435ms,1.984399ms,1.9844ms,1.984449ms,1.98445ms,1.984499ms,1.9845ms,1.984549ms,1.98455ms,1.984599ms,1.9846ms,1.984649ms,1.98465ms,1.984699ms,1.9847ms,1.984749ms,1.98475ms,1.984799ms,1.9848ms,1.984849ms,1.98485ms,1.984899ms,1.9849ms,1.984949ms,1.98495ms,1.984999ms,1.985ms,1.985049ms,1.98505ms,1.985099ms,1.9851ms,1.985149ms,1.98515ms,1.985199ms,1.9852ms,1.985249ms,1.98525ms,1.985299ms,1.9853ms,1.985349ms,1.98535ms,1.985399ms,1.9854ms,1.985449ms,1.98545ms,1.985499ms,1.9855ms,1.985549ms,1.98555ms,1.985599ms,1.9856ms,1.985649ms,1.98565ms,1.985699ms,1.9857ms,1.985749ms,1.98575ms,1.985799ms,1.9858ms,1.985849ms,1.98585ms,1.985899ms,1.9859ms,1.985949ms,1.98595ms,1.985999ms,1.986ms,1.986049ms,1.98605ms,1.986099ms,1.9861ms,1.986149ms,1.98615ms,1.986199ms,1.9862ms,1.986249ms,1.98625ms,1.986299ms,1.9863ms,1.986349ms,1.98635ms,1.986399ms,1.9864ms,1.986449ms,1.98645ms,1.986499ms,1.9865ms,1.986549ms,1.98655ms,1.986599ms,1.9866ms,1.986649ms,1.98665ms,1.986699ms,1.9867ms,1.986749ms,1.98675ms,1.986799ms,1.9868ms,1.986849ms,1.98685ms,1.986899ms,1.9869ms,1.986949ms,1.98695ms,1.986999ms,1.987ms,1.987049ms,1.98705ms,1.987099ms,1.9871ms,1.987149ms,1.98715ms,1.987199ms,1.9872ms,1.987249ms,1.98725ms,1.987299ms,1.9873ms,1.987349ms,1.98735ms,1.987399ms,1.9874ms,1.987449ms,1.98745ms,1.987499ms,1.9875ms,1.987549ms,1.98755ms,1.987599ms,1.9876ms,1.987649ms,1.98765ms,1.987699ms,1.9877ms,1.987749ms,1.98775ms,1.987799ms,1.9878ms,1.987849ms,1.98785ms,1.987899ms,1.9879ms,1.987949ms,1.98795ms,1.987999ms,1.988ms,1.988049ms,1.98805ms,1.988099ms,1.9881ms,1.988149ms,1.98815ms,1.988199ms,1.9882ms,1.988249ms,1.98825ms,1.988299ms,1.9883ms,1.988349ms,1.98835ms,1.988399ms,1.9884ms,1.988449ms,1.98845ms,1.988499ms,1.9885ms,1.988549ms,1.98855ms,1.988599ms,1.9886ms,1.988649ms,1.98865ms,1.988699ms,1.9887ms,1.988749ms,1.98875ms,1.988799ms,1.9888ms,1.988849ms,1.98885ms,1.988899ms,1.9889ms,1.988949ms,1.98895ms,1.988999ms,1.989ms,1.989049ms,1.98905ms,1.989099ms,1.9891ms,1.989149ms,1.98915ms,1.989199ms,1.9892ms,1.989249ms,1.98925ms,1.989299ms,1.9893ms,1.989349ms,1.98935ms,1.989399ms,1.9894ms,1.989449ms,1.98945ms,1.989499ms,1.9895ms,1.989549ms,1.98955ms,1.989599ms,1.9896ms,1.989649ms,1.98965ms,1.989699ms,1.9897ms,1.989749ms,1.98975ms,1.989799ms,1.9898ms,1.989849ms,1.98985ms,1.989899ms,1.9899ms,1.989949ms,1.98995ms,1.989999ms,1.99ms,1.990049ms,1.99005ms,1.990099ms,1.9901ms,1.990149ms,1.99015ms,1.990199ms,1.9902ms,1.990249ms,1.99025ms,1.990299ms,1.9903ms,1.990349ms,1.99035ms,1.990399ms,1.9904ms,1.990449ms,1.99045ms,1.990499ms,1.9905ms,1.990549ms,1.99055ms,1.990599ms,1.9906ms,1.990649ms,1.99065ms,1.990699ms,1.9907ms,1.990749ms,1.99075ms,1.990799ms,1.9908ms,1.990849ms,1.99085ms,1.990899ms,1.9909ms,1.990949ms,1.99095ms,1.990999ms,1.991ms,1.991049ms,1.99105ms,1.991099ms,1.9911ms,1.991149ms,1.99115ms,1.991199ms,1.9912ms,1.991249ms,1.99125ms,1.991299ms,1.9913ms,1.991349ms,1.99135ms,1.991399ms,1.9914ms,1.991449ms,1.99145ms,1.991499ms,1.9915ms,1.991549ms,1.99155ms,1.991599ms,1.9916ms,1.991649ms,1.99165ms,1.991699ms,1.9917ms,1.991749ms,1.99175ms,1.991799ms,1.9918ms,1.991849ms,1.99185ms,1.991899ms,1.9919ms,1.991949ms,1.99195ms,1.991999ms,1.992ms,1.992049ms,1.99205ms,1.992099ms,1.9921ms,1.992149ms,1.99215ms,1.992199ms,1.9922ms,1.992249ms,1.99225ms,1.992299ms,1.9923ms,1.992349ms,1.99235ms,1.992399ms,1.9924ms,1.992449ms,1.99245ms,1.992499ms,1.9925ms,1.992549ms,1.99255ms,1.992599ms,1.9926ms,1.992649ms,1.99265ms,1.992699ms,1.9927ms,1.992749ms,1.99275ms,1.992799ms,1.9928ms,1.992849ms,1.99285ms,1.992899ms,1.9929ms,1.992949ms,1.99295ms,1.992999ms,1.993ms,1.993049ms,1.99305ms,1.993099ms,1.9931ms,1.993149ms,1.99315ms,1.993199ms,1.9932ms,1.993249ms,1.99325ms,1.993299ms,1.9933ms,1.993349ms,1.99335ms,1.993399ms,1.9934ms,1.993449ms,1.99345ms,1.993499ms,1.9935ms,1.993549ms,1.99355ms,1.993599ms,1.9936ms,1.993649ms,1.99365ms,1.993699ms,1.9937ms,1.993749ms,1.99375ms,1.993799ms,1.9938ms,1.993849ms,1.99385ms,1.993899ms,1.9939ms,1.993949ms,1.99395ms,1.993999ms,1.994ms,1.994049ms,1.99405ms,1.994099ms,1.9941ms,1.994149ms,1.99415ms,1.994199ms,1.9942ms,1.994249ms,1.99425ms,1.994299ms,1.9943ms,1.994349ms,1.99435ms,1.994399ms,1.9944ms,1.994449ms,1.99445ms,1.994499ms,1.9945ms,1.994549ms,1.99455ms,1.994599ms,1.9946ms,1.994649ms,1.99465ms,1.994699ms,1.9947ms,1.994749ms,1.99475ms,1.994799ms,1.9948ms,1.994849ms,1.99485ms,1.994899ms,1.9949ms,1.994949ms,1.99495ms,1.994999ms,1.995ms,1.995049ms,1.99505ms,1.995099ms,1.9951ms,1.995149ms,1.99515ms,1.995199ms,1.9952ms,1.995249ms,1.99525ms,1.995299ms,1.9953ms,1.995349ms,1.99535ms,1.995399ms,1.9954ms,1.995449ms,1.99545ms,1.995499ms,1.9955ms,1.995549ms,1.99555ms,1.995599ms,1.9956ms,1.995649ms,1.99565ms,1.995699ms,1.9957ms,1.995749ms,1.99575ms,1.995799ms,1.9958ms,1.995849ms,1.99585ms,1.995899ms,1.9959ms,1.995949ms,1.99595ms,1.995999ms,1.996ms,1.996049ms,1.99605ms,1.996099ms,1.9961ms,1.996149ms,1.99615ms,1.996199ms,1.9962ms,1.996249ms,1.99625ms,1.996299ms,1.9963ms,1.996349ms,1.99635ms,1.996399ms,1.9964ms,1.996449ms,1.99645ms,1.996499ms,1.9965ms,1.996549ms,1.99655ms,1.996599ms,1.9966ms,1.996649ms,1.99665ms,1.996699ms,1.9967ms,1.996749ms,1.99675ms,1.996799ms,1.9968ms,1.996849ms,1.99685ms,1.996899ms,1.9969ms,1.996949ms,1.99695ms,1.996999ms,1.997ms,1.997049ms,1.99705ms,1.997099ms,1.9971ms,1.997149ms,1.99715ms,1.997199ms,1.9972ms,1.997249ms,1.99725ms,1.997299ms,1.9973ms,1.997349ms,1.99735ms,1.997399ms,1.9974ms,1.997449ms,1.99745ms,1.997499ms,1.9975ms,1.997549ms,1.99755ms,1.997599ms,1.9976ms,1.997649ms,1.99765ms,1.997699ms,1.9977ms,1.997749ms,1.99775ms,1.997799ms,1.9978ms,1.997849ms,1.99785ms,1.997899ms,1.9979ms,1.997949ms,1.99795ms,1.997999ms,1.998ms,1.998049ms,1.99805ms,1.998099ms,1.9981ms,1.998149ms,1.99815ms,1.998199ms,1.9982ms,1.998249ms,1.99825ms,1.998299ms,1.9983ms,1.998349ms,1.99835ms,1.998399ms,1.9984ms,1.998449ms,1.99845ms,1.998499ms,1.9985ms,1.998549ms,1.99855ms,1.998599ms,1.9986ms,1.998649ms,1.99865ms,1.998699ms,1.9987ms,1.998749ms,1.99875ms,1.998799ms,1.9988ms,1.998849ms,1.99885ms,1.998899ms,1.9989ms,1.998949ms,1.99895ms,1.998999ms,1.999ms,1.999049ms,1.99905ms,1.999099ms,1.9991ms,1.999149ms,1.99915ms,1.999199ms,1.9992ms,1.999249ms,1.99925ms,1.999299ms,1.9993ms,1.999349ms,1.99935ms,1.999399ms,1.9994ms,1.999449ms,1.99945ms,1.999499ms,1.9995ms,1.999549ms,1.99955ms,1.999599ms,1.9996ms,1.999649ms,1.99965ms,1.999699ms,1.9997ms,1.999749ms,1.99975ms,1.999799ms,1.9998ms,1.999849ms,1.99985ms,1.999899ms,1.9999ms,1.999949ms,1.99995ms,1.999999ms
.tran 25ns 2ms
.print tran format=csv file=scratchpad3.csv v(A*) v(B*) v(C*) v(d*)

.lib share/pdk/sky130A/libs.tech/combined/sky130.lib.spice tt
**** end user architecture code
**.ends
.end
