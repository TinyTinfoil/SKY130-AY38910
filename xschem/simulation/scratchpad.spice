** sch_path: /home/veswaranandam/SKY130-AY38910/xschem/scratchpad.sch
**.subckt scratchpad
X2 CLK cen VRST bdir bc1 bc2 din7 din6 din5 din4 din3 din2 din1 din0 test_core
C27 din7 0 1f
C26 din6 0 1f
C25 din5 0 1f
C24 din4 0 1f
C23 din3 0 1f
C22 din2 0 1f
C21 din1 0 1f
C20 din0 0 1f
C1 bc1 0 1f
C2 bc2 0 1f
C3 bdir 0 1f
C4 cen 0 1f
**** begin user architecture code

.param VDD=1.8
*.include ext/jt49_bus.spice
.include ext/test_core.spice
.tran 10ns 3ms
.print tran format=raw file=scratchpad.raw v(din*) v(CLK) v(cen)

**** end user architecture code
**.ends
.end
