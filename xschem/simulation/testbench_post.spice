** sch_path: /home/veswaranandam/SKY130-AY38910/xschem/testbench_post.sch
**.subckt testbench_post
X1 VP VN VN VN VN VN VN VN VN VN VN VN VN VN VN VN VN VN VN VN VN VN VN VN VN VN VN VN VN VN VN VN VN VN VN VN VN VN VN VN VN VN
+ VN VN VN VN VN VN VN VN VN VP net3 net2 net1 CLK net4 din_out0 din_out1 din_out2 din_out3 din_out4 din_out5 din_out6 din_out7 VN VN
+ VN VN VN VN VN VN VN net5 VN VP jt49_bus
a2 [ CLK net5 ] [ net4 net1 net3 net2 din_out7 din_out6 din_out5 din_out4 din_out3 din_out2 din_out1 din_out0 ] test_core
VCLOCK CLK GND pulse 0 'VDD' 49995p 10p 10p 49990p 100n
Vdd VP VN 1.8
Vss VN GND 0
VCLOCK1 net5 GND pulse 0 'VDD' 49995p 10p 10p 49990p 100n
**** begin user architecture code

.param VDD=1.8
.include ~/SKY130-AY38910/xschem/jt49_bus.spice
.control

**** change default parameters of auto adc/dac bridges
*pre_set auto_bridge_d_in =
*+ ( ".model auto_adc adc_bridge(
*+   in_low = '0.9 * 1.8 / 2' in_high = '1.1 * 1.8 / 2'
*+   rise_delay=1e-11 fall_delay=1e-11 )"
*+ "auto_bridge%d [ %s ] [ %s ] auto_adc" )

*pre_set auto_bridge_d_out =
*+ ( ".model auto_dac dac_bridge(
*+   out_low = 0 out_high = 1.8
*+   t_rise=1e-11 t_fall=1e-11 )"
*+ "auto_bridge%d [ %s ] [ %s ] auto_dac" )

*  save all
  tran 1p 2u
*  remzerovec
*  write tb_counter_wrapper.raw
.endc

**** end user architecture code
**.ends
.GLOBAL GND
**** begin user architecture code
.model test_core d_cosim simulation="ivlng" sim_args=["test_core"] delay=1e-12
**** end user architecture code
.end
