** sch_path: /home/veswaranandam/SKY130-AY38910/xschem/xyce_test.sch
**.subckt xyce_test
XM1 net1 G 0 0 sky130_fd_pr__nfet_01v8_lvt L=0.15 W=1 nf=1 ad=0.29 as=0.29 pd=2.58 ps=2.58 nrd=0.29 nrs=0.29 sa=0 sb=0 sd=0 mult=1
VD D 0 1.8
Vmeas D net1 0
VG G 0 pulse 0 1.8 49995p 10p 10p 49990p 100n
**** begin user architecture code
.lib share/pdk/sky130A/libs.tech/combined/sky130.lib.spice tt

.tran 10ps 3ms
.print tran format=raw file=xyce_test_dc.raw v(*) i(*)

**** end user architecture code
**.ends
.end
