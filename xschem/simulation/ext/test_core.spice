* SPICE subcircuit generated from VCD file: test.vcd
* Timescale: 1e-12 seconds
* VDD: 1.8V
* Signals: 14
*

.subckt test_core clk cen rst_n bdir bc1 bc2 din[7] din[6] din[5] din[4] din[3] din[2] din[1] din[0]

* Pin: clk <- VCD: test.tb.clk
Vclk clk 0 pwl(
+    0n 0
+    49n 0
+    50n 1.8
+    99n 1.8
+    100n 0
+    149n 0
+    150n 1.8
+    199n 1.8
+    200n 0
+    249n 0
+    250n 1.8
+    299n 1.8
+    300n 0
+    349n 0
+    350n 1.8
+    399n 1.8
+    400n 0
+    449n 0
+    450n 1.8
+    499n 1.8
+    500n 0
+    549n 0
+    550n 1.8
+    599n 1.8
+    600n 0
+    649n 0
+    650n 1.8
+    699n 1.8
+    700n 0
+    749n 0
+    750n 1.8
+    799n 1.8
+    800n 0
+    849n 0
+    850n 1.8
+    899n 1.8
+    900n 0
+    949n 0
+    950n 1.8
+    999n 1.8
+    1000n 0
+    1049n 0
+    1050n 1.8
+    1099n 1.8
+    1100n 0
+    1149n 0
+    1150n 1.8
+    1199n 1.8
+    1200n 0
+    1249n 0
+    1250n 1.8
+    1299n 1.8
+    1300n 0
+    1349n 0
+    1350n 1.8
+    1399n 1.8
+    1400n 0
+    1449n 0
+    1450n 1.8
+    1499n 1.8
+    1500n 0
+    1549n 0
+    1550n 1.8
+    1599n 1.8
+    1600n 0
+    1649n 0
+    1650n 1.8
+    1699n 1.8
+    1700n 0
+    1749n 0
+    1750n 1.8
+    1799n 1.8
+    1800n 0
+    1849n 0
+    1850n 1.8
+    1899n 1.8
+    1900n 0
+    1949n 0
+    1950n 1.8
+    1999n 1.8
+    2000n 0
+    2049n 0
+    2050n 1.8
+    2099n 1.8
+    2100n 0
+    2149n 0
+    2150n 1.8
+    2199n 1.8
+    2200n 0
+    2249n 0
+    2250n 1.8
+    2299n 1.8
+    2300n 0
+    2349n 0
+    2350n 1.8
+    2399n 1.8
+    2400n 0
+    2449n 0
+    2450n 1.8
+    2499n 1.8
+    2500n 0
+    2549n 0
+    2550n 1.8
+    2599n 1.8
+    2600n 0
+    2649n 0
+    2650n 1.8
+    2699n 1.8
+    2700n 0
+    2749n 0
+    2750n 1.8
+    2799n 1.8
+    2800n 0
+    2849n 0
+    2850n 1.8
+    2899n 1.8
+    2900n 0
+    2949n 0
+    2950n 1.8
+    2999n 1.8
+    3000n 0
+    3049n 0
+    3050n 1.8
+    3099n 1.8
+    3100n 0
+    3149n 0
+    3150n 1.8
+    3199n 1.8
+    3200n 0
+    3249n 0
+    3250n 1.8
+    3299n 1.8
+    3300n 0
+    3349n 0
+    3350n 1.8
+    3399n 1.8
+    3400n 0
+    3449n 0
+    3450n 1.8
+    3499n 1.8
+    3500n 0
+    3549n 0
+    3550n 1.8
+    3599n 1.8
+    3600n 0
+    3649n 0
+    3650n 1.8
+    3699n 1.8
+    3700n 0
+    3749n 0
+    3750n 1.8
+    3799n 1.8
+    3800n 0
+    3849n 0
+    3850n 1.8
+    3899n 1.8
+    3900n 0
+    3949n 0
+    3950n 1.8
+    3999n 1.8
+    4000n 0
+    4049n 0
+    4050n 1.8
+    4099n 1.8
+    4100n 0
+    4149n 0
+    4150n 1.8
+    4199n 1.8
+    4200n 0
+    4249n 0
+    4250n 1.8
+    4299n 1.8
+    4300n 0
+    4349n 0
+    4350n 1.8
+    4399n 1.8
+    4400n 0
+    4449n 0
+    4450n 1.8
+    4499n 1.8
+    4500n 0
+    4549n 0
+    4550n 1.8
+    4599n 1.8
+    4600n 0
+    4649n 0
+    4650n 1.8
+    4699n 1.8
+    4700n 0
+    4749n 0
+    4750n 1.8
+    4799n 1.8
+    4800n 0
+    4849n 0
+    4850n 1.8
+    4899n 1.8
+    4900n 0
+    4949n 0
+    4950n 1.8
+    4999n 1.8
+    5000n 0
+    5049n 0
+    5050n 1.8
+    5099n 1.8
+    5100n 0
+    5149n 0
+    5150n 1.8
+    5199n 1.8
+    5200n 0
+    5249n 0
+    5250n 1.8
+    5299n 1.8
+    5300n 0
+    5349n 0
+    5350n 1.8
+    5399n 1.8
+    5400n 0
+    5449n 0
+    5450n 1.8
+    5499n 1.8
+    5500n 0
+    5549n 0
+    5550n 1.8
+    5599n 1.8
+    5600n 0
+    5649n 0
+    5650n 1.8
+    5699n 1.8
+    5700n 0
+    5749n 0
+    5750n 1.8
+    5799n 1.8
+    5800n 0
+    5849n 0
+    5850n 1.8
+    5899n 1.8
+    5900n 0
+    5949n 0
+    5950n 1.8
+    5999n 1.8
+    6000n 0
+    6049n 0
+    6050n 1.8
+    6099n 1.8
+    6100n 0
+    6149n 0
+    6150n 1.8
+    6199n 1.8
+    6200n 0
+    6249n 0
+    6250n 1.8
+    6299n 1.8
+    6300n 0
+    6349n 0
+    6350n 1.8
+    6399n 1.8
+    6400n 0
+    6449n 0
+    6450n 1.8
+    6499n 1.8
+    6500n 0
+    6549n 0
+    6550n 1.8
+    6599n 1.8
+    6600n 0
+    6649n 0
+    6650n 1.8
+    6699n 1.8
+    6700n 0
+    6749n 0
+    6750n 1.8
+    6799n 1.8
+    6800n 0
+    6849n 0
+    6850n 1.8
+    6899n 1.8
+    6900n 0
+    6949n 0
+    6950n 1.8
+    6999n 1.8
+    7000n 0
+    7049n 0
+    7050n 1.8
+    7099n 1.8
+    7100n 0
+    7149n 0
+    7150n 1.8
+    7199n 1.8
+    7200n 0
+    7249n 0
+    7250n 1.8
+    7299n 1.8
+    7300n 0
+    7349n 0
+    7350n 1.8
+    7399n 1.8
+    7400n 0
+    7449n 0
+    7450n 1.8
+    7499n 1.8
+    7500n 0
+    7549n 0
+    7550n 1.8
+    7599n 1.8
+    7600n 0
+    7649n 0
+    7650n 1.8
+    7699n 1.8
+    7700n 0
+    7749n 0
+    7750n 1.8
+    7799n 1.8
+    7800n 0
+    7849n 0
+    7850n 1.8
+    7899n 1.8
+    7900n 0
+    7949n 0
+    7950n 1.8
+    7999n 1.8
+    8000n 0
+    8049n 0
+    8050n 1.8
+    8099n 1.8
+    8100n 0
+    8149n 0
+    8150n 1.8
+    8199n 1.8
+    8200n 0
+    8249n 0
+    8250n 1.8
+    8299n 1.8
+    8300n 0
+    8349n 0
+    8350n 1.8
+    8399n 1.8
+    8400n 0
+    8449n 0
+    8450n 1.8
+    8499n 1.8
+    8500n 0
+    8549n 0
+    8550n 1.8
+    8599n 1.8
+    8600n 0
+    8649n 0
+    8650n 1.8
+    8699n 1.8
+    8700n 0
+    8749n 0
+    8750n 1.8
+    8799n 1.8
+    8800n 0
+    8849n 0
+    8850n 1.8
+    8899n 1.8
+    8900n 0
+    8949n 0
+    8950n 1.8
+    8999n 1.8
+    9000n 0
+    9049n 0
+    9050n 1.8
+    9099n 1.8
+    9100n 0
+    9149n 0
+    9150n 1.8
+    9199n 1.8
+    9200n 0
+    9249n 0
+    9250n 1.8
+    9299n 1.8
+    9300n 0
+    9349n 0
+    9350n 1.8
+    9399n 1.8
+    9400n 0
+    9449n 0
+    9450n 1.8
+    9499n 1.8
+    9500n 0
+    9549n 0
+    9550n 1.8
+    9599n 1.8
+    9600n 0
+    9649n 0
+    9650n 1.8
+    9699n 1.8
+    9700n 0
+    9749n 0
+    9750n 1.8
+    9799n 1.8
+    9800n 0
+    9849n 0
+    9850n 1.8
+    9899n 1.8
+    9900n 0
+    9949n 0
+    9950n 1.8
+    9999n 1.8
+    10000n 0
+    10049n 0
+    10050n 1.8
+    10099n 1.8
+    10100n 0
+    10149n 0
+    10150n 1.8
+    10199n 1.8
+    10200n 0
+    10249n 0
+    10250n 1.8
+    10299n 1.8
+    10300n 0
+    10349n 0
+    10350n 1.8
+    10399n 1.8
+    10400n 0
+    10449n 0
+    10450n 1.8
+    10499n 1.8
+    10500n 0
+    10549n 0
+    10550n 1.8
+    10599n 1.8
+    10600n 0
+    10649n 0
+    10650n 1.8
+    10699n 1.8
+    10700n 0
+    10749n 0
+    10750n 1.8
+    10799n 1.8
+    10800n 0
+    10849n 0
+    10850n 1.8
+    10899n 1.8
+    10900n 0
+    10949n 0
+    10950n 1.8
+    10999n 1.8
+    11000n 0
+    11049n 0
+    11050n 1.8
+    11099n 1.8
+    11100n 0
+    11149n 0
+    11150n 1.8
+    11199n 1.8
+    11200n 0
+    11249n 0
+    11250n 1.8
+    11299n 1.8
+    11300n 0
+    11349n 0
+    11350n 1.8
+    11399n 1.8
+    11400n 0
+    11449n 0
+    11450n 1.8
+    11499n 1.8
+    11500n 0
+    11549n 0
+    11550n 1.8
+    11599n 1.8
+    11600n 0
+    11649n 0
+    11650n 1.8
+    11699n 1.8
+    11700n 0
+    11749n 0
+    11750n 1.8
+    11799n 1.8
+    11800n 0
+    11849n 0
+    11850n 1.8
+    11899n 1.8
+    11900n 0
+    11949n 0
+    11950n 1.8
+    11999n 1.8
+    12000n 0
+    12049n 0
+    12050n 1.8
+    12099n 1.8
+    12100n 0
+    12149n 0
+    12150n 1.8
+    12199n 1.8
+    12200n 0
+    12249n 0
+    12250n 1.8
+    12299n 1.8
+    12300n 0
+    12349n 0
+    12350n 1.8
+    12399n 1.8
+    12400n 0
+    12449n 0
+    12450n 1.8
+    12499n 1.8
+    12500n 0
+    12549n 0
+    12550n 1.8
+    12599n 1.8
+    12600n 0
+    12649n 0
+    12650n 1.8
+    12699n 1.8
+    12700n 0
+    12749n 0
+    12750n 1.8
+    12799n 1.8
+    12800n 0
+    12849n 0
+    12850n 1.8
+    12899n 1.8
+    12900n 0
+    12949n 0
+    12950n 1.8
+    12999n 1.8
+    13000n 0
+    13049n 0
+    13050n 1.8
+    13099n 1.8
+    13100n 0
+    13149n 0
+    13150n 1.8
+    13199n 1.8
+    13200n 0
+    13249n 0
+    13250n 1.8
+    13299n 1.8
+    13300n 0
+    13349n 0
+    13350n 1.8
+    13399n 1.8
+    13400n 0
+    13449n 0
+    13450n 1.8
+    13499n 1.8
+    13500n 0
+    13549n 0
+    13550n 1.8
+    13599n 1.8
+    13600n 0
+    13649n 0
+    13650n 1.8
+    13699n 1.8
+    13700n 0
+    13749n 0
+    13750n 1.8
+    13799n 1.8
+    13800n 0
+    13849n 0
+    13850n 1.8
+    13899n 1.8
+    13900n 0
+    13949n 0
+    13950n 1.8
+    13999n 1.8
+    14000n 0
+    14049n 0
+    14050n 1.8
+    14099n 1.8
+    14100n 0
+    14149n 0
+    14150n 1.8
+    14199n 1.8
+    14200n 0
+    14249n 0
+    14250n 1.8
+    14299n 1.8
+    14300n 0
+    14349n 0
+    14350n 1.8
+    14399n 1.8
+    14400n 0
+    14449n 0
+    14450n 1.8
+    14499n 1.8
+    14500n 0
+    14549n 0
+    14550n 1.8
+    14599n 1.8
+    14600n 0
+    14649n 0
+    14650n 1.8
+    14699n 1.8
+    14700n 0
+    14749n 0
+    14750n 1.8
+    14799n 1.8
+    14800n 0
+    14849n 0
+    14850n 1.8
+    14899n 1.8
+    14900n 0
+    14949n 0
+    14950n 1.8
+    14999n 1.8
+    15000n 0
+    15049n 0
+    15050n 1.8
+    15099n 1.8
+    15100n 0
+    15149n 0
+    15150n 1.8
+    15199n 1.8
+    15200n 0
+    15249n 0
+    15250n 1.8
+    15299n 1.8
+    15300n 0
+    15349n 0
+    15350n 1.8
+    15399n 1.8
+    15400n 0
+    15449n 0
+    15450n 1.8
+    15499n 1.8
+    15500n 0
+    15549n 0
+    15550n 1.8
+    15599n 1.8
+    15600n 0
+    15649n 0
+    15650n 1.8
+    15699n 1.8
+    15700n 0
+    15749n 0
+    15750n 1.8
+    15799n 1.8
+    15800n 0
+    15849n 0
+    15850n 1.8
+    15899n 1.8
+    15900n 0
+    15949n 0
+    15950n 1.8
+    15999n 1.8
+    16000n 0
+    16049n 0
+    16050n 1.8
+    16099n 1.8
+    16100n 0
+    16149n 0
+    16150n 1.8
+    16199n 1.8
+    16200n 0
+    16249n 0
+    16250n 1.8
+    16299n 1.8
+    16300n 0
+    16349n 0
+    16350n 1.8
+    16399n 1.8
+    16400n 0
+    16449n 0
+    16450n 1.8
+    16499n 1.8
+    16500n 0
+    16549n 0
+    16550n 1.8
+    16599n 1.8
+    16600n 0
+    16649n 0
+    16650n 1.8
+    16699n 1.8
+    16700n 0
+    16749n 0
+    16750n 1.8
+    16799n 1.8
+    16800n 0
+    16849n 0
+    16850n 1.8
+    16899n 1.8
+    16900n 0
+    16949n 0
+    16950n 1.8
+    16999n 1.8
+    17000n 0
+    17049n 0
+    17050n 1.8
+    17099n 1.8
+    17100n 0
+    17149n 0
+    17150n 1.8
+    17199n 1.8
+    17200n 0
+    17249n 0
+    17250n 1.8
+    17299n 1.8
+    17300n 0
+    17349n 0
+    17350n 1.8
+    17399n 1.8
+    17400n 0
+    17449n 0
+    17450n 1.8
+    17499n 1.8
+    17500n 0
+    17549n 0
+    17550n 1.8
+    17599n 1.8
+    17600n 0
+    17649n 0
+    17650n 1.8
+    17699n 1.8
+    17700n 0
+    17749n 0
+    17750n 1.8
+    17799n 1.8
+    17800n 0
+    17849n 0
+    17850n 1.8
+    17899n 1.8
+    17900n 0
+    17949n 0
+    17950n 1.8
+    17999n 1.8
+    18000n 0
+    18049n 0
+    18050n 1.8
+    18099n 1.8
+    18100n 0
+    18149n 0
+    18150n 1.8
+    18199n 1.8
+    18200n 0
+    18249n 0
+    18250n 1.8
+    18299n 1.8
+    18300n 0
+    18349n 0
+    18350n 1.8
+    18399n 1.8
+    18400n 0
+    18449n 0
+    18450n 1.8
+    18499n 1.8
+    18500n 0
+    18549n 0
+    18550n 1.8
+    18599n 1.8
+    18600n 0
+    18649n 0
+    18650n 1.8
+    18699n 1.8
+    18700n 0
+    18749n 0
+    18750n 1.8
+    18799n 1.8
+    18800n 0
+    18849n 0
+    18850n 1.8
+    18899n 1.8
+    18900n 0
+    18949n 0
+    18950n 1.8
+    18999n 1.8
+    19000n 0
+    19049n 0
+    19050n 1.8
+    19099n 1.8
+    19100n 0
+    19149n 0
+    19150n 1.8
+    19199n 1.8
+    19200n 0
+    19249n 0
+    19250n 1.8
+    19299n 1.8
+    19300n 0
+    19349n 0
+    19350n 1.8
+    19399n 1.8
+    19400n 0
+    19449n 0
+    19450n 1.8
+    19499n 1.8
+    19500n 0
+    19549n 0
+    19550n 1.8
+    19599n 1.8
+    19600n 0
+    19649n 0
+    19650n 1.8
+    19699n 1.8
+    19700n 0
+    19749n 0
+    19750n 1.8
+    19799n 1.8
+    19800n 0
+    19849n 0
+    19850n 1.8
+    19899n 1.8
+    19900n 0
+    19949n 0
+    19950n 1.8
+    19999n 1.8
+    20000n 0
+    20049n 0
+    20050n 1.8
+    20099n 1.8
+    20100n 0
+    20149n 0
+    20150n 1.8
+    20199n 1.8
+    20200n 0
+    20249n 0
+    20250n 1.8
+    20299n 1.8
+    20300n 0
+    20349n 0
+    20350n 1.8
+    20399n 1.8
+    20400n 0
+    20449n 0
+    20450n 1.8
+    20499n 1.8
+    20500n 0
+    20549n 0
+    20550n 1.8
+    20599n 1.8
+    20600n 0
+    20649n 0
+    20650n 1.8
+    20699n 1.8
+    20700n 0
+    20749n 0
+    20750n 1.8
+    20799n 1.8
+    20800n 0
+    20849n 0
+    20850n 1.8
+    20899n 1.8
+    20900n 0
+    20949n 0
+    20950n 1.8
+    20999n 1.8
+    21000n 0
+    21049n 0
+    21050n 1.8
+    21099n 1.8
+    21100n 0
+    21149n 0
+    21150n 1.8
+    21199n 1.8
+    21200n 0
+    21249n 0
+    21250n 1.8
+    21299n 1.8
+    21300n 0
+    21349n 0
+    21350n 1.8
+    21399n 1.8
+    21400n 0
+    21449n 0
+    21450n 1.8
+    21499n 1.8
+    21500n 0
+    21549n 0
+    21550n 1.8
+    21599n 1.8
+    21600n 0
+    21649n 0
+    21650n 1.8
+    21699n 1.8
+    21700n 0
+    21749n 0
+    21750n 1.8
+    21799n 1.8
+    21800n 0
+    21849n 0
+    21850n 1.8
+    21899n 1.8
+    21900n 0
+    21949n 0
+    21950n 1.8
+    21999n 1.8
+    22000n 0
+    22049n 0
+    22050n 1.8
+    22099n 1.8
+    22100n 0
+    22149n 0
+    22150n 1.8
+    22199n 1.8
+    22200n 0
+    22249n 0
+    22250n 1.8
+    22299n 1.8
+    22300n 0
+    22349n 0
+    22350n 1.8
+    22399n 1.8
+    22400n 0
+    22449n 0
+    22450n 1.8
+    22499n 1.8
+    22500n 0
+    22549n 0
+    22550n 1.8
+    22599n 1.8
+    22600n 0
+    22649n 0
+    22650n 1.8
+    22699n 1.8
+    22700n 0
+    22749n 0
+    22750n 1.8
+    22799n 1.8
+    22800n 0
+    22849n 0
+    22850n 1.8
+    22899n 1.8
+    22900n 0
+    22949n 0
+    22950n 1.8
+    22999n 1.8
+    23000n 0
+    23049n 0
+    23050n 1.8
+    23099n 1.8
+    23100n 0
+    23149n 0
+    23150n 1.8
+    23199n 1.8
+    23200n 0
+    23249n 0
+    23250n 1.8
+    23299n 1.8
+    23300n 0
+    23349n 0
+    23350n 1.8
+    23399n 1.8
+    23400n 0
+    23449n 0
+    23450n 1.8
+    23499n 1.8
+    23500n 0
+    23549n 0
+    23550n 1.8
+    23599n 1.8
+    23600n 0
+    23649n 0
+    23650n 1.8
+    23699n 1.8
+    23700n 0
+    23749n 0
+    23750n 1.8
+    23799n 1.8
+    23800n 0
+    23849n 0
+    23850n 1.8
+    23899n 1.8
+    23900n 0
+    23949n 0
+    23950n 1.8
+    23999n 1.8
+    24000n 0
+    24049n 0
+    24050n 1.8
+    24099n 1.8
+    24100n 0
+    24149n 0
+    24150n 1.8
+    24199n 1.8
+    24200n 0
+    24249n 0
+    24250n 1.8
+    24299n 1.8
+    24300n 0
+    24349n 0
+    24350n 1.8
+    24399n 1.8
+    24400n 0
+    24449n 0
+    24450n 1.8
+    24499n 1.8
+    24500n 0
+    24549n 0
+    24550n 1.8
+    24599n 1.8
+    24600n 0
+    24649n 0
+    24650n 1.8
+    24699n 1.8
+    24700n 0
+    24749n 0
+    24750n 1.8
+    24799n 1.8
+    24800n 0
+    24849n 0
+    24850n 1.8
+    24899n 1.8
+    24900n 0
+    24949n 0
+    24950n 1.8
+    24999n 1.8
+    25000n 0
+    25049n 0
+    25050n 1.8
+    25099n 1.8
+    25100n 0
+    25149n 0
+    25150n 1.8
+    25199n 1.8
+    25200n 0
+    25249n 0
+    25250n 1.8
+    25299n 1.8
+    25300n 0
+    25349n 0
+    25350n 1.8
+    25399n 1.8
+    25400n 0
+    25449n 0
+    25450n 1.8
+    25499n 1.8
+    25500n 0
+    25549n 0
+    25550n 1.8
+    25599n 1.8
+    25600n 0
+    25649n 0
+    25650n 1.8
+    25699n 1.8
+    25700n 0
+    25749n 0
+    25750n 1.8
+    25799n 1.8
+    25800n 0
+    25849n 0
+    25850n 1.8
+    25899n 1.8
+    25900n 0
+    25949n 0
+    25950n 1.8
+    25999n 1.8
+    26000n 0
+    26049n 0
+    26050n 1.8
+    26099n 1.8
+    26100n 0
+    26149n 0
+    26150n 1.8
+    26199n 1.8
+    26200n 0
+    26249n 0
+    26250n 1.8
+    26299n 1.8
+    26300n 0
+    26349n 0
+    26350n 1.8
+    26399n 1.8
+    26400n 0
+    26449n 0
+    26450n 1.8
+    26499n 1.8
+    26500n 0
+    26549n 0
+    26550n 1.8
+    26599n 1.8
+    26600n 0
+    26649n 0
+    26650n 1.8
+    26699n 1.8
+    26700n 0
+    26749n 0
+    26750n 1.8
+    26799n 1.8
+    26800n 0
+    26849n 0
+    26850n 1.8
+    26899n 1.8
+    26900n 0
+    26949n 0
+    26950n 1.8
+    26999n 1.8
+    27000n 0
+    27049n 0
+    27050n 1.8
+    27099n 1.8
+    27100n 0
+    27149n 0
+    27150n 1.8
+    27199n 1.8
+    27200n 0
+    27249n 0
+    27250n 1.8
+    27299n 1.8
+    27300n 0
+    27349n 0
+    27350n 1.8
+    27399n 1.8
+    27400n 0
+    27449n 0
+    27450n 1.8
+    27499n 1.8
+    27500n 0
+    27549n 0
+    27550n 1.8
+    27599n 1.8
+    27600n 0
+    27649n 0
+    27650n 1.8
+    27699n 1.8
+    27700n 0
+    27749n 0
+    27750n 1.8
+    27799n 1.8
+    27800n 0
+    27849n 0
+    27850n 1.8
+    27899n 1.8
+    27900n 0
+    27949n 0
+    27950n 1.8
+    27999n 1.8
+    28000n 0
+    28049n 0
+    28050n 1.8
+    28099n 1.8
+    28100n 0
+    28149n 0
+    28150n 1.8
+    28199n 1.8
+    28200n 0
+    28249n 0
+    28250n 1.8
+    28299n 1.8
+    28300n 0
+    28349n 0
+    28350n 1.8
+    28399n 1.8
+    28400n 0
+    28449n 0
+    28450n 1.8
+    28499n 1.8
+    28500n 0
+    28549n 0
+    28550n 1.8
+    28599n 1.8
+    28600n 0
+    28649n 0
+    28650n 1.8
+    28699n 1.8
+    28700n 0
+    28749n 0
+    28750n 1.8
+    28799n 1.8
+    28800n 0
+    28849n 0
+    28850n 1.8
+    28899n 1.8
+    28900n 0
+    28949n 0
+    28950n 1.8
+    28999n 1.8
+    29000n 0
+    29049n 0
+    29050n 1.8
+    29099n 1.8
+    29100n 0
+    29149n 0
+    29150n 1.8
+    29199n 1.8
+    29200n 0
+    29249n 0
+    29250n 1.8
+    29299n 1.8
+    29300n 0
+    29349n 0
+    29350n 1.8
+    29399n 1.8
+    29400n 0
+    29449n 0
+    29450n 1.8
+    29499n 1.8
+    29500n 0
+    29549n 0
+    29550n 1.8
+    29599n 1.8
+    29600n 0
+    29649n 0
+    29650n 1.8
+    29699n 1.8
+    29700n 0
+    29749n 0
+    29750n 1.8
+    29799n 1.8
+    29800n 0
+    29849n 0
+    29850n 1.8
+    29899n 1.8
+    29900n 0
+    29949n 0
+    29950n 1.8
+    29999n 1.8
+    30000n 0
+    30049n 0
+    30050n 1.8
+    30099n 1.8
+    30100n 0
+    30149n 0
+    30150n 1.8
+    30199n 1.8
+    30200n 0
+    30249n 0
+    30250n 1.8
+    30299n 1.8
+    30300n 0
+    30349n 0
+    30350n 1.8
+    30399n 1.8
+    30400n 0
+    30449n 0
+    30450n 1.8
+    30499n 1.8
+    30500n 0
+    30549n 0
+    30550n 1.8
+    30599n 1.8
+    30600n 0
+    30649n 0
+    30650n 1.8
+    30699n 1.8
+    30700n 0
+    30749n 0
+    30750n 1.8
+    30799n 1.8
+    30800n 0
+    30849n 0
+    30850n 1.8
+    30899n 1.8
+    30900n 0
+    30949n 0
+    30950n 1.8
+    30999n 1.8
+    31000n 0
+    31049n 0
+    31050n 1.8
+    31099n 1.8
+    31100n 0
+    31149n 0
+    31150n 1.8
+    31199n 1.8
+    31200n 0
+    31249n 0
+    31250n 1.8
+    31299n 1.8
+    31300n 0
+    31349n 0
+    31350n 1.8
+    31399n 1.8
+    31400n 0
+    31449n 0
+    31450n 1.8
+    31499n 1.8
+    31500n 0
+    31549n 0
+    31550n 1.8
+    31599n 1.8
+    31600n 0
+    31649n 0
+    31650n 1.8
+    31699n 1.8
+    31700n 0
+    31749n 0
+    31750n 1.8
+    31799n 1.8
+    31800n 0
+    31849n 0
+    31850n 1.8
+    31899n 1.8
+    31900n 0
+    31949n 0
+    31950n 1.8
+    31999n 1.8
+    32000n 0
+    32049n 0
+    32050n 1.8
+    32099n 1.8
+    32100n 0
+    32149n 0
+    32150n 1.8
+    32199n 1.8
+    32200n 0
+    32249n 0
+    32250n 1.8
+    32299n 1.8
+    32300n 0
+    32349n 0
+    32350n 1.8
+    32399n 1.8
+    32400n 0
+    32449n 0
+    32450n 1.8
+    32499n 1.8
+    32500n 0
+    32549n 0
+    32550n 1.8
+    32599n 1.8
+    32600n 0
+    32649n 0
+    32650n 1.8
+    32699n 1.8
+    32700n 0
+    32749n 0
+    32750n 1.8
+    32799n 1.8
+    32800n 0
+    32849n 0
+    32850n 1.8
+    32899n 1.8
+    32900n 0
+    32949n 0
+    32950n 1.8
+    32999n 1.8
+    33000n 0
+    33049n 0
+    33050n 1.8
+    33099n 1.8
+    33100n 0
+    33149n 0
+    33150n 1.8
+    33199n 1.8
+    33200n 0
+    33249n 0
+    33250n 1.8
+    33299n 1.8
+    33300n 0
+    33349n 0
+    33350n 1.8
+    33399n 1.8
+    33400n 0
+    33449n 0
+    33450n 1.8
+    33499n 1.8
+    33500n 0
+    33549n 0
+    33550n 1.8
+    33599n 1.8
+    33600n 0
+    33649n 0
+    33650n 1.8
+    33699n 1.8
+    33700n 0
+    33749n 0
+    33750n 1.8
+    33799n 1.8
+    33800n 0
+    33849n 0
+    33850n 1.8
+    33899n 1.8
+    33900n 0
+    33949n 0
+    33950n 1.8
+    33999n 1.8
+    34000n 0
+    34049n 0
+    34050n 1.8
+    34099n 1.8
+    34100n 0
+    34149n 0
+    34150n 1.8
+    34199n 1.8
+    34200n 0
+    34249n 0
+    34250n 1.8
+    34299n 1.8
+    34300n 0
+    34349n 0
+    34350n 1.8
+    34399n 1.8
+    34400n 0
+    34449n 0
+    34450n 1.8
+    34499n 1.8
+    34500n 0
+    34549n 0
+    34550n 1.8
+    34599n 1.8
+    34600n 0
+    34649n 0
+    34650n 1.8
+    34699n 1.8
+    34700n 0
+    34749n 0
+    34750n 1.8
+    34799n 1.8
+    34800n 0
+    34849n 0
+    34850n 1.8
+    34899n 1.8
+    34900n 0
+    34949n 0
+    34950n 1.8
+    34999n 1.8
+    35000n 0
+    35049n 0
+    35050n 1.8
+    35099n 1.8
+    35100n 0
+    35149n 0
+    35150n 1.8
+    35199n 1.8
+    35200n 0
+    35249n 0
+    35250n 1.8
+    35299n 1.8
+    35300n 0
+    35349n 0
+    35350n 1.8
+    35399n 1.8
+    35400n 0
+    35449n 0
+    35450n 1.8
+    35499n 1.8
+    35500n 0
+    35549n 0
+    35550n 1.8
+    35599n 1.8
+    35600n 0
+    35649n 0
+    35650n 1.8
+    35699n 1.8
+    35700n 0
+    35749n 0
+    35750n 1.8
+    35799n 1.8
+    35800n 0
+    35849n 0
+    35850n 1.8
+    35899n 1.8
+    35900n 0
+    35949n 0
+    35950n 1.8
+    35999n 1.8
+    36000n 0
+    36049n 0
+    36050n 1.8
+    36099n 1.8
+    36100n 0
+    36149n 0
+    36150n 1.8
+    36199n 1.8
+    36200n 0
+    36249n 0
+    36250n 1.8
+    36299n 1.8
+    36300n 0
+    36349n 0
+    36350n 1.8
+    36399n 1.8
+    36400n 0
+    36449n 0
+    36450n 1.8
+    36499n 1.8
+    36500n 0
+    36549n 0
+    36550n 1.8
+    36599n 1.8
+    36600n 0
+    36649n 0
+    36650n 1.8
+    36699n 1.8
+    36700n 0
+    36749n 0
+    36750n 1.8
+    36799n 1.8
+    36800n 0
+    36849n 0
+    36850n 1.8
+    36899n 1.8
+    36900n 0
+    36949n 0
+    36950n 1.8
+    36999n 1.8
+    37000n 0
+    37049n 0
+    37050n 1.8
+    37099n 1.8
+    37100n 0
+    37149n 0
+    37150n 1.8
+    37199n 1.8
+    37200n 0
+    37249n 0
+    37250n 1.8
+    37299n 1.8
+    37300n 0
+    37349n 0
+    37350n 1.8
+    37399n 1.8
+    37400n 0
+    37449n 0
+    37450n 1.8
+    37499n 1.8
+    37500n 0
+    37549n 0
+    37550n 1.8
+    37599n 1.8
+    37600n 0
+    37649n 0
+    37650n 1.8
+    37699n 1.8
+    37700n 0
+    37749n 0
+    37750n 1.8
+    37799n 1.8
+    37800n 0
+    37849n 0
+    37850n 1.8
+    37899n 1.8
+    37900n 0
+    37949n 0
+    37950n 1.8
+    37999n 1.8
+    38000n 0
+    38049n 0
+    38050n 1.8
+    38099n 1.8
+    38100n 0
+    38149n 0
+    38150n 1.8
+    38199n 1.8
+    38200n 0
+    38249n 0
+    38250n 1.8
+    38299n 1.8
+    38300n 0
+    38349n 0
+    38350n 1.8
+    38399n 1.8
+    38400n 0
+    38449n 0
+    38450n 1.8
+    38499n 1.8
+    38500n 0
+    38549n 0
+    38550n 1.8
+    38599n 1.8
+    38600n 0
+    38649n 0
+    38650n 1.8
+    38699n 1.8
+    38700n 0
+    38749n 0
+    38750n 1.8
+    38799n 1.8
+    38800n 0
+    38849n 0
+    38850n 1.8
+    38899n 1.8
+    38900n 0
+    38949n 0
+    38950n 1.8
+    38999n 1.8
+    39000n 0
+    39049n 0
+    39050n 1.8
+    39099n 1.8
+    39100n 0
+    39149n 0
+    39150n 1.8
+    39199n 1.8
+    39200n 0
+    39249n 0
+    39250n 1.8
+    39299n 1.8
+    39300n 0
+    39349n 0
+    39350n 1.8
+    39399n 1.8
+    39400n 0
+    39449n 0
+    39450n 1.8
+    39499n 1.8
+    39500n 0
+    39549n 0
+    39550n 1.8
+    39599n 1.8
+    39600n 0
+    39649n 0
+    39650n 1.8
+    39699n 1.8
+    39700n 0
+    39749n 0
+    39750n 1.8
+    39799n 1.8
+    39800n 0
+    39849n 0
+    39850n 1.8
+    39899n 1.8
+    39900n 0
+    39949n 0
+    39950n 1.8
+    39999n 1.8
+    40000n 0
+    40049n 0
+    40050n 1.8
+    40099n 1.8
+    40100n 0
+    40149n 0
+    40150n 1.8
+    40199n 1.8
+    40200n 0
+    40249n 0
+    40250n 1.8
+    40299n 1.8
+    40300n 0
+    40349n 0
+    40350n 1.8
+    40399n 1.8
+    40400n 0
+    40449n 0
+    40450n 1.8
+    40499n 1.8
+    40500n 0
+    40549n 0
+    40550n 1.8
+    40599n 1.8
+    40600n 0
+    40649n 0
+    40650n 1.8
+    40699n 1.8
+    40700n 0
+    40749n 0
+    40750n 1.8
+    40799n 1.8
+    40800n 0
+    40849n 0
+    40850n 1.8
+    40899n 1.8
+    40900n 0
+    40949n 0
+    40950n 1.8
+    40999n 1.8
+    41000n 0
+    41049n 0
+    41050n 1.8
+    41099n 1.8
+    41100n 0
+    41149n 0
+    41150n 1.8
+    41199n 1.8
+    41200n 0
+    41249n 0
+    41250n 1.8
+    41299n 1.8
+    41300n 0
+    41349n 0
+    41350n 1.8
+    41399n 1.8
+    41400n 0
+    41449n 0
+    41450n 1.8
+    41499n 1.8
+    41500n 0
+    41549n 0
+    41550n 1.8
+    41599n 1.8
+    41600n 0
+    41649n 0
+    41650n 1.8
+    41699n 1.8
+    41700n 0
+    41749n 0
+    41750n 1.8
+    41799n 1.8
+    41800n 0
+    41849n 0
+    41850n 1.8
+    41899n 1.8
+    41900n 0
+    41949n 0
+    41950n 1.8
+    41999n 1.8
+    42000n 0
+    42049n 0
+    42050n 1.8
+    42099n 1.8
+    42100n 0
+    42149n 0
+    42150n 1.8
+    42199n 1.8
+    42200n 0
+    42249n 0
+    42250n 1.8
+    42299n 1.8
+    42300n 0
+    42349n 0
+    42350n 1.8
+    42399n 1.8
+    42400n 0
+    42449n 0
+    42450n 1.8
+    42499n 1.8
+    42500n 0
+    42549n 0
+    42550n 1.8
+    42599n 1.8
+    42600n 0
+    42649n 0
+    42650n 1.8
+    42699n 1.8
+    42700n 0
+    42749n 0
+    42750n 1.8
+    42799n 1.8
+    42800n 0
+    42849n 0
+    42850n 1.8
+    42899n 1.8
+    42900n 0
+    42949n 0
+    42950n 1.8
+    42999n 1.8
+    43000n 0
+    43049n 0
+    43050n 1.8
+    43099n 1.8
+    43100n 0
+    43149n 0
+    43150n 1.8
+    43199n 1.8
+    43200n 0
+    43249n 0
+    43250n 1.8
+    43299n 1.8
+    43300n 0
+    43349n 0
+    43350n 1.8
+    43399n 1.8
+    43400n 0
+    43449n 0
+    43450n 1.8
+    43499n 1.8
+    43500n 0
+    43549n 0
+    43550n 1.8
+    43599n 1.8
+    43600n 0
+    43649n 0
+    43650n 1.8
+    43699n 1.8
+    43700n 0
+    43749n 0
+    43750n 1.8
+    43799n 1.8
+    43800n 0
+    43849n 0
+    43850n 1.8
+    43899n 1.8
+    43900n 0
+    43949n 0
+    43950n 1.8
+    43999n 1.8
+    44000n 0
+    44049n 0
+    44050n 1.8
+    44099n 1.8
+    44100n 0
+    44149n 0
+    44150n 1.8
+    44199n 1.8
+    44200n 0
+    44249n 0
+    44250n 1.8
+    44299n 1.8
+    44300n 0
+    44349n 0
+    44350n 1.8
+    44399n 1.8
+    44400n 0
+    44449n 0
+    44450n 1.8
+    44499n 1.8
+    44500n 0
+    44549n 0
+    44550n 1.8
+    44599n 1.8
+    44600n 0
+    44649n 0
+    44650n 1.8
+    44699n 1.8
+    44700n 0
+    44749n 0
+    44750n 1.8
+    44799n 1.8
+    44800n 0
+    44849n 0
+    44850n 1.8
+    44899n 1.8
+    44900n 0
+    44949n 0
+    44950n 1.8
+    44999n 1.8
+    45000n 0
+    45049n 0
+    45050n 1.8
+    45099n 1.8
+    45100n 0
+    45149n 0
+    45150n 1.8
+    45199n 1.8
+    45200n 0
+    45249n 0
+    45250n 1.8
+    45299n 1.8
+    45300n 0
+    45349n 0
+    45350n 1.8
+    45399n 1.8
+    45400n 0
+    45449n 0
+    45450n 1.8
+    45499n 1.8
+    45500n 0
+    45549n 0
+    45550n 1.8
+    45599n 1.8
+    45600n 0
+    45649n 0
+    45650n 1.8
+    45699n 1.8
+    45700n 0
+    45749n 0
+    45750n 1.8
+    45799n 1.8
+    45800n 0
+    45849n 0
+    45850n 1.8
+    45899n 1.8
+    45900n 0
+    45949n 0
+    45950n 1.8
+    45999n 1.8
+    46000n 0
+    46049n 0
+    46050n 1.8
+    46099n 1.8
+    46100n 0
+    46149n 0
+    46150n 1.8
+    46199n 1.8
+    46200n 0
+    46249n 0
+    46250n 1.8
+    46299n 1.8
+    46300n 0
+    46349n 0
+    46350n 1.8
+    46399n 1.8
+    46400n 0
+    46449n 0
+    46450n 1.8
+    46499n 1.8
+    46500n 0
+    46549n 0
+    46550n 1.8
+    46599n 1.8
+    46600n 0
+    46649n 0
+    46650n 1.8
+    46699n 1.8
+    46700n 0
+    46749n 0
+    46750n 1.8
+    46799n 1.8
+    46800n 0
+    46849n 0
+    46850n 1.8
+    46899n 1.8
+    46900n 0
+    46949n 0
+    46950n 1.8
+    46999n 1.8
+    47000n 0
+    47049n 0
+    47050n 1.8
+    47099n 1.8
+    47100n 0
+    47149n 0
+    47150n 1.8
+    47199n 1.8
+    47200n 0
+    47249n 0
+    47250n 1.8
+    47299n 1.8
+    47300n 0
+    47349n 0
+    47350n 1.8
+    47399n 1.8
+    47400n 0
+    47449n 0
+    47450n 1.8
+    47499n 1.8
+    47500n 0
+    47549n 0
+    47550n 1.8
+    47599n 1.8
+    47600n 0
+    47649n 0
+    47650n 1.8
+    47699n 1.8
+    47700n 0
+    47749n 0
+    47750n 1.8
+    47799n 1.8
+    47800n 0
+    47849n 0
+    47850n 1.8
+    47899n 1.8
+    47900n 0
+    47949n 0
+    47950n 1.8
+    47999n 1.8
+    48000n 0
+    48049n 0
+    48050n 1.8
+    48099n 1.8
+    48100n 0
+    48149n 0
+    48150n 1.8
+    48199n 1.8
+    48200n 0
+    48249n 0
+    48250n 1.8
+    48299n 1.8
+    48300n 0
+    48349n 0
+    48350n 1.8
+    48399n 1.8
+    48400n 0
+    48449n 0
+    48450n 1.8
+    48499n 1.8
+    48500n 0
+    48549n 0
+    48550n 1.8
+    48599n 1.8
+    48600n 0
+    48649n 0
+    48650n 1.8
+    48699n 1.8
+    48700n 0
+    48749n 0
+    48750n 1.8
+    48799n 1.8
+    48800n 0
+    48849n 0
+    48850n 1.8
+    48899n 1.8
+    48900n 0
+    48949n 0
+    48950n 1.8
+    48999n 1.8
+    49000n 0
+    49049n 0
+    49050n 1.8
+    49099n 1.8
+    49100n 0
+    49149n 0
+    49150n 1.8
+    49199n 1.8
+    49200n 0
+    49249n 0
+    49250n 1.8
+    49299n 1.8
+    49300n 0
+    49349n 0
+    49350n 1.8
+    49399n 1.8
+    49400n 0
+    49449n 0
+    49450n 1.8
+    49499n 1.8
+    49500n 0
+    49549n 0
+    49550n 1.8
+    49599n 1.8
+    49600n 0
+    49649n 0
+    49650n 1.8
+    49699n 1.8
+    49700n 0
+    49749n 0
+    49750n 1.8
+    49799n 1.8
+    49800n 0
+    49849n 0
+    49850n 1.8
+    49899n 1.8
+    49900n 0
+    49949n 0
+    49950n 1.8
+    49999n 1.8
+    50000n 0
+    50049n 0
+    50050n 1.8
+    50099n 1.8
+    50100n 0
+    50149n 0
+    50150n 1.8
+    50199n 1.8
+    50200n 0
+    50249n 0
+    50250n 1.8
+    50299n 1.8
+    50300n 0
+    50349n 0
+    50350n 1.8
+    50399n 1.8
+    50400n 0
+    50449n 0
+    50450n 1.8
+    50499n 1.8
+    50500n 0
+    50549n 0
+    50550n 1.8
+    50599n 1.8
+    50600n 0
+    50649n 0
+    50650n 1.8
+    50699n 1.8
+    50700n 0
+    50749n 0
+    50750n 1.8
+    50799n 1.8
+    50800n 0
+    50849n 0
+    50850n 1.8
+    50899n 1.8
+    50900n 0
+    50949n 0
+    50950n 1.8
+    50999n 1.8
+    51000n 0
+    51049n 0
+    51050n 1.8
+    51099n 1.8
+    51100n 0
+    51149n 0
+    51150n 1.8
+    51199n 1.8
+    51200n 0
+    51249n 0
+    51250n 1.8
+    51299n 1.8
+    51300n 0
+    51349n 0
+    51350n 1.8
+    51399n 1.8
+    51400n 0
+    51449n 0
+    51450n 1.8
+    51499n 1.8
+    51500n 0
+    51549n 0
+    51550n 1.8
+    51599n 1.8
+    51600n 0
+    51649n 0
+    51650n 1.8
+    51699n 1.8
+    51700n 0
+    51749n 0
+    51750n 1.8
+    51799n 1.8
+    51800n 0
+    51849n 0
+    51850n 1.8
+    51899n 1.8
+    51900n 0
+    51949n 0
+    51950n 1.8
+    51999n 1.8
+    52000n 0
+    52049n 0
+    52050n 1.8
+    52099n 1.8
+    52100n 0
+    52149n 0
+    52150n 1.8
+    52199n 1.8
+    52200n 0
+    52249n 0
+    52250n 1.8
+    52299n 1.8
+    52300n 0
+    52349n 0
+    52350n 1.8
+    52399n 1.8
+    52400n 0
+    52449n 0
+    52450n 1.8
+    52499n 1.8
+    52500n 0
+    52549n 0
+    52550n 1.8
+    52599n 1.8
+    52600n 0
+    52649n 0
+    52650n 1.8
+    52699n 1.8
+    52700n 0
+    52749n 0
+    52750n 1.8
+    52799n 1.8
+    52800n 0
+    52849n 0
+    52850n 1.8
+    52899n 1.8
+    52900n 0
+    52949n 0
+    52950n 1.8
+    52999n 1.8
+    53000n 0
+    53049n 0
+    53050n 1.8
+    53099n 1.8
+    53100n 0
+    53149n 0
+    53150n 1.8
+    53199n 1.8
+    53200n 0
+    53249n 0
+    53250n 1.8
+    53299n 1.8
+    53300n 0
+    53349n 0
+    53350n 1.8
+    53399n 1.8
+    53400n 0
+    53449n 0
+    53450n 1.8
+    53499n 1.8
+    53500n 0
+    53549n 0
+    53550n 1.8
+    53599n 1.8
+    53600n 0
+    53649n 0
+    53650n 1.8
+    53699n 1.8
+    53700n 0
+    53749n 0
+    53750n 1.8
+    53799n 1.8
+    53800n 0
+    53849n 0
+    53850n 1.8
+    53899n 1.8
+    53900n 0
+    53949n 0
+    53950n 1.8
+    53999n 1.8
+    54000n 0
+    54049n 0
+    54050n 1.8
+    54099n 1.8
+    54100n 0
+    54149n 0
+    54150n 1.8
+    54199n 1.8
+    54200n 0
+    54249n 0
+    54250n 1.8
+    54299n 1.8
+    54300n 0
+    54349n 0
+    54350n 1.8
+    54399n 1.8
+    54400n 0
+    54449n 0
+    54450n 1.8
+    54499n 1.8
+    54500n 0
+    54549n 0
+    54550n 1.8
+    54599n 1.8
+    54600n 0
+    54649n 0
+    54650n 1.8
+    54699n 1.8
+    54700n 0
+    54749n 0
+    54750n 1.8
+    54799n 1.8
+    54800n 0
+    54849n 0
+    54850n 1.8
+    54899n 1.8
+    54900n 0
+    54949n 0
+    54950n 1.8
+    54999n 1.8
+    55000n 0
+    55049n 0
+    55050n 1.8
+    55099n 1.8
+    55100n 0
+    55149n 0
+    55150n 1.8
+    55199n 1.8
+    55200n 0
+    55249n 0
+    55250n 1.8
+    55299n 1.8
+    55300n 0
+    55349n 0
+    55350n 1.8
+    55399n 1.8
+    55400n 0
+    55449n 0
+    55450n 1.8
+    55499n 1.8
+    55500n 0
+    55549n 0
+    55550n 1.8
+    55599n 1.8
+    55600n 0
+    55649n 0
+    55650n 1.8
+    55699n 1.8
+    55700n 0
+    55749n 0
+    55750n 1.8
+    55799n 1.8
+    55800n 0
+    55849n 0
+    55850n 1.8
+    55899n 1.8
+    55900n 0
+    55949n 0
+    55950n 1.8
+    55999n 1.8
+    56000n 0
+    56049n 0
+    56050n 1.8
+    56099n 1.8
+    56100n 0
+    56149n 0
+    56150n 1.8
+    56199n 1.8
+    56200n 0
+    56249n 0
+    56250n 1.8
+    56299n 1.8
+    56300n 0
+    56349n 0
+    56350n 1.8
+    56399n 1.8
+    56400n 0
+    56449n 0
+    56450n 1.8
+    56499n 1.8
+    56500n 0
+    56549n 0
+    56550n 1.8
+    56599n 1.8
+    56600n 0
+    56649n 0
+    56650n 1.8
+    56699n 1.8
+    56700n 0
+    56749n 0
+    56750n 1.8
+    56799n 1.8
+    56800n 0
+    56849n 0
+    56850n 1.8
+    56899n 1.8
+    56900n 0
+    56949n 0
+    56950n 1.8
+    56999n 1.8
+    57000n 0
+    57049n 0
+    57050n 1.8
+    57099n 1.8
+    57100n 0
+    57149n 0
+    57150n 1.8
+    57199n 1.8
+    57200n 0
+    57249n 0
+    57250n 1.8
+    57299n 1.8
+    57300n 0
+    57349n 0
+    57350n 1.8
+    57399n 1.8
+    57400n 0
+    57449n 0
+    57450n 1.8
+    57499n 1.8
+    57500n 0
+    57549n 0
+    57550n 1.8
+    57599n 1.8
+    57600n 0
+    57649n 0
+    57650n 1.8
+    57699n 1.8
+    57700n 0
+    57749n 0
+    57750n 1.8
+    57799n 1.8
+    57800n 0
+    57849n 0
+    57850n 1.8
+    57899n 1.8
+    57900n 0
+    57949n 0
+    57950n 1.8
+    57999n 1.8
+    58000n 0
+    58049n 0
+    58050n 1.8
+    58099n 1.8
+    58100n 0
+    58149n 0
+    58150n 1.8
+    58199n 1.8
+    58200n 0
+    58249n 0
+    58250n 1.8
+    58299n 1.8
+    58300n 0
+    58349n 0
+    58350n 1.8
+    58399n 1.8
+    58400n 0
+    58449n 0
+    58450n 1.8
+    58499n 1.8
+    58500n 0
+    58549n 0
+    58550n 1.8
+    58599n 1.8
+    58600n 0
+    58649n 0
+    58650n 1.8
+    58699n 1.8
+    58700n 0
+    58749n 0
+    58750n 1.8
+    58799n 1.8
+    58800n 0
+    58849n 0
+    58850n 1.8
+    58899n 1.8
+    58900n 0
+    58949n 0
+    58950n 1.8
+    58999n 1.8
+    59000n 0
+    59049n 0
+    59050n 1.8
+    59099n 1.8
+    59100n 0
+    59149n 0
+    59150n 1.8
+    59199n 1.8
+    59200n 0
+    59249n 0
+    59250n 1.8
+    59299n 1.8
+    59300n 0
+    59349n 0
+    59350n 1.8
+    59399n 1.8
+    59400n 0
+    59449n 0
+    59450n 1.8
+    59499n 1.8
+    59500n 0
+    59549n 0
+    59550n 1.8
+    59599n 1.8
+    59600n 0
+    59649n 0
+    59650n 1.8
+    59699n 1.8
+    59700n 0
+    59749n 0
+    59750n 1.8
+    59799n 1.8
+    59800n 0
+    59849n 0
+    59850n 1.8
+    59899n 1.8
+    59900n 0
+    59949n 0
+    59950n 1.8
+    59999n 1.8
+    60000n 0
+    60049n 0
+    60050n 1.8
+    60099n 1.8
+    60100n 0
+    60149n 0
+    60150n 1.8
+    60199n 1.8
+    60200n 0
+    60249n 0
+    60250n 1.8
+    60299n 1.8
+    60300n 0
+    60349n 0
+    60350n 1.8
+    60399n 1.8
+    60400n 0
+    60449n 0
+    60450n 1.8
+    60499n 1.8
+    60500n 0
+    60549n 0
+    60550n 1.8
+    60599n 1.8
+    60600n 0
+    60649n 0
+    60650n 1.8
+    60699n 1.8
+    60700n 0
+    60749n 0
+    60750n 1.8
+    60799n 1.8
+    60800n 0
+    60849n 0
+    60850n 1.8
+    60899n 1.8
+    60900n 0
+    60949n 0
+    60950n 1.8
+    60999n 1.8
+    61000n 0
+    61049n 0
+    61050n 1.8
+    61099n 1.8
+    61100n 0
+    61149n 0
+    61150n 1.8
+    61199n 1.8
+    61200n 0
+    61249n 0
+    61250n 1.8
+    61299n 1.8
+    61300n 0
+    61349n 0
+    61350n 1.8
+    61399n 1.8
+    61400n 0
+    61449n 0
+    61450n 1.8
+    61499n 1.8
+    61500n 0
+    61549n 0
+    61550n 1.8
+    61599n 1.8
+    61600n 0
+    61649n 0
+    61650n 1.8
+    61699n 1.8
+    61700n 0
+    61749n 0
+    61750n 1.8
+    61799n 1.8
+    61800n 0
+    61849n 0
+    61850n 1.8
+    61899n 1.8
+    61900n 0
+    61949n 0
+    61950n 1.8
+    61999n 1.8
+    62000n 0
+    62049n 0
+    62050n 1.8
+    62099n 1.8
+    62100n 0
+    62149n 0
+    62150n 1.8
+    62199n 1.8
+    62200n 0
+    62249n 0
+    62250n 1.8
+    62299n 1.8
+    62300n 0
+    62349n 0
+    62350n 1.8
+    62399n 1.8
+    62400n 0
+    62449n 0
+    62450n 1.8
+    62499n 1.8
+    62500n 0
+    62549n 0
+    62550n 1.8
+    62599n 1.8
+    62600n 0
+    62649n 0
+    62650n 1.8
+    62699n 1.8
+    62700n 0
+    62749n 0
+    62750n 1.8
+    62799n 1.8
+    62800n 0
+    62849n 0
+    62850n 1.8
+    62899n 1.8
+    62900n 0
+    62949n 0
+    62950n 1.8
+    62999n 1.8
+    63000n 0
+    63049n 0
+    63050n 1.8
+    63099n 1.8
+    63100n 0
+    63149n 0
+    63150n 1.8
+    63199n 1.8
+    63200n 0
+    63249n 0
+    63250n 1.8
+    63299n 1.8
+    63300n 0
+    63349n 0
+    63350n 1.8
+    63399n 1.8
+    63400n 0
+    63449n 0
+    63450n 1.8
+    63499n 1.8
+    63500n 0
+    63549n 0
+    63550n 1.8
+    63599n 1.8
+    63600n 0
+    63649n 0
+    63650n 1.8
+    63699n 1.8
+    63700n 0
+    63749n 0
+    63750n 1.8
+    63799n 1.8
+    63800n 0
+    63849n 0
+    63850n 1.8
+    63899n 1.8
+    63900n 0
+    63949n 0
+    63950n 1.8
+    63999n 1.8
+    64000n 0
+    64049n 0
+    64050n 1.8
+    64099n 1.8
+    64100n 0
+    64149n 0
+    64150n 1.8
+    64199n 1.8
+    64200n 0
+    64249n 0
+    64250n 1.8
+    64299n 1.8
+    64300n 0
+    64349n 0
+    64350n 1.8
+    64399n 1.8
+    64400n 0
+    64449n 0
+    64450n 1.8
+    64499n 1.8
+    64500n 0
+    64549n 0
+    64550n 1.8
+    64599n 1.8
+    64600n 0
+    64649n 0
+    64650n 1.8
+    64699n 1.8
+    64700n 0
+    64749n 0
+    64750n 1.8
+    64799n 1.8
+    64800n 0
+    64849n 0
+    64850n 1.8
+    64899n 1.8
+    64900n 0
+    64949n 0
+    64950n 1.8
+    64999n 1.8
+    65000n 0
+    65049n 0
+    65050n 1.8
+    65099n 1.8
+    65100n 0
+    65149n 0
+    65150n 1.8
+    65199n 1.8
+    65200n 0
+    65249n 0
+    65250n 1.8
+    65299n 1.8
+    65300n 0
+    65349n 0
+    65350n 1.8
+    65399n 1.8
+    65400n 0
+    65449n 0
+    65450n 1.8
+    65499n 1.8
+    65500n 0
+    65549n 0
+    65550n 1.8
+    65599n 1.8
+    65600n 0
+    65649n 0
+    65650n 1.8
+    65699n 1.8
+    65700n 0
+    65749n 0
+    65750n 1.8
+    65799n 1.8
+    65800n 0
+    65849n 0
+    65850n 1.8
+    65899n 1.8
+    65900n 0
+    65949n 0
+    65950n 1.8
+    65999n 1.8
+    66000n 0
+    66049n 0
+    66050n 1.8
+    66099n 1.8
+    66100n 0
+    66149n 0
+    66150n 1.8
+    66199n 1.8
+    66200n 0
+    66249n 0
+    66250n 1.8
+    66299n 1.8
+    66300n 0
+    66349n 0
+    66350n 1.8
+    66399n 1.8
+    66400n 0
+    66449n 0
+    66450n 1.8
+    66499n 1.8
+    66500n 0
+    66549n 0
+    66550n 1.8
+    66599n 1.8
+    66600n 0
+    66649n 0
+    66650n 1.8
+    66699n 1.8
+    66700n 0
+    66749n 0
+    66750n 1.8
+    66799n 1.8
+    66800n 0
+    66849n 0
+    66850n 1.8
+    66899n 1.8
+    66900n 0
+    66949n 0
+    66950n 1.8
+    66999n 1.8
+    67000n 0
+    67049n 0
+    67050n 1.8
+    67099n 1.8
+    67100n 0
+    67149n 0
+    67150n 1.8
+    67199n 1.8
+    67200n 0
+    67249n 0
+    67250n 1.8
+    67299n 1.8
+    67300n 0
+    67349n 0
+    67350n 1.8
+    67399n 1.8
+    67400n 0
+    67449n 0
+    67450n 1.8
+    67499n 1.8
+    67500n 0
+    67549n 0
+    67550n 1.8
+    67599n 1.8
+    67600n 0
+    67649n 0
+    67650n 1.8
+    67699n 1.8
+    67700n 0
+    67749n 0
+    67750n 1.8
+    67799n 1.8
+    67800n 0
+    67849n 0
+    67850n 1.8
+    67899n 1.8
+    67900n 0
+    67949n 0
+    67950n 1.8
+    67999n 1.8
+    68000n 0
+    68049n 0
+    68050n 1.8
+    68099n 1.8
+    68100n 0
+    68149n 0
+    68150n 1.8
+    68199n 1.8
+    68200n 0
+    68249n 0
+    68250n 1.8
+    68299n 1.8
+    68300n 0
+    68349n 0
+    68350n 1.8
+    68399n 1.8
+    68400n 0
+    68449n 0
+    68450n 1.8
+    68499n 1.8
+    68500n 0
+    68549n 0
+    68550n 1.8
+    68599n 1.8
+    68600n 0
+    68649n 0
+    68650n 1.8
+    68699n 1.8
+    68700n 0
+    68749n 0
+    68750n 1.8
+    68799n 1.8
+    68800n 0
+    68849n 0
+    68850n 1.8
+    68899n 1.8
+    68900n 0
+    68949n 0
+    68950n 1.8
+    68999n 1.8
+    69000n 0
+    69049n 0
+    69050n 1.8
+    69099n 1.8
+    69100n 0
+    69149n 0
+    69150n 1.8
+    69199n 1.8
+    69200n 0
+    69249n 0
+    69250n 1.8
+    69299n 1.8
+    69300n 0
+    69349n 0
+    69350n 1.8
+    69399n 1.8
+    69400n 0
+    69449n 0
+    69450n 1.8
+    69499n 1.8
+    69500n 0
+    69549n 0
+    69550n 1.8
+    69599n 1.8
+    69600n 0
+    69649n 0
+    69650n 1.8
+    69699n 1.8
+    69700n 0
+    69749n 0
+    69750n 1.8
+    69799n 1.8
+    69800n 0
+    69849n 0
+    69850n 1.8
+    69899n 1.8
+    69900n 0
+    69949n 0
+    69950n 1.8
+    69999n 1.8
+    70000n 0
+    70049n 0
+    70050n 1.8
+    70099n 1.8
+    70100n 0
+    70149n 0
+    70150n 1.8
+    70199n 1.8
+    70200n 0
+    70249n 0
+    70250n 1.8
+    70299n 1.8
+    70300n 0
+    70349n 0
+    70350n 1.8
+    70399n 1.8
+    70400n 0
+    70449n 0
+    70450n 1.8
+    70499n 1.8
+    70500n 0
+    70549n 0
+    70550n 1.8
+    70599n 1.8
+    70600n 0
+    70649n 0
+    70650n 1.8
+    70699n 1.8
+    70700n 0
+    70749n 0
+    70750n 1.8
+    70799n 1.8
+    70800n 0
+    70849n 0
+    70850n 1.8
+    70899n 1.8
+    70900n 0
+    70949n 0
+    70950n 1.8
+    70999n 1.8
+    71000n 0
+    71049n 0
+    71050n 1.8
+    71099n 1.8
+    71100n 0
+    71149n 0
+    71150n 1.8
+    71199n 1.8
+    71200n 0
+    71249n 0
+    71250n 1.8
+    71299n 1.8
+    71300n 0
+    71349n 0
+    71350n 1.8
+    71399n 1.8
+    71400n 0
+    71449n 0
+    71450n 1.8
+    71499n 1.8
+    71500n 0
+    71549n 0
+    71550n 1.8
+    71599n 1.8
+    71600n 0
+    71649n 0
+    71650n 1.8
+    71699n 1.8
+    71700n 0
+    71749n 0
+    71750n 1.8
+    71799n 1.8
+    71800n 0
+    71849n 0
+    71850n 1.8
+    71899n 1.8
+    71900n 0
+    71949n 0
+    71950n 1.8
+    71999n 1.8
+    72000n 0
+    72049n 0
+    72050n 1.8
+    72099n 1.8
+    72100n 0
+    72149n 0
+    72150n 1.8
+    72199n 1.8
+    72200n 0
+    72249n 0
+    72250n 1.8
+    72299n 1.8
+    72300n 0
+    72349n 0
+    72350n 1.8
+    72399n 1.8
+    72400n 0
+    72449n 0
+    72450n 1.8
+    72499n 1.8
+    72500n 0
+    72549n 0
+    72550n 1.8
+    72599n 1.8
+    72600n 0
+    72649n 0
+    72650n 1.8
+    72699n 1.8
+    72700n 0
+    72749n 0
+    72750n 1.8
+    72799n 1.8
+    72800n 0
+    72849n 0
+    72850n 1.8
+    72899n 1.8
+    72900n 0
+    72949n 0
+    72950n 1.8
+    72999n 1.8
+    73000n 0
+    73049n 0
+    73050n 1.8
+    73099n 1.8
+    73100n 0
+    73149n 0
+    73150n 1.8
+    73199n 1.8
+    73200n 0
+    73249n 0
+    73250n 1.8
+    73299n 1.8
+    73300n 0
+    73349n 0
+    73350n 1.8
+    73399n 1.8
+    73400n 0
+    73449n 0
+    73450n 1.8
+    73499n 1.8
+    73500n 0
+    73549n 0
+    73550n 1.8
+    73599n 1.8
+    73600n 0
+    73649n 0
+    73650n 1.8
+    73699n 1.8
+    73700n 0
+    73749n 0
+    73750n 1.8
+    73799n 1.8
+    73800n 0
+    73849n 0
+    73850n 1.8
+    73899n 1.8
+    73900n 0
+    73949n 0
+    73950n 1.8
+    73999n 1.8
+    74000n 0
+    74049n 0
+    74050n 1.8
+    74099n 1.8
+    74100n 0
+    74149n 0
+    74150n 1.8
+    74199n 1.8
+    74200n 0
+    74249n 0
+    74250n 1.8
+    74299n 1.8
+    74300n 0
+    74349n 0
+    74350n 1.8
+    74399n 1.8
+    74400n 0
+    74449n 0
+    74450n 1.8
+    74499n 1.8
+    74500n 0
+    74549n 0
+    74550n 1.8
+    74599n 1.8
+    74600n 0
+    74649n 0
+    74650n 1.8
+    74699n 1.8
+    74700n 0
+    74749n 0
+    74750n 1.8
+    74799n 1.8
+    74800n 0
+    74849n 0
+    74850n 1.8
+    74899n 1.8
+    74900n 0
+    74949n 0
+    74950n 1.8
+    74999n 1.8
+    75000n 0
+    75049n 0
+    75050n 1.8
+    75099n 1.8
+    75100n 0
+    75149n 0
+    75150n 1.8
+    75199n 1.8
+    75200n 0
+    75249n 0
+    75250n 1.8
+    75299n 1.8
+    75300n 0
+    75349n 0
+    75350n 1.8
+    75399n 1.8
+    75400n 0
+    75449n 0
+    75450n 1.8
+    75499n 1.8
+    75500n 0
+    75549n 0
+    75550n 1.8
+    75599n 1.8
+    75600n 0
+    75649n 0
+    75650n 1.8
+    75699n 1.8
+    75700n 0
+    75749n 0
+    75750n 1.8
+    75799n 1.8
+    75800n 0
+    75849n 0
+    75850n 1.8
+    75899n 1.8
+    75900n 0
+    75949n 0
+    75950n 1.8
+    75999n 1.8
+    76000n 0
+    76049n 0
+    76050n 1.8
+    76099n 1.8
+    76100n 0
+    76149n 0
+    76150n 1.8
+    76199n 1.8
+    76200n 0
+    76249n 0
+    76250n 1.8
+    76299n 1.8
+    76300n 0
+    76349n 0
+    76350n 1.8
+    76399n 1.8
+    76400n 0
+    76449n 0
+    76450n 1.8
+    76499n 1.8
+    76500n 0
+    76549n 0
+    76550n 1.8
+    76599n 1.8
+    76600n 0
+    76649n 0
+    76650n 1.8
+    76699n 1.8
+    76700n 0
+    76749n 0
+    76750n 1.8
+    76799n 1.8
+    76800n 0
+    76849n 0
+    76850n 1.8
+    76899n 1.8
+    76900n 0
+    76949n 0
+    76950n 1.8
+    76999n 1.8
+    77000n 0
+    77049n 0
+    77050n 1.8
+    77099n 1.8
+    77100n 0
+    77149n 0
+    77150n 1.8
+    77199n 1.8
+    77200n 0
+    77249n 0
+    77250n 1.8
+    77299n 1.8
+    77300n 0
+    77349n 0
+    77350n 1.8
+    77399n 1.8
+    77400n 0
+    77449n 0
+    77450n 1.8
+    77499n 1.8
+    77500n 0
+    77549n 0
+    77550n 1.8
+    77599n 1.8
+    77600n 0
+    77649n 0
+    77650n 1.8
+    77699n 1.8
+    77700n 0
+    77749n 0
+    77750n 1.8
+    77799n 1.8
+    77800n 0
+    77849n 0
+    77850n 1.8
+    77899n 1.8
+    77900n 0
+    77949n 0
+    77950n 1.8
+    77999n 1.8
+    78000n 0
+    78049n 0
+    78050n 1.8
+    78099n 1.8
+    78100n 0
+    78149n 0
+    78150n 1.8
+    78199n 1.8
+    78200n 0
+    78249n 0
+    78250n 1.8
+    78299n 1.8
+    78300n 0
+    78349n 0
+    78350n 1.8
+    78399n 1.8
+    78400n 0
+    78449n 0
+    78450n 1.8
+    78499n 1.8
+    78500n 0
+    78549n 0
+    78550n 1.8
+    78599n 1.8
+    78600n 0
+    78649n 0
+    78650n 1.8
+    78699n 1.8
+    78700n 0
+    78749n 0
+    78750n 1.8
+    78799n 1.8
+    78800n 0
+    78849n 0
+    78850n 1.8
+    78899n 1.8
+    78900n 0
+    78949n 0
+    78950n 1.8
+    78999n 1.8
+    79000n 0
+    79049n 0
+    79050n 1.8
+    79099n 1.8
+    79100n 0
+    79149n 0
+    79150n 1.8
+    79199n 1.8
+    79200n 0
+    79249n 0
+    79250n 1.8
+    79299n 1.8
+    79300n 0
+    79349n 0
+    79350n 1.8
+    79399n 1.8
+    79400n 0
+    79449n 0
+    79450n 1.8
+    79499n 1.8
+    79500n 0
+    79549n 0
+    79550n 1.8
+    79599n 1.8
+    79600n 0
+    79649n 0
+    79650n 1.8
+    79699n 1.8
+    79700n 0
+    79749n 0
+    79750n 1.8
+    79799n 1.8
+    79800n 0
+    79849n 0
+    79850n 1.8
+    79899n 1.8
+    79900n 0
+    79949n 0
+    79950n 1.8
+    79999n 1.8
+    80000n 0
+    80049n 0
+    80050n 1.8
+    80099n 1.8
+    80100n 0
+    80149n 0
+    80150n 1.8
+    80199n 1.8
+    80200n 0
+    80249n 0
+    80250n 1.8
+    80299n 1.8
+    80300n 0
+    80349n 0
+    80350n 1.8
+    80399n 1.8
+    80400n 0
+    80449n 0
+    80450n 1.8
+    80499n 1.8
+    80500n 0
+    80549n 0
+    80550n 1.8
+    80599n 1.8
+    80600n 0
+    80649n 0
+    80650n 1.8
+    80699n 1.8
+    80700n 0
+    80749n 0
+    80750n 1.8
+    80799n 1.8
+    80800n 0
+    80849n 0
+    80850n 1.8
+    80899n 1.8
+    80900n 0
+    80949n 0
+    80950n 1.8
+    80999n 1.8
+    81000n 0
+    81049n 0
+    81050n 1.8
+    81099n 1.8
+    81100n 0
+    81149n 0
+    81150n 1.8
+    81199n 1.8
+    81200n 0
+    81249n 0
+    81250n 1.8
+    81299n 1.8
+    81300n 0
+    81349n 0
+    81350n 1.8
+    81399n 1.8
+    81400n 0
+    81449n 0
+    81450n 1.8
+    81499n 1.8
+    81500n 0
+    81549n 0
+    81550n 1.8
+    81599n 1.8
+    81600n 0
+    81649n 0
+    81650n 1.8
+    81699n 1.8
+    81700n 0
+    81749n 0
+    81750n 1.8
+    81799n 1.8
+    81800n 0
+    81849n 0
+    81850n 1.8
+    81899n 1.8
+    81900n 0
+    81949n 0
+    81950n 1.8
+    81999n 1.8
+    82000n 0
+    82049n 0
+    82050n 1.8
+    82099n 1.8
+    82100n 0
+    82149n 0
+    82150n 1.8
+    82199n 1.8
+    82200n 0
+    82249n 0
+    82250n 1.8
+    82299n 1.8
+    82300n 0
+    82349n 0
+    82350n 1.8
+    82399n 1.8
+    82400n 0
+    82449n 0
+    82450n 1.8
+    82499n 1.8
+    82500n 0
+    82549n 0
+    82550n 1.8
+    82599n 1.8
+    82600n 0
+    82649n 0
+    82650n 1.8
+    82699n 1.8
+    82700n 0
+    82749n 0
+    82750n 1.8
+    82799n 1.8
+    82800n 0
+    82849n 0
+    82850n 1.8
+    82899n 1.8
+    82900n 0
+    82949n 0
+    82950n 1.8
+    82999n 1.8
+    83000n 0
+    83049n 0
+    83050n 1.8
+    83099n 1.8
+    83100n 0
+    83149n 0
+    83150n 1.8
+    83199n 1.8
+    83200n 0
+    83249n 0
+    83250n 1.8
+    83299n 1.8
+    83300n 0
+    83349n 0
+    83350n 1.8
+    83399n 1.8
+    83400n 0
+    83449n 0
+    83450n 1.8
+    83499n 1.8
+    83500n 0
+    83549n 0
+    83550n 1.8
+    83599n 1.8
+    83600n 0
+    83649n 0
+    83650n 1.8
+    83699n 1.8
+    83700n 0
+    83749n 0
+    83750n 1.8
+    83799n 1.8
+    83800n 0
+    83849n 0
+    83850n 1.8
+    83899n 1.8
+    83900n 0
+    83949n 0
+    83950n 1.8
+    83999n 1.8
+    84000n 0
+    84049n 0
+    84050n 1.8
+    84099n 1.8
+    84100n 0
+    84149n 0
+    84150n 1.8
+    84199n 1.8
+    84200n 0
+    84249n 0
+    84250n 1.8
+    84299n 1.8
+    84300n 0
+    84349n 0
+    84350n 1.8
+    84399n 1.8
+    84400n 0
+    84449n 0
+    84450n 1.8
+    84499n 1.8
+    84500n 0
+    84549n 0
+    84550n 1.8
+    84599n 1.8
+    84600n 0
+    84649n 0
+    84650n 1.8
+    84699n 1.8
+    84700n 0
+    84749n 0
+    84750n 1.8
+    84799n 1.8
+    84800n 0
+    84849n 0
+    84850n 1.8
+    84899n 1.8
+    84900n 0
+    84949n 0
+    84950n 1.8
+    84999n 1.8
+    85000n 0
+    85049n 0
+    85050n 1.8
+    85099n 1.8
+    85100n 0
+    85149n 0
+    85150n 1.8
+    85199n 1.8
+    85200n 0
+    85249n 0
+    85250n 1.8
+    85299n 1.8
+    85300n 0
+    85349n 0
+    85350n 1.8
+    85399n 1.8
+    85400n 0
+    85449n 0
+    85450n 1.8
+    85499n 1.8
+    85500n 0
+    85549n 0
+    85550n 1.8
+    85599n 1.8
+    85600n 0
+    85649n 0
+    85650n 1.8
+    85699n 1.8
+    85700n 0
+    85749n 0
+    85750n 1.8
+    85799n 1.8
+    85800n 0
+    85849n 0
+    85850n 1.8
+    85899n 1.8
+    85900n 0
+    85949n 0
+    85950n 1.8
+    85999n 1.8
+    86000n 0
+    86049n 0
+    86050n 1.8
+    86099n 1.8
+    86100n 0
+    86149n 0
+    86150n 1.8
+    86199n 1.8
+    86200n 0
+    86249n 0
+    86250n 1.8
+    86299n 1.8
+    86300n 0
+    86349n 0
+    86350n 1.8
+    86399n 1.8
+    86400n 0
+    86449n 0
+    86450n 1.8
+    86499n 1.8
+    86500n 0
+    86549n 0
+    86550n 1.8
+    86599n 1.8
+    86600n 0
+    86649n 0
+    86650n 1.8
+    86699n 1.8
+    86700n 0
+    86749n 0
+    86750n 1.8
+    86799n 1.8
+    86800n 0
+    86849n 0
+    86850n 1.8
+    86899n 1.8
+    86900n 0
+    86949n 0
+    86950n 1.8
+    86999n 1.8
+    87000n 0
+    87049n 0
+    87050n 1.8
+    87099n 1.8
+    87100n 0
+    87149n 0
+    87150n 1.8
+    87199n 1.8
+    87200n 0
+    87249n 0
+    87250n 1.8
+    87299n 1.8
+    87300n 0
+    87349n 0
+    87350n 1.8
+    87399n 1.8
+    87400n 0
+    87449n 0
+    87450n 1.8
+    87499n 1.8
+    87500n 0
+    87549n 0
+    87550n 1.8
+    87599n 1.8
+    87600n 0
+    87649n 0
+    87650n 1.8
+    87699n 1.8
+    87700n 0
+    87749n 0
+    87750n 1.8
+    87799n 1.8
+    87800n 0
+    87849n 0
+    87850n 1.8
+    87899n 1.8
+    87900n 0
+    87949n 0
+    87950n 1.8
+    87999n 1.8
+    88000n 0
+    88049n 0
+    88050n 1.8
+    88099n 1.8
+    88100n 0
+    88149n 0
+    88150n 1.8
+    88199n 1.8
+    88200n 0
+    88249n 0
+    88250n 1.8
+    88299n 1.8
+    88300n 0
+    88349n 0
+    88350n 1.8
+    88399n 1.8
+    88400n 0
+    88449n 0
+    88450n 1.8
+    88499n 1.8
+    88500n 0
+    88549n 0
+    88550n 1.8
+    88599n 1.8
+    88600n 0
+    88649n 0
+    88650n 1.8
+    88699n 1.8
+    88700n 0
+    88749n 0
+    88750n 1.8
+    88799n 1.8
+    88800n 0
+    88849n 0
+    88850n 1.8
+    88899n 1.8
+    88900n 0
+    88949n 0
+    88950n 1.8
+    88999n 1.8
+    89000n 0
+    89049n 0
+    89050n 1.8
+    89099n 1.8
+    89100n 0
+    89149n 0
+    89150n 1.8
+    89199n 1.8
+    89200n 0
+    89249n 0
+    89250n 1.8
+    89299n 1.8
+    89300n 0
+    89349n 0
+    89350n 1.8
+    89399n 1.8
+    89400n 0
+    89449n 0
+    89450n 1.8
+    89499n 1.8
+    89500n 0
+    89549n 0
+    89550n 1.8
+    89599n 1.8
+    89600n 0
+    89649n 0
+    89650n 1.8
+    89699n 1.8
+    89700n 0
+    89749n 0
+    89750n 1.8
+    89799n 1.8
+    89800n 0
+    89849n 0
+    89850n 1.8
+    89899n 1.8
+    89900n 0
+    89949n 0
+    89950n 1.8
+    89999n 1.8
+    90000n 0
+    90049n 0
+    90050n 1.8
+    90099n 1.8
+    90100n 0
+    90149n 0
+    90150n 1.8
+    90199n 1.8
+    90200n 0
+    90249n 0
+    90250n 1.8
+    90299n 1.8
+    90300n 0
+    90349n 0
+    90350n 1.8
+    90399n 1.8
+    90400n 0
+    90449n 0
+    90450n 1.8
+    90499n 1.8
+    90500n 0
+    90549n 0
+    90550n 1.8
+    90599n 1.8
+    90600n 0
+    90649n 0
+    90650n 1.8
+    90699n 1.8
+    90700n 0
+    90749n 0
+    90750n 1.8
+    90799n 1.8
+    90800n 0
+    90849n 0
+    90850n 1.8
+    90899n 1.8
+    90900n 0
+    90949n 0
+    90950n 1.8
+    90999n 1.8
+    91000n 0
+    91049n 0
+    91050n 1.8
+    91099n 1.8
+    91100n 0
+    91149n 0
+    91150n 1.8
+    91199n 1.8
+    91200n 0
+    91249n 0
+    91250n 1.8
+    91299n 1.8
+    91300n 0
+    91349n 0
+    91350n 1.8
+    91399n 1.8
+    91400n 0
+    91449n 0
+    91450n 1.8
+    91499n 1.8
+    91500n 0
+    91549n 0
+    91550n 1.8
+    91599n 1.8
+    91600n 0
+    91649n 0
+    91650n 1.8
+    91699n 1.8
+    91700n 0
+    91749n 0
+    91750n 1.8
+    91799n 1.8
+    91800n 0
+    91849n 0
+    91850n 1.8
+    91899n 1.8
+    91900n 0
+    91949n 0
+    91950n 1.8
+    91999n 1.8
+    92000n 0
+    92049n 0
+    92050n 1.8
+    92099n 1.8
+    92100n 0
+    92149n 0
+    92150n 1.8
+    92199n 1.8
+    92200n 0
+    92249n 0
+    92250n 1.8
+    92299n 1.8
+    92300n 0
+    92349n 0
+    92350n 1.8
+    92399n 1.8
+    92400n 0
+    92449n 0
+    92450n 1.8
+    92499n 1.8
+    92500n 0
+    92549n 0
+    92550n 1.8
+    92599n 1.8
+    92600n 0
+    92649n 0
+    92650n 1.8
+    92699n 1.8
+    92700n 0
+    92749n 0
+    92750n 1.8
+    92799n 1.8
+    92800n 0
+    92849n 0
+    92850n 1.8
+    92899n 1.8
+    92900n 0
+    92949n 0
+    92950n 1.8
+    92999n 1.8
+    93000n 0
+    93049n 0
+    93050n 1.8
+    93099n 1.8
+    93100n 0
+    93149n 0
+    93150n 1.8
+    93199n 1.8
+    93200n 0
+    93249n 0
+    93250n 1.8
+    93299n 1.8
+    93300n 0
+    93349n 0
+    93350n 1.8
+    93399n 1.8
+    93400n 0
+    93449n 0
+    93450n 1.8
+    93499n 1.8
+    93500n 0
+    93549n 0
+    93550n 1.8
+    93599n 1.8
+    93600n 0
+    93649n 0
+    93650n 1.8
+    93699n 1.8
+    93700n 0
+    93749n 0
+    93750n 1.8
+    93799n 1.8
+    93800n 0
+    93849n 0
+    93850n 1.8
+    93899n 1.8
+    93900n 0
+    93949n 0
+    93950n 1.8
+    93999n 1.8
+    94000n 0
+    94049n 0
+    94050n 1.8
+    94099n 1.8
+    94100n 0
+    94149n 0
+    94150n 1.8
+    94199n 1.8
+    94200n 0
+    94249n 0
+    94250n 1.8
+    94299n 1.8
+    94300n 0
+    94349n 0
+    94350n 1.8
+    94399n 1.8
+    94400n 0
+    94449n 0
+    94450n 1.8
+    94499n 1.8
+    94500n 0
+    94549n 0
+    94550n 1.8
+    94599n 1.8
+    94600n 0
+    94649n 0
+    94650n 1.8
+    94699n 1.8
+    94700n 0
+    94749n 0
+    94750n 1.8
+    94799n 1.8
+    94800n 0
+    94849n 0
+    94850n 1.8
+    94899n 1.8
+    94900n 0
+    94949n 0
+    94950n 1.8
+    94999n 1.8
+    95000n 0
+    95049n 0
+    95050n 1.8
+    95099n 1.8
+    95100n 0
+    95149n 0
+    95150n 1.8
+    95199n 1.8
+    95200n 0
+    95249n 0
+    95250n 1.8
+    95299n 1.8
+    95300n 0
+    95349n 0
+    95350n 1.8
+    95399n 1.8
+    95400n 0
+    95449n 0
+    95450n 1.8
+    95499n 1.8
+    95500n 0
+    95549n 0
+    95550n 1.8
+    95599n 1.8
+    95600n 0
+    95649n 0
+    95650n 1.8
+    95699n 1.8
+    95700n 0
+    95749n 0
+    95750n 1.8
+    95799n 1.8
+    95800n 0
+    95849n 0
+    95850n 1.8
+    95899n 1.8
+    95900n 0
+    95949n 0
+    95950n 1.8
+    95999n 1.8
+    96000n 0
+    96049n 0
+    96050n 1.8
+    96099n 1.8
+    96100n 0
+    96149n 0
+    96150n 1.8
+    96199n 1.8
+    96200n 0
+    96249n 0
+    96250n 1.8
+    96299n 1.8
+    96300n 0
+    96349n 0
+    96350n 1.8
+    96399n 1.8
+    96400n 0
+    96449n 0
+    96450n 1.8
+    96499n 1.8
+    96500n 0
+    96549n 0
+    96550n 1.8
+    96599n 1.8
+    96600n 0
+    96649n 0
+    96650n 1.8
+    96699n 1.8
+    96700n 0
+    96749n 0
+    96750n 1.8
+    96799n 1.8
+    96800n 0
+    96849n 0
+    96850n 1.8
+    96899n 1.8
+    96900n 0
+    96949n 0
+    96950n 1.8
+    96999n 1.8
+    97000n 0
+    97049n 0
+    97050n 1.8
+    97099n 1.8
+    97100n 0
+    97149n 0
+    97150n 1.8
+    97199n 1.8
+    97200n 0
+    97249n 0
+    97250n 1.8
+    97299n 1.8
+    97300n 0
+    97349n 0
+    97350n 1.8
+    97399n 1.8
+    97400n 0
+    97449n 0
+    97450n 1.8
+    97499n 1.8
+    97500n 0
+    97549n 0
+    97550n 1.8
+    97599n 1.8
+    97600n 0
+    97649n 0
+    97650n 1.8
+    97699n 1.8
+    97700n 0
+    97749n 0
+    97750n 1.8
+    97799n 1.8
+    97800n 0
+    97849n 0
+    97850n 1.8
+    97899n 1.8
+    97900n 0
+    97949n 0
+    97950n 1.8
+    97999n 1.8
+    98000n 0
+    98049n 0
+    98050n 1.8
+    98099n 1.8
+    98100n 0
+    98149n 0
+    98150n 1.8
+    98199n 1.8
+    98200n 0
+    98249n 0
+    98250n 1.8
+    98299n 1.8
+    98300n 0
+    98349n 0
+    98350n 1.8
+    98399n 1.8
+    98400n 0
+    98449n 0
+    98450n 1.8
+    98499n 1.8
+    98500n 0
+    98549n 0
+    98550n 1.8
+    98599n 1.8
+    98600n 0
+    98649n 0
+    98650n 1.8
+    98699n 1.8
+    98700n 0
+    98749n 0
+    98750n 1.8
+    98799n 1.8
+    98800n 0
+    98849n 0
+    98850n 1.8
+    98899n 1.8
+    98900n 0
+    98949n 0
+    98950n 1.8
+    98999n 1.8
+    99000n 0
+    99049n 0
+    99050n 1.8
+    99099n 1.8
+    99100n 0
+    99149n 0
+    99150n 1.8
+    99199n 1.8
+    99200n 0
+    99249n 0
+    99250n 1.8
+    99299n 1.8
+    99300n 0
+    99349n 0
+    99350n 1.8
+    99399n 1.8
+    99400n 0
+    99449n 0
+    99450n 1.8
+    99499n 1.8
+    99500n 0
+    99549n 0
+    99550n 1.8
+    99599n 1.8
+    99600n 0
+    99649n 0
+    99650n 1.8
+    99699n 1.8
+    99700n 0
+    99749n 0
+    99750n 1.8
+    99799n 1.8
+    99800n 0
+    99849n 0
+    99850n 1.8
+    99899n 1.8
+    99900n 0
+    99949n 0
+    99950n 1.8
+    99999n 1.8
+    100000n 0
+    100049n 0
+    100050n 1.8
+    100099n 1.8
+    100100n 0
+    100149n 0
+    100150n 1.8
+    100199n 1.8
+    100200n 0
+    100249n 0
+    100250n 1.8
+    100299n 1.8
+    100300n 0
+    100349n 0
+    100350n 1.8
+    100399n 1.8
+    100400n 0
+    100449n 0
+    100450n 1.8
+    100499n 1.8
+    100500n 0
+    100549n 0
+    100550n 1.8
+    100599n 1.8
+    100600n 0
+    100649n 0
+    100650n 1.8
+    100699n 1.8
+    100700n 0
+    100749n 0
+    100750n 1.8
+    100799n 1.8
+    100800n 0
+    100849n 0
+    100850n 1.8
+    100899n 1.8
+    100900n 0
+    100949n 0
+    100950n 1.8
+    100999n 1.8
+    101000n 0
+    101049n 0
+    101050n 1.8
+    101099n 1.8
+    101100n 0
+    101149n 0
+    101150n 1.8
+    101199n 1.8
+    101200n 0
+    101249n 0
+    101250n 1.8
+    101299n 1.8
+    101300n 0
+    101349n 0
+    101350n 1.8
+    101399n 1.8
+    101400n 0
+    101449n 0
+    101450n 1.8
+    101499n 1.8
+    101500n 0
+    101549n 0
+    101550n 1.8
+    101599n 1.8
+    101600n 0
+    101649n 0
+    101650n 1.8
+    101699n 1.8
+    101700n 0
+    101749n 0
+    101750n 1.8
+    101799n 1.8
+    101800n 0
+    101849n 0
+    101850n 1.8
+    101899n 1.8
+    101900n 0
+    101949n 0
+    101950n 1.8
+    101999n 1.8
+    102000n 0
+    102049n 0
+    102050n 1.8
+    102099n 1.8
+    102100n 0
+    102149n 0
+    102150n 1.8
+    102199n 1.8
+    102200n 0
+    102249n 0
+    102250n 1.8
+    102299n 1.8
+    102300n 0
+    102349n 0
+    102350n 1.8
+    102399n 1.8
+    102400n 0
+    102449n 0
+    102450n 1.8
+    102499n 1.8
+    102500n 0
+    102549n 0
+    102550n 1.8
+    102599n 1.8
+    102600n 0
+    102649n 0
+    102650n 1.8
+    102699n 1.8
+    102700n 0
+    102749n 0
+    102750n 1.8
+    102799n 1.8
+    102800n 0
+    102849n 0
+    102850n 1.8
+    102899n 1.8
+    102900n 0
+    102949n 0
+    102950n 1.8
+    102999n 1.8
+    103000n 0
+    103049n 0
+    103050n 1.8
+    103099n 1.8
+    103100n 0
+    103149n 0
+    103150n 1.8
+    103199n 1.8
+    103200n 0
+    103249n 0
+    103250n 1.8
+    103299n 1.8
+    103300n 0
+    103349n 0
+    103350n 1.8
+    103399n 1.8
+    103400n 0
+    103449n 0
+    103450n 1.8
+    103499n 1.8
+    103500n 0
+    103549n 0
+    103550n 1.8
+    103599n 1.8
+    103600n 0
+    103649n 0
+    103650n 1.8
+    103699n 1.8
+    103700n 0
+    103749n 0
+    103750n 1.8
+    103799n 1.8
+    103800n 0
+    103849n 0
+    103850n 1.8
+    103899n 1.8
+    103900n 0
+    103949n 0
+    103950n 1.8
+    103999n 1.8
+    104000n 0
+    104049n 0
+    104050n 1.8
+    104099n 1.8
+    104100n 0
+    104149n 0
+    104150n 1.8
+    104199n 1.8
+    104200n 0
+    104249n 0
+    104250n 1.8
+    104299n 1.8
+    104300n 0
+    104349n 0
+    104350n 1.8
+    104399n 1.8
+    104400n 0
+    104449n 0
+    104450n 1.8
+    104499n 1.8
+    104500n 0
+    104549n 0
+    104550n 1.8
+    104599n 1.8
+    104600n 0
+    104649n 0
+    104650n 1.8
+    104699n 1.8
+    104700n 0
+    104749n 0
+    104750n 1.8
+    104799n 1.8
+    104800n 0
+    104849n 0
+    104850n 1.8
+    104899n 1.8
+    104900n 0
+    104949n 0
+    104950n 1.8
+    104999n 1.8
+    105000n 0
+    105049n 0
+    105050n 1.8
+    105099n 1.8
+    105100n 0
+    105149n 0
+    105150n 1.8
+    105199n 1.8
+    105200n 0
+    105249n 0
+    105250n 1.8
+    105299n 1.8
+    105300n 0
+    105349n 0
+    105350n 1.8
+    105399n 1.8
+    105400n 0
+    105449n 0
+    105450n 1.8
+    105499n 1.8
+    105500n 0
+    105549n 0
+    105550n 1.8
+    105599n 1.8
+    105600n 0
+    105649n 0
+    105650n 1.8
+    105699n 1.8
+    105700n 0
+    105749n 0
+    105750n 1.8
+    105799n 1.8
+    105800n 0
+    105849n 0
+    105850n 1.8
+    105899n 1.8
+    105900n 0
+    105949n 0
+    105950n 1.8
+    105999n 1.8
+    106000n 0
+    106049n 0
+    106050n 1.8
+    106099n 1.8
+    106100n 0
+    106149n 0
+    106150n 1.8
+    106199n 1.8
+    106200n 0
+    106249n 0
+    106250n 1.8
+    106299n 1.8
+    106300n 0
+    106349n 0
+    106350n 1.8
+    106399n 1.8
+    106400n 0
+    106449n 0
+    106450n 1.8
+    106499n 1.8
+    106500n 0
+    106549n 0
+    106550n 1.8
+    106599n 1.8
+    106600n 0
+    106649n 0
+    106650n 1.8
+    106699n 1.8
+    106700n 0
+    106749n 0
+    106750n 1.8
+    106799n 1.8
+    106800n 0
+    106849n 0
+    106850n 1.8
+    106899n 1.8
+    106900n 0
+    106949n 0
+    106950n 1.8
+    106999n 1.8
+    107000n 0
+    107049n 0
+    107050n 1.8
+    107099n 1.8
+    107100n 0
+    107149n 0
+    107150n 1.8
+    107199n 1.8
+    107200n 0
+    107249n 0
+    107250n 1.8
+    107299n 1.8
+    107300n 0
+    107349n 0
+    107350n 1.8
+    107399n 1.8
+    107400n 0
+    107449n 0
+    107450n 1.8
+    107499n 1.8
+    107500n 0
+    107549n 0
+    107550n 1.8
+    107599n 1.8
+    107600n 0
+    107649n 0
+    107650n 1.8
+    107699n 1.8
+    107700n 0
+    107749n 0
+    107750n 1.8
+    107799n 1.8
+    107800n 0
+    107849n 0
+    107850n 1.8
+    107899n 1.8
+    107900n 0
+    107949n 0
+    107950n 1.8
+    107999n 1.8
+    108000n 0
+    108049n 0
+    108050n 1.8
+    108099n 1.8
+    108100n 0
+    108149n 0
+    108150n 1.8
+    108199n 1.8
+    108200n 0
+    108249n 0
+    108250n 1.8
+    108299n 1.8
+    108300n 0
+    108349n 0
+    108350n 1.8
+    108399n 1.8
+    108400n 0
+    108449n 0
+    108450n 1.8
+    108499n 1.8
+    108500n 0
+    108549n 0
+    108550n 1.8
+    108599n 1.8
+    108600n 0
+    108649n 0
+    108650n 1.8
+    108699n 1.8
+    108700n 0
+    108749n 0
+    108750n 1.8
+    108799n 1.8
+    108800n 0
+    108849n 0
+    108850n 1.8
+    108899n 1.8
+    108900n 0
+    108949n 0
+    108950n 1.8
+    108999n 1.8
+    109000n 0
+    109049n 0
+    109050n 1.8
+    109099n 1.8
+    109100n 0
+    109149n 0
+    109150n 1.8
+    109199n 1.8
+    109200n 0
+    109249n 0
+    109250n 1.8
+    109299n 1.8
+    109300n 0
+    109349n 0
+    109350n 1.8
+    109399n 1.8
+    109400n 0
+    109449n 0
+    109450n 1.8
+    109499n 1.8
+    109500n 0
+    109549n 0
+    109550n 1.8
+    109599n 1.8
+    109600n 0
+    109649n 0
+    109650n 1.8
+    109699n 1.8
+    109700n 0
+    109749n 0
+    109750n 1.8
+    109799n 1.8
+    109800n 0
+    109849n 0
+    109850n 1.8
+    109899n 1.8
+    109900n 0
+    109949n 0
+    109950n 1.8
+    109999n 1.8
+    110000n 0
+    110049n 0
+    110050n 1.8
+    110099n 1.8
+    110100n 0
+    110149n 0
+    110150n 1.8
+    110199n 1.8
+    110200n 0
+    110249n 0
+    110250n 1.8
+    110299n 1.8
+    110300n 0
+    110349n 0
+    110350n 1.8
+    110399n 1.8
+    110400n 0
+    110449n 0
+    110450n 1.8
+    110499n 1.8
+    110500n 0
+    110549n 0
+    110550n 1.8
+    110599n 1.8
+    110600n 0
+    110649n 0
+    110650n 1.8
+    110699n 1.8
+    110700n 0
+    110749n 0
+    110750n 1.8
+    110799n 1.8
+    110800n 0
+    110849n 0
+    110850n 1.8
+    110899n 1.8
+    110900n 0
+    110949n 0
+    110950n 1.8
+    110999n 1.8
+    111000n 0
+    111049n 0
+    111050n 1.8
+    111099n 1.8
+    111100n 0
+    111149n 0
+    111150n 1.8
+    111199n 1.8
+    111200n 0
+    111249n 0
+    111250n 1.8
+    111299n 1.8
+    111300n 0
+    111349n 0
+    111350n 1.8
+    111399n 1.8
+    111400n 0
+    111449n 0
+    111450n 1.8
+    111499n 1.8
+    111500n 0
+    111549n 0
+    111550n 1.8
+    111599n 1.8
+    111600n 0
+    111649n 0
+    111650n 1.8
+    111699n 1.8
+    111700n 0
+    111749n 0
+    111750n 1.8
+    111799n 1.8
+    111800n 0
+    111849n 0
+    111850n 1.8
+    111899n 1.8
+    111900n 0
+    111949n 0
+    111950n 1.8
+    111999n 1.8
+    112000n 0
+    112049n 0
+    112050n 1.8
+    112099n 1.8
+    112100n 0
+    112149n 0
+    112150n 1.8
+    112199n 1.8
+    112200n 0
+    112249n 0
+    112250n 1.8
+    112299n 1.8
+    112300n 0
+    112349n 0
+    112350n 1.8
+    112399n 1.8
+    112400n 0
+    112449n 0
+    112450n 1.8
+    112499n 1.8
+    112500n 0
+    112549n 0
+    112550n 1.8
+    112599n 1.8
+    112600n 0
+    112649n 0
+    112650n 1.8
+    112699n 1.8
+    112700n 0
+    112749n 0
+    112750n 1.8
+    112799n 1.8
+    112800n 0
+    112849n 0
+    112850n 1.8
+    112899n 1.8
+    112900n 0
+    112949n 0
+    112950n 1.8
+    112999n 1.8
+    113000n 0
+    113049n 0
+    113050n 1.8
+    113099n 1.8
+    113100n 0
+    113149n 0
+    113150n 1.8
+    113199n 1.8
+    113200n 0
+    113249n 0
+    113250n 1.8
+    113299n 1.8
+    113300n 0
+    113349n 0
+    113350n 1.8
+    113399n 1.8
+    113400n 0
+    113449n 0
+    113450n 1.8
+    113499n 1.8
+    113500n 0
+    113549n 0
+    113550n 1.8
+    113599n 1.8
+    113600n 0
+    113649n 0
+    113650n 1.8
+    113699n 1.8
+    113700n 0
+    113749n 0
+    113750n 1.8
+    113799n 1.8
+    113800n 0
+    113849n 0
+    113850n 1.8
+    113899n 1.8
+    113900n 0
+    113949n 0
+    113950n 1.8
+    113999n 1.8
+    114000n 0
+    114049n 0
+    114050n 1.8
+    114099n 1.8
+    114100n 0
+    114149n 0
+    114150n 1.8
+    114199n 1.8
+    114200n 0
+    114249n 0
+    114250n 1.8
+    114299n 1.8
+    114300n 0
+    114349n 0
+    114350n 1.8
+    114399n 1.8
+    114400n 0
+    114449n 0
+    114450n 1.8
+    114499n 1.8
+    114500n 0
+    114549n 0
+    114550n 1.8
+    114599n 1.8
+    114600n 0
+    114649n 0
+    114650n 1.8
+    114699n 1.8
+    114700n 0
+    114749n 0
+    114750n 1.8
+    114799n 1.8
+    114800n 0
+    114849n 0
+    114850n 1.8
+    114899n 1.8
+    114900n 0
+    114949n 0
+    114950n 1.8
+    114999n 1.8
+    115000n 0
+    115049n 0
+    115050n 1.8
+    115099n 1.8
+    115100n 0
+    115149n 0
+    115150n 1.8
+    115199n 1.8
+    115200n 0
+    115249n 0
+    115250n 1.8
+    115299n 1.8
+    115300n 0
+    115349n 0
+    115350n 1.8
+    115399n 1.8
+    115400n 0
+    115449n 0
+    115450n 1.8
+    115499n 1.8
+    115500n 0
+    115549n 0
+    115550n 1.8
+    115599n 1.8
+    115600n 0
+    115649n 0
+    115650n 1.8
+    115699n 1.8
+    115700n 0
+    115749n 0
+    115750n 1.8
+    115799n 1.8
+    115800n 0
+    115849n 0
+    115850n 1.8
+    115899n 1.8
+    115900n 0
+    115949n 0
+    115950n 1.8
+    115999n 1.8
+    116000n 0
+    116049n 0
+    116050n 1.8
+    116099n 1.8
+    116100n 0
+    116149n 0
+    116150n 1.8
+    116199n 1.8
+    116200n 0
+    116249n 0
+    116250n 1.8
+    116299n 1.8
+    116300n 0
+    116349n 0
+    116350n 1.8
+    116399n 1.8
+    116400n 0
+    116449n 0
+    116450n 1.8
+    116499n 1.8
+    116500n 0
+    116549n 0
+    116550n 1.8
+    116599n 1.8
+    116600n 0
+    116649n 0
+    116650n 1.8
+    116699n 1.8
+    116700n 0
+    116749n 0
+    116750n 1.8
+    116799n 1.8
+    116800n 0
+    116849n 0
+    116850n 1.8
+    116899n 1.8
+    116900n 0
+    116949n 0
+    116950n 1.8
+    116999n 1.8
+    117000n 0
+    117049n 0
+    117050n 1.8
+    117099n 1.8
+    117100n 0
+    117149n 0
+    117150n 1.8
+    117199n 1.8
+    117200n 0
+    117249n 0
+    117250n 1.8
+    117299n 1.8
+    117300n 0
+    117349n 0
+    117350n 1.8
+    117399n 1.8
+    117400n 0
+    117449n 0
+    117450n 1.8
+    117499n 1.8
+    117500n 0
+    117549n 0
+    117550n 1.8
+    117599n 1.8
+    117600n 0
+    117649n 0
+    117650n 1.8
+    117699n 1.8
+    117700n 0
+    117749n 0
+    117750n 1.8
+    117799n 1.8
+    117800n 0
+    117849n 0
+    117850n 1.8
+    117899n 1.8
+    117900n 0
+    117949n 0
+    117950n 1.8
+    117999n 1.8
+    118000n 0
+    118049n 0
+    118050n 1.8
+    118099n 1.8
+    118100n 0
+    118149n 0
+    118150n 1.8
+    118199n 1.8
+    118200n 0
+    118249n 0
+    118250n 1.8
+    118299n 1.8
+    118300n 0
+    118349n 0
+    118350n 1.8
+    118399n 1.8
+    118400n 0
+    118449n 0
+    118450n 1.8
+    118499n 1.8
+    118500n 0
+    118549n 0
+    118550n 1.8
+    118599n 1.8
+    118600n 0
+    118649n 0
+    118650n 1.8
+    118699n 1.8
+    118700n 0
+    118749n 0
+    118750n 1.8
+    118799n 1.8
+    118800n 0
+    118849n 0
+    118850n 1.8
+    118899n 1.8
+    118900n 0
+    118949n 0
+    118950n 1.8
+    118999n 1.8
+    119000n 0
+    119049n 0
+    119050n 1.8
+    119099n 1.8
+    119100n 0
+    119149n 0
+    119150n 1.8
+    119199n 1.8
+    119200n 0
+    119249n 0
+    119250n 1.8
+    119299n 1.8
+    119300n 0
+    119349n 0
+    119350n 1.8
+    119399n 1.8
+    119400n 0
+    119449n 0
+    119450n 1.8
+    119499n 1.8
+    119500n 0
+    119549n 0
+    119550n 1.8
+    119599n 1.8
+    119600n 0
+    119649n 0
+    119650n 1.8
+    119699n 1.8
+    119700n 0
+    119749n 0
+    119750n 1.8
+    119799n 1.8
+    119800n 0
+    119849n 0
+    119850n 1.8
+    119899n 1.8
+    119900n 0
+    119949n 0
+    119950n 1.8
+    119999n 1.8
+    120000n 0
+    120049n 0
+    120050n 1.8
+    120099n 1.8
+    120100n 0
+    120149n 0
+    120150n 1.8
+    120199n 1.8
+    120200n 0
+    120249n 0
+    120250n 1.8
+    120299n 1.8
+    120300n 0
+    120349n 0
+    120350n 1.8
+    120399n 1.8
+    120400n 0
+    120449n 0
+    120450n 1.8
+    120499n 1.8
+    120500n 0
+    120549n 0
+    120550n 1.8
+    120599n 1.8
+    120600n 0
+    120649n 0
+    120650n 1.8
+    120699n 1.8
+    120700n 0
+    120749n 0
+    120750n 1.8
+    120799n 1.8
+    120800n 0
+    120849n 0
+    120850n 1.8
+    120899n 1.8
+    120900n 0
+    120949n 0
+    120950n 1.8
+    120999n 1.8
+    121000n 0
+    121049n 0
+    121050n 1.8
+    121099n 1.8
+    121100n 0
+    121149n 0
+    121150n 1.8
+    121199n 1.8
+    121200n 0
+    121249n 0
+    121250n 1.8
+    121299n 1.8
+    121300n 0
+    121349n 0
+    121350n 1.8
+    121399n 1.8
+    121400n 0
+    121449n 0
+    121450n 1.8
+    121499n 1.8
+    121500n 0
+    121549n 0
+    121550n 1.8
+    121599n 1.8
+    121600n 0
+    121649n 0
+    121650n 1.8
+    121699n 1.8
+    121700n 0
+    121749n 0
+    121750n 1.8
+    121799n 1.8
+    121800n 0
+    121849n 0
+    121850n 1.8
+    121899n 1.8
+    121900n 0
+    121949n 0
+    121950n 1.8
+    121999n 1.8
+    122000n 0
+    122049n 0
+    122050n 1.8
+    122099n 1.8
+    122100n 0
+    122149n 0
+    122150n 1.8
+    122199n 1.8
+    122200n 0
+    122249n 0
+    122250n 1.8
+    122299n 1.8
+    122300n 0
+    122349n 0
+    122350n 1.8
+    122399n 1.8
+    122400n 0
+    122449n 0
+    122450n 1.8
+    122499n 1.8
+    122500n 0
+    122549n 0
+    122550n 1.8
+    122599n 1.8
+    122600n 0
+    122649n 0
+    122650n 1.8
+    122699n 1.8
+    122700n 0
+    122749n 0
+    122750n 1.8
+    122799n 1.8
+    122800n 0
+    122849n 0
+    122850n 1.8
+    122899n 1.8
+    122900n 0
+    122949n 0
+    122950n 1.8
+    122999n 1.8
+    123000n 0
+    123049n 0
+    123050n 1.8
+    123099n 1.8
+    123100n 0
+    123149n 0
+    123150n 1.8
+    123199n 1.8
+    123200n 0
+    123249n 0
+    123250n 1.8
+    123299n 1.8
+    123300n 0
+    123349n 0
+    123350n 1.8
+    123399n 1.8
+    123400n 0
+    123449n 0
+    123450n 1.8
+    123499n 1.8
+    123500n 0
+    123549n 0
+    123550n 1.8
+    123599n 1.8
+    123600n 0
+    123649n 0
+    123650n 1.8
+    123699n 1.8
+    123700n 0
+    123749n 0
+    123750n 1.8
+    123799n 1.8
+    123800n 0
+    123849n 0
+    123850n 1.8
+    123899n 1.8
+    123900n 0
+    123949n 0
+    123950n 1.8
+    123999n 1.8
+    124000n 0
+    124049n 0
+    124050n 1.8
+    124099n 1.8
+    124100n 0
+    124149n 0
+    124150n 1.8
+    124199n 1.8
+    124200n 0
+    124249n 0
+    124250n 1.8
+    124299n 1.8
+    124300n 0
+    124349n 0
+    124350n 1.8
+    124399n 1.8
+    124400n 0
+    124449n 0
+    124450n 1.8
+    124499n 1.8
+    124500n 0
+    124549n 0
+    124550n 1.8
+    124599n 1.8
+    124600n 0
+    124649n 0
+    124650n 1.8
+    124699n 1.8
+    124700n 0
+    124749n 0
+    124750n 1.8
+    124799n 1.8
+    124800n 0
+    124849n 0
+    124850n 1.8
+    124899n 1.8
+    124900n 0
+    124949n 0
+    124950n 1.8
+    124999n 1.8
+    125000n 0
+    125049n 0
+    125050n 1.8
+    125099n 1.8
+    125100n 0
+    125149n 0
+    125150n 1.8
+    125199n 1.8
+    125200n 0
+    125249n 0
+    125250n 1.8
+    125299n 1.8
+    125300n 0
+    125349n 0
+    125350n 1.8
+    125399n 1.8
+    125400n 0
+    125449n 0
+    125450n 1.8
+    125499n 1.8
+    125500n 0
+    125549n 0
+    125550n 1.8
+    125599n 1.8
+    125600n 0
+    125649n 0
+    125650n 1.8
+    125699n 1.8
+    125700n 0
+    125749n 0
+    125750n 1.8
+    125799n 1.8
+    125800n 0
+    125849n 0
+    125850n 1.8
+    125899n 1.8
+    125900n 0
+    125949n 0
+    125950n 1.8
+    125999n 1.8
+    126000n 0
+    126049n 0
+    126050n 1.8
+    126099n 1.8
+    126100n 0
+    126149n 0
+    126150n 1.8
+    126199n 1.8
+    126200n 0
+    126249n 0
+    126250n 1.8
+    126299n 1.8
+    126300n 0
+    126349n 0
+    126350n 1.8
+    126399n 1.8
+    126400n 0
+    126449n 0
+    126450n 1.8
+    126499n 1.8
+    126500n 0
+    126549n 0
+    126550n 1.8
+    126599n 1.8
+    126600n 0
+    126649n 0
+    126650n 1.8
+    126699n 1.8
+    126700n 0
+    126749n 0
+    126750n 1.8
+    126799n 1.8
+    126800n 0
+    126849n 0
+    126850n 1.8
+    126899n 1.8
+    126900n 0
+    126949n 0
+    126950n 1.8
+    126999n 1.8
+    127000n 0
+    127049n 0
+    127050n 1.8
+    127099n 1.8
+    127100n 0
+    127149n 0
+    127150n 1.8
+    127199n 1.8
+    127200n 0
+    127249n 0
+    127250n 1.8
+    127299n 1.8
+    127300n 0
+    127349n 0
+    127350n 1.8
+    127399n 1.8
+    127400n 0
+    127449n 0
+    127450n 1.8
+    127499n 1.8
+    127500n 0
+    127549n 0
+    127550n 1.8
+    127599n 1.8
+    127600n 0
+    127649n 0
+    127650n 1.8
+    127699n 1.8
+    127700n 0
+    127749n 0
+    127750n 1.8
+    127799n 1.8
+    127800n 0
+    127849n 0
+    127850n 1.8
+    127899n 1.8
+    127900n 0
+    127949n 0
+    127950n 1.8
+    127999n 1.8
+    128000n 0
+    128049n 0
+    128050n 1.8
+    128099n 1.8
+    128100n 0
+    128149n 0
+    128150n 1.8
+    128199n 1.8
+    128200n 0
+    128249n 0
+    128250n 1.8
+    128299n 1.8
+    128300n 0
+    128349n 0
+    128350n 1.8
+    128399n 1.8
+    128400n 0
+    128449n 0
+    128450n 1.8
+    128499n 1.8
+    128500n 0
+    128549n 0
+    128550n 1.8
+    128599n 1.8
+    128600n 0
+    128649n 0
+    128650n 1.8
+    128699n 1.8
+    128700n 0
+    128749n 0
+    128750n 1.8
+    128799n 1.8
+    128800n 0
+    128849n 0
+    128850n 1.8
+    128899n 1.8
+    128900n 0
+    128949n 0
+    128950n 1.8
+    128999n 1.8
+    129000n 0
+    129049n 0
+    129050n 1.8
+    129099n 1.8
+    129100n 0
+    129149n 0
+    129150n 1.8
+    129199n 1.8
+    129200n 0
+    129249n 0
+    129250n 1.8
+    129299n 1.8
+    129300n 0
+    129349n 0
+    129350n 1.8
+    129399n 1.8
+    129400n 0
+    129449n 0
+    129450n 1.8
+    129499n 1.8
+    129500n 0
+    129549n 0
+    129550n 1.8
+    129599n 1.8
+    129600n 0
+    129649n 0
+    129650n 1.8
+    129699n 1.8
+    129700n 0
+    129749n 0
+    129750n 1.8
+    129799n 1.8
+    129800n 0
+    129849n 0
+    129850n 1.8
+    129899n 1.8
+    129900n 0
+    129949n 0
+    129950n 1.8
+    129999n 1.8
+    130000n 0
+    130049n 0
+    130050n 1.8
+    130099n 1.8
+    130100n 0
+    130149n 0
+    130150n 1.8
+    130199n 1.8
+    130200n 0
+    130249n 0
+    130250n 1.8
+    130299n 1.8
+    130300n 0
+    130349n 0
+    130350n 1.8
+    130399n 1.8
+    130400n 0
+    130449n 0
+    130450n 1.8
+    130499n 1.8
+    130500n 0
+    130549n 0
+    130550n 1.8
+    130599n 1.8
+    130600n 0
+    130649n 0
+    130650n 1.8
+    130699n 1.8
+    130700n 0
+    130749n 0
+    130750n 1.8
+    130799n 1.8
+    130800n 0
+    130849n 0
+    130850n 1.8
+    130899n 1.8
+    130900n 0
+    130949n 0
+    130950n 1.8
+    130999n 1.8
+    131000n 0
+    131049n 0
+    131050n 1.8
+    131099n 1.8
+    131100n 0
+    131149n 0
+    131150n 1.8
+    131199n 1.8
+    131200n 0
+    131249n 0
+    131250n 1.8
+    131299n 1.8
+    131300n 0
+    131349n 0
+    131350n 1.8
+    131399n 1.8
+    131400n 0
+    131449n 0
+    131450n 1.8
+    131499n 1.8
+    131500n 0
+    131549n 0
+    131550n 1.8
+    131599n 1.8
+    131600n 0
+    131649n 0
+    131650n 1.8
+    131699n 1.8
+    131700n 0
+    131749n 0
+    131750n 1.8
+    131799n 1.8
+    131800n 0
+    131849n 0
+    131850n 1.8
+    131899n 1.8
+    131900n 0
+    131949n 0
+    131950n 1.8
+    131999n 1.8
+    132000n 0
+    132049n 0
+    132050n 1.8
+    132099n 1.8
+    132100n 0
+    132149n 0
+    132150n 1.8
+    132199n 1.8
+    132200n 0
+    132249n 0
+    132250n 1.8
+    132299n 1.8
+    132300n 0
+    132349n 0
+    132350n 1.8
+    132399n 1.8
+    132400n 0
+    132449n 0
+    132450n 1.8
+    132499n 1.8
+    132500n 0
+    132549n 0
+    132550n 1.8
+    132599n 1.8
+    132600n 0
+    132649n 0
+    132650n 1.8
+    132699n 1.8
+    132700n 0
+    132749n 0
+    132750n 1.8
+    132799n 1.8
+    132800n 0
+    132849n 0
+    132850n 1.8
+    132899n 1.8
+    132900n 0
+    132949n 0
+    132950n 1.8
+    132999n 1.8
+    133000n 0
+    133049n 0
+    133050n 1.8
+    133099n 1.8
+    133100n 0
+    133149n 0
+    133150n 1.8
+    133199n 1.8
+    133200n 0
+    133249n 0
+    133250n 1.8
+    133299n 1.8
+    133300n 0
+    133349n 0
+    133350n 1.8
+    133399n 1.8
+    133400n 0
+    133449n 0
+    133450n 1.8
+    133499n 1.8
+    133500n 0
+    133549n 0
+    133550n 1.8
+    133599n 1.8
+    133600n 0
+    133649n 0
+    133650n 1.8
+    133699n 1.8
+    133700n 0
+    133749n 0
+    133750n 1.8
+    133799n 1.8
+    133800n 0
+    133849n 0
+    133850n 1.8
+    133899n 1.8
+    133900n 0
+    133949n 0
+    133950n 1.8
+    133999n 1.8
+    134000n 0
+    134049n 0
+    134050n 1.8
+    134099n 1.8
+    134100n 0
+    134149n 0
+    134150n 1.8
+    134199n 1.8
+    134200n 0
+    134249n 0
+    134250n 1.8
+    134299n 1.8
+    134300n 0
+    134349n 0
+    134350n 1.8
+    134399n 1.8
+    134400n 0
+    134449n 0
+    134450n 1.8
+    134499n 1.8
+    134500n 0
+    134549n 0
+    134550n 1.8
+    134599n 1.8
+    134600n 0
+    134649n 0
+    134650n 1.8
+    134699n 1.8
+    134700n 0
+    134749n 0
+    134750n 1.8
+    134799n 1.8
+    134800n 0
+    134849n 0
+    134850n 1.8
+    134899n 1.8
+    134900n 0
+    134949n 0
+    134950n 1.8
+    134999n 1.8
+    135000n 0
+    135049n 0
+    135050n 1.8
+    135099n 1.8
+    135100n 0
+    135149n 0
+    135150n 1.8
+    135199n 1.8
+    135200n 0
+    135249n 0
+    135250n 1.8
+    135299n 1.8
+    135300n 0
+    135349n 0
+    135350n 1.8
+    135399n 1.8
+    135400n 0
+    135449n 0
+    135450n 1.8
+    135499n 1.8
+    135500n 0
+    135549n 0
+    135550n 1.8
+    135599n 1.8
+    135600n 0
+    135649n 0
+    135650n 1.8
+    135699n 1.8
+    135700n 0
+    135749n 0
+    135750n 1.8
+    135799n 1.8
+    135800n 0
+    135849n 0
+    135850n 1.8
+    135899n 1.8
+    135900n 0
+    135949n 0
+    135950n 1.8
+    135999n 1.8
+    136000n 0
+    136049n 0
+    136050n 1.8
+    136099n 1.8
+    136100n 0
+    136149n 0
+    136150n 1.8
+    136199n 1.8
+    136200n 0
+    136249n 0
+    136250n 1.8
+    136299n 1.8
+    136300n 0
+    136349n 0
+    136350n 1.8
+    136399n 1.8
+    136400n 0
+    136449n 0
+    136450n 1.8
+    136499n 1.8
+    136500n 0
+    136549n 0
+    136550n 1.8
+    136599n 1.8
+    136600n 0
+    136649n 0
+    136650n 1.8
+    136699n 1.8
+    136700n 0
+    136749n 0
+    136750n 1.8
+    136799n 1.8
+    136800n 0
+    136849n 0
+    136850n 1.8
+    136899n 1.8
+    136900n 0
+    136949n 0
+    136950n 1.8
+    136999n 1.8
+    137000n 0
+    137049n 0
+    137050n 1.8
+    137099n 1.8
+    137100n 0
+    137149n 0
+    137150n 1.8
+    137199n 1.8
+    137200n 0
+    137249n 0
+    137250n 1.8
+    137299n 1.8
+    137300n 0
+    137349n 0
+    137350n 1.8
+    137399n 1.8
+    137400n 0
+    137449n 0
+    137450n 1.8
+    137499n 1.8
+    137500n 0
+    137549n 0
+    137550n 1.8
+    137599n 1.8
+    137600n 0
+    137649n 0
+    137650n 1.8
+    137699n 1.8
+    137700n 0
+    137749n 0
+    137750n 1.8
+    137799n 1.8
+    137800n 0
+    137849n 0
+    137850n 1.8
+    137899n 1.8
+    137900n 0
+    137949n 0
+    137950n 1.8
+    137999n 1.8
+    138000n 0
+    138049n 0
+    138050n 1.8
+    138099n 1.8
+    138100n 0
+    138149n 0
+    138150n 1.8
+    138199n 1.8
+    138200n 0
+    138249n 0
+    138250n 1.8
+    138299n 1.8
+    138300n 0
+    138349n 0
+    138350n 1.8
+    138399n 1.8
+    138400n 0
+    138449n 0
+    138450n 1.8
+    138499n 1.8
+    138500n 0
+    138549n 0
+    138550n 1.8
+    138599n 1.8
+    138600n 0
+    138649n 0
+    138650n 1.8
+    138699n 1.8
+    138700n 0
+    138749n 0
+    138750n 1.8
+    138799n 1.8
+    138800n 0
+    138849n 0
+    138850n 1.8
+    138899n 1.8
+    138900n 0
+    138949n 0
+    138950n 1.8
+    138999n 1.8
+    139000n 0
+    139049n 0
+    139050n 1.8
+    139099n 1.8
+    139100n 0
+    139149n 0
+    139150n 1.8
+    139199n 1.8
+    139200n 0
+    139249n 0
+    139250n 1.8
+    139299n 1.8
+    139300n 0
+    139349n 0
+    139350n 1.8
+    139399n 1.8
+    139400n 0
+    139449n 0
+    139450n 1.8
+    139499n 1.8
+    139500n 0
+    139549n 0
+    139550n 1.8
+    139599n 1.8
+    139600n 0
+    139649n 0
+    139650n 1.8
+    139699n 1.8
+    139700n 0
+    139749n 0
+    139750n 1.8
+    139799n 1.8
+    139800n 0
+    139849n 0
+    139850n 1.8
+    139899n 1.8
+    139900n 0
+    139949n 0
+    139950n 1.8
+    139999n 1.8
+    140000n 0
+    140049n 0
+    140050n 1.8
+    140099n 1.8
+    140100n 0
+    140149n 0
+    140150n 1.8
+    140199n 1.8
+    140200n 0
+    140249n 0
+    140250n 1.8
+    140299n 1.8
+    140300n 0
+    140349n 0
+    140350n 1.8
+    140399n 1.8
+    140400n 0
+    140449n 0
+    140450n 1.8
+    140499n 1.8
+    140500n 0
+    140549n 0
+    140550n 1.8
+    140599n 1.8
+    140600n 0
+    140649n 0
+    140650n 1.8
+    140699n 1.8
+    140700n 0
+    140749n 0
+    140750n 1.8
+    140799n 1.8
+    140800n 0
+    140849n 0
+    140850n 1.8
+    140899n 1.8
+    140900n 0
+    140949n 0
+    140950n 1.8
+    140999n 1.8
+    141000n 0
+    141049n 0
+    141050n 1.8
+    141099n 1.8
+    141100n 0
+    141149n 0
+    141150n 1.8
+    141199n 1.8
+    141200n 0
+    141249n 0
+    141250n 1.8
+    141299n 1.8
+    141300n 0
+    141349n 0
+    141350n 1.8
+    141399n 1.8
+    141400n 0
+    141449n 0
+    141450n 1.8
+    141499n 1.8
+    141500n 0
+    141549n 0
+    141550n 1.8
+    141599n 1.8
+    141600n 0
+    141649n 0
+    141650n 1.8
+    141699n 1.8
+    141700n 0
+    141749n 0
+    141750n 1.8
+    141799n 1.8
+    141800n 0
+    141849n 0
+    141850n 1.8
+    141899n 1.8
+    141900n 0
+    141949n 0
+    141950n 1.8
+    141999n 1.8
+    142000n 0
+    142049n 0
+    142050n 1.8
+    142099n 1.8
+    142100n 0
+    142149n 0
+    142150n 1.8
+    142199n 1.8
+    142200n 0
+    142249n 0
+    142250n 1.8
+    142299n 1.8
+    142300n 0
+    142349n 0
+    142350n 1.8
+    142399n 1.8
+    142400n 0
+    142449n 0
+    142450n 1.8
+    142499n 1.8
+    142500n 0
+    142549n 0
+    142550n 1.8
+    142599n 1.8
+    142600n 0
+    142649n 0
+    142650n 1.8
+    142699n 1.8
+    142700n 0
+    142749n 0
+    142750n 1.8
+    142799n 1.8
+    142800n 0
+    142849n 0
+    142850n 1.8
+    142899n 1.8
+    142900n 0
+    142949n 0
+    142950n 1.8
+    142999n 1.8
+    143000n 0
+    143049n 0
+    143050n 1.8
+    143099n 1.8
+    143100n 0
+    143149n 0
+    143150n 1.8
+    143199n 1.8
+    143200n 0
+    143249n 0
+    143250n 1.8
+    143299n 1.8
+    143300n 0
+    143349n 0
+    143350n 1.8
+    143399n 1.8
+    143400n 0
+    143449n 0
+    143450n 1.8
+    143499n 1.8
+    143500n 0
+    143549n 0
+    143550n 1.8
+    143599n 1.8
+    143600n 0
+    143649n 0
+    143650n 1.8
+    143699n 1.8
+    143700n 0
+    143749n 0
+    143750n 1.8
+    143799n 1.8
+    143800n 0
+    143849n 0
+    143850n 1.8
+    143899n 1.8
+    143900n 0
+    143949n 0
+    143950n 1.8
+    143999n 1.8
+    144000n 0
+    144049n 0
+    144050n 1.8
+    144099n 1.8
+    144100n 0
+    144149n 0
+    144150n 1.8
+    144199n 1.8
+    144200n 0
+    144249n 0
+    144250n 1.8
+    144299n 1.8
+    144300n 0
+    144349n 0
+    144350n 1.8
+    144399n 1.8
+    144400n 0
+    144449n 0
+    144450n 1.8
+    144499n 1.8
+    144500n 0
+    144549n 0
+    144550n 1.8
+    144599n 1.8
+    144600n 0
+    144649n 0
+    144650n 1.8
+    144699n 1.8
+    144700n 0
+    144749n 0
+    144750n 1.8
+    144799n 1.8
+    144800n 0
+    144849n 0
+    144850n 1.8
+    144899n 1.8
+    144900n 0
+    144949n 0
+    144950n 1.8
+    144999n 1.8
+    145000n 0
+    145049n 0
+    145050n 1.8
+    145099n 1.8
+    145100n 0
+    145149n 0
+    145150n 1.8
+    145199n 1.8
+    145200n 0
+    145249n 0
+    145250n 1.8
+    145299n 1.8
+    145300n 0
+    145349n 0
+    145350n 1.8
+    145399n 1.8
+    145400n 0
+    145449n 0
+    145450n 1.8
+    145499n 1.8
+    145500n 0
+    145549n 0
+    145550n 1.8
+    145599n 1.8
+    145600n 0
+    145649n 0
+    145650n 1.8
+    145699n 1.8
+    145700n 0
+    145749n 0
+    145750n 1.8
+    145799n 1.8
+    145800n 0
+    145849n 0
+    145850n 1.8
+    145899n 1.8
+    145900n 0
+    145949n 0
+    145950n 1.8
+    145999n 1.8
+    146000n 0
+    146049n 0
+    146050n 1.8
+    146099n 1.8
+    146100n 0
+    146149n 0
+    146150n 1.8
+    146199n 1.8
+    146200n 0
+    146249n 0
+    146250n 1.8
+    146299n 1.8
+    146300n 0
+    146349n 0
+    146350n 1.8
+    146399n 1.8
+    146400n 0
+    146449n 0
+    146450n 1.8
+    146499n 1.8
+    146500n 0
+    146549n 0
+    146550n 1.8
+    146599n 1.8
+    146600n 0
+    146649n 0
+    146650n 1.8
+    146699n 1.8
+    146700n 0
+    146749n 0
+    146750n 1.8
+    146799n 1.8
+    146800n 0
+    146849n 0
+    146850n 1.8
+    146899n 1.8
+    146900n 0
+    146949n 0
+    146950n 1.8
+    146999n 1.8
+    147000n 0
+    147049n 0
+    147050n 1.8
+    147099n 1.8
+    147100n 0
+    147149n 0
+    147150n 1.8
+    147199n 1.8
+    147200n 0
+    147249n 0
+    147250n 1.8
+    147299n 1.8
+    147300n 0
+    147349n 0
+    147350n 1.8
+    147399n 1.8
+    147400n 0
+    147449n 0
+    147450n 1.8
+    147499n 1.8
+    147500n 0
+    147549n 0
+    147550n 1.8
+    147599n 1.8
+    147600n 0
+    147649n 0
+    147650n 1.8
+    147699n 1.8
+    147700n 0
+    147749n 0
+    147750n 1.8
+    147799n 1.8
+    147800n 0
+    147849n 0
+    147850n 1.8
+    147899n 1.8
+    147900n 0
+    147949n 0
+    147950n 1.8
+    147999n 1.8
+    148000n 0
+    148049n 0
+    148050n 1.8
+    148099n 1.8
+    148100n 0
+    148149n 0
+    148150n 1.8
+    148199n 1.8
+    148200n 0
+    148249n 0
+    148250n 1.8
+    148299n 1.8
+    148300n 0
+    148349n 0
+    148350n 1.8
+    148399n 1.8
+    148400n 0
+    148449n 0
+    148450n 1.8
+    148499n 1.8
+    148500n 0
+    148549n 0
+    148550n 1.8
+    148599n 1.8
+    148600n 0
+    148649n 0
+    148650n 1.8
+    148699n 1.8
+    148700n 0
+    148749n 0
+    148750n 1.8
+    148799n 1.8
+    148800n 0
+    148849n 0
+    148850n 1.8
+    148899n 1.8
+    148900n 0
+    148949n 0
+    148950n 1.8
+    148999n 1.8
+    149000n 0
+    149049n 0
+    149050n 1.8
+    149099n 1.8
+    149100n 0
+    149149n 0
+    149150n 1.8
+    149199n 1.8
+    149200n 0
+    149249n 0
+    149250n 1.8
+    149299n 1.8
+    149300n 0
+    149349n 0
+    149350n 1.8
+    149399n 1.8
+    149400n 0
+    149449n 0
+    149450n 1.8
+    149499n 1.8
+    149500n 0
+    149549n 0
+    149550n 1.8
+    149599n 1.8
+    149600n 0
+    149649n 0
+    149650n 1.8
+    149699n 1.8
+    149700n 0
+    149749n 0
+    149750n 1.8
+    149799n 1.8
+    149800n 0
+    149849n 0
+    149850n 1.8
+    149899n 1.8
+    149900n 0
+    149949n 0
+    149950n 1.8
+    149999n 1.8
+    150000n 0
+    150049n 0
+    150050n 1.8
+    150099n 1.8
+    150100n 0
+    150149n 0
+    150150n 1.8
+    150199n 1.8
+    150200n 0
+    150249n 0
+    150250n 1.8
+    150299n 1.8
+    150300n 0
+    150349n 0
+    150350n 1.8
+    150399n 1.8
+    150400n 0
+    150449n 0
+    150450n 1.8
+    150499n 1.8
+    150500n 0
+    150549n 0
+    150550n 1.8
+    150599n 1.8
+    150600n 0
+    150649n 0
+    150650n 1.8
+    150699n 1.8
+    150700n 0
+    150749n 0
+    150750n 1.8
+    150799n 1.8
+    150800n 0
+    150849n 0
+    150850n 1.8
+    150899n 1.8
+    150900n 0
+    150949n 0
+    150950n 1.8
+    150999n 1.8
+    151000n 0
+    151049n 0
+    151050n 1.8
+    151099n 1.8
+    151100n 0
+    151149n 0
+    151150n 1.8
+    151199n 1.8
+    151200n 0
+    151249n 0
+    151250n 1.8
+    151299n 1.8
+    151300n 0
+    151349n 0
+    151350n 1.8
+    151399n 1.8
+    151400n 0
+    151449n 0
+    151450n 1.8
+    151499n 1.8
+    151500n 0
+    151549n 0
+    151550n 1.8
+    151599n 1.8
+    151600n 0
+    151649n 0
+    151650n 1.8
+    151699n 1.8
+    151700n 0
+    151749n 0
+    151750n 1.8
+    151799n 1.8
+    151800n 0
+    151849n 0
+    151850n 1.8
+    151899n 1.8
+    151900n 0
+    151949n 0
+    151950n 1.8
+    151999n 1.8
+    152000n 0
+    152049n 0
+    152050n 1.8
+    152099n 1.8
+    152100n 0
+    152149n 0
+    152150n 1.8
+    152199n 1.8
+    152200n 0
+    152249n 0
+    152250n 1.8
+    152299n 1.8
+    152300n 0
+    152349n 0
+    152350n 1.8
+    152399n 1.8
+    152400n 0
+    152449n 0
+    152450n 1.8
+    152499n 1.8
+    152500n 0
+    152549n 0
+    152550n 1.8
+    152599n 1.8
+    152600n 0
+    152649n 0
+    152650n 1.8
+    152699n 1.8
+    152700n 0
+    152749n 0
+    152750n 1.8
+    152799n 1.8
+    152800n 0
+    152849n 0
+    152850n 1.8
+    152899n 1.8
+    152900n 0
+    152949n 0
+    152950n 1.8
+    152999n 1.8
+    153000n 0
+    153049n 0
+    153050n 1.8
+    153099n 1.8
+    153100n 0
+    153149n 0
+    153150n 1.8
+    153199n 1.8
+    153200n 0
+    153249n 0
+    153250n 1.8
+    153299n 1.8
+    153300n 0
+    153349n 0
+    153350n 1.8
+    153399n 1.8
+    153400n 0
+    153449n 0
+    153450n 1.8
+    153499n 1.8
+    153500n 0
+    153549n 0
+    153550n 1.8
+    153599n 1.8
+    153600n 0
+    153649n 0
+    153650n 1.8
+    153699n 1.8
+    153700n 0
+    153749n 0
+    153750n 1.8
+    153799n 1.8
+    153800n 0
+    153849n 0
+    153850n 1.8
+    153899n 1.8
+    153900n 0
+    153949n 0
+    153950n 1.8
+    153999n 1.8
+    154000n 0
+    154049n 0
+    154050n 1.8
+    154099n 1.8
+    154100n 0
+    154149n 0
+    154150n 1.8
+    154199n 1.8
+    154200n 0
+    154249n 0
+    154250n 1.8
+    154299n 1.8
+    154300n 0
+    154349n 0
+    154350n 1.8
+    154399n 1.8
+    154400n 0
+    154449n 0
+    154450n 1.8
+    154499n 1.8
+    154500n 0
+    154549n 0
+    154550n 1.8
+    154599n 1.8
+    154600n 0
+    154649n 0
+    154650n 1.8
+    154699n 1.8
+    154700n 0
+    154749n 0
+    154750n 1.8
+    154799n 1.8
+    154800n 0
+    154849n 0
+    154850n 1.8
+    154899n 1.8
+    154900n 0
+    154949n 0
+    154950n 1.8
+    154999n 1.8
+    155000n 0
+    155049n 0
+    155050n 1.8
+    155099n 1.8
+    155100n 0
+    155149n 0
+    155150n 1.8
+    155199n 1.8
+    155200n 0
+    155249n 0
+    155250n 1.8
+    155299n 1.8
+    155300n 0
+    155349n 0
+    155350n 1.8
+    155399n 1.8
+    155400n 0
+    155449n 0
+    155450n 1.8
+    155499n 1.8
+    155500n 0
+    155549n 0
+    155550n 1.8
+    155599n 1.8
+    155600n 0
+    155649n 0
+    155650n 1.8
+    155699n 1.8
+    155700n 0
+    155749n 0
+    155750n 1.8
+    155799n 1.8
+    155800n 0
+    155849n 0
+    155850n 1.8
+    155899n 1.8
+    155900n 0
+    155949n 0
+    155950n 1.8
+    155999n 1.8
+    156000n 0
+    156049n 0
+    156050n 1.8
+    156099n 1.8
+    156100n 0
+    156149n 0
+    156150n 1.8
+    156199n 1.8
+    156200n 0
+    156249n 0
+    156250n 1.8
+    156299n 1.8
+    156300n 0
+    156349n 0
+    156350n 1.8
+    156399n 1.8
+    156400n 0
+    156449n 0
+    156450n 1.8
+    156499n 1.8
+    156500n 0
+    156549n 0
+    156550n 1.8
+    156599n 1.8
+    156600n 0
+    156649n 0
+    156650n 1.8
+    156699n 1.8
+    156700n 0
+    156749n 0
+    156750n 1.8
+    156799n 1.8
+    156800n 0
+    156849n 0
+    156850n 1.8
+    156899n 1.8
+    156900n 0
+    156949n 0
+    156950n 1.8
+    156999n 1.8
+    157000n 0
+    157049n 0
+    157050n 1.8
+    157099n 1.8
+    157100n 0
+    157149n 0
+    157150n 1.8
+    157199n 1.8
+    157200n 0
+    157249n 0
+    157250n 1.8
+    157299n 1.8
+    157300n 0
+    157349n 0
+    157350n 1.8
+    157399n 1.8
+    157400n 0
+    157449n 0
+    157450n 1.8
+    157499n 1.8
+    157500n 0
+    157549n 0
+    157550n 1.8
+    157599n 1.8
+    157600n 0
+    157649n 0
+    157650n 1.8
+    157699n 1.8
+    157700n 0
+    157749n 0
+    157750n 1.8
+    157799n 1.8
+    157800n 0
+    157849n 0
+    157850n 1.8
+    157899n 1.8
+    157900n 0
+    157949n 0
+    157950n 1.8
+    157999n 1.8
+    158000n 0
+    158049n 0
+    158050n 1.8
+    158099n 1.8
+    158100n 0
+    158149n 0
+    158150n 1.8
+    158199n 1.8
+    158200n 0
+    158249n 0
+    158250n 1.8
+    158299n 1.8
+    158300n 0
+    158349n 0
+    158350n 1.8
+    158399n 1.8
+    158400n 0
+    158449n 0
+    158450n 1.8
+    158499n 1.8
+    158500n 0
+    158549n 0
+    158550n 1.8
+    158599n 1.8
+    158600n 0
+    158649n 0
+    158650n 1.8
+    158699n 1.8
+    158700n 0
+    158749n 0
+    158750n 1.8
+    158799n 1.8
+    158800n 0
+    158849n 0
+    158850n 1.8
+    158899n 1.8
+    158900n 0
+    158949n 0
+    158950n 1.8
+    158999n 1.8
+    159000n 0
+    159049n 0
+    159050n 1.8
+    159099n 1.8
+    159100n 0
+    159149n 0
+    159150n 1.8
+    159199n 1.8
+    159200n 0
+    159249n 0
+    159250n 1.8
+    159299n 1.8
+    159300n 0
+    159349n 0
+    159350n 1.8
+    159399n 1.8
+    159400n 0
+    159449n 0
+    159450n 1.8
+    159499n 1.8
+    159500n 0
+    159549n 0
+    159550n 1.8
+    159599n 1.8
+    159600n 0
+    159649n 0
+    159650n 1.8
+    159699n 1.8
+    159700n 0
+    159749n 0
+    159750n 1.8
+    159799n 1.8
+    159800n 0
+    159849n 0
+    159850n 1.8
+    159899n 1.8
+    159900n 0
+    159949n 0
+    159950n 1.8
+    159999n 1.8
+    160000n 0
+    160049n 0
+    160050n 1.8
+    160099n 1.8
+    160100n 0
+    160149n 0
+    160150n 1.8
+    160199n 1.8
+    160200n 0
+    160249n 0
+    160250n 1.8
+    160299n 1.8
+    160300n 0
+    160349n 0
+    160350n 1.8
+    160399n 1.8
+    160400n 0
+    160449n 0
+    160450n 1.8
+    160499n 1.8
+    160500n 0
+    160549n 0
+    160550n 1.8
+    160599n 1.8
+    160600n 0
+    160649n 0
+    160650n 1.8
+    160699n 1.8
+    160700n 0
+    160749n 0
+    160750n 1.8
+    160799n 1.8
+    160800n 0
+    160849n 0
+    160850n 1.8
+    160899n 1.8
+    160900n 0
+    160949n 0
+    160950n 1.8
+    160999n 1.8
+    161000n 0
+    161049n 0
+    161050n 1.8
+    161099n 1.8
+    161100n 0
+    161149n 0
+    161150n 1.8
+    161199n 1.8
+    161200n 0
+    161249n 0
+    161250n 1.8
+    161299n 1.8
+    161300n 0
+    161349n 0
+    161350n 1.8
+    161399n 1.8
+    161400n 0
+    161449n 0
+    161450n 1.8
+    161499n 1.8
+    161500n 0
+    161549n 0
+    161550n 1.8
+    161599n 1.8
+    161600n 0
+    161649n 0
+    161650n 1.8
+    161699n 1.8
+    161700n 0
+    161749n 0
+    161750n 1.8
+    161799n 1.8
+    161800n 0
+    161849n 0
+    161850n 1.8
+    161899n 1.8
+    161900n 0
+    161949n 0
+    161950n 1.8
+    161999n 1.8
+    162000n 0
+    162049n 0
+    162050n 1.8
+    162099n 1.8
+    162100n 0
+    162149n 0
+    162150n 1.8
+    162199n 1.8
+    162200n 0
+    162249n 0
+    162250n 1.8
+    162299n 1.8
+    162300n 0
+    162349n 0
+    162350n 1.8
+    162399n 1.8
+    162400n 0
+    162449n 0
+    162450n 1.8
+    162499n 1.8
+    162500n 0
+    162549n 0
+    162550n 1.8
+    162599n 1.8
+    162600n 0
+    162649n 0
+    162650n 1.8
+    162699n 1.8
+    162700n 0
+    162749n 0
+    162750n 1.8
+    162799n 1.8
+    162800n 0
+    162849n 0
+    162850n 1.8
+    162899n 1.8
+    162900n 0
+    162949n 0
+    162950n 1.8
+    162999n 1.8
+    163000n 0
+    163049n 0
+    163050n 1.8
+    163099n 1.8
+    163100n 0
+    163149n 0
+    163150n 1.8
+    163199n 1.8
+    163200n 0
+    163249n 0
+    163250n 1.8
+    163299n 1.8
+    163300n 0
+    163349n 0
+    163350n 1.8
+    163399n 1.8
+    163400n 0
+    163449n 0
+    163450n 1.8
+    163499n 1.8
+    163500n 0
+    163549n 0
+    163550n 1.8
+    163599n 1.8
+    163600n 0
+    163649n 0
+    163650n 1.8
+    163699n 1.8
+    163700n 0
+    163749n 0
+    163750n 1.8
+    163799n 1.8
+    163800n 0
+    163849n 0
+    163850n 1.8
+    163899n 1.8
+    163900n 0
+    163949n 0
+    163950n 1.8
+    163999n 1.8
+    164000n 0
+    164049n 0
+    164050n 1.8
+    164099n 1.8
+    164100n 0
+    164149n 0
+    164150n 1.8
+    164199n 1.8
+    164200n 0
+    164249n 0
+    164250n 1.8
+    164299n 1.8
+    164300n 0
+    164349n 0
+    164350n 1.8
+    164399n 1.8
+    164400n 0
+    164449n 0
+    164450n 1.8
+    164499n 1.8
+    164500n 0
+    164549n 0
+    164550n 1.8
+    164599n 1.8
+    164600n 0
+    164649n 0
+    164650n 1.8
+    164699n 1.8
+    164700n 0
+    164749n 0
+    164750n 1.8
+    164799n 1.8
+    164800n 0
+    164849n 0
+    164850n 1.8
+    164899n 1.8
+    164900n 0
+    164949n 0
+    164950n 1.8
+    164999n 1.8
+    165000n 0
+    165049n 0
+    165050n 1.8
+    165099n 1.8
+    165100n 0
+    165149n 0
+    165150n 1.8
+    165199n 1.8
+    165200n 0
+    165249n 0
+    165250n 1.8
+    165299n 1.8
+    165300n 0
+    165349n 0
+    165350n 1.8
+    165399n 1.8
+    165400n 0
+    165449n 0
+    165450n 1.8
+    165499n 1.8
+    165500n 0
+    165549n 0
+    165550n 1.8
+    165599n 1.8
+    165600n 0
+    165649n 0
+    165650n 1.8
+    165699n 1.8
+    165700n 0
+    165749n 0
+    165750n 1.8
+    165799n 1.8
+    165800n 0
+    165849n 0
+    165850n 1.8
+    165899n 1.8
+    165900n 0
+    165949n 0
+    165950n 1.8
+    165999n 1.8
+    166000n 0
+    166049n 0
+    166050n 1.8
+    166099n 1.8
+    166100n 0
+    166149n 0
+    166150n 1.8
+    166199n 1.8
+    166200n 0
+    166249n 0
+    166250n 1.8
+    166299n 1.8
+    166300n 0
+    166349n 0
+    166350n 1.8
+    166399n 1.8
+    166400n 0
+    166449n 0
+    166450n 1.8
+    166499n 1.8
+    166500n 0
+    166549n 0
+    166550n 1.8
+    166599n 1.8
+    166600n 0
+    166649n 0
+    166650n 1.8
+    166699n 1.8
+    166700n 0
+    166749n 0
+    166750n 1.8
+    166799n 1.8
+    166800n 0
+    166849n 0
+    166850n 1.8
+    166899n 1.8
+    166900n 0
+    166949n 0
+    166950n 1.8
+    166999n 1.8
+    167000n 0
+    167049n 0
+    167050n 1.8
+    167099n 1.8
+    167100n 0
+    167149n 0
+    167150n 1.8
+    167199n 1.8
+    167200n 0
+    167249n 0
+    167250n 1.8
+    167299n 1.8
+    167300n 0
+    167349n 0
+    167350n 1.8
+    167399n 1.8
+    167400n 0
+    167449n 0
+    167450n 1.8
+    167499n 1.8
+    167500n 0
+    167549n 0
+    167550n 1.8
+    167599n 1.8
+    167600n 0
+    167649n 0
+    167650n 1.8
+    167699n 1.8
+    167700n 0
+    167749n 0
+    167750n 1.8
+    167799n 1.8
+    167800n 0
+    167849n 0
+    167850n 1.8
+    167899n 1.8
+    167900n 0
+    167949n 0
+    167950n 1.8
+    167999n 1.8
+    168000n 0
+    168049n 0
+    168050n 1.8
+    168099n 1.8
+    168100n 0
+    168149n 0
+    168150n 1.8
+    168199n 1.8
+    168200n 0
+    168249n 0
+    168250n 1.8
+    168299n 1.8
+    168300n 0
+    168349n 0
+    168350n 1.8
+    168399n 1.8
+    168400n 0
+    168449n 0
+    168450n 1.8
+    168499n 1.8
+    168500n 0
+    168549n 0
+    168550n 1.8
+    168599n 1.8
+    168600n 0
+    168649n 0
+    168650n 1.8
+    168699n 1.8
+    168700n 0
+    168749n 0
+    168750n 1.8
+    168799n 1.8
+    168800n 0
+    168849n 0
+    168850n 1.8
+    168899n 1.8
+    168900n 0
+    168949n 0
+    168950n 1.8
+    168999n 1.8
+    169000n 0
+    169049n 0
+    169050n 1.8
+    169099n 1.8
+    169100n 0
+    169149n 0
+    169150n 1.8
+    169199n 1.8
+    169200n 0
+    169249n 0
+    169250n 1.8
+    169299n 1.8
+    169300n 0
+    169349n 0
+    169350n 1.8
+    169399n 1.8
+    169400n 0
+    169449n 0
+    169450n 1.8
+    169499n 1.8
+    169500n 0
+    169549n 0
+    169550n 1.8
+    169599n 1.8
+    169600n 0
+    169649n 0
+    169650n 1.8
+    169699n 1.8
+    169700n 0
+    169749n 0
+    169750n 1.8
+    169799n 1.8
+    169800n 0
+    169849n 0
+    169850n 1.8
+    169899n 1.8
+    169900n 0
+    169949n 0
+    169950n 1.8
+    169999n 1.8
+    170000n 0
+    170049n 0
+    170050n 1.8
+    170099n 1.8
+    170100n 0
+    170149n 0
+    170150n 1.8
+    170199n 1.8
+    170200n 0
+    170249n 0
+    170250n 1.8
+    170299n 1.8
+    170300n 0
+    170349n 0
+    170350n 1.8
+    170399n 1.8
+    170400n 0
+    170449n 0
+    170450n 1.8
+    170499n 1.8
+    170500n 0
+    170549n 0
+    170550n 1.8
+    170599n 1.8
+    170600n 0
+    170649n 0
+    170650n 1.8
+    170699n 1.8
+    170700n 0
+    170749n 0
+    170750n 1.8
+    170799n 1.8
+    170800n 0
+    170849n 0
+    170850n 1.8
+    170899n 1.8
+    170900n 0
+    170949n 0
+    170950n 1.8
+    170999n 1.8
+    171000n 0
+    171049n 0
+    171050n 1.8
+    171099n 1.8
+    171100n 0
+    171149n 0
+    171150n 1.8
+    171199n 1.8
+    171200n 0
+    171249n 0
+    171250n 1.8
+    171299n 1.8
+    171300n 0
+    171349n 0
+    171350n 1.8
+    171399n 1.8
+    171400n 0
+    171449n 0
+    171450n 1.8
+    171499n 1.8
+    171500n 0
+    171549n 0
+    171550n 1.8
+    171599n 1.8
+    171600n 0
+    171649n 0
+    171650n 1.8
+    171699n 1.8
+    171700n 0
+    171749n 0
+    171750n 1.8
+    171799n 1.8
+    171800n 0
+    171849n 0
+    171850n 1.8
+    171899n 1.8
+    171900n 0
+    171949n 0
+    171950n 1.8
+    171999n 1.8
+    172000n 0
+    172049n 0
+    172050n 1.8
+    172099n 1.8
+    172100n 0
+    172149n 0
+    172150n 1.8
+    172199n 1.8
+    172200n 0
+    172249n 0
+    172250n 1.8
+    172299n 1.8
+    172300n 0
+    172349n 0
+    172350n 1.8
+    172399n 1.8
+    172400n 0
+    172449n 0
+    172450n 1.8
+    172499n 1.8
+    172500n 0
+    172549n 0
+    172550n 1.8
+    172599n 1.8
+    172600n 0
+    172649n 0
+    172650n 1.8
+    172699n 1.8
+    172700n 0
+    172749n 0
+    172750n 1.8
+    172799n 1.8
+    172800n 0
+    172849n 0
+    172850n 1.8
+    172899n 1.8
+    172900n 0
+    172949n 0
+    172950n 1.8
+    172999n 1.8
+    173000n 0
+    173049n 0
+    173050n 1.8
+    173099n 1.8
+    173100n 0
+    173149n 0
+    173150n 1.8
+    173199n 1.8
+    173200n 0
+    173249n 0
+    173250n 1.8
+    173299n 1.8
+    173300n 0
+    173349n 0
+    173350n 1.8
+    173399n 1.8
+    173400n 0
+    173449n 0
+    173450n 1.8
+    173499n 1.8
+    173500n 0
+    173549n 0
+    173550n 1.8
+    173599n 1.8
+    173600n 0
+    173649n 0
+    173650n 1.8
+    173699n 1.8
+    173700n 0
+    173749n 0
+    173750n 1.8
+    173799n 1.8
+    173800n 0
+    173849n 0
+    173850n 1.8
+    173899n 1.8
+    173900n 0
+    173949n 0
+    173950n 1.8
+    173999n 1.8
+    174000n 0
+    174049n 0
+    174050n 1.8
+    174099n 1.8
+    174100n 0
+    174149n 0
+    174150n 1.8
+    174199n 1.8
+    174200n 0
+    174249n 0
+    174250n 1.8
+    174299n 1.8
+    174300n 0
+    174349n 0
+    174350n 1.8
+    174399n 1.8
+    174400n 0
+    174449n 0
+    174450n 1.8
+    174499n 1.8
+    174500n 0
+    174549n 0
+    174550n 1.8
+    174599n 1.8
+    174600n 0
+    174649n 0
+    174650n 1.8
+    174699n 1.8
+    174700n 0
+    174749n 0
+    174750n 1.8
+    174799n 1.8
+    174800n 0
+    174849n 0
+    174850n 1.8
+    174899n 1.8
+    174900n 0
+    174949n 0
+    174950n 1.8
+    174999n 1.8
+    175000n 0
+    175049n 0
+    175050n 1.8
+    175099n 1.8
+    175100n 0
+    175149n 0
+    175150n 1.8
+    175199n 1.8
+    175200n 0
+    175249n 0
+    175250n 1.8
+    175299n 1.8
+    175300n 0
+    175349n 0
+    175350n 1.8
+    175399n 1.8
+    175400n 0
+    175449n 0
+    175450n 1.8
+    175499n 1.8
+    175500n 0
+    175549n 0
+    175550n 1.8
+    175599n 1.8
+    175600n 0
+    175649n 0
+    175650n 1.8
+    175699n 1.8
+    175700n 0
+    175749n 0
+    175750n 1.8
+    175799n 1.8
+    175800n 0
+    175849n 0
+    175850n 1.8
+    175899n 1.8
+    175900n 0
+    175949n 0
+    175950n 1.8
+    175999n 1.8
+    176000n 0
+    176049n 0
+    176050n 1.8
+    176099n 1.8
+    176100n 0
+    176149n 0
+    176150n 1.8
+    176199n 1.8
+    176200n 0
+    176249n 0
+    176250n 1.8
+    176299n 1.8
+    176300n 0
+    176349n 0
+    176350n 1.8
+    176399n 1.8
+    176400n 0
+    176449n 0
+    176450n 1.8
+    176499n 1.8
+    176500n 0
+    176549n 0
+    176550n 1.8
+    176599n 1.8
+    176600n 0
+    176649n 0
+    176650n 1.8
+    176699n 1.8
+    176700n 0
+    176749n 0
+    176750n 1.8
+    176799n 1.8
+    176800n 0
+    176849n 0
+    176850n 1.8
+    176899n 1.8
+    176900n 0
+    176949n 0
+    176950n 1.8
+    176999n 1.8
+    177000n 0
+    177049n 0
+    177050n 1.8
+    177099n 1.8
+    177100n 0
+    177149n 0
+    177150n 1.8
+    177199n 1.8
+    177200n 0
+    177249n 0
+    177250n 1.8
+    177299n 1.8
+    177300n 0
+    177349n 0
+    177350n 1.8
+    177399n 1.8
+    177400n 0
+    177449n 0
+    177450n 1.8
+    177499n 1.8
+    177500n 0
+    177549n 0
+    177550n 1.8
+    177599n 1.8
+    177600n 0
+    177649n 0
+    177650n 1.8
+    177699n 1.8
+    177700n 0
+    177749n 0
+    177750n 1.8
+    177799n 1.8
+    177800n 0
+    177849n 0
+    177850n 1.8
+    177899n 1.8
+    177900n 0
+    177949n 0
+    177950n 1.8
+    177999n 1.8
+    178000n 0
+    178049n 0
+    178050n 1.8
+    178099n 1.8
+    178100n 0
+    178149n 0
+    178150n 1.8
+    178199n 1.8
+    178200n 0
+    178249n 0
+    178250n 1.8
+    178299n 1.8
+    178300n 0
+    178349n 0
+    178350n 1.8
+    178399n 1.8
+    178400n 0
+    178449n 0
+    178450n 1.8
+    178499n 1.8
+    178500n 0
+    178549n 0
+    178550n 1.8
+    178599n 1.8
+    178600n 0
+    178649n 0
+    178650n 1.8
+    178699n 1.8
+    178700n 0
+    178749n 0
+    178750n 1.8
+    178799n 1.8
+    178800n 0
+    178849n 0
+    178850n 1.8
+    178899n 1.8
+    178900n 0
+    178949n 0
+    178950n 1.8
+    178999n 1.8
+    179000n 0
+    179049n 0
+    179050n 1.8
+    179099n 1.8
+    179100n 0
+    179149n 0
+    179150n 1.8
+    179199n 1.8
+    179200n 0
+    179249n 0
+    179250n 1.8
+    179299n 1.8
+    179300n 0
+    179349n 0
+    179350n 1.8
+    179399n 1.8
+    179400n 0
+    179449n 0
+    179450n 1.8
+    179499n 1.8
+    179500n 0
+    179549n 0
+    179550n 1.8
+    179599n 1.8
+    179600n 0
+    179649n 0
+    179650n 1.8
+    179699n 1.8
+    179700n 0
+    179749n 0
+    179750n 1.8
+    179799n 1.8
+    179800n 0
+    179849n 0
+    179850n 1.8
+    179899n 1.8
+    179900n 0
+    179949n 0
+    179950n 1.8
+    179999n 1.8
+    180000n 0
+    180049n 0
+    180050n 1.8
+    180099n 1.8
+    180100n 0
+    180149n 0
+    180150n 1.8
+    180199n 1.8
+    180200n 0
+    180249n 0
+    180250n 1.8
+    180299n 1.8
+    180300n 0
+    180349n 0
+    180350n 1.8
+    180399n 1.8
+    180400n 0
+    180449n 0
+    180450n 1.8
+    180499n 1.8
+    180500n 0
+    180549n 0
+    180550n 1.8
+    180599n 1.8
+    180600n 0
+    180649n 0
+    180650n 1.8
+    180699n 1.8
+    180700n 0
+    180749n 0
+    180750n 1.8
+    180799n 1.8
+    180800n 0
+    180849n 0
+    180850n 1.8
+    180899n 1.8
+    180900n 0
+    180949n 0
+    180950n 1.8
+    180999n 1.8
+    181000n 0
+    181049n 0
+    181050n 1.8
+    181099n 1.8
+    181100n 0
+    181149n 0
+    181150n 1.8
+    181199n 1.8
+    181200n 0
+    181249n 0
+    181250n 1.8
+    181299n 1.8
+    181300n 0
+    181349n 0
+    181350n 1.8
+    181399n 1.8
+    181400n 0
+    181449n 0
+    181450n 1.8
+    181499n 1.8
+    181500n 0
+    181549n 0
+    181550n 1.8
+    181599n 1.8
+    181600n 0
+    181649n 0
+    181650n 1.8
+    181699n 1.8
+    181700n 0
+    181749n 0
+    181750n 1.8
+    181799n 1.8
+    181800n 0
+    181849n 0
+    181850n 1.8
+    181899n 1.8
+    181900n 0
+    181949n 0
+    181950n 1.8
+    181999n 1.8
+    182000n 0
+    182049n 0
+    182050n 1.8
+    182099n 1.8
+    182100n 0
+    182149n 0
+    182150n 1.8
+    182199n 1.8
+    182200n 0
+    182249n 0
+    182250n 1.8
+    182299n 1.8
+    182300n 0
+    182349n 0
+    182350n 1.8
+    182399n 1.8
+    182400n 0
+    182449n 0
+    182450n 1.8
+    182499n 1.8
+    182500n 0
+    182549n 0
+    182550n 1.8
+    182599n 1.8
+    182600n 0
+    182649n 0
+    182650n 1.8
+    182699n 1.8
+    182700n 0
+    182749n 0
+    182750n 1.8
+    182799n 1.8
+    182800n 0
+    182849n 0
+    182850n 1.8
+    182899n 1.8
+    182900n 0
+    182949n 0
+    182950n 1.8
+    182999n 1.8
+    183000n 0
+    183049n 0
+    183050n 1.8
+    183099n 1.8
+    183100n 0
+    183149n 0
+    183150n 1.8
+    183199n 1.8
+    183200n 0
+    183249n 0
+    183250n 1.8
+    183299n 1.8
+    183300n 0
+    183349n 0
+    183350n 1.8
+    183399n 1.8
+    183400n 0
+    183449n 0
+    183450n 1.8
+    183499n 1.8
+    183500n 0
+    183549n 0
+    183550n 1.8
+    183599n 1.8
+    183600n 0
+    183649n 0
+    183650n 1.8
+    183699n 1.8
+    183700n 0
+    183749n 0
+    183750n 1.8
+    183799n 1.8
+    183800n 0
+    183849n 0
+    183850n 1.8
+    183899n 1.8
+    183900n 0
+    183949n 0
+    183950n 1.8
+    183999n 1.8
+    184000n 0
+    184049n 0
+    184050n 1.8
+    184099n 1.8
+    184100n 0
+    184149n 0
+    184150n 1.8
+    184199n 1.8
+    184200n 0
+    184249n 0
+    184250n 1.8
+    184299n 1.8
+    184300n 0
+    184349n 0
+    184350n 1.8
+    184399n 1.8
+    184400n 0
+    184449n 0
+    184450n 1.8
+    184499n 1.8
+    184500n 0
+    184549n 0
+    184550n 1.8
+    184599n 1.8
+    184600n 0
+    184649n 0
+    184650n 1.8
+    184699n 1.8
+    184700n 0
+    184749n 0
+    184750n 1.8
+    184799n 1.8
+    184800n 0
+    184849n 0
+    184850n 1.8
+    184899n 1.8
+    184900n 0
+    184949n 0
+    184950n 1.8
+    184999n 1.8
+    185000n 0
+    185049n 0
+    185050n 1.8
+    185099n 1.8
+    185100n 0
+    185149n 0
+    185150n 1.8
+    185199n 1.8
+    185200n 0
+    185249n 0
+    185250n 1.8
+    185299n 1.8
+    185300n 0
+    185349n 0
+    185350n 1.8
+    185399n 1.8
+    185400n 0
+    185449n 0
+    185450n 1.8
+    185499n 1.8
+    185500n 0
+    185549n 0
+    185550n 1.8
+    185599n 1.8
+    185600n 0
+    185649n 0
+    185650n 1.8
+    185699n 1.8
+    185700n 0
+    185749n 0
+    185750n 1.8
+    185799n 1.8
+    185800n 0
+    185849n 0
+    185850n 1.8
+    185899n 1.8
+    185900n 0
+    185949n 0
+    185950n 1.8
+    185999n 1.8
+    186000n 0
+    186049n 0
+    186050n 1.8
+    186099n 1.8
+    186100n 0
+    186149n 0
+    186150n 1.8
+    186199n 1.8
+    186200n 0
+    186249n 0
+    186250n 1.8
+    186299n 1.8
+    186300n 0
+    186349n 0
+    186350n 1.8
+    186399n 1.8
+    186400n 0
+    186449n 0
+    186450n 1.8
+    186499n 1.8
+    186500n 0
+    186549n 0
+    186550n 1.8
+    186599n 1.8
+    186600n 0
+    186649n 0
+    186650n 1.8
+    186699n 1.8
+    186700n 0
+    186749n 0
+    186750n 1.8
+    186799n 1.8
+    186800n 0
+    186849n 0
+    186850n 1.8
+    186899n 1.8
+    186900n 0
+    186949n 0
+    186950n 1.8
+    186999n 1.8
+    187000n 0
+    187049n 0
+    187050n 1.8
+    187099n 1.8
+    187100n 0
+    187149n 0
+    187150n 1.8
+    187199n 1.8
+    187200n 0
+    187249n 0
+    187250n 1.8
+    187299n 1.8
+    187300n 0
+    187349n 0
+    187350n 1.8
+    187399n 1.8
+    187400n 0
+    187449n 0
+    187450n 1.8
+    187499n 1.8
+    187500n 0
+    187549n 0
+    187550n 1.8
+    187599n 1.8
+    187600n 0
+    187649n 0
+    187650n 1.8
+    187699n 1.8
+    187700n 0
+    187749n 0
+    187750n 1.8
+    187799n 1.8
+    187800n 0
+    187849n 0
+    187850n 1.8
+    187899n 1.8
+    187900n 0
+    187949n 0
+    187950n 1.8
+    187999n 1.8
+    188000n 0
+    188049n 0
+    188050n 1.8
+    188099n 1.8
+    188100n 0
+    188149n 0
+    188150n 1.8
+    188199n 1.8
+    188200n 0
+    188249n 0
+    188250n 1.8
+    188299n 1.8
+    188300n 0
+    188349n 0
+    188350n 1.8
+    188399n 1.8
+    188400n 0
+    188449n 0
+    188450n 1.8
+    188499n 1.8
+    188500n 0
+    188549n 0
+    188550n 1.8
+    188599n 1.8
+    188600n 0
+    188649n 0
+    188650n 1.8
+    188699n 1.8
+    188700n 0
+    188749n 0
+    188750n 1.8
+    188799n 1.8
+    188800n 0
+    188849n 0
+    188850n 1.8
+    188899n 1.8
+    188900n 0
+    188949n 0
+    188950n 1.8
+    188999n 1.8
+    189000n 0
+    189049n 0
+    189050n 1.8
+    189099n 1.8
+    189100n 0
+    189149n 0
+    189150n 1.8
+    189199n 1.8
+    189200n 0
+    189249n 0
+    189250n 1.8
+    189299n 1.8
+    189300n 0
+    189349n 0
+    189350n 1.8
+    189399n 1.8
+    189400n 0
+    189449n 0
+    189450n 1.8
+    189499n 1.8
+    189500n 0
+    189549n 0
+    189550n 1.8
+    189599n 1.8
+    189600n 0
+    189649n 0
+    189650n 1.8
+    189699n 1.8
+    189700n 0
+    189749n 0
+    189750n 1.8
+    189799n 1.8
+    189800n 0
+    189849n 0
+    189850n 1.8
+    189899n 1.8
+    189900n 0
+    189949n 0
+    189950n 1.8
+    189999n 1.8
+    190000n 0
+    190049n 0
+    190050n 1.8
+    190099n 1.8
+    190100n 0
+    190149n 0
+    190150n 1.8
+    190199n 1.8
+    190200n 0
+    190249n 0
+    190250n 1.8
+    190299n 1.8
+    190300n 0
+    190349n 0
+    190350n 1.8
+    190399n 1.8
+    190400n 0
+    190449n 0
+    190450n 1.8
+    190499n 1.8
+    190500n 0
+    190549n 0
+    190550n 1.8
+    190599n 1.8
+    190600n 0
+    190649n 0
+    190650n 1.8
+    190699n 1.8
+    190700n 0
+    190749n 0
+    190750n 1.8
+    190799n 1.8
+    190800n 0
+    190849n 0
+    190850n 1.8
+    190899n 1.8
+    190900n 0
+    190949n 0
+    190950n 1.8
+    190999n 1.8
+    191000n 0
+    191049n 0
+    191050n 1.8
+    191099n 1.8
+    191100n 0
+    191149n 0
+    191150n 1.8
+    191199n 1.8
+    191200n 0
+    191249n 0
+    191250n 1.8
+    191299n 1.8
+    191300n 0
+    191349n 0
+    191350n 1.8
+    191399n 1.8
+    191400n 0
+    191449n 0
+    191450n 1.8
+    191499n 1.8
+    191500n 0
+    191549n 0
+    191550n 1.8
+    191599n 1.8
+    191600n 0
+    191649n 0
+    191650n 1.8
+    191699n 1.8
+    191700n 0
+    191749n 0
+    191750n 1.8
+    191799n 1.8
+    191800n 0
+    191849n 0
+    191850n 1.8
+    191899n 1.8
+    191900n 0
+    191949n 0
+    191950n 1.8
+    191999n 1.8
+    192000n 0
+    192049n 0
+    192050n 1.8
+    192099n 1.8
+    192100n 0
+    192149n 0
+    192150n 1.8
+    192199n 1.8
+    192200n 0
+    192249n 0
+    192250n 1.8
+    192299n 1.8
+    192300n 0
+    192349n 0
+    192350n 1.8
+    192399n 1.8
+    192400n 0
+    192449n 0
+    192450n 1.8
+    192499n 1.8
+    192500n 0
+    192549n 0
+    192550n 1.8
+    192599n 1.8
+    192600n 0
+    192649n 0
+    192650n 1.8
+    192699n 1.8
+    192700n 0
+    192749n 0
+    192750n 1.8
+    192799n 1.8
+    192800n 0
+    192849n 0
+    192850n 1.8
+    192899n 1.8
+    192900n 0
+    192949n 0
+    192950n 1.8
+    192999n 1.8
+    193000n 0
+    193049n 0
+    193050n 1.8
+    193099n 1.8
+    193100n 0
+    193149n 0
+    193150n 1.8
+    193199n 1.8
+    193200n 0
+    193249n 0
+    193250n 1.8
+    193299n 1.8
+    193300n 0
+    193349n 0
+    193350n 1.8
+    193399n 1.8
+    193400n 0
+    193449n 0
+    193450n 1.8
+    193499n 1.8
+    193500n 0
+    193549n 0
+    193550n 1.8
+    193599n 1.8
+    193600n 0
+    193649n 0
+    193650n 1.8
+    193699n 1.8
+    193700n 0
+    193749n 0
+    193750n 1.8
+    193799n 1.8
+    193800n 0
+    193849n 0
+    193850n 1.8
+    193899n 1.8
+    193900n 0
+    193949n 0
+    193950n 1.8
+    193999n 1.8
+    194000n 0
+    194049n 0
+    194050n 1.8
+    194099n 1.8
+    194100n 0
+    194149n 0
+    194150n 1.8
+    194199n 1.8
+    194200n 0
+    194249n 0
+    194250n 1.8
+    194299n 1.8
+    194300n 0
+    194349n 0
+    194350n 1.8
+    194399n 1.8
+    194400n 0
+    194449n 0
+    194450n 1.8
+    194499n 1.8
+    194500n 0
+    194549n 0
+    194550n 1.8
+    194599n 1.8
+    194600n 0
+    194649n 0
+    194650n 1.8
+    194699n 1.8
+    194700n 0
+    194749n 0
+    194750n 1.8
+    194799n 1.8
+    194800n 0
+    194849n 0
+    194850n 1.8
+    194899n 1.8
+    194900n 0
+    194949n 0
+    194950n 1.8
+    194999n 1.8
+    195000n 0
+    195049n 0
+    195050n 1.8
+    195099n 1.8
+    195100n 0
+    195149n 0
+    195150n 1.8
+    195199n 1.8
+    195200n 0
+    195249n 0
+    195250n 1.8
+    195299n 1.8
+    195300n 0
+    195349n 0
+    195350n 1.8
+    195399n 1.8
+    195400n 0
+    195449n 0
+    195450n 1.8
+    195499n 1.8
+    195500n 0
+    195549n 0
+    195550n 1.8
+    195599n 1.8
+    195600n 0
+    195649n 0
+    195650n 1.8
+    195699n 1.8
+    195700n 0
+    195749n 0
+    195750n 1.8
+    195799n 1.8
+    195800n 0
+    195849n 0
+    195850n 1.8
+    195899n 1.8
+    195900n 0
+    195949n 0
+    195950n 1.8
+    195999n 1.8
+    196000n 0
+    196049n 0
+    196050n 1.8
+    196099n 1.8
+    196100n 0
+    196149n 0
+    196150n 1.8
+    196199n 1.8
+    196200n 0
+    196249n 0
+    196250n 1.8
+    196299n 1.8
+    196300n 0
+    196349n 0
+    196350n 1.8
+    196399n 1.8
+    196400n 0
+    196449n 0
+    196450n 1.8
+    196499n 1.8
+    196500n 0
+    196549n 0
+    196550n 1.8
+    196599n 1.8
+    196600n 0
+    196649n 0
+    196650n 1.8
+    196699n 1.8
+    196700n 0
+    196749n 0
+    196750n 1.8
+    196799n 1.8
+    196800n 0
+    196849n 0
+    196850n 1.8
+    196899n 1.8
+    196900n 0
+    196949n 0
+    196950n 1.8
+    196999n 1.8
+    197000n 0
+    197049n 0
+    197050n 1.8
+    197099n 1.8
+    197100n 0
+    197149n 0
+    197150n 1.8
+    197199n 1.8
+    197200n 0
+    197249n 0
+    197250n 1.8
+    197299n 1.8
+    197300n 0
+    197349n 0
+    197350n 1.8
+    197399n 1.8
+    197400n 0
+    197449n 0
+    197450n 1.8
+    197499n 1.8
+    197500n 0
+    197549n 0
+    197550n 1.8
+    197599n 1.8
+    197600n 0
+    197649n 0
+    197650n 1.8
+    197699n 1.8
+    197700n 0
+    197749n 0
+    197750n 1.8
+    197799n 1.8
+    197800n 0
+    197849n 0
+    197850n 1.8
+    197899n 1.8
+    197900n 0
+    197949n 0
+    197950n 1.8
+    197999n 1.8
+    198000n 0
+    198049n 0
+    198050n 1.8
+    198099n 1.8
+    198100n 0
+    198149n 0
+    198150n 1.8
+    198199n 1.8
+    198200n 0
+    198249n 0
+    198250n 1.8
+    198299n 1.8
+    198300n 0
+    198349n 0
+    198350n 1.8
+    198399n 1.8
+    198400n 0
+    198449n 0
+    198450n 1.8
+    198499n 1.8
+    198500n 0
+    198549n 0
+    198550n 1.8
+    198599n 1.8
+    198600n 0
+    198649n 0
+    198650n 1.8
+    198699n 1.8
+    198700n 0
+    198749n 0
+    198750n 1.8
+    198799n 1.8
+    198800n 0
+    198849n 0
+    198850n 1.8
+    198899n 1.8
+    198900n 0
+    198949n 0
+    198950n 1.8
+    198999n 1.8
+    199000n 0
+    199049n 0
+    199050n 1.8
+    199099n 1.8
+    199100n 0
+    199149n 0
+    199150n 1.8
+    199199n 1.8
+    199200n 0
+    199249n 0
+    199250n 1.8
+    199299n 1.8
+    199300n 0
+    199349n 0
+    199350n 1.8
+    199399n 1.8
+    199400n 0
+    199449n 0
+    199450n 1.8
+    199499n 1.8
+    199500n 0
+    199549n 0
+    199550n 1.8
+    199599n 1.8
+    199600n 0
+    199649n 0
+    199650n 1.8
+    199699n 1.8
+    199700n 0
+    199749n 0
+    199750n 1.8
+    199799n 1.8
+    199800n 0
+    199849n 0
+    199850n 1.8
+    199899n 1.8
+    199900n 0
+    199949n 0
+    199950n 1.8
+    199999n 1.8
+    200000n 0
+    200049n 0
+    200050n 1.8
+    200099n 1.8
+    200100n 0
+    200149n 0
+    200150n 1.8
+    200199n 1.8
+    200200n 0
+    200249n 0
+    200250n 1.8
+    200299n 1.8
+    200300n 0
+    200349n 0
+    200350n 1.8
+    200399n 1.8
+    200400n 0
+    200449n 0
+    200450n 1.8
+    200499n 1.8
+    200500n 0
+    200549n 0
+    200550n 1.8
+    200599n 1.8
+    200600n 0
+    200649n 0
+    200650n 1.8
+    200699n 1.8
+    200700n 0
+    200749n 0
+    200750n 1.8
+    200799n 1.8
+    200800n 0
+    200849n 0
+    200850n 1.8
+    200899n 1.8
+    200900n 0
+    200949n 0
+    200950n 1.8
+    200999n 1.8
+    201000n 0
+    201049n 0
+    201050n 1.8
+    201099n 1.8
+    201100n 0
+    201149n 0
+    201150n 1.8
+    201199n 1.8
+    201200n 0
+    201249n 0
+    201250n 1.8
+    201299n 1.8
+    201300n 0
+    201349n 0
+    201350n 1.8
+    201399n 1.8
+    201400n 0
+    201449n 0
+    201450n 1.8
+    201499n 1.8
+    201500n 0
+    201549n 0
+    201550n 1.8
+    201599n 1.8
+    201600n 0
+    201649n 0
+    201650n 1.8
+    201699n 1.8
+    201700n 0
+    201749n 0
+    201750n 1.8
+    201799n 1.8
+    201800n 0
+    201849n 0
+    201850n 1.8
+    201899n 1.8
+    201900n 0
+    201949n 0
+    201950n 1.8
+    201999n 1.8
+    202000n 0
+    202049n 0
+    202050n 1.8
+    202099n 1.8
+    202100n 0
+    202149n 0
+    202150n 1.8
+    202199n 1.8
+    202200n 0
+    202249n 0
+    202250n 1.8
+    202299n 1.8
+    202300n 0
+    202349n 0
+    202350n 1.8
+    202399n 1.8
+    202400n 0
+    202449n 0
+    202450n 1.8
+    202499n 1.8
+    202500n 0
+    202549n 0
+    202550n 1.8
+    202599n 1.8
+    202600n 0
+    202649n 0
+    202650n 1.8
+    202699n 1.8
+    202700n 0
+    202749n 0
+    202750n 1.8
+    202799n 1.8
+    202800n 0
+    202849n 0
+    202850n 1.8
+    202899n 1.8
+    202900n 0
+    202949n 0
+    202950n 1.8
+    202999n 1.8
+    203000n 0
+    203049n 0
+    203050n 1.8
+    203099n 1.8
+    203100n 0
+    203149n 0
+    203150n 1.8
+    203199n 1.8
+    203200n 0
+    203249n 0
+    203250n 1.8
+    203299n 1.8
+    203300n 0
+    203349n 0
+    203350n 1.8
+    203399n 1.8
+    203400n 0
+    203449n 0
+    203450n 1.8
+    203499n 1.8
+    203500n 0
+    203549n 0
+    203550n 1.8
+    203599n 1.8
+    203600n 0
+    203649n 0
+    203650n 1.8
+    203699n 1.8
+    203700n 0
+    203749n 0
+    203750n 1.8
+    203799n 1.8
+    203800n 0
+    203849n 0
+    203850n 1.8
+    203899n 1.8
+    203900n 0
+    203949n 0
+    203950n 1.8
+    203999n 1.8
+    204000n 0
+    204049n 0
+    204050n 1.8
+    204099n 1.8
+    204100n 0
+    204149n 0
+    204150n 1.8
+    204199n 1.8
+    204200n 0
+    204249n 0
+    204250n 1.8
+    204299n 1.8
+    204300n 0
+    204349n 0
+    204350n 1.8
+    204399n 1.8
+    204400n 0
+    204449n 0
+    204450n 1.8
+    204499n 1.8
+    204500n 0
+    204549n 0
+    204550n 1.8
+    204599n 1.8
+    204600n 0
+    204649n 0
+    204650n 1.8
+    204699n 1.8
+    204700n 0
+    204749n 0
+    204750n 1.8
+    204799n 1.8
+    204800n 0
+    204849n 0
+    204850n 1.8
+    204899n 1.8
+    204900n 0
+    204949n 0
+    204950n 1.8
+    204999n 1.8
+    205000n 0
+    205049n 0
+    205050n 1.8
+    205099n 1.8
+    205100n 0
+    205149n 0
+    205150n 1.8
+    205199n 1.8
+    205200n 0
+    205249n 0
+    205250n 1.8
+    205299n 1.8
+    205300n 0
+    205349n 0
+    205350n 1.8
+    205399n 1.8
+    205400n 0
+    205449n 0
+    205450n 1.8
+    205499n 1.8
+    205500n 0
+    205549n 0
+    205550n 1.8
+    205599n 1.8
+    205600n 0
+    205649n 0
+    205650n 1.8
+    205699n 1.8
+    205700n 0
+    205749n 0
+    205750n 1.8
+    205799n 1.8
+    205800n 0
+    205849n 0
+    205850n 1.8
+    205899n 1.8
+    205900n 0
+    205949n 0
+    205950n 1.8
+    205999n 1.8
+    206000n 0
+    206049n 0
+    206050n 1.8
+    206099n 1.8
+    206100n 0
+    206149n 0
+    206150n 1.8
+    206199n 1.8
+    206200n 0
+    206249n 0
+    206250n 1.8
+    206299n 1.8
+    206300n 0
+    206349n 0
+    206350n 1.8
+    206399n 1.8
+    206400n 0
+    206449n 0
+    206450n 1.8
+    206499n 1.8
+    206500n 0
+    206549n 0
+    206550n 1.8
+    206599n 1.8
+    206600n 0
+    206649n 0
+    206650n 1.8
+    206699n 1.8
+    206700n 0
+    206749n 0
+    206750n 1.8
+    206799n 1.8
+    206800n 0
+    206849n 0
+    206850n 1.8
+    206899n 1.8
+    206900n 0
+    206949n 0
+    206950n 1.8
+    206999n 1.8
+    207000n 0
+    207049n 0
+    207050n 1.8
+    207099n 1.8
+    207100n 0
+    207149n 0
+    207150n 1.8
+    207199n 1.8
+    207200n 0
+    207249n 0
+    207250n 1.8
+    207299n 1.8
+    207300n 0
+    207349n 0
+    207350n 1.8
+    207399n 1.8
+    207400n 0
+    207449n 0
+    207450n 1.8
+    207499n 1.8
+    207500n 0
+    207549n 0
+    207550n 1.8
+    207599n 1.8
+    207600n 0
+    207649n 0
+    207650n 1.8
+    207699n 1.8
+    207700n 0
+    207749n 0
+    207750n 1.8
+    207799n 1.8
+    207800n 0
+    207849n 0
+    207850n 1.8
+    207899n 1.8
+    207900n 0
+    207949n 0
+    207950n 1.8
+    207999n 1.8
+    208000n 0
+    208049n 0
+    208050n 1.8
+    208099n 1.8
+    208100n 0
+    208149n 0
+    208150n 1.8
+    208199n 1.8
+    208200n 0
+    208249n 0
+    208250n 1.8
+    208299n 1.8
+    208300n 0
+    208349n 0
+    208350n 1.8
+    208399n 1.8
+    208400n 0
+    208449n 0
+    208450n 1.8
+    208499n 1.8
+    208500n 0
+    208549n 0
+    208550n 1.8
+    208599n 1.8
+    208600n 0
+    208649n 0
+    208650n 1.8
+    208699n 1.8
+    208700n 0
+    208749n 0
+    208750n 1.8
+    208799n 1.8
+    208800n 0
+    208849n 0
+    208850n 1.8
+    208899n 1.8
+    208900n 0
+    208949n 0
+    208950n 1.8
+    208999n 1.8
+    209000n 0
+    209049n 0
+    209050n 1.8
+    209099n 1.8
+    209100n 0
+    209149n 0
+    209150n 1.8
+    209199n 1.8
+    209200n 0
+    209249n 0
+    209250n 1.8
+    209299n 1.8
+    209300n 0
+    209349n 0
+    209350n 1.8
+    209399n 1.8
+    209400n 0
+    209449n 0
+    209450n 1.8
+    209499n 1.8
+    209500n 0
+    209549n 0
+    209550n 1.8
+    209599n 1.8
+    209600n 0
+    209649n 0
+    209650n 1.8
+    209699n 1.8
+    209700n 0
+    209749n 0
+    209750n 1.8
+    209799n 1.8
+    209800n 0
+    209849n 0
+    209850n 1.8
+    209899n 1.8
+    209900n 0
+    209949n 0
+    209950n 1.8
+    209999n 1.8
+    210000n 0
+    210049n 0
+    210050n 1.8
+    210099n 1.8
+    210100n 0
+    210149n 0
+    210150n 1.8
+    210199n 1.8
+    210200n 0
+    210249n 0
+    210250n 1.8
+    210299n 1.8
+    210300n 0
+    210349n 0
+    210350n 1.8
+    210399n 1.8
+    210400n 0
+    210449n 0
+    210450n 1.8
+    210499n 1.8
+    210500n 0
+    210549n 0
+    210550n 1.8
+    210599n 1.8
+    210600n 0
+    210649n 0
+    210650n 1.8
+    210699n 1.8
+    210700n 0
+    210749n 0
+    210750n 1.8
+    210799n 1.8
+    210800n 0
+    210849n 0
+    210850n 1.8
+    210899n 1.8
+    210900n 0
+    210949n 0
+    210950n 1.8
+    210999n 1.8
+    211000n 0
+    211049n 0
+    211050n 1.8
+    211099n 1.8
+    211100n 0
+    211149n 0
+    211150n 1.8
+    211199n 1.8
+    211200n 0
+    211249n 0
+    211250n 1.8
+    211299n 1.8
+    211300n 0
+    211349n 0
+    211350n 1.8
+    211399n 1.8
+    211400n 0
+    211449n 0
+    211450n 1.8
+    211499n 1.8
+    211500n 0
+    211549n 0
+    211550n 1.8
+    211599n 1.8
+    211600n 0
+    211649n 0
+    211650n 1.8
+    211699n 1.8
+    211700n 0
+    211749n 0
+    211750n 1.8
+    211799n 1.8
+    211800n 0
+    211849n 0
+    211850n 1.8
+    211899n 1.8
+    211900n 0
+    211949n 0
+    211950n 1.8
+    211999n 1.8
+    212000n 0
+    212049n 0
+    212050n 1.8
+    212099n 1.8
+    212100n 0
+    212149n 0
+    212150n 1.8
+    212199n 1.8
+    212200n 0
+    212249n 0
+    212250n 1.8
+    212299n 1.8
+    212300n 0
+    212349n 0
+    212350n 1.8
+    212399n 1.8
+    212400n 0
+    212449n 0
+    212450n 1.8
+    212499n 1.8
+    212500n 0
+    212549n 0
+    212550n 1.8
+    212599n 1.8
+    212600n 0
+    212649n 0
+    212650n 1.8
+    212699n 1.8
+    212700n 0
+    212749n 0
+    212750n 1.8
+    212799n 1.8
+    212800n 0
+    212849n 0
+    212850n 1.8
+    212899n 1.8
+    212900n 0
+    212949n 0
+    212950n 1.8
+    212999n 1.8
+    213000n 0
+    213049n 0
+    213050n 1.8
+    213099n 1.8
+    213100n 0
+    213149n 0
+    213150n 1.8
+    213199n 1.8
+    213200n 0
+    213249n 0
+    213250n 1.8
+    213299n 1.8
+    213300n 0
+    213349n 0
+    213350n 1.8
+    213399n 1.8
+    213400n 0
+    213449n 0
+    213450n 1.8
+    213499n 1.8
+    213500n 0
+    213549n 0
+    213550n 1.8
+    213599n 1.8
+    213600n 0
+    213649n 0
+    213650n 1.8
+    213699n 1.8
+    213700n 0
+    213749n 0
+    213750n 1.8
+    213799n 1.8
+    213800n 0
+    213849n 0
+    213850n 1.8
+    213899n 1.8
+    213900n 0
+    213949n 0
+    213950n 1.8
+    213999n 1.8
+    214000n 0
+    214049n 0
+    214050n 1.8
+    214099n 1.8
+    214100n 0
+    214149n 0
+    214150n 1.8
+    214199n 1.8
+    214200n 0
+    214249n 0
+    214250n 1.8
+    214299n 1.8
+    214300n 0
+    214349n 0
+    214350n 1.8
+    214399n 1.8
+    214400n 0
+    214449n 0
+    214450n 1.8
+    214499n 1.8
+    214500n 0
+    214549n 0
+    214550n 1.8
+    214599n 1.8
+    214600n 0
+    214649n 0
+    214650n 1.8
+    214699n 1.8
+    214700n 0
+    214749n 0
+    214750n 1.8
+    214799n 1.8
+    214800n 0
+    214849n 0
+    214850n 1.8
+    214899n 1.8
+    214900n 0
+    214949n 0
+    214950n 1.8
+    214999n 1.8
+    215000n 0
+    215049n 0
+    215050n 1.8
+    215099n 1.8
+    215100n 0
+    215149n 0
+    215150n 1.8
+    215199n 1.8
+    215200n 0
+    215249n 0
+    215250n 1.8
+    215299n 1.8
+    215300n 0
+    215349n 0
+    215350n 1.8
+    215399n 1.8
+    215400n 0
+    215449n 0
+    215450n 1.8
+    215499n 1.8
+    215500n 0
+    215549n 0
+    215550n 1.8
+    215599n 1.8
+    215600n 0
+    215649n 0
+    215650n 1.8
+    215699n 1.8
+    215700n 0
+    215749n 0
+    215750n 1.8
+    215799n 1.8
+    215800n 0
+    215849n 0
+    215850n 1.8
+    215899n 1.8
+    215900n 0
+    215949n 0
+    215950n 1.8
+    215999n 1.8
+    216000n 0
+    216049n 0
+    216050n 1.8
+    216099n 1.8
+    216100n 0
+    216149n 0
+    216150n 1.8
+    216199n 1.8
+    216200n 0
+    216249n 0
+    216250n 1.8
+    216299n 1.8
+    216300n 0
+    216349n 0
+    216350n 1.8
+    216399n 1.8
+    216400n 0
+    216449n 0
+    216450n 1.8
+    216499n 1.8
+    216500n 0
+    216549n 0
+    216550n 1.8
+    216599n 1.8
+    216600n 0
+    216649n 0
+    216650n 1.8
+    216699n 1.8
+    216700n 0
+    216749n 0
+    216750n 1.8
+    216799n 1.8
+    216800n 0
+    216849n 0
+    216850n 1.8
+    216899n 1.8
+    216900n 0
+    216949n 0
+    216950n 1.8
+    216999n 1.8
+    217000n 0
+    217049n 0
+    217050n 1.8
+    217099n 1.8
+    217100n 0
+    217149n 0
+    217150n 1.8
+    217199n 1.8
+    217200n 0
+    217249n 0
+    217250n 1.8
+    217299n 1.8
+    217300n 0
+    217349n 0
+    217350n 1.8
+    217399n 1.8
+    217400n 0
+    217449n 0
+    217450n 1.8
+    217499n 1.8
+    217500n 0
+    217549n 0
+    217550n 1.8
+    217599n 1.8
+    217600n 0
+    217649n 0
+    217650n 1.8
+    217699n 1.8
+    217700n 0
+    217749n 0
+    217750n 1.8
+    217799n 1.8
+    217800n 0
+    217849n 0
+    217850n 1.8
+    217899n 1.8
+    217900n 0
+    217949n 0
+    217950n 1.8
+    217999n 1.8
+    218000n 0
+    218049n 0
+    218050n 1.8
+    218099n 1.8
+    218100n 0
+    218149n 0
+    218150n 1.8
+    218199n 1.8
+    218200n 0
+    218249n 0
+    218250n 1.8
+    218299n 1.8
+    218300n 0
+    218349n 0
+    218350n 1.8
+    218399n 1.8
+    218400n 0
+    218449n 0
+    218450n 1.8
+    218499n 1.8
+    218500n 0
+    218549n 0
+    218550n 1.8
+    218599n 1.8
+    218600n 0
+    218649n 0
+    218650n 1.8
+    218699n 1.8
+    218700n 0
+    218749n 0
+    218750n 1.8
+    218799n 1.8
+    218800n 0
+    218849n 0
+    218850n 1.8
+    218899n 1.8
+    218900n 0
+    218949n 0
+    218950n 1.8
+    218999n 1.8
+    219000n 0
+    219049n 0
+    219050n 1.8
+    219099n 1.8
+    219100n 0
+    219149n 0
+    219150n 1.8
+    219199n 1.8
+    219200n 0
+    219249n 0
+    219250n 1.8
+    219299n 1.8
+    219300n 0
+    219349n 0
+    219350n 1.8
+    219399n 1.8
+    219400n 0
+    219449n 0
+    219450n 1.8
+    219499n 1.8
+    219500n 0
+    219549n 0
+    219550n 1.8
+    219599n 1.8
+    219600n 0
+    219649n 0
+    219650n 1.8
+    219699n 1.8
+    219700n 0
+    219749n 0
+    219750n 1.8
+    219799n 1.8
+    219800n 0
+    219849n 0
+    219850n 1.8
+    219899n 1.8
+    219900n 0
+    219949n 0
+    219950n 1.8
+    219999n 1.8
+    220000n 0
+    220049n 0
+    220050n 1.8
+    220099n 1.8
+    220100n 0
+    220149n 0
+    220150n 1.8
+    220199n 1.8
+    220200n 0
+    220249n 0
+    220250n 1.8
+    220299n 1.8
+    220300n 0
+    220349n 0
+    220350n 1.8
+    220399n 1.8
+    220400n 0
+    220449n 0
+    220450n 1.8
+    220499n 1.8
+    220500n 0
+    220549n 0
+    220550n 1.8
+    220599n 1.8
+    220600n 0
+    220649n 0
+    220650n 1.8
+    220699n 1.8
+    220700n 0
+    220749n 0
+    220750n 1.8
+    220799n 1.8
+    220800n 0
+    220849n 0
+    220850n 1.8
+    220899n 1.8
+    220900n 0
+    220949n 0
+    220950n 1.8
+    220999n 1.8
+    221000n 0
+    221049n 0
+    221050n 1.8
+    221099n 1.8
+    221100n 0
+    221149n 0
+    221150n 1.8
+    221199n 1.8
+    221200n 0
+    221249n 0
+    221250n 1.8
+    221299n 1.8
+    221300n 0
+    221349n 0
+    221350n 1.8
+    221399n 1.8
+    221400n 0
+    221449n 0
+    221450n 1.8
+    221499n 1.8
+    221500n 0
+    221549n 0
+    221550n 1.8
+    221599n 1.8
+    221600n 0
+    221649n 0
+    221650n 1.8
+    221699n 1.8
+    221700n 0
+    221749n 0
+    221750n 1.8
+    221799n 1.8
+    221800n 0
+    221849n 0
+    221850n 1.8
+    221899n 1.8
+    221900n 0
+    221949n 0
+    221950n 1.8
+    221999n 1.8
+    222000n 0
+    222049n 0
+    222050n 1.8
+    222099n 1.8
+    222100n 0
+    222149n 0
+    222150n 1.8
+    222199n 1.8
+    222200n 0
+    222249n 0
+    222250n 1.8
+    222299n 1.8
+    222300n 0
+    222349n 0
+    222350n 1.8
+    222399n 1.8
+    222400n 0
+    222449n 0
+    222450n 1.8
+    222499n 1.8
+    222500n 0
+    222549n 0
+    222550n 1.8
+    222599n 1.8
+    222600n 0
+    222649n 0
+    222650n 1.8
+    222699n 1.8
+    222700n 0
+    222749n 0
+    222750n 1.8
+    222799n 1.8
+    222800n 0
+    222849n 0
+    222850n 1.8
+    222899n 1.8
+    222900n 0
+    222949n 0
+    222950n 1.8
+    222999n 1.8
+    223000n 0
+    223049n 0
+    223050n 1.8
+    223099n 1.8
+    223100n 0
+    223149n 0
+    223150n 1.8
+    223199n 1.8
+    223200n 0
+    223249n 0
+    223250n 1.8
+    223299n 1.8
+    223300n 0
+    223349n 0
+    223350n 1.8
+    223399n 1.8
+    223400n 0
+    223449n 0
+    223450n 1.8
+    223499n 1.8
+    223500n 0
+    223549n 0
+    223550n 1.8
+    223599n 1.8
+    223600n 0
+    223649n 0
+    223650n 1.8
+    223699n 1.8
+    223700n 0
+    223749n 0
+    223750n 1.8
+    223799n 1.8
+    223800n 0
+    223849n 0
+    223850n 1.8
+    223899n 1.8
+    223900n 0
+    223949n 0
+    223950n 1.8
+    223999n 1.8
+    224000n 0
+    224049n 0
+    224050n 1.8
+    224099n 1.8
+    224100n 0
+    224149n 0
+    224150n 1.8
+    224199n 1.8
+    224200n 0
+    224249n 0
+    224250n 1.8
+    224299n 1.8
+    224300n 0
+    224349n 0
+    224350n 1.8
+    224399n 1.8
+    224400n 0
+    224449n 0
+    224450n 1.8
+    224499n 1.8
+    224500n 0
+    224549n 0
+    224550n 1.8
+    224599n 1.8
+    224600n 0
+    224649n 0
+    224650n 1.8
+    224699n 1.8
+    224700n 0
+    224749n 0
+    224750n 1.8
+    224799n 1.8
+    224800n 0
+    224849n 0
+    224850n 1.8
+    224899n 1.8
+    224900n 0
+    224949n 0
+    224950n 1.8
+    224999n 1.8
+    225000n 0
+    225049n 0
+    225050n 1.8
+    225099n 1.8
+    225100n 0
+    225149n 0
+    225150n 1.8
+    225199n 1.8
+    225200n 0
+    225249n 0
+    225250n 1.8
+    225299n 1.8
+    225300n 0
+    225349n 0
+    225350n 1.8
+    225399n 1.8
+    225400n 0
+    225449n 0
+    225450n 1.8
+    225499n 1.8
+    225500n 0
+    225549n 0
+    225550n 1.8
+    225599n 1.8
+    225600n 0
+    225649n 0
+    225650n 1.8
+    225699n 1.8
+    225700n 0
+    225749n 0
+    225750n 1.8
+    225799n 1.8
+    225800n 0
+    225849n 0
+    225850n 1.8
+    225899n 1.8
+    225900n 0
+    225949n 0
+    225950n 1.8
+    225999n 1.8
+    226000n 0
+    226049n 0
+    226050n 1.8
+    226099n 1.8
+    226100n 0
+    226149n 0
+    226150n 1.8
+    226199n 1.8
+    226200n 0
+    226249n 0
+    226250n 1.8
+    226299n 1.8
+    226300n 0
+    226349n 0
+    226350n 1.8
+    226399n 1.8
+    226400n 0
+    226449n 0
+    226450n 1.8
+    226499n 1.8
+    226500n 0
+    226549n 0
+    226550n 1.8
+    226599n 1.8
+    226600n 0
+    226649n 0
+    226650n 1.8
+    226699n 1.8
+    226700n 0
+    226749n 0
+    226750n 1.8
+    226799n 1.8
+    226800n 0
+    226849n 0
+    226850n 1.8
+    226899n 1.8
+    226900n 0
+    226949n 0
+    226950n 1.8
+    226999n 1.8
+    227000n 0
+    227049n 0
+    227050n 1.8
+    227099n 1.8
+    227100n 0
+    227149n 0
+    227150n 1.8
+    227199n 1.8
+    227200n 0
+    227249n 0
+    227250n 1.8
+    227299n 1.8
+    227300n 0
+    227349n 0
+    227350n 1.8
+    227399n 1.8
+    227400n 0
+    227449n 0
+    227450n 1.8
+    227499n 1.8
+    227500n 0
+    227549n 0
+    227550n 1.8
+    227599n 1.8
+    227600n 0
+    227649n 0
+    227650n 1.8
+    227699n 1.8
+    227700n 0
+    227749n 0
+    227750n 1.8
+    227799n 1.8
+    227800n 0
+    227849n 0
+    227850n 1.8
+    227899n 1.8
+    227900n 0
+    227949n 0
+    227950n 1.8
+    227999n 1.8
+    228000n 0
+    228049n 0
+    228050n 1.8
+    228099n 1.8
+    228100n 0
+    228149n 0
+    228150n 1.8
+    228199n 1.8
+    228200n 0
+    228249n 0
+    228250n 1.8
+    228299n 1.8
+    228300n 0
+    228349n 0
+    228350n 1.8
+    228399n 1.8
+    228400n 0
+    228449n 0
+    228450n 1.8
+    228499n 1.8
+    228500n 0
+    228549n 0
+    228550n 1.8
+    228599n 1.8
+    228600n 0
+    228649n 0
+    228650n 1.8
+    228699n 1.8
+    228700n 0
+    228749n 0
+    228750n 1.8
+    228799n 1.8
+    228800n 0
+    228849n 0
+    228850n 1.8
+    228899n 1.8
+    228900n 0
+    228949n 0
+    228950n 1.8
+    228999n 1.8
+    229000n 0
+    229049n 0
+    229050n 1.8
+    229099n 1.8
+    229100n 0
+    229149n 0
+    229150n 1.8
+    229199n 1.8
+    229200n 0
+    229249n 0
+    229250n 1.8
+    229299n 1.8
+    229300n 0
+    229349n 0
+    229350n 1.8
+    229399n 1.8
+    229400n 0
+    229449n 0
+    229450n 1.8
+    229499n 1.8
+    229500n 0
+    229549n 0
+    229550n 1.8
+    229599n 1.8
+    229600n 0
+    229649n 0
+    229650n 1.8
+    229699n 1.8
+    229700n 0
+    229749n 0
+    229750n 1.8
+    229799n 1.8
+    229800n 0
+    229849n 0
+    229850n 1.8
+    229899n 1.8
+    229900n 0
+    229949n 0
+    229950n 1.8
+    229999n 1.8
+    230000n 0
+    230049n 0
+    230050n 1.8
+    230099n 1.8
+    230100n 0
+    230149n 0
+    230150n 1.8
+    230199n 1.8
+    230200n 0
+    230249n 0
+    230250n 1.8
+    230299n 1.8
+    230300n 0
+    230349n 0
+    230350n 1.8
+    230399n 1.8
+    230400n 0
+    230449n 0
+    230450n 1.8
+    230499n 1.8
+    230500n 0
+    230549n 0
+    230550n 1.8
+    230599n 1.8
+    230600n 0
+    230649n 0
+    230650n 1.8
+    230699n 1.8
+    230700n 0
+    230749n 0
+    230750n 1.8
+    230799n 1.8
+    230800n 0
+    230849n 0
+    230850n 1.8
+    230899n 1.8
+    230900n 0
+    230949n 0
+    230950n 1.8
+    230999n 1.8
+    231000n 0
+    231049n 0
+    231050n 1.8
+    231099n 1.8
+    231100n 0
+    231149n 0
+    231150n 1.8
+    231199n 1.8
+    231200n 0
+    231249n 0
+    231250n 1.8
+    231299n 1.8
+    231300n 0
+    231349n 0
+    231350n 1.8
+    231399n 1.8
+    231400n 0
+    231449n 0
+    231450n 1.8
+    231499n 1.8
+    231500n 0
+    231549n 0
+    231550n 1.8
+    231599n 1.8
+    231600n 0
+    231649n 0
+    231650n 1.8
+    231699n 1.8
+    231700n 0
+    231749n 0
+    231750n 1.8
+    231799n 1.8
+    231800n 0
+    231849n 0
+    231850n 1.8
+    231899n 1.8
+    231900n 0
+    231949n 0
+    231950n 1.8
+    231999n 1.8
+    232000n 0
+    232049n 0
+    232050n 1.8
+    232099n 1.8
+    232100n 0
+    232149n 0
+    232150n 1.8
+    232199n 1.8
+    232200n 0
+    232249n 0
+    232250n 1.8
+    232299n 1.8
+    232300n 0
+    232349n 0
+    232350n 1.8
+    232399n 1.8
+    232400n 0
+    232449n 0
+    232450n 1.8
+    232499n 1.8
+    232500n 0
+    232549n 0
+    232550n 1.8
+    232599n 1.8
+    232600n 0
+    232649n 0
+    232650n 1.8
+    232699n 1.8
+    232700n 0
+    232749n 0
+    232750n 1.8
+    232799n 1.8
+    232800n 0
+    232849n 0
+    232850n 1.8
+    232899n 1.8
+    232900n 0
+    232949n 0
+    232950n 1.8
+    232999n 1.8
+    233000n 0
+    233049n 0
+    233050n 1.8
+    233099n 1.8
+    233100n 0
+    233149n 0
+    233150n 1.8
+    233199n 1.8
+    233200n 0
+    233249n 0
+    233250n 1.8
+    233299n 1.8
+    233300n 0
+    233349n 0
+    233350n 1.8
+    233399n 1.8
+    233400n 0
+    233449n 0
+    233450n 1.8
+    233499n 1.8
+    233500n 0
+    233549n 0
+    233550n 1.8
+    233599n 1.8
+    233600n 0
+    233649n 0
+    233650n 1.8
+    233699n 1.8
+    233700n 0
+    233749n 0
+    233750n 1.8
+    233799n 1.8
+    233800n 0
+    233849n 0
+    233850n 1.8
+    233899n 1.8
+    233900n 0
+    233949n 0
+    233950n 1.8
+    233999n 1.8
+    234000n 0
+    234049n 0
+    234050n 1.8
+    234099n 1.8
+    234100n 0
+    234149n 0
+    234150n 1.8
+    234199n 1.8
+    234200n 0
+    234249n 0
+    234250n 1.8
+    234299n 1.8
+    234300n 0
+    234349n 0
+    234350n 1.8
+    234399n 1.8
+    234400n 0
+    234449n 0
+    234450n 1.8
+    234499n 1.8
+    234500n 0
+    234549n 0
+    234550n 1.8
+    234599n 1.8
+    234600n 0
+    234649n 0
+    234650n 1.8
+    234699n 1.8
+    234700n 0
+    234749n 0
+    234750n 1.8
+    234799n 1.8
+    234800n 0
+    234849n 0
+    234850n 1.8
+    234899n 1.8
+    234900n 0
+    234949n 0
+    234950n 1.8
+    234999n 1.8
+    235000n 0
+    235049n 0
+    235050n 1.8
+    235099n 1.8
+    235100n 0
+    235149n 0
+    235150n 1.8
+    235199n 1.8
+    235200n 0
+    235249n 0
+    235250n 1.8
+    235299n 1.8
+    235300n 0
+    235349n 0
+    235350n 1.8
+    235399n 1.8
+    235400n 0
+    235449n 0
+    235450n 1.8
+    235499n 1.8
+    235500n 0
+    235549n 0
+    235550n 1.8
+    235599n 1.8
+    235600n 0
+    235649n 0
+    235650n 1.8
+    235699n 1.8
+    235700n 0
+    235749n 0
+    235750n 1.8
+    235799n 1.8
+    235800n 0
+    235849n 0
+    235850n 1.8
+    235899n 1.8
+    235900n 0
+    235949n 0
+    235950n 1.8
+    235999n 1.8
+    236000n 0
+    236049n 0
+    236050n 1.8
+    236099n 1.8
+    236100n 0
+    236149n 0
+    236150n 1.8
+    236199n 1.8
+    236200n 0
+    236249n 0
+    236250n 1.8
+    236299n 1.8
+    236300n 0
+    236349n 0
+    236350n 1.8
+    236399n 1.8
+    236400n 0
+    236449n 0
+    236450n 1.8
+    236499n 1.8
+    236500n 0
+    236549n 0
+    236550n 1.8
+    236599n 1.8
+    236600n 0
+    236649n 0
+    236650n 1.8
+    236699n 1.8
+    236700n 0
+    236749n 0
+    236750n 1.8
+    236799n 1.8
+    236800n 0
+    236849n 0
+    236850n 1.8
+    236899n 1.8
+    236900n 0
+    236949n 0
+    236950n 1.8
+    236999n 1.8
+    237000n 0
+    237049n 0
+    237050n 1.8
+    237099n 1.8
+    237100n 0
+    237149n 0
+    237150n 1.8
+    237199n 1.8
+    237200n 0
+    237249n 0
+    237250n 1.8
+    237299n 1.8
+    237300n 0
+    237349n 0
+    237350n 1.8
+    237399n 1.8
+    237400n 0
+    237449n 0
+    237450n 1.8
+    237499n 1.8
+    237500n 0
+    237549n 0
+    237550n 1.8
+    237599n 1.8
+    237600n 0
+    237649n 0
+    237650n 1.8
+    237699n 1.8
+    237700n 0
+    237749n 0
+    237750n 1.8
+    237799n 1.8
+    237800n 0
+    237849n 0
+    237850n 1.8
+    237899n 1.8
+    237900n 0
+    237949n 0
+    237950n 1.8
+    237999n 1.8
+    238000n 0
+    238049n 0
+    238050n 1.8
+    238099n 1.8
+    238100n 0
+    238149n 0
+    238150n 1.8
+    238199n 1.8
+    238200n 0
+    238249n 0
+    238250n 1.8
+    238299n 1.8
+    238300n 0
+    238349n 0
+    238350n 1.8
+    238399n 1.8
+    238400n 0
+    238449n 0
+    238450n 1.8
+    238499n 1.8
+    238500n 0
+    238549n 0
+    238550n 1.8
+    238599n 1.8
+    238600n 0
+    238649n 0
+    238650n 1.8
+    238699n 1.8
+    238700n 0
+    238749n 0
+    238750n 1.8
+    238799n 1.8
+    238800n 0
+    238849n 0
+    238850n 1.8
+    238899n 1.8
+    238900n 0
+    238949n 0
+    238950n 1.8
+    238999n 1.8
+    239000n 0
+    239049n 0
+    239050n 1.8
+    239099n 1.8
+    239100n 0
+    239149n 0
+    239150n 1.8
+    239199n 1.8
+    239200n 0
+    239249n 0
+    239250n 1.8
+    239299n 1.8
+    239300n 0
+    239349n 0
+    239350n 1.8
+    239399n 1.8
+    239400n 0
+    239449n 0
+    239450n 1.8
+    239499n 1.8
+    239500n 0
+    239549n 0
+    239550n 1.8
+    239599n 1.8
+    239600n 0
+    239649n 0
+    239650n 1.8
+    239699n 1.8
+    239700n 0
+    239749n 0
+    239750n 1.8
+    239799n 1.8
+    239800n 0
+    239849n 0
+    239850n 1.8
+    239899n 1.8
+    239900n 0
+    239949n 0
+    239950n 1.8
+    239999n 1.8
+    240000n 0
+    240049n 0
+    240050n 1.8
+    240099n 1.8
+    240100n 0
+    240149n 0
+    240150n 1.8
+    240199n 1.8
+    240200n 0
+    240249n 0
+    240250n 1.8
+    240299n 1.8
+    240300n 0
+    240349n 0
+    240350n 1.8
+    240399n 1.8
+    240400n 0
+    240449n 0
+    240450n 1.8
+    240499n 1.8
+    240500n 0
+    240549n 0
+    240550n 1.8
+    240599n 1.8
+    240600n 0
+    240649n 0
+    240650n 1.8
+    240699n 1.8
+    240700n 0
+    240749n 0
+    240750n 1.8
+    240799n 1.8
+    240800n 0
+    240849n 0
+    240850n 1.8
+    240899n 1.8
+    240900n 0
+    240949n 0
+    240950n 1.8
+    240999n 1.8
+    241000n 0
+    241049n 0
+    241050n 1.8
+    241099n 1.8
+    241100n 0
+    241149n 0
+    241150n 1.8
+    241199n 1.8
+    241200n 0
+    241249n 0
+    241250n 1.8
+    241299n 1.8
+    241300n 0
+    241349n 0
+    241350n 1.8
+    241399n 1.8
+    241400n 0
+    241449n 0
+    241450n 1.8
+    241499n 1.8
+    241500n 0
+    241549n 0
+    241550n 1.8
+    241599n 1.8
+    241600n 0
+    241649n 0
+    241650n 1.8
+    241699n 1.8
+    241700n 0
+    241749n 0
+    241750n 1.8
+    241799n 1.8
+    241800n 0
+    241849n 0
+    241850n 1.8
+    241899n 1.8
+    241900n 0
+    241949n 0
+    241950n 1.8
+    241999n 1.8
+    242000n 0
+    242049n 0
+    242050n 1.8
+    242099n 1.8
+    242100n 0
+    242149n 0
+    242150n 1.8
+    242199n 1.8
+    242200n 0
+    242249n 0
+    242250n 1.8
+    242299n 1.8
+    242300n 0
+    242349n 0
+    242350n 1.8
+    242399n 1.8
+    242400n 0
+    242449n 0
+    242450n 1.8
+    242499n 1.8
+    242500n 0
+    242549n 0
+    242550n 1.8
+    242599n 1.8
+    242600n 0
+    242649n 0
+    242650n 1.8
+    242699n 1.8
+    242700n 0
+    242749n 0
+    242750n 1.8
+    242799n 1.8
+    242800n 0
+    242849n 0
+    242850n 1.8
+    242899n 1.8
+    242900n 0
+    242949n 0
+    242950n 1.8
+    242999n 1.8
+    243000n 0
+    243049n 0
+    243050n 1.8
+    243099n 1.8
+    243100n 0
+    243149n 0
+    243150n 1.8
+    243199n 1.8
+    243200n 0
+    243249n 0
+    243250n 1.8
+    243299n 1.8
+    243300n 0
+    243349n 0
+    243350n 1.8
+    243399n 1.8
+    243400n 0
+    243449n 0
+    243450n 1.8
+    243499n 1.8
+    243500n 0
+    243549n 0
+    243550n 1.8
+    243599n 1.8
+    243600n 0
+    243649n 0
+    243650n 1.8
+    243699n 1.8
+    243700n 0
+    243749n 0
+    243750n 1.8
+    243799n 1.8
+    243800n 0
+    243849n 0
+    243850n 1.8
+    243899n 1.8
+    243900n 0
+    243949n 0
+    243950n 1.8
+    243999n 1.8
+    244000n 0
+    244049n 0
+    244050n 1.8
+    244099n 1.8
+    244100n 0
+    244149n 0
+    244150n 1.8
+    244199n 1.8
+    244200n 0
+    244249n 0
+    244250n 1.8
+    244299n 1.8
+    244300n 0
+    244349n 0
+    244350n 1.8
+    244399n 1.8
+    244400n 0
+    244449n 0
+    244450n 1.8
+    244499n 1.8
+    244500n 0
+    244549n 0
+    244550n 1.8
+    244599n 1.8
+    244600n 0
+    244649n 0
+    244650n 1.8
+    244699n 1.8
+    244700n 0
+    244749n 0
+    244750n 1.8
+    244799n 1.8
+    244800n 0
+    244849n 0
+    244850n 1.8
+    244899n 1.8
+    244900n 0
+    244949n 0
+    244950n 1.8
+    244999n 1.8
+    245000n 0
+    245049n 0
+    245050n 1.8
+    245099n 1.8
+    245100n 0
+    245149n 0
+    245150n 1.8
+    245199n 1.8
+    245200n 0
+    245249n 0
+    245250n 1.8
+    245299n 1.8
+    245300n 0
+    245349n 0
+    245350n 1.8
+    245399n 1.8
+    245400n 0
+    245449n 0
+    245450n 1.8
+    245499n 1.8
+    245500n 0
+    245549n 0
+    245550n 1.8
+    245599n 1.8
+    245600n 0
+    245649n 0
+    245650n 1.8
+    245699n 1.8
+    245700n 0
+    245749n 0
+    245750n 1.8
+    245799n 1.8
+    245800n 0
+    245849n 0
+    245850n 1.8
+    245899n 1.8
+    245900n 0
+    245949n 0
+    245950n 1.8
+    245999n 1.8
+    246000n 0
+    246049n 0
+    246050n 1.8
+    246099n 1.8
+    246100n 0
+    246149n 0
+    246150n 1.8
+    246199n 1.8
+    246200n 0
+    246249n 0
+    246250n 1.8
+    246299n 1.8
+    246300n 0
+    246349n 0
+    246350n 1.8
+    246399n 1.8
+    246400n 0
+    246449n 0
+    246450n 1.8
+    246499n 1.8
+    246500n 0
+    246549n 0
+    246550n 1.8
+    246599n 1.8
+    246600n 0
+    246649n 0
+    246650n 1.8
+    246699n 1.8
+    246700n 0
+    246749n 0
+    246750n 1.8
+    246799n 1.8
+    246800n 0
+    246849n 0
+    246850n 1.8
+    246899n 1.8
+    246900n 0
+    246949n 0
+    246950n 1.8
+    246999n 1.8
+    247000n 0
+    247049n 0
+    247050n 1.8
+    247099n 1.8
+    247100n 0
+    247149n 0
+    247150n 1.8
+    247199n 1.8
+    247200n 0
+    247249n 0
+    247250n 1.8
+    247299n 1.8
+    247300n 0
+    247349n 0
+    247350n 1.8
+    247399n 1.8
+    247400n 0
+    247449n 0
+    247450n 1.8
+    247499n 1.8
+    247500n 0
+    247549n 0
+    247550n 1.8
+    247599n 1.8
+    247600n 0
+    247649n 0
+    247650n 1.8
+    247699n 1.8
+    247700n 0
+    247749n 0
+    247750n 1.8
+    247799n 1.8
+    247800n 0
+    247849n 0
+    247850n 1.8
+    247899n 1.8
+    247900n 0
+    247949n 0
+    247950n 1.8
+    247999n 1.8
+    248000n 0
+    248049n 0
+    248050n 1.8
+    248099n 1.8
+    248100n 0
+    248149n 0
+    248150n 1.8
+    248199n 1.8
+    248200n 0
+    248249n 0
+    248250n 1.8
+    248299n 1.8
+    248300n 0
+    248349n 0
+    248350n 1.8
+    248399n 1.8
+    248400n 0
+    248449n 0
+    248450n 1.8
+    248499n 1.8
+    248500n 0
+    248549n 0
+    248550n 1.8
+    248599n 1.8
+    248600n 0
+    248649n 0
+    248650n 1.8
+    248699n 1.8
+    248700n 0
+    248749n 0
+    248750n 1.8
+    248799n 1.8
+    248800n 0
+    248849n 0
+    248850n 1.8
+    248899n 1.8
+    248900n 0
+    248949n 0
+    248950n 1.8
+    248999n 1.8
+    249000n 0
+    249049n 0
+    249050n 1.8
+    249099n 1.8
+    249100n 0
+    249149n 0
+    249150n 1.8
+    249199n 1.8
+    249200n 0
+    249249n 0
+    249250n 1.8
+    249299n 1.8
+    249300n 0
+    249349n 0
+    249350n 1.8
+    249399n 1.8
+    249400n 0
+    249449n 0
+    249450n 1.8
+    249499n 1.8
+    249500n 0
+    249549n 0
+    249550n 1.8
+    249599n 1.8
+    249600n 0
+    249649n 0
+    249650n 1.8
+    249699n 1.8
+    249700n 0
+    249749n 0
+    249750n 1.8
+    249799n 1.8
+    249800n 0
+    249849n 0
+    249850n 1.8
+    249899n 1.8
+    249900n 0
+    249949n 0
+    249950n 1.8
+    249999n 1.8
+    250000n 0
+    250049n 0
+    250050n 1.8
+    250099n 1.8
+    250100n 0
+    250149n 0
+    250150n 1.8
+    250199n 1.8
+    250200n 0
+    250249n 0
+    250250n 1.8
+    250299n 1.8
+    250300n 0
+    250349n 0
+    250350n 1.8
+    250399n 1.8
+    250400n 0
+    250449n 0
+    250450n 1.8
+    250499n 1.8
+    250500n 0
+    250549n 0
+    250550n 1.8
+    250599n 1.8
+    250600n 0
+    250649n 0
+    250650n 1.8
+    250699n 1.8
+    250700n 0
+    250749n 0
+    250750n 1.8
+    250799n 1.8
+    250800n 0
+    250849n 0
+    250850n 1.8
+    250899n 1.8
+    250900n 0
+    250949n 0
+    250950n 1.8
+    250999n 1.8
+    251000n 0
+    251049n 0
+    251050n 1.8
+    251099n 1.8
+    251100n 0
+    251149n 0
+    251150n 1.8
+    251199n 1.8
+    251200n 0
+    251249n 0
+    251250n 1.8
+    251299n 1.8
+    251300n 0
+    251349n 0
+    251350n 1.8
+    251399n 1.8
+    251400n 0
+    251449n 0
+    251450n 1.8
+    251499n 1.8
+    251500n 0
+    251549n 0
+    251550n 1.8
+    251599n 1.8
+    251600n 0
+    251649n 0
+    251650n 1.8
+    251699n 1.8
+    251700n 0
+    251749n 0
+    251750n 1.8
+    251799n 1.8
+    251800n 0
+    251849n 0
+    251850n 1.8
+    251899n 1.8
+    251900n 0
+    251949n 0
+    251950n 1.8
+    251999n 1.8
+    252000n 0
+    252049n 0
+    252050n 1.8
+    252099n 1.8
+    252100n 0
+    252149n 0
+    252150n 1.8
+    252199n 1.8
+    252200n 0
+    252249n 0
+    252250n 1.8
+    252299n 1.8
+    252300n 0
+    252349n 0
+    252350n 1.8
+    252399n 1.8
+    252400n 0
+    252449n 0
+    252450n 1.8
+    252499n 1.8
+    252500n 0
+    252549n 0
+    252550n 1.8
+    252599n 1.8
+    252600n 0
+    252649n 0
+    252650n 1.8
+    252699n 1.8
+    252700n 0
+    252749n 0
+    252750n 1.8
+    252799n 1.8
+    252800n 0
+    252849n 0
+    252850n 1.8
+    252899n 1.8
+    252900n 0
+    252949n 0
+    252950n 1.8
+    252999n 1.8
+    253000n 0
+    253049n 0
+    253050n 1.8
+    253099n 1.8
+    253100n 0
+    253149n 0
+    253150n 1.8
+    253199n 1.8
+    253200n 0
+    253249n 0
+    253250n 1.8
+    253299n 1.8
+    253300n 0
+    253349n 0
+    253350n 1.8
+    253399n 1.8
+    253400n 0
+    253449n 0
+    253450n 1.8
+    253499n 1.8
+    253500n 0
+    253549n 0
+    253550n 1.8
+    253599n 1.8
+    253600n 0
+    253649n 0
+    253650n 1.8
+    253699n 1.8
+    253700n 0
+    253749n 0
+    253750n 1.8
+    253799n 1.8
+    253800n 0
+    253849n 0
+    253850n 1.8
+    253899n 1.8
+    253900n 0
+    253949n 0
+    253950n 1.8
+    253999n 1.8
+    254000n 0
+    254049n 0
+    254050n 1.8
+    254099n 1.8
+    254100n 0
+    254149n 0
+    254150n 1.8
+    254199n 1.8
+    254200n 0
+    254249n 0
+    254250n 1.8
+    254299n 1.8
+    254300n 0
+    254349n 0
+    254350n 1.8
+    254399n 1.8
+    254400n 0
+    254449n 0
+    254450n 1.8
+    254499n 1.8
+    254500n 0
+    254549n 0
+    254550n 1.8
+    254599n 1.8
+    254600n 0
+    254649n 0
+    254650n 1.8
+    254699n 1.8
+    254700n 0
+    254749n 0
+    254750n 1.8
+    254799n 1.8
+    254800n 0
+    254849n 0
+    254850n 1.8
+    254899n 1.8
+    254900n 0
+    254949n 0
+    254950n 1.8
+    254999n 1.8
+    255000n 0
+    255049n 0
+    255050n 1.8
+    255099n 1.8
+    255100n 0
+    255149n 0
+    255150n 1.8
+    255199n 1.8
+    255200n 0
+    255249n 0
+    255250n 1.8
+    255299n 1.8
+    255300n 0
+    255349n 0
+    255350n 1.8
+    255399n 1.8
+    255400n 0
+    255449n 0
+    255450n 1.8
+    255499n 1.8
+    255500n 0
+    255549n 0
+    255550n 1.8
+    255599n 1.8
+    255600n 0
+    255649n 0
+    255650n 1.8
+    255699n 1.8
+    255700n 0
+    255749n 0
+    255750n 1.8
+    255799n 1.8
+    255800n 0
+    255849n 0
+    255850n 1.8
+    255899n 1.8
+    255900n 0
+    255949n 0
+    255950n 1.8
+    255999n 1.8
+    256000n 0
+    256049n 0
+    256050n 1.8
+    256099n 1.8
+    256100n 0
+    256149n 0
+    256150n 1.8
+    256199n 1.8
+    256200n 0
+    256249n 0
+    256250n 1.8
+    256299n 1.8
+    256300n 0
+    256349n 0
+    256350n 1.8
+    256399n 1.8
+    256400n 0
+    256449n 0
+    256450n 1.8
+    256499n 1.8
+    256500n 0
+    256549n 0
+    256550n 1.8
+    256599n 1.8
+    256600n 0
+    256649n 0
+    256650n 1.8
+    256699n 1.8
+    256700n 0
+    256749n 0
+    256750n 1.8
+    256799n 1.8
+    256800n 0
+    256849n 0
+    256850n 1.8
+    256899n 1.8
+    256900n 0
+    256949n 0
+    256950n 1.8
+    256999n 1.8
+    257000n 0
+    257049n 0
+    257050n 1.8
+    257099n 1.8
+    257100n 0
+    257149n 0
+    257150n 1.8
+    257199n 1.8
+    257200n 0
+    257249n 0
+    257250n 1.8
+    257299n 1.8
+    257300n 0
+    257349n 0
+    257350n 1.8
+    257399n 1.8
+    257400n 0
+    257449n 0
+    257450n 1.8
+    257499n 1.8
+    257500n 0
+    257549n 0
+    257550n 1.8
+    257599n 1.8
+    257600n 0
+    257649n 0
+    257650n 1.8
+    257699n 1.8
+    257700n 0
+    257749n 0
+    257750n 1.8
+    257799n 1.8
+    257800n 0
+    257849n 0
+    257850n 1.8
+    257899n 1.8
+    257900n 0
+    257949n 0
+    257950n 1.8
+    257999n 1.8
+    258000n 0
+    258049n 0
+    258050n 1.8
+    258099n 1.8
+    258100n 0
+    258149n 0
+    258150n 1.8
+    258199n 1.8
+    258200n 0
+    258249n 0
+    258250n 1.8
+    258299n 1.8
+    258300n 0
+    258349n 0
+    258350n 1.8
+    258399n 1.8
+    258400n 0
+    258449n 0
+    258450n 1.8
+    258499n 1.8
+    258500n 0
+    258549n 0
+    258550n 1.8
+    258599n 1.8
+    258600n 0
+    258649n 0
+    258650n 1.8
+    258699n 1.8
+    258700n 0
+    258749n 0
+    258750n 1.8
+    258799n 1.8
+    258800n 0
+    258849n 0
+    258850n 1.8
+    258899n 1.8
+    258900n 0
+    258949n 0
+    258950n 1.8
+    258999n 1.8
+    259000n 0
+    259049n 0
+    259050n 1.8
+    259099n 1.8
+    259100n 0
+    259149n 0
+    259150n 1.8
+    259199n 1.8
+    259200n 0
+    259249n 0
+    259250n 1.8
+    259299n 1.8
+    259300n 0
+    259349n 0
+    259350n 1.8
+    259399n 1.8
+    259400n 0
+    259449n 0
+    259450n 1.8
+    259499n 1.8
+    259500n 0
+    259549n 0
+    259550n 1.8
+    259599n 1.8
+    259600n 0
+    259649n 0
+    259650n 1.8
+    259699n 1.8
+    259700n 0
+    259749n 0
+    259750n 1.8
+    259799n 1.8
+    259800n 0
+    259849n 0
+    259850n 1.8
+    259899n 1.8
+    259900n 0
+    259949n 0
+    259950n 1.8
+    259999n 1.8
+    260000n 0
+    260049n 0
+    260050n 1.8
+    260099n 1.8
+    260100n 0
+    260149n 0
+    260150n 1.8
+    260199n 1.8
+    260200n 0
+    260249n 0
+    260250n 1.8
+    260299n 1.8
+    260300n 0
+    260349n 0
+    260350n 1.8
+    260399n 1.8
+    260400n 0
+    260449n 0
+    260450n 1.8
+    260499n 1.8
+    260500n 0
+    260549n 0
+    260550n 1.8
+    260599n 1.8
+    260600n 0
+    260649n 0
+    260650n 1.8
+    260699n 1.8
+    260700n 0
+    260749n 0
+    260750n 1.8
+    260799n 1.8
+    260800n 0
+    260849n 0
+    260850n 1.8
+    260899n 1.8
+    260900n 0
+    260949n 0
+    260950n 1.8
+    260999n 1.8
+    261000n 0
+    261049n 0
+    261050n 1.8
+    261099n 1.8
+    261100n 0
+    261149n 0
+    261150n 1.8
+    261199n 1.8
+    261200n 0
+    261249n 0
+    261250n 1.8
+    261299n 1.8
+    261300n 0
+    261349n 0
+    261350n 1.8
+    261399n 1.8
+    261400n 0
+    261449n 0
+    261450n 1.8
+    261499n 1.8
+    261500n 0
+    261549n 0
+    261550n 1.8
+    261599n 1.8
+    261600n 0
+    261649n 0
+    261650n 1.8
+    261699n 1.8
+    261700n 0
+    261749n 0
+    261750n 1.8
+    261799n 1.8
+    261800n 0
+    261849n 0
+    261850n 1.8
+    261899n 1.8
+    261900n 0
+    261949n 0
+    261950n 1.8
+    261999n 1.8
+    262000n 0
+    262049n 0
+    262050n 1.8
+    262099n 1.8
+    262100n 0
+    262149n 0
+    262150n 1.8
+    262199n 1.8
+    262200n 0
+    262249n 0
+    262250n 1.8
+    262299n 1.8
+    262300n 0
+    262349n 0
+    262350n 1.8
+    262399n 1.8
+    262400n 0
+    262449n 0
+    262450n 1.8
+    262499n 1.8
+    262500n 0
+    262549n 0
+    262550n 1.8
+    262599n 1.8
+    262600n 0
+    262649n 0
+    262650n 1.8
+    262699n 1.8
+    262700n 0
+    262749n 0
+    262750n 1.8
+    262799n 1.8
+    262800n 0
+    262849n 0
+    262850n 1.8
+    262899n 1.8
+    262900n 0
+    262949n 0
+    262950n 1.8
+    262999n 1.8
+    263000n 0
+    263049n 0
+    263050n 1.8
+    263099n 1.8
+    263100n 0
+    263149n 0
+    263150n 1.8
+    263199n 1.8
+    263200n 0
+    263249n 0
+    263250n 1.8
+    263299n 1.8
+    263300n 0
+    263349n 0
+    263350n 1.8
+    263399n 1.8
+    263400n 0
+    263449n 0
+    263450n 1.8
+    263499n 1.8
+    263500n 0
+    263549n 0
+    263550n 1.8
+    263599n 1.8
+    263600n 0
+    263649n 0
+    263650n 1.8
+    263699n 1.8
+    263700n 0
+    263749n 0
+    263750n 1.8
+    263799n 1.8
+    263800n 0
+    263849n 0
+    263850n 1.8
+    263899n 1.8
+    263900n 0
+    263949n 0
+    263950n 1.8
+    263999n 1.8
+    264000n 0
+    264049n 0
+    264050n 1.8
+    264099n 1.8
+    264100n 0
+    264149n 0
+    264150n 1.8
+    264199n 1.8
+    264200n 0
+    264249n 0
+    264250n 1.8
+    264299n 1.8
+    264300n 0
+    264349n 0
+    264350n 1.8
+    264399n 1.8
+    264400n 0
+    264449n 0
+    264450n 1.8
+    264499n 1.8
+    264500n 0
+    264549n 0
+    264550n 1.8
+    264599n 1.8
+    264600n 0
+    264649n 0
+    264650n 1.8
+    264699n 1.8
+    264700n 0
+    264749n 0
+    264750n 1.8
+    264799n 1.8
+    264800n 0
+    264849n 0
+    264850n 1.8
+    264899n 1.8
+    264900n 0
+    264949n 0
+    264950n 1.8
+    264999n 1.8
+    265000n 0
+    265049n 0
+    265050n 1.8
+    265099n 1.8
+    265100n 0
+    265149n 0
+    265150n 1.8
+    265199n 1.8
+    265200n 0
+    265249n 0
+    265250n 1.8
+    265299n 1.8
+    265300n 0
+    265349n 0
+    265350n 1.8
+    265399n 1.8
+    265400n 0
+    265449n 0
+    265450n 1.8
+    265499n 1.8
+    265500n 0
+    265549n 0
+    265550n 1.8
+    265599n 1.8
+    265600n 0
+    265649n 0
+    265650n 1.8
+    265699n 1.8
+    265700n 0
+    265749n 0
+    265750n 1.8
+    265799n 1.8
+    265800n 0
+    265849n 0
+    265850n 1.8
+    265899n 1.8
+    265900n 0
+    265949n 0
+    265950n 1.8
+    265999n 1.8
+    266000n 0
+    266049n 0
+    266050n 1.8
+    266099n 1.8
+    266100n 0
+    266149n 0
+    266150n 1.8
+    266199n 1.8
+    266200n 0
+    266249n 0
+    266250n 1.8
+    266299n 1.8
+    266300n 0
+    266349n 0
+    266350n 1.8
+    266399n 1.8
+    266400n 0
+    266449n 0
+    266450n 1.8
+    266499n 1.8
+    266500n 0
+    266549n 0
+    266550n 1.8
+    266599n 1.8
+    266600n 0
+    266649n 0
+    266650n 1.8
+    266699n 1.8
+    266700n 0
+    266749n 0
+    266750n 1.8
+    266799n 1.8
+    266800n 0
+    266849n 0
+    266850n 1.8
+    266899n 1.8
+    266900n 0
+    266949n 0
+    266950n 1.8
+    266999n 1.8
+    267000n 0
+    267049n 0
+    267050n 1.8
+    267099n 1.8
+    267100n 0
+    267149n 0
+    267150n 1.8
+    267199n 1.8
+    267200n 0
+    267249n 0
+    267250n 1.8
+    267299n 1.8
+    267300n 0
+    267349n 0
+    267350n 1.8
+    267399n 1.8
+    267400n 0
+    267449n 0
+    267450n 1.8
+    267499n 1.8
+    267500n 0
+    267549n 0
+    267550n 1.8
+    267599n 1.8
+    267600n 0
+    267649n 0
+    267650n 1.8
+    267699n 1.8
+    267700n 0
+    267749n 0
+    267750n 1.8
+    267799n 1.8
+    267800n 0
+    267849n 0
+    267850n 1.8
+    267899n 1.8
+    267900n 0
+    267949n 0
+    267950n 1.8
+    267999n 1.8
+    268000n 0
+    268049n 0
+    268050n 1.8
+    268099n 1.8
+    268100n 0
+    268149n 0
+    268150n 1.8
+    268199n 1.8
+    268200n 0
+    268249n 0
+    268250n 1.8
+    268299n 1.8
+    268300n 0
+    268349n 0
+    268350n 1.8
+    268399n 1.8
+    268400n 0
+    268449n 0
+    268450n 1.8
+    268499n 1.8
+    268500n 0
+    268549n 0
+    268550n 1.8
+    268599n 1.8
+    268600n 0
+    268649n 0
+    268650n 1.8
+    268699n 1.8
+    268700n 0
+    268749n 0
+    268750n 1.8
+    268799n 1.8
+    268800n 0
+    268849n 0
+    268850n 1.8
+    268899n 1.8
+    268900n 0
+    268949n 0
+    268950n 1.8
+    268999n 1.8
+    269000n 0
+    269049n 0
+    269050n 1.8
+    269099n 1.8
+    269100n 0
+    269149n 0
+    269150n 1.8
+    269199n 1.8
+    269200n 0
+    269249n 0
+    269250n 1.8
+    269299n 1.8
+    269300n 0
+    269349n 0
+    269350n 1.8
+    269399n 1.8
+    269400n 0
+    269449n 0
+    269450n 1.8
+    269499n 1.8
+    269500n 0
+    269549n 0
+    269550n 1.8
+    269599n 1.8
+    269600n 0
+    269649n 0
+    269650n 1.8
+    269699n 1.8
+    269700n 0
+    269749n 0
+    269750n 1.8
+    269799n 1.8
+    269800n 0
+    269849n 0
+    269850n 1.8
+    269899n 1.8
+    269900n 0
+    269949n 0
+    269950n 1.8
+    269999n 1.8
+    270000n 0
+    270049n 0
+    270050n 1.8
+    270099n 1.8
+    270100n 0
+    270149n 0
+    270150n 1.8
+    270199n 1.8
+    270200n 0
+    270249n 0
+    270250n 1.8
+    270299n 1.8
+    270300n 0
+    270349n 0
+    270350n 1.8
+    270399n 1.8
+    270400n 0
+    270449n 0
+    270450n 1.8
+    270499n 1.8
+    270500n 0
+    270549n 0
+    270550n 1.8
+    270599n 1.8
+    270600n 0
+    270649n 0
+    270650n 1.8
+    270699n 1.8
+    270700n 0
+    270749n 0
+    270750n 1.8
+    270799n 1.8
+    270800n 0
+    270849n 0
+    270850n 1.8
+    270899n 1.8
+    270900n 0
+    270949n 0
+    270950n 1.8
+    270999n 1.8
+    271000n 0
+    271049n 0
+    271050n 1.8
+    271099n 1.8
+    271100n 0
+    271149n 0
+    271150n 1.8
+    271199n 1.8
+    271200n 0
+    271249n 0
+    271250n 1.8
+    271299n 1.8
+    271300n 0
+    271349n 0
+    271350n 1.8
+    271399n 1.8
+    271400n 0
+    271449n 0
+    271450n 1.8
+    271499n 1.8
+    271500n 0
+    271549n 0
+    271550n 1.8
+    271599n 1.8
+    271600n 0
+    271649n 0
+    271650n 1.8
+    271699n 1.8
+    271700n 0
+    271749n 0
+    271750n 1.8
+    271799n 1.8
+    271800n 0
+    271849n 0
+    271850n 1.8
+    271899n 1.8
+    271900n 0
+    271949n 0
+    271950n 1.8
+    271999n 1.8
+    272000n 0
+    272049n 0
+    272050n 1.8
+    272099n 1.8
+    272100n 0
+    272149n 0
+    272150n 1.8
+    272199n 1.8
+    272200n 0
+    272249n 0
+    272250n 1.8
+    272299n 1.8
+    272300n 0
+    272349n 0
+    272350n 1.8
+    272399n 1.8
+    272400n 0
+    272449n 0
+    272450n 1.8
+    272499n 1.8
+    272500n 0
+    272549n 0
+    272550n 1.8
+    272599n 1.8
+    272600n 0
+    272649n 0
+    272650n 1.8
+    272699n 1.8
+    272700n 0
+    272749n 0
+    272750n 1.8
+    272799n 1.8
+    272800n 0
+    272849n 0
+    272850n 1.8
+    272899n 1.8
+    272900n 0
+    272949n 0
+    272950n 1.8
+    272999n 1.8
+    273000n 0
+    273049n 0
+    273050n 1.8
+    273099n 1.8
+    273100n 0
+    273149n 0
+    273150n 1.8
+    273199n 1.8
+    273200n 0
+    273249n 0
+    273250n 1.8
+    273299n 1.8
+    273300n 0
+    273349n 0
+    273350n 1.8
+    273399n 1.8
+    273400n 0
+    273449n 0
+    273450n 1.8
+    273499n 1.8
+    273500n 0
+    273549n 0
+    273550n 1.8
+    273599n 1.8
+    273600n 0
+    273649n 0
+    273650n 1.8
+    273699n 1.8
+    273700n 0
+    273749n 0
+    273750n 1.8
+    273799n 1.8
+    273800n 0
+    273849n 0
+    273850n 1.8
+    273899n 1.8
+    273900n 0
+    273949n 0
+    273950n 1.8
+    273999n 1.8
+    274000n 0
+    274049n 0
+    274050n 1.8
+    274099n 1.8
+    274100n 0
+    274149n 0
+    274150n 1.8
+    274199n 1.8
+    274200n 0
+    274249n 0
+    274250n 1.8
+    274299n 1.8
+    274300n 0
+    274349n 0
+    274350n 1.8
+    274399n 1.8
+    274400n 0
+    274449n 0
+    274450n 1.8
+    274499n 1.8
+    274500n 0
+    274549n 0
+    274550n 1.8
+    274599n 1.8
+    274600n 0
+    274649n 0
+    274650n 1.8
+    274699n 1.8
+    274700n 0
+    274749n 0
+    274750n 1.8
+    274799n 1.8
+    274800n 0
+    274849n 0
+    274850n 1.8
+    274899n 1.8
+    274900n 0
+    274949n 0
+    274950n 1.8
+    274999n 1.8
+    275000n 0
+    275049n 0
+    275050n 1.8
+    275099n 1.8
+    275100n 0
+    275149n 0
+    275150n 1.8
+    275199n 1.8
+    275200n 0
+    275249n 0
+    275250n 1.8
+    275299n 1.8
+    275300n 0
+    275349n 0
+    275350n 1.8
+    275399n 1.8
+    275400n 0
+    275449n 0
+    275450n 1.8
+    275499n 1.8
+    275500n 0
+    275549n 0
+    275550n 1.8
+    275599n 1.8
+    275600n 0
+    275649n 0
+    275650n 1.8
+    275699n 1.8
+    275700n 0
+    275749n 0
+    275750n 1.8
+    275799n 1.8
+    275800n 0
+    275849n 0
+    275850n 1.8
+    275899n 1.8
+    275900n 0
+    275949n 0
+    275950n 1.8
+    275999n 1.8
+    276000n 0
+    276049n 0
+    276050n 1.8
+    276099n 1.8
+    276100n 0
+    276149n 0
+    276150n 1.8
+    276199n 1.8
+    276200n 0
+    276249n 0
+    276250n 1.8
+    276299n 1.8
+    276300n 0
+    276349n 0
+    276350n 1.8
+    276399n 1.8
+    276400n 0
+    276449n 0
+    276450n 1.8
+    276499n 1.8
+    276500n 0
+    276549n 0
+    276550n 1.8
+    276599n 1.8
+    276600n 0
+    276649n 0
+    276650n 1.8
+    276699n 1.8
+    276700n 0
+    276749n 0
+    276750n 1.8
+    276799n 1.8
+    276800n 0
+    276849n 0
+    276850n 1.8
+    276899n 1.8
+    276900n 0
+    276949n 0
+    276950n 1.8
+    276999n 1.8
+    277000n 0
+    277049n 0
+    277050n 1.8
+    277099n 1.8
+    277100n 0
+    277149n 0
+    277150n 1.8
+    277199n 1.8
+    277200n 0
+    277249n 0
+    277250n 1.8
+    277299n 1.8
+    277300n 0
+    277349n 0
+    277350n 1.8
+    277399n 1.8
+    277400n 0
+    277449n 0
+    277450n 1.8
+    277499n 1.8
+    277500n 0
+    277549n 0
+    277550n 1.8
+    277599n 1.8
+    277600n 0
+    277649n 0
+    277650n 1.8
+    277699n 1.8
+    277700n 0
+    277749n 0
+    277750n 1.8
+    277799n 1.8
+    277800n 0
+    277849n 0
+    277850n 1.8
+    277899n 1.8
+    277900n 0
+    277949n 0
+    277950n 1.8
+    277999n 1.8
+    278000n 0
+    278049n 0
+    278050n 1.8
+    278099n 1.8
+    278100n 0
+    278149n 0
+    278150n 1.8
+    278199n 1.8
+    278200n 0
+    278249n 0
+    278250n 1.8
+    278299n 1.8
+    278300n 0
+    278349n 0
+    278350n 1.8
+    278399n 1.8
+    278400n 0
+    278449n 0
+    278450n 1.8
+    278499n 1.8
+    278500n 0
+    278549n 0
+    278550n 1.8
+    278599n 1.8
+    278600n 0
+    278649n 0
+    278650n 1.8
+    278699n 1.8
+    278700n 0
+    278749n 0
+    278750n 1.8
+    278799n 1.8
+    278800n 0
+    278849n 0
+    278850n 1.8
+    278899n 1.8
+    278900n 0
+    278949n 0
+    278950n 1.8
+    278999n 1.8
+    279000n 0
+    279049n 0
+    279050n 1.8
+    279099n 1.8
+    279100n 0
+    279149n 0
+    279150n 1.8
+    279199n 1.8
+    279200n 0
+    279249n 0
+    279250n 1.8
+    279299n 1.8
+    279300n 0
+    279349n 0
+    279350n 1.8
+    279399n 1.8
+    279400n 0
+    279449n 0
+    279450n 1.8
+    279499n 1.8
+    279500n 0
+    279549n 0
+    279550n 1.8
+    279599n 1.8
+    279600n 0
+    279649n 0
+    279650n 1.8
+    279699n 1.8
+    279700n 0
+    279749n 0
+    279750n 1.8
+    279799n 1.8
+    279800n 0
+    279849n 0
+    279850n 1.8
+    279899n 1.8
+    279900n 0
+    279949n 0
+    279950n 1.8
+    279999n 1.8
+    280000n 0
+    280049n 0
+    280050n 1.8
+    280099n 1.8
+    280100n 0
+    280149n 0
+    280150n 1.8
+    280199n 1.8
+    280200n 0
+    280249n 0
+    280250n 1.8
+    280299n 1.8
+    280300n 0
+    280349n 0
+    280350n 1.8
+    280399n 1.8
+    280400n 0
+    280449n 0
+    280450n 1.8
+    280499n 1.8
+    280500n 0
+    280549n 0
+    280550n 1.8
+    280599n 1.8
+    280600n 0
+    280649n 0
+    280650n 1.8
+    280699n 1.8
+    280700n 0
+    280749n 0
+    280750n 1.8
+    280799n 1.8
+    280800n 0
+    280849n 0
+    280850n 1.8
+    280899n 1.8
+    280900n 0
+    280949n 0
+    280950n 1.8
+    280999n 1.8
+    281000n 0
+    281049n 0
+    281050n 1.8
+    281099n 1.8
+    281100n 0
+    281149n 0
+    281150n 1.8
+    281199n 1.8
+    281200n 0
+    281249n 0
+    281250n 1.8
+    281299n 1.8
+    281300n 0
+    281349n 0
+    281350n 1.8
+    281399n 1.8
+    281400n 0
+    281449n 0
+    281450n 1.8
+    281499n 1.8
+    281500n 0
+    281549n 0
+    281550n 1.8
+    281599n 1.8
+    281600n 0
+    281649n 0
+    281650n 1.8
+    281699n 1.8
+    281700n 0
+    281749n 0
+    281750n 1.8
+    281799n 1.8
+    281800n 0
+    281849n 0
+    281850n 1.8
+    281899n 1.8
+    281900n 0
+    281949n 0
+    281950n 1.8
+    281999n 1.8
+    282000n 0
+    282049n 0
+    282050n 1.8
+    282099n 1.8
+    282100n 0
+    282149n 0
+    282150n 1.8
+    282199n 1.8
+    282200n 0
+    282249n 0
+    282250n 1.8
+    282299n 1.8
+    282300n 0
+    282349n 0
+    282350n 1.8
+    282399n 1.8
+    282400n 0
+    282449n 0
+    282450n 1.8
+    282499n 1.8
+    282500n 0
+    282549n 0
+    282550n 1.8
+    282599n 1.8
+    282600n 0
+    282649n 0
+    282650n 1.8
+    282699n 1.8
+    282700n 0
+    282749n 0
+    282750n 1.8
+    282799n 1.8
+    282800n 0
+    282849n 0
+    282850n 1.8
+    282899n 1.8
+    282900n 0
+    282949n 0
+    282950n 1.8
+    282999n 1.8
+    283000n 0
+    283049n 0
+    283050n 1.8
+    283099n 1.8
+    283100n 0
+    283149n 0
+    283150n 1.8
+    283199n 1.8
+    283200n 0
+    283249n 0
+    283250n 1.8
+    283299n 1.8
+    283300n 0
+    283349n 0
+    283350n 1.8
+    283399n 1.8
+    283400n 0
+    283449n 0
+    283450n 1.8
+    283499n 1.8
+    283500n 0
+    283549n 0
+    283550n 1.8
+    283599n 1.8
+    283600n 0
+    283649n 0
+    283650n 1.8
+    283699n 1.8
+    283700n 0
+    283749n 0
+    283750n 1.8
+    283799n 1.8
+    283800n 0
+    283849n 0
+    283850n 1.8
+    283899n 1.8
+    283900n 0
+    283949n 0
+    283950n 1.8
+    283999n 1.8
+    284000n 0
+    284049n 0
+    284050n 1.8
+    284099n 1.8
+    284100n 0
+    284149n 0
+    284150n 1.8
+    284199n 1.8
+    284200n 0
+    284249n 0
+    284250n 1.8
+    284299n 1.8
+    284300n 0
+    284349n 0
+    284350n 1.8
+    284399n 1.8
+    284400n 0
+    284449n 0
+    284450n 1.8
+    284499n 1.8
+    284500n 0
+    284549n 0
+    284550n 1.8
+    284599n 1.8
+    284600n 0
+    284649n 0
+    284650n 1.8
+    284699n 1.8
+    284700n 0
+    284749n 0
+    284750n 1.8
+    284799n 1.8
+    284800n 0
+    284849n 0
+    284850n 1.8
+    284899n 1.8
+    284900n 0
+    284949n 0
+    284950n 1.8
+    284999n 1.8
+    285000n 0
+    285049n 0
+    285050n 1.8
+    285099n 1.8
+    285100n 0
+    285149n 0
+    285150n 1.8
+    285199n 1.8
+    285200n 0
+    285249n 0
+    285250n 1.8
+    285299n 1.8
+    285300n 0
+    285349n 0
+    285350n 1.8
+    285399n 1.8
+    285400n 0
+    285449n 0
+    285450n 1.8
+    285499n 1.8
+    285500n 0
+    285549n 0
+    285550n 1.8
+    285599n 1.8
+    285600n 0
+    285649n 0
+    285650n 1.8
+    285699n 1.8
+    285700n 0
+    285749n 0
+    285750n 1.8
+    285799n 1.8
+    285800n 0
+    285849n 0
+    285850n 1.8
+    285899n 1.8
+    285900n 0
+    285949n 0
+    285950n 1.8
+    285999n 1.8
+    286000n 0
+    286049n 0
+    286050n 1.8
+    286099n 1.8
+    286100n 0
+    286149n 0
+    286150n 1.8
+    286199n 1.8
+    286200n 0
+    286249n 0
+    286250n 1.8
+    286299n 1.8
+    286300n 0
+    286349n 0
+    286350n 1.8
+    286399n 1.8
+    286400n 0
+    286449n 0
+    286450n 1.8
+    286499n 1.8
+    286500n 0
+    286549n 0
+    286550n 1.8
+    286599n 1.8
+    286600n 0
+    286649n 0
+    286650n 1.8
+    286699n 1.8
+    286700n 0
+    286749n 0
+    286750n 1.8
+    286799n 1.8
+    286800n 0
+    286849n 0
+    286850n 1.8
+    286899n 1.8
+    286900n 0
+    286949n 0
+    286950n 1.8
+    286999n 1.8
+    287000n 0
+    287049n 0
+    287050n 1.8
+    287099n 1.8
+    287100n 0
+    287149n 0
+    287150n 1.8
+    287199n 1.8
+    287200n 0
+    287249n 0
+    287250n 1.8
+    287299n 1.8
+    287300n 0
+    287349n 0
+    287350n 1.8
+    287399n 1.8
+    287400n 0
+    287449n 0
+    287450n 1.8
+    287499n 1.8
+    287500n 0
+    287549n 0
+    287550n 1.8
+    287599n 1.8
+    287600n 0
+    287649n 0
+    287650n 1.8
+    287699n 1.8
+    287700n 0
+    287749n 0
+    287750n 1.8
+    287799n 1.8
+    287800n 0
+    287849n 0
+    287850n 1.8
+    287899n 1.8
+    287900n 0
+    287949n 0
+    287950n 1.8
+    287999n 1.8
+    288000n 0
+    288049n 0
+    288050n 1.8
+    288099n 1.8
+    288100n 0
+    288149n 0
+    288150n 1.8
+    288199n 1.8
+    288200n 0
+    288249n 0
+    288250n 1.8
+    288299n 1.8
+    288300n 0
+    288349n 0
+    288350n 1.8
+    288399n 1.8
+    288400n 0
+    288449n 0
+    288450n 1.8
+    288499n 1.8
+    288500n 0
+    288549n 0
+    288550n 1.8
+    288599n 1.8
+    288600n 0
+    288649n 0
+    288650n 1.8
+    288699n 1.8
+    288700n 0
+    288749n 0
+    288750n 1.8
+    288799n 1.8
+    288800n 0
+    288849n 0
+    288850n 1.8
+    288899n 1.8
+    288900n 0
+    288949n 0
+    288950n 1.8
+    288999n 1.8
+    289000n 0
+    289049n 0
+    289050n 1.8
+    289099n 1.8
+    289100n 0
+    289149n 0
+    289150n 1.8
+    289199n 1.8
+    289200n 0
+    289249n 0
+    289250n 1.8
+    289299n 1.8
+    289300n 0
+    289349n 0
+    289350n 1.8
+    289399n 1.8
+    289400n 0
+    289449n 0
+    289450n 1.8
+    289499n 1.8
+    289500n 0
+    289549n 0
+    289550n 1.8
+    289599n 1.8
+    289600n 0
+    289649n 0
+    289650n 1.8
+    289699n 1.8
+    289700n 0
+    289749n 0
+    289750n 1.8
+    289799n 1.8
+    289800n 0
+    289849n 0
+    289850n 1.8
+    289899n 1.8
+    289900n 0
+    289949n 0
+    289950n 1.8
+    289999n 1.8
+    290000n 0
+    290049n 0
+    290050n 1.8
+    290099n 1.8
+    290100n 0
+    290149n 0
+    290150n 1.8
+    290199n 1.8
+    290200n 0
+    290249n 0
+    290250n 1.8
+    290299n 1.8
+    290300n 0
+    290349n 0
+    290350n 1.8
+    290399n 1.8
+    290400n 0
+    290449n 0
+    290450n 1.8
+    290499n 1.8
+    290500n 0
+    290549n 0
+    290550n 1.8
+    290599n 1.8
+    290600n 0
+    290649n 0
+    290650n 1.8
+    290699n 1.8
+    290700n 0
+    290749n 0
+    290750n 1.8
+    290799n 1.8
+    290800n 0
+    290849n 0
+    290850n 1.8
+    290899n 1.8
+    290900n 0
+    290949n 0
+    290950n 1.8
+    290999n 1.8
+    291000n 0
+    291049n 0
+    291050n 1.8
+    291099n 1.8
+    291100n 0
+    291149n 0
+    291150n 1.8
+    291199n 1.8
+    291200n 0
+    291249n 0
+    291250n 1.8
+    291299n 1.8
+    291300n 0
+    291349n 0
+    291350n 1.8
+    291399n 1.8
+    291400n 0
+    291449n 0
+    291450n 1.8
+    291499n 1.8
+    291500n 0
+    291549n 0
+    291550n 1.8
+    291599n 1.8
+    291600n 0
+    291649n 0
+    291650n 1.8
+    291699n 1.8
+    291700n 0
+    291749n 0
+    291750n 1.8
+    291799n 1.8
+    291800n 0
+    291849n 0
+    291850n 1.8
+    291899n 1.8
+    291900n 0
+    291949n 0
+    291950n 1.8
+    291999n 1.8
+    292000n 0
+    292049n 0
+    292050n 1.8
+    292099n 1.8
+    292100n 0
+    292149n 0
+    292150n 1.8
+    292199n 1.8
+    292200n 0
+    292249n 0
+    292250n 1.8
+    292299n 1.8
+    292300n 0
+    292349n 0
+    292350n 1.8
+    292399n 1.8
+    292400n 0
+    292449n 0
+    292450n 1.8
+    292499n 1.8
+    292500n 0
+    292549n 0
+    292550n 1.8
+    292599n 1.8
+    292600n 0
+    292649n 0
+    292650n 1.8
+    292699n 1.8
+    292700n 0
+    292749n 0
+    292750n 1.8
+    292799n 1.8
+    292800n 0
+    292849n 0
+    292850n 1.8
+    292899n 1.8
+    292900n 0
+    292949n 0
+    292950n 1.8
+    292999n 1.8
+    293000n 0
+    293049n 0
+    293050n 1.8
+    293099n 1.8
+    293100n 0
+    293149n 0
+    293150n 1.8
+    293199n 1.8
+    293200n 0
+    293249n 0
+    293250n 1.8
+    293299n 1.8
+    293300n 0
+    293349n 0
+    293350n 1.8
+    293399n 1.8
+    293400n 0
+    293449n 0
+    293450n 1.8
+    293499n 1.8
+    293500n 0
+    293549n 0
+    293550n 1.8
+    293599n 1.8
+    293600n 0
+    293649n 0
+    293650n 1.8
+    293699n 1.8
+    293700n 0
+    293749n 0
+    293750n 1.8
+    293799n 1.8
+    293800n 0
+    293849n 0
+    293850n 1.8
+    293899n 1.8
+    293900n 0
+    293949n 0
+    293950n 1.8
+    293999n 1.8
+    294000n 0
+    294049n 0
+    294050n 1.8
+    294099n 1.8
+    294100n 0
+    294149n 0
+    294150n 1.8
+    294199n 1.8
+    294200n 0
+    294249n 0
+    294250n 1.8
+    294299n 1.8
+    294300n 0
+    294349n 0
+    294350n 1.8
+    294399n 1.8
+    294400n 0
+    294449n 0
+    294450n 1.8
+    294499n 1.8
+    294500n 0
+    294549n 0
+    294550n 1.8
+    294599n 1.8
+    294600n 0
+    294649n 0
+    294650n 1.8
+    294699n 1.8
+    294700n 0
+    294749n 0
+    294750n 1.8
+    294799n 1.8
+    294800n 0
+    294849n 0
+    294850n 1.8
+    294899n 1.8
+    294900n 0
+    294949n 0
+    294950n 1.8
+    294999n 1.8
+    295000n 0
+    295049n 0
+    295050n 1.8
+    295099n 1.8
+    295100n 0
+    295149n 0
+    295150n 1.8
+    295199n 1.8
+    295200n 0
+    295249n 0
+    295250n 1.8
+    295299n 1.8
+    295300n 0
+    295349n 0
+    295350n 1.8
+    295399n 1.8
+    295400n 0
+    295449n 0
+    295450n 1.8
+    295499n 1.8
+    295500n 0
+    295549n 0
+    295550n 1.8
+    295599n 1.8
+    295600n 0
+    295649n 0
+    295650n 1.8
+    295699n 1.8
+    295700n 0
+    295749n 0
+    295750n 1.8
+    295799n 1.8
+    295800n 0
+    295849n 0
+    295850n 1.8
+    295899n 1.8
+    295900n 0
+    295949n 0
+    295950n 1.8
+    295999n 1.8
+    296000n 0
+    296049n 0
+    296050n 1.8
+    296099n 1.8
+    296100n 0
+    296149n 0
+    296150n 1.8
+    296199n 1.8
+    296200n 0
+    296249n 0
+    296250n 1.8
+    296299n 1.8
+    296300n 0
+    296349n 0
+    296350n 1.8
+    296399n 1.8
+    296400n 0
+    296449n 0
+    296450n 1.8
+    296499n 1.8
+    296500n 0
+    296549n 0
+    296550n 1.8
+    296599n 1.8
+    296600n 0
+    296649n 0
+    296650n 1.8
+    296699n 1.8
+    296700n 0
+    296749n 0
+    296750n 1.8
+    296799n 1.8
+    296800n 0
+    296849n 0
+    296850n 1.8
+    296899n 1.8
+    296900n 0
+    296949n 0
+    296950n 1.8
+    296999n 1.8
+    297000n 0
+    297049n 0
+    297050n 1.8
+    297099n 1.8
+    297100n 0
+    297149n 0
+    297150n 1.8
+    297199n 1.8
+    297200n 0
+    297249n 0
+    297250n 1.8
+    297299n 1.8
+    297300n 0
+    297349n 0
+    297350n 1.8
+    297399n 1.8
+    297400n 0
+    297449n 0
+    297450n 1.8
+    297499n 1.8
+    297500n 0
+    297549n 0
+    297550n 1.8
+    297599n 1.8
+    297600n 0
+    297649n 0
+    297650n 1.8
+    297699n 1.8
+    297700n 0
+    297749n 0
+    297750n 1.8
+    297799n 1.8
+    297800n 0
+    297849n 0
+    297850n 1.8
+    297899n 1.8
+    297900n 0
+    297949n 0
+    297950n 1.8
+    297999n 1.8
+    298000n 0
+    298049n 0
+    298050n 1.8
+    298099n 1.8
+    298100n 0
+    298149n 0
+    298150n 1.8
+    298199n 1.8
+    298200n 0
+    298249n 0
+    298250n 1.8
+    298299n 1.8
+    298300n 0
+    298349n 0
+    298350n 1.8
+    298399n 1.8
+    298400n 0
+    298449n 0
+    298450n 1.8
+    298499n 1.8
+    298500n 0
+    298549n 0
+    298550n 1.8
+    298599n 1.8
+    298600n 0
+    298649n 0
+    298650n 1.8
+    298699n 1.8
+    298700n 0
+    298749n 0
+    298750n 1.8
+    298799n 1.8
+    298800n 0
+    298849n 0
+    298850n 1.8
+    298899n 1.8
+    298900n 0
+    298949n 0
+    298950n 1.8
+    298999n 1.8
+    299000n 0
+    299049n 0
+    299050n 1.8
+    299099n 1.8
+    299100n 0
+    299149n 0
+    299150n 1.8
+    299199n 1.8
+    299200n 0
+    299249n 0
+    299250n 1.8
+    299299n 1.8
+    299300n 0
+    299349n 0
+    299350n 1.8
+    299399n 1.8
+    299400n 0
+    299449n 0
+    299450n 1.8
+    299499n 1.8
+    299500n 0
+    299549n 0
+    299550n 1.8
+    299599n 1.8
+    299600n 0
+    299649n 0
+    299650n 1.8
+    299699n 1.8
+    299700n 0
+    299749n 0
+    299750n 1.8
+    299799n 1.8
+    299800n 0
+    299849n 0
+    299850n 1.8
+    299899n 1.8
+    299900n 0
+    299949n 0
+    299950n 1.8
+    299999n 1.8
+    300000n 0
+    300049n 0
+    300050n 1.8
+    300099n 1.8
+    300100n 0
+    300149n 0
+    300150n 1.8
+    300199n 1.8
+    300200n 0
+    300249n 0
+    300250n 1.8
+    300299n 1.8
+    300300n 0
+    300349n 0
+    300350n 1.8
+    300399n 1.8
+    300400n 0
+    300449n 0
+    300450n 1.8
+    300499n 1.8
+    300500n 0
+    300549n 0
+    300550n 1.8
+    300599n 1.8
+    300600n 0
+    300649n 0
+    300650n 1.8
+    300699n 1.8
+    300700n 0
+    300749n 0
+    300750n 1.8
+    300799n 1.8
+    300800n 0
+    300849n 0
+    300850n 1.8
+    300899n 1.8
+    300900n 0
+    300949n 0
+    300950n 1.8
+    300999n 1.8
+    301000n 0
+    301049n 0
+    301050n 1.8
+    301099n 1.8
+    301100n 0
+    301149n 0
+    301150n 1.8
+    301199n 1.8
+    301200n 0
+    301249n 0
+    301250n 1.8
+    301299n 1.8
+    301300n 0
+    301349n 0
+    301350n 1.8
+    301399n 1.8
+    301400n 0
+    301449n 0
+    301450n 1.8
+    301499n 1.8
+    301500n 0
+    301549n 0
+    301550n 1.8
+    301599n 1.8
+    301600n 0
+    301649n 0
+    301650n 1.8
+    301699n 1.8
+    301700n 0
+    301749n 0
+    301750n 1.8
+    301799n 1.8
+    301800n 0
+    301849n 0
+    301850n 1.8
+    301899n 1.8
+    301900n 0
+    301949n 0
+    301950n 1.8
+    301999n 1.8
+    302000n 0
+    302049n 0
+    302050n 1.8
+    302099n 1.8
+    302100n 0
+    302149n 0
+    302150n 1.8
+    302199n 1.8
+    302200n 0
+    302249n 0
+    302250n 1.8
+    302299n 1.8
+    302300n 0
+    302349n 0
+    302350n 1.8
+    302399n 1.8
+    302400n 0
+    302449n 0
+    302450n 1.8
+    302499n 1.8
+    302500n 0
+    302549n 0
+    302550n 1.8
+    302599n 1.8
+    302600n 0
+    302649n 0
+    302650n 1.8
+    302699n 1.8
+    302700n 0
+    302749n 0
+    302750n 1.8
+    302799n 1.8
+    302800n 0
+    302849n 0
+    302850n 1.8
+    302899n 1.8
+    302900n 0
+    302949n 0
+    302950n 1.8
+    302999n 1.8
+    303000n 0
+    303049n 0
+    303050n 1.8
+    303099n 1.8
+    303100n 0
+    303149n 0
+    303150n 1.8
+    303199n 1.8
+    303200n 0
+    303249n 0
+    303250n 1.8
+    303299n 1.8
+    303300n 0
+    303349n 0
+    303350n 1.8
+    303399n 1.8
+    303400n 0
+    303449n 0
+    303450n 1.8
+    303499n 1.8
+    303500n 0
+    303549n 0
+    303550n 1.8
+    303599n 1.8
+    303600n 0
+    303649n 0
+    303650n 1.8
+    303699n 1.8
+    303700n 0
+    303749n 0
+    303750n 1.8
+    303799n 1.8
+    303800n 0
+    303849n 0
+    303850n 1.8
+    303899n 1.8
+    303900n 0
+    303949n 0
+    303950n 1.8
+    303999n 1.8
+    304000n 0
+    304049n 0
+    304050n 1.8
+    304099n 1.8
+    304100n 0
+    304149n 0
+    304150n 1.8
+    304199n 1.8
+    304200n 0
+    304249n 0
+    304250n 1.8
+    304299n 1.8
+    304300n 0
+    304349n 0
+    304350n 1.8
+    304399n 1.8
+    304400n 0
+    304449n 0
+    304450n 1.8
+    304499n 1.8
+    304500n 0
+    304549n 0
+    304550n 1.8
+    304599n 1.8
+    304600n 0
+    304649n 0
+    304650n 1.8
+    304699n 1.8
+    304700n 0
+    304749n 0
+    304750n 1.8
+    304799n 1.8
+    304800n 0
+    304849n 0
+    304850n 1.8
+    304899n 1.8
+    304900n 0
+    304949n 0
+    304950n 1.8
+    304999n 1.8
+    305000n 0
+    305049n 0
+    305050n 1.8
+    305099n 1.8
+    305100n 0
+    305149n 0
+    305150n 1.8
+    305199n 1.8
+    305200n 0
+    305249n 0
+    305250n 1.8
+    305299n 1.8
+    305300n 0
+    305349n 0
+    305350n 1.8
+    305399n 1.8
+    305400n 0
+    305449n 0
+    305450n 1.8
+    305499n 1.8
+    305500n 0
+    305549n 0
+    305550n 1.8
+    305599n 1.8
+    305600n 0
+    305649n 0
+    305650n 1.8
+    305699n 1.8
+    305700n 0
+    305749n 0
+    305750n 1.8
+    305799n 1.8
+    305800n 0
+    305849n 0
+    305850n 1.8
+    305899n 1.8
+    305900n 0
+    305949n 0
+    305950n 1.8
+    305999n 1.8
+    306000n 0
+    306049n 0
+    306050n 1.8
+    306099n 1.8
+    306100n 0
+    306149n 0
+    306150n 1.8
+    306199n 1.8
+    306200n 0
+    306249n 0
+    306250n 1.8
+    306299n 1.8
+    306300n 0
+    306349n 0
+    306350n 1.8
+    306399n 1.8
+    306400n 0
+    306449n 0
+    306450n 1.8
+    306499n 1.8
+    306500n 0
+    306549n 0
+    306550n 1.8
+    306599n 1.8
+    306600n 0
+    306649n 0
+    306650n 1.8
+    306699n 1.8
+    306700n 0
+    306749n 0
+    306750n 1.8
+    306799n 1.8
+    306800n 0
+    306849n 0
+    306850n 1.8
+    306899n 1.8
+    306900n 0
+    306949n 0
+    306950n 1.8
+    306999n 1.8
+    307000n 0
+    307049n 0
+    307050n 1.8
+    307099n 1.8
+    307100n 0
+    307149n 0
+    307150n 1.8
+    307199n 1.8
+    307200n 0
+    307249n 0
+    307250n 1.8
+    307299n 1.8
+    307300n 0
+    307349n 0
+    307350n 1.8
+    307399n 1.8
+    307400n 0
+    307449n 0
+    307450n 1.8
+    307499n 1.8
+    307500n 0
+    307549n 0
+    307550n 1.8
+    307599n 1.8
+    307600n 0
+    307649n 0
+    307650n 1.8
+    307699n 1.8
+    307700n 0
+    307749n 0
+    307750n 1.8
+    307799n 1.8
+    307800n 0
+    307849n 0
+    307850n 1.8
+    307899n 1.8
+    307900n 0
+    307949n 0
+    307950n 1.8
+    307999n 1.8
+    308000n 0
+    308049n 0
+    308050n 1.8
+    308099n 1.8
+    308100n 0
+    308149n 0
+    308150n 1.8
+    308199n 1.8
+    308200n 0
+    308249n 0
+    308250n 1.8
+    308299n 1.8
+    308300n 0
+    308349n 0
+    308350n 1.8
+    308399n 1.8
+    308400n 0
+    308449n 0
+    308450n 1.8
+    308499n 1.8
+    308500n 0
+    308549n 0
+    308550n 1.8
+    308599n 1.8
+    308600n 0
+    308649n 0
+    308650n 1.8
+    308699n 1.8
+    308700n 0
+    308749n 0
+    308750n 1.8
+    308799n 1.8
+    308800n 0
+    308849n 0
+    308850n 1.8
+    308899n 1.8
+    308900n 0
+    308949n 0
+    308950n 1.8
+    308999n 1.8
+    309000n 0
+    309049n 0
+    309050n 1.8
+    309099n 1.8
+    309100n 0
+    309149n 0
+    309150n 1.8
+    309199n 1.8
+    309200n 0
+    309249n 0
+    309250n 1.8
+    309299n 1.8
+    309300n 0
+    309349n 0
+    309350n 1.8
+    309399n 1.8
+    309400n 0
+    309449n 0
+    309450n 1.8
+    309499n 1.8
+    309500n 0
+    309549n 0
+    309550n 1.8
+    309599n 1.8
+    309600n 0
+    309649n 0
+    309650n 1.8
+    309699n 1.8
+    309700n 0
+    309749n 0
+    309750n 1.8
+    309799n 1.8
+    309800n 0
+    309849n 0
+    309850n 1.8
+    309899n 1.8
+    309900n 0
+    309949n 0
+    309950n 1.8
+    309999n 1.8
+    310000n 0
+    310049n 0
+    310050n 1.8
+    310099n 1.8
+    310100n 0
+    310149n 0
+    310150n 1.8
+    310199n 1.8
+    310200n 0
+    310249n 0
+    310250n 1.8
+    310299n 1.8
+    310300n 0
+    310349n 0
+    310350n 1.8
+    310399n 1.8
+    310400n 0
+    310449n 0
+    310450n 1.8
+    310499n 1.8
+    310500n 0
+    310549n 0
+    310550n 1.8
+    310599n 1.8
+    310600n 0
+    310649n 0
+    310650n 1.8
+    310699n 1.8
+    310700n 0
+    310749n 0
+    310750n 1.8
+    310799n 1.8
+    310800n 0
+    310849n 0
+    310850n 1.8
+    310899n 1.8
+    310900n 0
+    310949n 0
+    310950n 1.8
+    310999n 1.8
+    311000n 0
+    311049n 0
+    311050n 1.8
+    311099n 1.8
+    311100n 0
+    311149n 0
+    311150n 1.8
+    311199n 1.8
+    311200n 0
+    311249n 0
+    311250n 1.8
+    311299n 1.8
+    311300n 0
+    311349n 0
+    311350n 1.8
+    311399n 1.8
+    311400n 0
+    311449n 0
+    311450n 1.8
+    311499n 1.8
+    311500n 0
+    311549n 0
+    311550n 1.8
+    311599n 1.8
+    311600n 0
+    311649n 0
+    311650n 1.8
+    311699n 1.8
+    311700n 0
+    311749n 0
+    311750n 1.8
+    311799n 1.8
+    311800n 0
+    311849n 0
+    311850n 1.8
+    311899n 1.8
+    311900n 0
+    311949n 0
+    311950n 1.8
+    311999n 1.8
+    312000n 0
+    312049n 0
+    312050n 1.8
+    312099n 1.8
+    312100n 0
+    312149n 0
+    312150n 1.8
+    312199n 1.8
+    312200n 0
+    312249n 0
+    312250n 1.8
+    312299n 1.8
+    312300n 0
+    312349n 0
+    312350n 1.8
+    312399n 1.8
+    312400n 0
+    312449n 0
+    312450n 1.8
+    312499n 1.8
+    312500n 0
+    312549n 0
+    312550n 1.8
+    312599n 1.8
+    312600n 0
+    312649n 0
+    312650n 1.8
+    312699n 1.8
+    312700n 0
+    312749n 0
+    312750n 1.8
+    312799n 1.8
+    312800n 0
+    312849n 0
+    312850n 1.8
+    312899n 1.8
+    312900n 0
+    312949n 0
+    312950n 1.8
+    312999n 1.8
+    313000n 0
+    313049n 0
+    313050n 1.8
+    313099n 1.8
+    313100n 0
+    313149n 0
+    313150n 1.8
+    313199n 1.8
+    313200n 0
+    313249n 0
+    313250n 1.8
+    313299n 1.8
+    313300n 0
+    313349n 0
+    313350n 1.8
+    313399n 1.8
+    313400n 0
+    313449n 0
+    313450n 1.8
+    313499n 1.8
+    313500n 0
+    313549n 0
+    313550n 1.8
+    313599n 1.8
+    313600n 0
+    313649n 0
+    313650n 1.8
+    313699n 1.8
+    313700n 0
+    313749n 0
+    313750n 1.8
+    313799n 1.8
+    313800n 0
+    313849n 0
+    313850n 1.8
+    313899n 1.8
+    313900n 0
+    313949n 0
+    313950n 1.8
+    313999n 1.8
+    314000n 0
+    314049n 0
+    314050n 1.8
+    314099n 1.8
+    314100n 0
+    314149n 0
+    314150n 1.8
+    314199n 1.8
+    314200n 0
+    314249n 0
+    314250n 1.8
+    314299n 1.8
+    314300n 0
+    314349n 0
+    314350n 1.8
+    314399n 1.8
+    314400n 0
+    314449n 0
+    314450n 1.8
+    314499n 1.8
+    314500n 0
+    314549n 0
+    314550n 1.8
+    314599n 1.8
+    314600n 0
+    314649n 0
+    314650n 1.8
+    314699n 1.8
+    314700n 0
+    314749n 0
+    314750n 1.8
+    314799n 1.8
+    314800n 0
+    314849n 0
+    314850n 1.8
+    314899n 1.8
+    314900n 0
+    314949n 0
+    314950n 1.8
+    314999n 1.8
+    315000n 0
+    315049n 0
+    315050n 1.8
+    315099n 1.8
+    315100n 0
+    315149n 0
+    315150n 1.8
+    315199n 1.8
+    315200n 0
+    315249n 0
+    315250n 1.8
+    315299n 1.8
+    315300n 0
+    315349n 0
+    315350n 1.8
+    315399n 1.8
+    315400n 0
+    315449n 0
+    315450n 1.8
+    315499n 1.8
+    315500n 0
+    315549n 0
+    315550n 1.8
+    315599n 1.8
+    315600n 0
+    315649n 0
+    315650n 1.8
+    315699n 1.8
+    315700n 0
+    315749n 0
+    315750n 1.8
+    315799n 1.8
+    315800n 0
+    315849n 0
+    315850n 1.8
+    315899n 1.8
+    315900n 0
+    315949n 0
+    315950n 1.8
+    315999n 1.8
+    316000n 0
+    316049n 0
+    316050n 1.8
+    316099n 1.8
+    316100n 0
+    316149n 0
+    316150n 1.8
+    316199n 1.8
+    316200n 0
+    316249n 0
+    316250n 1.8
+    316299n 1.8
+    316300n 0
+    316349n 0
+    316350n 1.8
+    316399n 1.8
+    316400n 0
+    316449n 0
+    316450n 1.8
+    316499n 1.8
+    316500n 0
+    316549n 0
+    316550n 1.8
+    316599n 1.8
+    316600n 0
+    316649n 0
+    316650n 1.8
+    316699n 1.8
+    316700n 0
+    316749n 0
+    316750n 1.8
+    316799n 1.8
+    316800n 0
+    316849n 0
+    316850n 1.8
+    316899n 1.8
+    316900n 0
+    316949n 0
+    316950n 1.8
+    316999n 1.8
+    317000n 0
+    317049n 0
+    317050n 1.8
+    317099n 1.8
+    317100n 0
+    317149n 0
+    317150n 1.8
+    317199n 1.8
+    317200n 0
+    317249n 0
+    317250n 1.8
+    317299n 1.8
+    317300n 0
+    317349n 0
+    317350n 1.8
+    317399n 1.8
+    317400n 0
+    317449n 0
+    317450n 1.8
+    317499n 1.8
+    317500n 0
+    317549n 0
+    317550n 1.8
+    317599n 1.8
+    317600n 0
+    317649n 0
+    317650n 1.8
+    317699n 1.8
+    317700n 0
+    317749n 0
+    317750n 1.8
+    317799n 1.8
+    317800n 0
+    317849n 0
+    317850n 1.8
+    317899n 1.8
+    317900n 0
+    317949n 0
+    317950n 1.8
+    317999n 1.8
+    318000n 0
+    318049n 0
+    318050n 1.8
+    318099n 1.8
+    318100n 0
+    318149n 0
+    318150n 1.8
+    318199n 1.8
+    318200n 0
+    318249n 0
+    318250n 1.8
+    318299n 1.8
+    318300n 0
+    318349n 0
+    318350n 1.8
+    318399n 1.8
+    318400n 0
+    318449n 0
+    318450n 1.8
+    318499n 1.8
+    318500n 0
+    318549n 0
+    318550n 1.8
+    318599n 1.8
+    318600n 0
+    318649n 0
+    318650n 1.8
+    318699n 1.8
+    318700n 0
+    318749n 0
+    318750n 1.8
+    318799n 1.8
+    318800n 0
+    318849n 0
+    318850n 1.8
+    318899n 1.8
+    318900n 0
+    318949n 0
+    318950n 1.8
+    318999n 1.8
+    319000n 0
+    319049n 0
+    319050n 1.8
+    319099n 1.8
+    319100n 0
+    319149n 0
+    319150n 1.8
+    319199n 1.8
+    319200n 0
+    319249n 0
+    319250n 1.8
+    319299n 1.8
+    319300n 0
+    319349n 0
+    319350n 1.8
+    319399n 1.8
+    319400n 0
+    319449n 0
+    319450n 1.8
+    319499n 1.8
+    319500n 0
+    319549n 0
+    319550n 1.8
+    319599n 1.8
+    319600n 0
+    319649n 0
+    319650n 1.8
+    319699n 1.8
+    319700n 0
+    319749n 0
+    319750n 1.8
+    319799n 1.8
+    319800n 0
+    319849n 0
+    319850n 1.8
+    319899n 1.8
+    319900n 0
+    319949n 0
+    319950n 1.8
+    319999n 1.8
+    320000n 0
+    320049n 0
+    320050n 1.8
+    320099n 1.8
+    320100n 0
+    320149n 0
+    320150n 1.8
+    320199n 1.8
+    320200n 0
+    320249n 0
+    320250n 1.8
+    320299n 1.8
+    320300n 0
+    320349n 0
+    320350n 1.8
+    320399n 1.8
+    320400n 0
+    320449n 0
+    320450n 1.8
+    320499n 1.8
+    320500n 0
+    320549n 0
+    320550n 1.8
+    320599n 1.8
+    320600n 0
+    320649n 0
+    320650n 1.8
+    320699n 1.8
+    320700n 0
+    320749n 0
+    320750n 1.8
+    320799n 1.8
+    320800n 0
+    320849n 0
+    320850n 1.8
+    320899n 1.8
+    320900n 0
+    320949n 0
+    320950n 1.8
+    320999n 1.8
+    321000n 0
+    321049n 0
+    321050n 1.8
+    321099n 1.8
+    321100n 0
+    321149n 0
+    321150n 1.8
+    321199n 1.8
+    321200n 0
+    321249n 0
+    321250n 1.8
+    321299n 1.8
+    321300n 0
+    321349n 0
+    321350n 1.8
+    321399n 1.8
+    321400n 0
+    321449n 0
+    321450n 1.8
+    321499n 1.8
+    321500n 0
+    321549n 0
+    321550n 1.8
+    321599n 1.8
+    321600n 0
+    321649n 0
+    321650n 1.8
+    321699n 1.8
+    321700n 0
+    321749n 0
+    321750n 1.8
+    321799n 1.8
+    321800n 0
+    321849n 0
+    321850n 1.8
+    321899n 1.8
+    321900n 0
+    321949n 0
+    321950n 1.8
+    321999n 1.8
+    322000n 0
+    322049n 0
+    322050n 1.8
+    322099n 1.8
+    322100n 0
+    322149n 0
+    322150n 1.8
+    322199n 1.8
+    322200n 0
+    322249n 0
+    322250n 1.8
+    322299n 1.8
+    322300n 0
+    322349n 0
+    322350n 1.8
+    322399n 1.8
+    322400n 0
+    322449n 0
+    322450n 1.8
+    322499n 1.8
+    322500n 0
+    322549n 0
+    322550n 1.8
+    322599n 1.8
+    322600n 0
+    322649n 0
+    322650n 1.8
+    322699n 1.8
+    322700n 0
+    322749n 0
+    322750n 1.8
+    322799n 1.8
+    322800n 0
+    322849n 0
+    322850n 1.8
+    322899n 1.8
+    322900n 0
+    322949n 0
+    322950n 1.8
+    322999n 1.8
+    323000n 0
+    323049n 0
+    323050n 1.8
+    323099n 1.8
+    323100n 0
+    323149n 0
+    323150n 1.8
+    323199n 1.8
+    323200n 0
+    323249n 0
+    323250n 1.8
+    323299n 1.8
+    323300n 0
+    323349n 0
+    323350n 1.8
+    323399n 1.8
+    323400n 0
+    323449n 0
+    323450n 1.8
+    323499n 1.8
+    323500n 0
+    323549n 0
+    323550n 1.8
+    323599n 1.8
+    323600n 0
+    323649n 0
+    323650n 1.8
+    323699n 1.8
+    323700n 0
+    323749n 0
+    323750n 1.8
+    323799n 1.8
+    323800n 0
+    323849n 0
+    323850n 1.8
+    323899n 1.8
+    323900n 0
+    323949n 0
+    323950n 1.8
+    323999n 1.8
+    324000n 0
+    324049n 0
+    324050n 1.8
+    324099n 1.8
+    324100n 0
+    324149n 0
+    324150n 1.8
+    324199n 1.8
+    324200n 0
+    324249n 0
+    324250n 1.8
+    324299n 1.8
+    324300n 0
+    324349n 0
+    324350n 1.8
+    324399n 1.8
+    324400n 0
+    324449n 0
+    324450n 1.8
+    324499n 1.8
+    324500n 0
+    324549n 0
+    324550n 1.8
+    324599n 1.8
+    324600n 0
+    324649n 0
+    324650n 1.8
+    324699n 1.8
+    324700n 0
+    324749n 0
+    324750n 1.8
+    324799n 1.8
+    324800n 0
+    324849n 0
+    324850n 1.8
+    324899n 1.8
+    324900n 0
+    324949n 0
+    324950n 1.8
+    324999n 1.8
+    325000n 0
+    325049n 0
+    325050n 1.8
+    325099n 1.8
+    325100n 0
+    325149n 0
+    325150n 1.8
+    325199n 1.8
+    325200n 0
+    325249n 0
+    325250n 1.8
+    325299n 1.8
+    325300n 0
+    325349n 0
+    325350n 1.8
+    325399n 1.8
+    325400n 0
+    325449n 0
+    325450n 1.8
+    325499n 1.8
+    325500n 0
+    325549n 0
+    325550n 1.8
+    325599n 1.8
+    325600n 0
+    325649n 0
+    325650n 1.8
+    325699n 1.8
+    325700n 0
+    325749n 0
+    325750n 1.8
+    325799n 1.8
+    325800n 0
+    325849n 0
+    325850n 1.8
+    325899n 1.8
+    325900n 0
+    325949n 0
+    325950n 1.8
+    325999n 1.8
+    326000n 0
+    326049n 0
+    326050n 1.8
+    326099n 1.8
+    326100n 0
+    326149n 0
+    326150n 1.8
+    326199n 1.8
+    326200n 0
+    326249n 0
+    326250n 1.8
+    326299n 1.8
+    326300n 0
+    326349n 0
+    326350n 1.8
+    326399n 1.8
+    326400n 0
+    326449n 0
+    326450n 1.8
+    326499n 1.8
+    326500n 0
+    326549n 0
+    326550n 1.8
+    326599n 1.8
+    326600n 0
+    326649n 0
+    326650n 1.8
+    326699n 1.8
+    326700n 0
+    326749n 0
+    326750n 1.8
+    326799n 1.8
+    326800n 0
+    326849n 0
+    326850n 1.8
+    326899n 1.8
+    326900n 0
+    326949n 0
+    326950n 1.8
+    326999n 1.8
+    327000n 0
+    327049n 0
+    327050n 1.8
+    327099n 1.8
+    327100n 0
+    327149n 0
+    327150n 1.8
+    327199n 1.8
+    327200n 0
+    327249n 0
+    327250n 1.8
+    327299n 1.8
+    327300n 0
+    327349n 0
+    327350n 1.8
+    327399n 1.8
+    327400n 0
+    327449n 0
+    327450n 1.8
+    327499n 1.8
+    327500n 0
+    327549n 0
+    327550n 1.8
+    327599n 1.8
+    327600n 0
+    327649n 0
+    327650n 1.8
+    327699n 1.8
+    327700n 0
+    327749n 0
+    327750n 1.8
+    327799n 1.8
+    327800n 0
+    327849n 0
+    327850n 1.8
+    327899n 1.8
+    327900n 0
+    327949n 0
+    327950n 1.8
+    327999n 1.8
+    328000n 0
+    328049n 0
+    328050n 1.8
+    328099n 1.8
+    328100n 0
+    328149n 0
+    328150n 1.8
+    328199n 1.8
+    328200n 0
+    328249n 0
+    328250n 1.8
+    328299n 1.8
+    328300n 0
+    328349n 0
+    328350n 1.8
+    328399n 1.8
+    328400n 0
+    328449n 0
+    328450n 1.8
+    328499n 1.8
+    328500n 0
+    328549n 0
+    328550n 1.8
+    328599n 1.8
+    328600n 0
+    328649n 0
+    328650n 1.8
+    328699n 1.8
+    328700n 0
+    328749n 0
+    328750n 1.8
+    328799n 1.8
+    328800n 0
+    328849n 0
+    328850n 1.8
+    328899n 1.8
+    328900n 0
+    328949n 0
+    328950n 1.8
+    328999n 1.8
+    329000n 0
+    329049n 0
+    329050n 1.8
+    329099n 1.8
+    329100n 0
+    329149n 0
+    329150n 1.8
+    329199n 1.8
+    329200n 0
+    329249n 0
+    329250n 1.8
+    329299n 1.8
+    329300n 0
+    329349n 0
+    329350n 1.8
+    329399n 1.8
+    329400n 0
+    329449n 0
+    329450n 1.8
+    329499n 1.8
+    329500n 0
+    329549n 0
+    329550n 1.8
+    329599n 1.8
+    329600n 0
+    329649n 0
+    329650n 1.8
+    329699n 1.8
+    329700n 0
+    329749n 0
+    329750n 1.8
+    329799n 1.8
+    329800n 0
+    329849n 0
+    329850n 1.8
+    329899n 1.8
+    329900n 0
+    329949n 0
+    329950n 1.8
+    329999n 1.8
+    330000n 0
+    330049n 0
+    330050n 1.8
+    330099n 1.8
+    330100n 0
+    330149n 0
+    330150n 1.8
+    330199n 1.8
+    330200n 0
+    330249n 0
+    330250n 1.8
+    330299n 1.8
+    330300n 0
+    330349n 0
+    330350n 1.8
+    330399n 1.8
+    330400n 0
+    330449n 0
+    330450n 1.8
+    330499n 1.8
+    330500n 0
+    330549n 0
+    330550n 1.8
+    330599n 1.8
+    330600n 0
+    330649n 0
+    330650n 1.8
+    330699n 1.8
+    330700n 0
+    330749n 0
+    330750n 1.8
+    330799n 1.8
+    330800n 0
+    330849n 0
+    330850n 1.8
+    330899n 1.8
+    330900n 0
+    330949n 0
+    330950n 1.8
+    330999n 1.8
+    331000n 0
+    331049n 0
+    331050n 1.8
+    331099n 1.8
+    331100n 0
+    331149n 0
+    331150n 1.8
+    331199n 1.8
+    331200n 0
+    331249n 0
+    331250n 1.8
+    331299n 1.8
+    331300n 0
+    331349n 0
+    331350n 1.8
+    331399n 1.8
+    331400n 0
+    331449n 0
+    331450n 1.8
+    331499n 1.8
+    331500n 0
+    331549n 0
+    331550n 1.8
+    331599n 1.8
+    331600n 0
+    331649n 0
+    331650n 1.8
+    331699n 1.8
+    331700n 0
+    331749n 0
+    331750n 1.8
+    331799n 1.8
+    331800n 0
+    331849n 0
+    331850n 1.8
+    331899n 1.8
+    331900n 0
+    331949n 0
+    331950n 1.8
+    331999n 1.8
+    332000n 0
+    332049n 0
+    332050n 1.8
+    332099n 1.8
+    332100n 0
+    332149n 0
+    332150n 1.8
+    332199n 1.8
+    332200n 0
+    332249n 0
+    332250n 1.8
+    332299n 1.8
+    332300n 0
+    332349n 0
+    332350n 1.8
+    332399n 1.8
+    332400n 0
+    332449n 0
+    332450n 1.8
+    332499n 1.8
+    332500n 0
+    332549n 0
+    332550n 1.8
+    332599n 1.8
+    332600n 0
+    332649n 0
+    332650n 1.8
+    332699n 1.8
+    332700n 0
+    332749n 0
+    332750n 1.8
+    332799n 1.8
+    332800n 0
+    332849n 0
+    332850n 1.8
+    332899n 1.8
+    332900n 0
+    332949n 0
+    332950n 1.8
+    332999n 1.8
+    333000n 0
+    333049n 0
+    333050n 1.8
+    333099n 1.8
+    333100n 0
+    333149n 0
+    333150n 1.8
+    333199n 1.8
+    333200n 0
+    333249n 0
+    333250n 1.8
+    333299n 1.8
+    333300n 0
+    333349n 0
+    333350n 1.8
+    333399n 1.8
+    333400n 0
+    333449n 0
+    333450n 1.8
+    333499n 1.8
+    333500n 0
+    333549n 0
+    333550n 1.8
+    333599n 1.8
+    333600n 0
+    333649n 0
+    333650n 1.8
+    333699n 1.8
+    333700n 0
+    333749n 0
+    333750n 1.8
+    333799n 1.8
+    333800n 0
+    333849n 0
+    333850n 1.8
+    333899n 1.8
+    333900n 0
+    333949n 0
+    333950n 1.8
+    333999n 1.8
+    334000n 0
+    334049n 0
+    334050n 1.8
+    334099n 1.8
+    334100n 0
+    334149n 0
+    334150n 1.8
+    334199n 1.8
+    334200n 0
+    334249n 0
+    334250n 1.8
+    334299n 1.8
+    334300n 0
+    334349n 0
+    334350n 1.8
+    334399n 1.8
+    334400n 0
+    334449n 0
+    334450n 1.8
+    334499n 1.8
+    334500n 0
+    334549n 0
+    334550n 1.8
+    334599n 1.8
+    334600n 0
+    334649n 0
+    334650n 1.8
+    334699n 1.8
+    334700n 0
+    334749n 0
+    334750n 1.8
+    334799n 1.8
+    334800n 0
+    334849n 0
+    334850n 1.8
+    334899n 1.8
+    334900n 0
+    334949n 0
+    334950n 1.8
+    334999n 1.8
+    335000n 0
+    335049n 0
+    335050n 1.8
+    335099n 1.8
+    335100n 0
+    335149n 0
+    335150n 1.8
+    335199n 1.8
+    335200n 0
+    335249n 0
+    335250n 1.8
+    335299n 1.8
+    335300n 0
+    335349n 0
+    335350n 1.8
+    335399n 1.8
+    335400n 0
+    335449n 0
+    335450n 1.8
+    335499n 1.8
+    335500n 0
+    335549n 0
+    335550n 1.8
+    335599n 1.8
+    335600n 0
+    335649n 0
+    335650n 1.8
+    335699n 1.8
+    335700n 0
+    335749n 0
+    335750n 1.8
+    335799n 1.8
+    335800n 0
+    335849n 0
+    335850n 1.8
+    335899n 1.8
+    335900n 0
+    335949n 0
+    335950n 1.8
+    335999n 1.8
+    336000n 0
+    336049n 0
+    336050n 1.8
+    336099n 1.8
+    336100n 0
+    336149n 0
+    336150n 1.8
+    336199n 1.8
+    336200n 0
+    336249n 0
+    336250n 1.8
+    336299n 1.8
+    336300n 0
+    336349n 0
+    336350n 1.8
+    336399n 1.8
+    336400n 0
+    336449n 0
+    336450n 1.8
+    336499n 1.8
+    336500n 0
+    336549n 0
+    336550n 1.8
+    336599n 1.8
+    336600n 0
+    336649n 0
+    336650n 1.8
+    336699n 1.8
+    336700n 0
+    336749n 0
+    336750n 1.8
+    336799n 1.8
+    336800n 0
+    336849n 0
+    336850n 1.8
+    336899n 1.8
+    336900n 0
+    336949n 0
+    336950n 1.8
+    336999n 1.8
+    337000n 0
+    337049n 0
+    337050n 1.8
+    337099n 1.8
+    337100n 0
+    337149n 0
+    337150n 1.8
+    337199n 1.8
+    337200n 0
+    337249n 0
+    337250n 1.8
+    337299n 1.8
+    337300n 0
+    337349n 0
+    337350n 1.8
+    337399n 1.8
+    337400n 0
+    337449n 0
+    337450n 1.8
+    337499n 1.8
+    337500n 0
+    337549n 0
+    337550n 1.8
+    337599n 1.8
+    337600n 0
+    337649n 0
+    337650n 1.8
+    337699n 1.8
+    337700n 0
+    337749n 0
+    337750n 1.8
+    337799n 1.8
+    337800n 0
+    337849n 0
+    337850n 1.8
+    337899n 1.8
+    337900n 0
+    337949n 0
+    337950n 1.8
+    337999n 1.8
+    338000n 0
+    338049n 0
+    338050n 1.8
+    338099n 1.8
+    338100n 0
+    338149n 0
+    338150n 1.8
+    338199n 1.8
+    338200n 0
+    338249n 0
+    338250n 1.8
+    338299n 1.8
+    338300n 0
+    338349n 0
+    338350n 1.8
+    338399n 1.8
+    338400n 0
+    338449n 0
+    338450n 1.8
+    338499n 1.8
+    338500n 0
+    338549n 0
+    338550n 1.8
+    338599n 1.8
+    338600n 0
+    338649n 0
+    338650n 1.8
+    338699n 1.8
+    338700n 0
+    338749n 0
+    338750n 1.8
+    338799n 1.8
+    338800n 0
+    338849n 0
+    338850n 1.8
+    338899n 1.8
+    338900n 0
+    338949n 0
+    338950n 1.8
+    338999n 1.8
+    339000n 0
+    339049n 0
+    339050n 1.8
+    339099n 1.8
+    339100n 0
+    339149n 0
+    339150n 1.8
+    339199n 1.8
+    339200n 0
+    339249n 0
+    339250n 1.8
+    339299n 1.8
+    339300n 0
+    339349n 0
+    339350n 1.8
+    339399n 1.8
+    339400n 0
+    339449n 0
+    339450n 1.8
+    339499n 1.8
+    339500n 0
+    339549n 0
+    339550n 1.8
+    339599n 1.8
+    339600n 0
+    339649n 0
+    339650n 1.8
+    339699n 1.8
+    339700n 0
+    339749n 0
+    339750n 1.8
+    339799n 1.8
+    339800n 0
+    339849n 0
+    339850n 1.8
+    339899n 1.8
+    339900n 0
+    339949n 0
+    339950n 1.8
+    339999n 1.8
+    340000n 0
+    340049n 0
+    340050n 1.8
+    340099n 1.8
+    340100n 0
+    340149n 0
+    340150n 1.8
+    340199n 1.8
+    340200n 0
+    340249n 0
+    340250n 1.8
+    340299n 1.8
+    340300n 0
+    340349n 0
+    340350n 1.8
+    340399n 1.8
+    340400n 0
+    340449n 0
+    340450n 1.8
+    340499n 1.8
+    340500n 0
+    340549n 0
+    340550n 1.8
+    340599n 1.8
+    340600n 0
+    340649n 0
+    340650n 1.8
+    340699n 1.8
+    340700n 0
+    340749n 0
+    340750n 1.8
+    340799n 1.8
+    340800n 0
+    340849n 0
+    340850n 1.8
+    340899n 1.8
+    340900n 0
+    340949n 0
+    340950n 1.8
+    340999n 1.8
+    341000n 0
+    341049n 0
+    341050n 1.8
+    341099n 1.8
+    341100n 0
+    341149n 0
+    341150n 1.8
+    341199n 1.8
+    341200n 0
+    341249n 0
+    341250n 1.8
+    341299n 1.8
+    341300n 0
+    341349n 0
+    341350n 1.8
+    341399n 1.8
+    341400n 0
+    341449n 0
+    341450n 1.8
+    341499n 1.8
+    341500n 0
+    341549n 0
+    341550n 1.8
+    341599n 1.8
+    341600n 0
+    341649n 0
+    341650n 1.8
+    341699n 1.8
+    341700n 0
+    341749n 0
+    341750n 1.8
+    341799n 1.8
+    341800n 0
+    341849n 0
+    341850n 1.8
+    341899n 1.8
+    341900n 0
+    341949n 0
+    341950n 1.8
+    341999n 1.8
+    342000n 0
+    342049n 0
+    342050n 1.8
+    342099n 1.8
+    342100n 0
+    342149n 0
+    342150n 1.8
+    342199n 1.8
+    342200n 0
+    342249n 0
+    342250n 1.8
+    342299n 1.8
+    342300n 0
+    342349n 0
+    342350n 1.8
+    342399n 1.8
+    342400n 0
+    342449n 0
+    342450n 1.8
+    342499n 1.8
+    342500n 0
+    342549n 0
+    342550n 1.8
+    342599n 1.8
+    342600n 0
+    342649n 0
+    342650n 1.8
+    342699n 1.8
+    342700n 0
+    342749n 0
+    342750n 1.8
+    342799n 1.8
+    342800n 0
+    342849n 0
+    342850n 1.8
+    342899n 1.8
+    342900n 0
+    342949n 0
+    342950n 1.8
+    342999n 1.8
+    343000n 0
+    343049n 0
+    343050n 1.8
+    343099n 1.8
+    343100n 0
+    343149n 0
+    343150n 1.8
+    343199n 1.8
+    343200n 0
+    343249n 0
+    343250n 1.8
+    343299n 1.8
+    343300n 0
+    343349n 0
+    343350n 1.8
+    343399n 1.8
+    343400n 0
+    343449n 0
+    343450n 1.8
+    343499n 1.8
+    343500n 0
+    343549n 0
+    343550n 1.8
+    343599n 1.8
+    343600n 0
+    343649n 0
+    343650n 1.8
+    343699n 1.8
+    343700n 0
+    343749n 0
+    343750n 1.8
+    343799n 1.8
+    343800n 0
+    343849n 0
+    343850n 1.8
+    343899n 1.8
+    343900n 0
+    343949n 0
+    343950n 1.8
+    343999n 1.8
+    344000n 0
+    344049n 0
+    344050n 1.8
+    344099n 1.8
+    344100n 0
+    344149n 0
+    344150n 1.8
+    344199n 1.8
+    344200n 0
+    344249n 0
+    344250n 1.8
+    344299n 1.8
+    344300n 0
+    344349n 0
+    344350n 1.8
+    344399n 1.8
+    344400n 0
+    344449n 0
+    344450n 1.8
+    344499n 1.8
+    344500n 0
+    344549n 0
+    344550n 1.8
+    344599n 1.8
+    344600n 0
+    344649n 0
+    344650n 1.8
+    344699n 1.8
+    344700n 0
+    344749n 0
+    344750n 1.8
+    344799n 1.8
+    344800n 0
+    344849n 0
+    344850n 1.8
+    344899n 1.8
+    344900n 0
+    344949n 0
+    344950n 1.8
+    344999n 1.8
+    345000n 0
+    345049n 0
+    345050n 1.8
+    345099n 1.8
+    345100n 0
+    345149n 0
+    345150n 1.8
+    345199n 1.8
+    345200n 0
+    345249n 0
+    345250n 1.8
+    345299n 1.8
+    345300n 0
+    345349n 0
+    345350n 1.8
+    345399n 1.8
+    345400n 0
+    345449n 0
+    345450n 1.8
+    345499n 1.8
+    345500n 0
+    345549n 0
+    345550n 1.8
+    345599n 1.8
+    345600n 0
+    345649n 0
+    345650n 1.8
+    345699n 1.8
+    345700n 0
+    345749n 0
+    345750n 1.8
+    345799n 1.8
+    345800n 0
+    345849n 0
+    345850n 1.8
+    345899n 1.8
+    345900n 0
+    345949n 0
+    345950n 1.8
+    345999n 1.8
+    346000n 0
+    346049n 0
+    346050n 1.8
+    346099n 1.8
+    346100n 0
+    346149n 0
+    346150n 1.8
+    346199n 1.8
+    346200n 0
+    346249n 0
+    346250n 1.8
+    346299n 1.8
+    346300n 0
+    346349n 0
+    346350n 1.8
+    346399n 1.8
+    346400n 0
+    346449n 0
+    346450n 1.8
+    346499n 1.8
+    346500n 0
+    346549n 0
+    346550n 1.8
+    346599n 1.8
+    346600n 0
+    346649n 0
+    346650n 1.8
+    346699n 1.8
+    346700n 0
+    346749n 0
+    346750n 1.8
+    346799n 1.8
+    346800n 0
+    346849n 0
+    346850n 1.8
+    346899n 1.8
+    346900n 0
+    346949n 0
+    346950n 1.8
+    346999n 1.8
+    347000n 0
+    347049n 0
+    347050n 1.8
+    347099n 1.8
+    347100n 0
+    347149n 0
+    347150n 1.8
+    347199n 1.8
+    347200n 0
+    347249n 0
+    347250n 1.8
+    347299n 1.8
+    347300n 0
+    347349n 0
+    347350n 1.8
+    347399n 1.8
+    347400n 0
+    347449n 0
+    347450n 1.8
+    347499n 1.8
+    347500n 0
+    347549n 0
+    347550n 1.8
+    347599n 1.8
+    347600n 0
+    347649n 0
+    347650n 1.8
+    347699n 1.8
+    347700n 0
+    347749n 0
+    347750n 1.8
+    347799n 1.8
+    347800n 0
+    347849n 0
+    347850n 1.8
+    347899n 1.8
+    347900n 0
+    347949n 0
+    347950n 1.8
+    347999n 1.8
+    348000n 0
+    348049n 0
+    348050n 1.8
+    348099n 1.8
+    348100n 0
+    348149n 0
+    348150n 1.8
+    348199n 1.8
+    348200n 0
+    348249n 0
+    348250n 1.8
+    348299n 1.8
+    348300n 0
+    348349n 0
+    348350n 1.8
+    348399n 1.8
+    348400n 0
+    348449n 0
+    348450n 1.8
+    348499n 1.8
+    348500n 0
+    348549n 0
+    348550n 1.8
+    348599n 1.8
+    348600n 0
+    348649n 0
+    348650n 1.8
+    348699n 1.8
+    348700n 0
+    348749n 0
+    348750n 1.8
+    348799n 1.8
+    348800n 0
+    348849n 0
+    348850n 1.8
+    348899n 1.8
+    348900n 0
+    348949n 0
+    348950n 1.8
+    348999n 1.8
+    349000n 0
+    349049n 0
+    349050n 1.8
+    349099n 1.8
+    349100n 0
+    349149n 0
+    349150n 1.8
+    349199n 1.8
+    349200n 0
+    349249n 0
+    349250n 1.8
+    349299n 1.8
+    349300n 0
+    349349n 0
+    349350n 1.8
+    349399n 1.8
+    349400n 0
+    349449n 0
+    349450n 1.8
+    349499n 1.8
+    349500n 0
+    349549n 0
+    349550n 1.8
+    349599n 1.8
+    349600n 0
+    349649n 0
+    349650n 1.8
+    349699n 1.8
+    349700n 0
+    349749n 0
+    349750n 1.8
+    349799n 1.8
+    349800n 0
+    349849n 0
+    349850n 1.8
+    349899n 1.8
+    349900n 0
+    349949n 0
+    349950n 1.8
+    349999n 1.8
+    350000n 0
+    350049n 0
+    350050n 1.8
+    350099n 1.8
+    350100n 0
+    350149n 0
+    350150n 1.8
+    350199n 1.8
+    350200n 0
+    350249n 0
+    350250n 1.8
+    350299n 1.8
+    350300n 0
+    350349n 0
+    350350n 1.8
+    350399n 1.8
+    350400n 0
+    350449n 0
+    350450n 1.8
+    350499n 1.8
+    350500n 0
+    350549n 0
+    350550n 1.8
+    350599n 1.8
+    350600n 0
+    350649n 0
+    350650n 1.8
+    350699n 1.8
+    350700n 0
+    350749n 0
+    350750n 1.8
+    350799n 1.8
+    350800n 0
+    350849n 0
+    350850n 1.8
+    350899n 1.8
+    350900n 0
+    350949n 0
+    350950n 1.8
+    350999n 1.8
+    351000n 0
+    351049n 0
+    351050n 1.8
+    351099n 1.8
+    351100n 0
+    351149n 0
+    351150n 1.8
+    351199n 1.8
+    351200n 0
+    351249n 0
+    351250n 1.8
+    351299n 1.8
+    351300n 0
+    351349n 0
+    351350n 1.8
+    351399n 1.8
+    351400n 0
+    351449n 0
+    351450n 1.8
+    351499n 1.8
+    351500n 0
+    351549n 0
+    351550n 1.8
+    351599n 1.8
+    351600n 0
+    351649n 0
+    351650n 1.8
+    351699n 1.8
+    351700n 0
+    351749n 0
+    351750n 1.8
+    351799n 1.8
+    351800n 0
+    351849n 0
+    351850n 1.8
+    351899n 1.8
+    351900n 0
+    351949n 0
+    351950n 1.8
+    351999n 1.8
+    352000n 0
+    352049n 0
+    352050n 1.8
+    352099n 1.8
+    352100n 0
+    352149n 0
+    352150n 1.8
+    352199n 1.8
+    352200n 0
+    352249n 0
+    352250n 1.8
+    352299n 1.8
+    352300n 0
+    352349n 0
+    352350n 1.8
+    352399n 1.8
+    352400n 0
+    352449n 0
+    352450n 1.8
+    352499n 1.8
+    352500n 0
+    352549n 0
+    352550n 1.8
+    352599n 1.8
+    352600n 0
+    352649n 0
+    352650n 1.8
+    352699n 1.8
+    352700n 0
+    352749n 0
+    352750n 1.8
+    352799n 1.8
+    352800n 0
+    352849n 0
+    352850n 1.8
+    352899n 1.8
+    352900n 0
+    352949n 0
+    352950n 1.8
+    352999n 1.8
+    353000n 0
+    353049n 0
+    353050n 1.8
+    353099n 1.8
+    353100n 0
+    353149n 0
+    353150n 1.8
+    353199n 1.8
+    353200n 0
+    353249n 0
+    353250n 1.8
+    353299n 1.8
+    353300n 0
+    353349n 0
+    353350n 1.8
+    353399n 1.8
+    353400n 0
+    353449n 0
+    353450n 1.8
+    353499n 1.8
+    353500n 0
+    353549n 0
+    353550n 1.8
+    353599n 1.8
+    353600n 0
+    353649n 0
+    353650n 1.8
+    353699n 1.8
+    353700n 0
+    353749n 0
+    353750n 1.8
+    353799n 1.8
+    353800n 0
+    353849n 0
+    353850n 1.8
+    353899n 1.8
+    353900n 0
+    353949n 0
+    353950n 1.8
+    353999n 1.8
+    354000n 0
+    354049n 0
+    354050n 1.8
+    354099n 1.8
+    354100n 0
+    354149n 0
+    354150n 1.8
+    354199n 1.8
+    354200n 0
+    354249n 0
+    354250n 1.8
+    354299n 1.8
+    354300n 0
+    354349n 0
+    354350n 1.8
+    354399n 1.8
+    354400n 0
+    354449n 0
+    354450n 1.8
+    354499n 1.8
+    354500n 0
+    354549n 0
+    354550n 1.8
+    354599n 1.8
+    354600n 0
+    354649n 0
+    354650n 1.8
+    354699n 1.8
+    354700n 0
+    354749n 0
+    354750n 1.8
+    354799n 1.8
+    354800n 0
+    354849n 0
+    354850n 1.8
+    354899n 1.8
+    354900n 0
+    354949n 0
+    354950n 1.8
+    354999n 1.8
+    355000n 0
+    355049n 0
+    355050n 1.8
+    355099n 1.8
+    355100n 0
+    355149n 0
+    355150n 1.8
+    355199n 1.8
+    355200n 0
+    355249n 0
+    355250n 1.8
+    355299n 1.8
+    355300n 0
+    355349n 0
+    355350n 1.8
+    355399n 1.8
+    355400n 0
+    355449n 0
+    355450n 1.8
+    355499n 1.8
+    355500n 0
+    355549n 0
+    355550n 1.8
+    355599n 1.8
+    355600n 0
+    355649n 0
+    355650n 1.8
+    355699n 1.8
+    355700n 0
+    355749n 0
+    355750n 1.8
+    355799n 1.8
+    355800n 0
+    355849n 0
+    355850n 1.8
+    355899n 1.8
+    355900n 0
+    355949n 0
+    355950n 1.8
+    355999n 1.8
+    356000n 0
+    356049n 0
+    356050n 1.8
+    356099n 1.8
+    356100n 0
+    356149n 0
+    356150n 1.8
+    356199n 1.8
+    356200n 0
+    356249n 0
+    356250n 1.8
+    356299n 1.8
+    356300n 0
+    356349n 0
+    356350n 1.8
+    356399n 1.8
+    356400n 0
+    356449n 0
+    356450n 1.8
+    356499n 1.8
+    356500n 0
+    356549n 0
+    356550n 1.8
+    356599n 1.8
+    356600n 0
+    356649n 0
+    356650n 1.8
+    356699n 1.8
+    356700n 0
+    356749n 0
+    356750n 1.8
+    356799n 1.8
+    356800n 0
+    356849n 0
+    356850n 1.8
+    356899n 1.8
+    356900n 0
+    356949n 0
+    356950n 1.8
+    356999n 1.8
+    357000n 0
+    357049n 0
+    357050n 1.8
+    357099n 1.8
+    357100n 0
+    357149n 0
+    357150n 1.8
+    357199n 1.8
+    357200n 0
+    357249n 0
+    357250n 1.8
+    357299n 1.8
+    357300n 0
+    357349n 0
+    357350n 1.8
+    357399n 1.8
+    357400n 0
+    357449n 0
+    357450n 1.8
+    357499n 1.8
+    357500n 0
+    357549n 0
+    357550n 1.8
+    357599n 1.8
+    357600n 0
+    357649n 0
+    357650n 1.8
+    357699n 1.8
+    357700n 0
+    357749n 0
+    357750n 1.8
+    357799n 1.8
+    357800n 0
+    357849n 0
+    357850n 1.8
+    357899n 1.8
+    357900n 0
+    357949n 0
+    357950n 1.8
+    357999n 1.8
+    358000n 0
+    358049n 0
+    358050n 1.8
+    358099n 1.8
+    358100n 0
+    358149n 0
+    358150n 1.8
+    358199n 1.8
+    358200n 0
+    358249n 0
+    358250n 1.8
+    358299n 1.8
+    358300n 0
+    358349n 0
+    358350n 1.8
+    358399n 1.8
+    358400n 0
+    358449n 0
+    358450n 1.8
+    358499n 1.8
+    358500n 0
+    358549n 0
+    358550n 1.8
+    358599n 1.8
+    358600n 0
+    358649n 0
+    358650n 1.8
+    358699n 1.8
+    358700n 0
+    358749n 0
+    358750n 1.8
+    358799n 1.8
+    358800n 0
+    358849n 0
+    358850n 1.8
+    358899n 1.8
+    358900n 0
+    358949n 0
+    358950n 1.8
+    358999n 1.8
+    359000n 0
+    359049n 0
+    359050n 1.8
+    359099n 1.8
+    359100n 0
+    359149n 0
+    359150n 1.8
+    359199n 1.8
+    359200n 0
+    359249n 0
+    359250n 1.8
+    359299n 1.8
+    359300n 0
+    359349n 0
+    359350n 1.8
+    359399n 1.8
+    359400n 0
+    359449n 0
+    359450n 1.8
+    359499n 1.8
+    359500n 0
+    359549n 0
+    359550n 1.8
+    359599n 1.8
+    359600n 0
+    359649n 0
+    359650n 1.8
+    359699n 1.8
+    359700n 0
+    359749n 0
+    359750n 1.8
+    359799n 1.8
+    359800n 0
+    359849n 0
+    359850n 1.8
+    359899n 1.8
+    359900n 0
+    359949n 0
+    359950n 1.8
+    359999n 1.8
+    360000n 0
+    360049n 0
+    360050n 1.8
+    360099n 1.8
+    360100n 0
+    360149n 0
+    360150n 1.8
+    360199n 1.8
+    360200n 0
+    360249n 0
+    360250n 1.8
+    360299n 1.8
+    360300n 0
+    360349n 0
+    360350n 1.8
+    360399n 1.8
+    360400n 0
+    360449n 0
+    360450n 1.8
+    360499n 1.8
+    360500n 0
+    360549n 0
+    360550n 1.8
+    360599n 1.8
+    360600n 0
+    360649n 0
+    360650n 1.8
+    360699n 1.8
+    360700n 0
+    360749n 0
+    360750n 1.8
+    360799n 1.8
+    360800n 0
+    360849n 0
+    360850n 1.8
+    360899n 1.8
+    360900n 0
+    360949n 0
+    360950n 1.8
+    360999n 1.8
+    361000n 0
+    361049n 0
+    361050n 1.8
+    361099n 1.8
+    361100n 0
+    361149n 0
+    361150n 1.8
+    361199n 1.8
+    361200n 0
+    361249n 0
+    361250n 1.8
+    361299n 1.8
+    361300n 0
+    361349n 0
+    361350n 1.8
+    361399n 1.8
+    361400n 0
+    361449n 0
+    361450n 1.8
+    361499n 1.8
+    361500n 0
+    361549n 0
+    361550n 1.8
+    361599n 1.8
+    361600n 0
+    361649n 0
+    361650n 1.8
+    361699n 1.8
+    361700n 0
+    361749n 0
+    361750n 1.8
+    361799n 1.8
+    361800n 0
+    361849n 0
+    361850n 1.8
+    361899n 1.8
+    361900n 0
+    361949n 0
+    361950n 1.8
+    361999n 1.8
+    362000n 0
+    362049n 0
+    362050n 1.8
+    362099n 1.8
+    362100n 0
+    362149n 0
+    362150n 1.8
+    362199n 1.8
+    362200n 0
+    362249n 0
+    362250n 1.8
+    362299n 1.8
+    362300n 0
+    362349n 0
+    362350n 1.8
+    362399n 1.8
+    362400n 0
+    362449n 0
+    362450n 1.8
+    362499n 1.8
+    362500n 0
+    362549n 0
+    362550n 1.8
+    362599n 1.8
+    362600n 0
+    362649n 0
+    362650n 1.8
+    362699n 1.8
+    362700n 0
+    362749n 0
+    362750n 1.8
+    362799n 1.8
+    362800n 0
+    362849n 0
+    362850n 1.8
+    362899n 1.8
+    362900n 0
+    362949n 0
+    362950n 1.8
+    362999n 1.8
+    363000n 0
+    363049n 0
+    363050n 1.8
+    363099n 1.8
+    363100n 0
+    363149n 0
+    363150n 1.8
+    363199n 1.8
+    363200n 0
+    363249n 0
+    363250n 1.8
+    363299n 1.8
+    363300n 0
+    363349n 0
+    363350n 1.8
+    363399n 1.8
+    363400n 0
+    363449n 0
+    363450n 1.8
+    363499n 1.8
+    363500n 0
+    363549n 0
+    363550n 1.8
+    363599n 1.8
+    363600n 0
+    363649n 0
+    363650n 1.8
+    363699n 1.8
+    363700n 0
+    363749n 0
+    363750n 1.8
+    363799n 1.8
+    363800n 0
+    363849n 0
+    363850n 1.8
+    363899n 1.8
+    363900n 0
+    363949n 0
+    363950n 1.8
+    363999n 1.8
+    364000n 0
+    364049n 0
+    364050n 1.8
+    364099n 1.8
+    364100n 0
+    364149n 0
+    364150n 1.8
+    364199n 1.8
+    364200n 0
+    364249n 0
+    364250n 1.8
+    364299n 1.8
+    364300n 0
+    364349n 0
+    364350n 1.8
+    364399n 1.8
+    364400n 0
+    364449n 0
+    364450n 1.8
+    364499n 1.8
+    364500n 0
+    364549n 0
+    364550n 1.8
+    364599n 1.8
+    364600n 0
+    364649n 0
+    364650n 1.8
+    364699n 1.8
+    364700n 0
+    364749n 0
+    364750n 1.8
+    364799n 1.8
+    364800n 0
+    364849n 0
+    364850n 1.8
+    364899n 1.8
+    364900n 0
+    364949n 0
+    364950n 1.8
+    364999n 1.8
+    365000n 0
+    365049n 0
+    365050n 1.8
+    365099n 1.8
+    365100n 0
+    365149n 0
+    365150n 1.8
+    365199n 1.8
+    365200n 0
+    365249n 0
+    365250n 1.8
+    365299n 1.8
+    365300n 0
+    365349n 0
+    365350n 1.8
+    365399n 1.8
+    365400n 0
+    365449n 0
+    365450n 1.8
+    365499n 1.8
+    365500n 0
+    365549n 0
+    365550n 1.8
+    365599n 1.8
+    365600n 0
+    365649n 0
+    365650n 1.8
+    365699n 1.8
+    365700n 0
+    365749n 0
+    365750n 1.8
+    365799n 1.8
+    365800n 0
+    365849n 0
+    365850n 1.8
+    365899n 1.8
+    365900n 0
+    365949n 0
+    365950n 1.8
+    365999n 1.8
+    366000n 0
+    366049n 0
+    366050n 1.8
+    366099n 1.8
+    366100n 0
+    366149n 0
+    366150n 1.8
+    366199n 1.8
+    366200n 0
+    366249n 0
+    366250n 1.8
+    366299n 1.8
+    366300n 0
+    366349n 0
+    366350n 1.8
+    366399n 1.8
+    366400n 0
+    366449n 0
+    366450n 1.8
+    366499n 1.8
+    366500n 0
+    366549n 0
+    366550n 1.8
+    366599n 1.8
+    366600n 0
+    366649n 0
+    366650n 1.8
+    366699n 1.8
+    366700n 0
+    366749n 0
+    366750n 1.8
+    366799n 1.8
+    366800n 0
+    366849n 0
+    366850n 1.8
+    366899n 1.8
+    366900n 0
+    366949n 0
+    366950n 1.8
+    366999n 1.8
+    367000n 0
+    367049n 0
+    367050n 1.8
+    367099n 1.8
+    367100n 0
+    367149n 0
+    367150n 1.8
+    367199n 1.8
+    367200n 0
+    367249n 0
+    367250n 1.8
+    367299n 1.8
+    367300n 0
+    367349n 0
+    367350n 1.8
+    367399n 1.8
+    367400n 0
+    367449n 0
+    367450n 1.8
+    367499n 1.8
+    367500n 0
+    367549n 0
+    367550n 1.8
+    367599n 1.8
+    367600n 0
+    367649n 0
+    367650n 1.8
+    367699n 1.8
+    367700n 0
+    367749n 0
+    367750n 1.8
+    367799n 1.8
+    367800n 0
+    367849n 0
+    367850n 1.8
+    367899n 1.8
+    367900n 0
+    367949n 0
+    367950n 1.8
+    367999n 1.8
+    368000n 0
+    368049n 0
+    368050n 1.8
+    368099n 1.8
+    368100n 0
+    368149n 0
+    368150n 1.8
+    368199n 1.8
+    368200n 0
+    368249n 0
+    368250n 1.8
+    368299n 1.8
+    368300n 0
+    368349n 0
+    368350n 1.8
+    368399n 1.8
+    368400n 0
+    368449n 0
+    368450n 1.8
+    368499n 1.8
+    368500n 0
+    368549n 0
+    368550n 1.8
+    368599n 1.8
+    368600n 0
+    368649n 0
+    368650n 1.8
+    368699n 1.8
+    368700n 0
+    368749n 0
+    368750n 1.8
+    368799n 1.8
+    368800n 0
+    368849n 0
+    368850n 1.8
+    368899n 1.8
+    368900n 0
+    368949n 0
+    368950n 1.8
+    368999n 1.8
+    369000n 0
+    369049n 0
+    369050n 1.8
+    369099n 1.8
+    369100n 0
+    369149n 0
+    369150n 1.8
+    369199n 1.8
+    369200n 0
+    369249n 0
+    369250n 1.8
+    369299n 1.8
+    369300n 0
+    369349n 0
+    369350n 1.8
+    369399n 1.8
+    369400n 0
+    369449n 0
+    369450n 1.8
+    369499n 1.8
+    369500n 0
+    369549n 0
+    369550n 1.8
+    369599n 1.8
+    369600n 0
+    369649n 0
+    369650n 1.8
+    369699n 1.8
+    369700n 0
+    369749n 0
+    369750n 1.8
+    369799n 1.8
+    369800n 0
+    369849n 0
+    369850n 1.8
+    369899n 1.8
+    369900n 0
+    369949n 0
+    369950n 1.8
+    369999n 1.8
+    370000n 0
+    370049n 0
+    370050n 1.8
+    370099n 1.8
+    370100n 0
+    370149n 0
+    370150n 1.8
+    370199n 1.8
+    370200n 0
+    370249n 0
+    370250n 1.8
+    370299n 1.8
+    370300n 0
+    370349n 0
+    370350n 1.8
+    370399n 1.8
+    370400n 0
+    370449n 0
+    370450n 1.8
+    370499n 1.8
+    370500n 0
+    370549n 0
+    370550n 1.8
+    370599n 1.8
+    370600n 0
+    370649n 0
+    370650n 1.8
+    370699n 1.8
+    370700n 0
+    370749n 0
+    370750n 1.8
+    370799n 1.8
+    370800n 0
+    370849n 0
+    370850n 1.8
+    370899n 1.8
+    370900n 0
+    370949n 0
+    370950n 1.8
+    370999n 1.8
+    371000n 0
+    371049n 0
+    371050n 1.8
+    371099n 1.8
+    371100n 0
+    371149n 0
+    371150n 1.8
+    371199n 1.8
+    371200n 0
+    371249n 0
+    371250n 1.8
+    371299n 1.8
+    371300n 0
+    371349n 0
+    371350n 1.8
+    371399n 1.8
+    371400n 0
+    371449n 0
+    371450n 1.8
+    371499n 1.8
+    371500n 0
+    371549n 0
+    371550n 1.8
+    371599n 1.8
+    371600n 0
+    371649n 0
+    371650n 1.8
+    371699n 1.8
+    371700n 0
+    371749n 0
+    371750n 1.8
+    371799n 1.8
+    371800n 0
+    371849n 0
+    371850n 1.8
+    371899n 1.8
+    371900n 0
+    371949n 0
+    371950n 1.8
+    371999n 1.8
+    372000n 0
+    372049n 0
+    372050n 1.8
+    372099n 1.8
+    372100n 0
+    372149n 0
+    372150n 1.8
+    372199n 1.8
+    372200n 0
+    372249n 0
+    372250n 1.8
+    372299n 1.8
+    372300n 0
+    372349n 0
+    372350n 1.8
+    372399n 1.8
+    372400n 0
+    372449n 0
+    372450n 1.8
+    372499n 1.8
+    372500n 0
+    372549n 0
+    372550n 1.8
+    372599n 1.8
+    372600n 0
+    372649n 0
+    372650n 1.8
+    372699n 1.8
+    372700n 0
+    372749n 0
+    372750n 1.8
+    372799n 1.8
+    372800n 0
+    372849n 0
+    372850n 1.8
+    372899n 1.8
+    372900n 0
+    372949n 0
+    372950n 1.8
+    372999n 1.8
+    373000n 0
+    373049n 0
+    373050n 1.8
+    373099n 1.8
+    373100n 0
+    373149n 0
+    373150n 1.8
+    373199n 1.8
+    373200n 0
+    373249n 0
+    373250n 1.8
+    373299n 1.8
+    373300n 0
+    373349n 0
+    373350n 1.8
+    373399n 1.8
+    373400n 0
+    373449n 0
+    373450n 1.8
+    373499n 1.8
+    373500n 0
+    373549n 0
+    373550n 1.8
+    373599n 1.8
+    373600n 0
+    373649n 0
+    373650n 1.8
+    373699n 1.8
+    373700n 0
+    373749n 0
+    373750n 1.8
+    373799n 1.8
+    373800n 0
+    373849n 0
+    373850n 1.8
+    373899n 1.8
+    373900n 0
+    373949n 0
+    373950n 1.8
+    373999n 1.8
+    374000n 0
+    374049n 0
+    374050n 1.8
+    374099n 1.8
+    374100n 0
+    374149n 0
+    374150n 1.8
+    374199n 1.8
+    374200n 0
+    374249n 0
+    374250n 1.8
+    374299n 1.8
+    374300n 0
+    374349n 0
+    374350n 1.8
+    374399n 1.8
+    374400n 0
+    374449n 0
+    374450n 1.8
+    374499n 1.8
+    374500n 0
+    374549n 0
+    374550n 1.8
+    374599n 1.8
+    374600n 0
+    374649n 0
+    374650n 1.8
+    374699n 1.8
+    374700n 0
+    374749n 0
+    374750n 1.8
+    374799n 1.8
+    374800n 0
+    374849n 0
+    374850n 1.8
+    374899n 1.8
+    374900n 0
+    374949n 0
+    374950n 1.8
+    374999n 1.8
+    375000n 0
+    375049n 0
+    375050n 1.8
+    375099n 1.8
+    375100n 0
+    375149n 0
+    375150n 1.8
+    375199n 1.8
+    375200n 0
+    375249n 0
+    375250n 1.8
+    375299n 1.8
+    375300n 0
+    375349n 0
+    375350n 1.8
+    375399n 1.8
+    375400n 0
+    375449n 0
+    375450n 1.8
+    375499n 1.8
+    375500n 0
+    375549n 0
+    375550n 1.8
+    375599n 1.8
+    375600n 0
+    375649n 0
+    375650n 1.8
+    375699n 1.8
+    375700n 0
+    375749n 0
+    375750n 1.8
+    375799n 1.8
+    375800n 0
+    375849n 0
+    375850n 1.8
+    375899n 1.8
+    375900n 0
+    375949n 0
+    375950n 1.8
+    375999n 1.8
+    376000n 0
+    376049n 0
+    376050n 1.8
+    376099n 1.8
+    376100n 0
+    376149n 0
+    376150n 1.8
+    376199n 1.8
+    376200n 0
+    376249n 0
+    376250n 1.8
+    376299n 1.8
+    376300n 0
+    376349n 0
+    376350n 1.8
+    376399n 1.8
+    376400n 0
+    376449n 0
+    376450n 1.8
+    376499n 1.8
+    376500n 0
+    376549n 0
+    376550n 1.8
+    376599n 1.8
+    376600n 0
+    376649n 0
+    376650n 1.8
+    376699n 1.8
+    376700n 0
+    376749n 0
+    376750n 1.8
+    376799n 1.8
+    376800n 0
+    376849n 0
+    376850n 1.8
+    376899n 1.8
+    376900n 0
+    376949n 0
+    376950n 1.8
+    376999n 1.8
+    377000n 0
+    377049n 0
+    377050n 1.8
+    377099n 1.8
+    377100n 0
+    377149n 0
+    377150n 1.8
+    377199n 1.8
+    377200n 0
+    377249n 0
+    377250n 1.8
+    377299n 1.8
+    377300n 0
+    377349n 0
+    377350n 1.8
+    377399n 1.8
+    377400n 0
+    377449n 0
+    377450n 1.8
+    377499n 1.8
+    377500n 0
+    377549n 0
+    377550n 1.8
+    377599n 1.8
+    377600n 0
+    377649n 0
+    377650n 1.8
+    377699n 1.8
+    377700n 0
+    377749n 0
+    377750n 1.8
+    377799n 1.8
+    377800n 0
+    377849n 0
+    377850n 1.8
+    377899n 1.8
+    377900n 0
+    377949n 0
+    377950n 1.8
+    377999n 1.8
+    378000n 0
+    378049n 0
+    378050n 1.8
+    378099n 1.8
+    378100n 0
+    378149n 0
+    378150n 1.8
+    378199n 1.8
+    378200n 0
+    378249n 0
+    378250n 1.8
+    378299n 1.8
+    378300n 0
+    378349n 0
+    378350n 1.8
+    378399n 1.8
+    378400n 0
+    378449n 0
+    378450n 1.8
+    378499n 1.8
+    378500n 0
+    378549n 0
+    378550n 1.8
+    378599n 1.8
+    378600n 0
+    378649n 0
+    378650n 1.8
+    378699n 1.8
+    378700n 0
+    378749n 0
+    378750n 1.8
+    378799n 1.8
+    378800n 0
+    378849n 0
+    378850n 1.8
+    378899n 1.8
+    378900n 0
+    378949n 0
+    378950n 1.8
+    378999n 1.8
+    379000n 0
+    379049n 0
+    379050n 1.8
+    379099n 1.8
+    379100n 0
+    379149n 0
+    379150n 1.8
+    379199n 1.8
+    379200n 0
+    379249n 0
+    379250n 1.8
+    379299n 1.8
+    379300n 0
+    379349n 0
+    379350n 1.8
+    379399n 1.8
+    379400n 0
+    379449n 0
+    379450n 1.8
+    379499n 1.8
+    379500n 0
+    379549n 0
+    379550n 1.8
+    379599n 1.8
+    379600n 0
+    379649n 0
+    379650n 1.8
+    379699n 1.8
+    379700n 0
+    379749n 0
+    379750n 1.8
+    379799n 1.8
+    379800n 0
+    379849n 0
+    379850n 1.8
+    379899n 1.8
+    379900n 0
+    379949n 0
+    379950n 1.8
+    379999n 1.8
+    380000n 0
+    380049n 0
+    380050n 1.8
+    380099n 1.8
+    380100n 0
+    380149n 0
+    380150n 1.8
+    380199n 1.8
+    380200n 0
+    380249n 0
+    380250n 1.8
+    380299n 1.8
+    380300n 0
+    380349n 0
+    380350n 1.8
+    380399n 1.8
+    380400n 0
+    380449n 0
+    380450n 1.8
+    380499n 1.8
+    380500n 0
+    380549n 0
+    380550n 1.8
+    380599n 1.8
+    380600n 0
+    380649n 0
+    380650n 1.8
+    380699n 1.8
+    380700n 0
+    380749n 0
+    380750n 1.8
+    380799n 1.8
+    380800n 0
+    380849n 0
+    380850n 1.8
+    380899n 1.8
+    380900n 0
+    380949n 0
+    380950n 1.8
+    380999n 1.8
+    381000n 0
+    381049n 0
+    381050n 1.8
+    381099n 1.8
+    381100n 0
+    381149n 0
+    381150n 1.8
+    381199n 1.8
+    381200n 0
+    381249n 0
+    381250n 1.8
+    381299n 1.8
+    381300n 0
+    381349n 0
+    381350n 1.8
+    381399n 1.8
+    381400n 0
+    381449n 0
+    381450n 1.8
+    381499n 1.8
+    381500n 0
+    381549n 0
+    381550n 1.8
+    381599n 1.8
+    381600n 0
+    381649n 0
+    381650n 1.8
+    381699n 1.8
+    381700n 0
+    381749n 0
+    381750n 1.8
+    381799n 1.8
+    381800n 0
+    381849n 0
+    381850n 1.8
+    381899n 1.8
+    381900n 0
+    381949n 0
+    381950n 1.8
+    381999n 1.8
+    382000n 0
+    382049n 0
+    382050n 1.8
+    382099n 1.8
+    382100n 0
+    382149n 0
+    382150n 1.8
+    382199n 1.8
+    382200n 0
+    382249n 0
+    382250n 1.8
+    382299n 1.8
+    382300n 0
+    382349n 0
+    382350n 1.8
+    382399n 1.8
+    382400n 0
+    382449n 0
+    382450n 1.8
+    382499n 1.8
+    382500n 0
+    382549n 0
+    382550n 1.8
+    382599n 1.8
+    382600n 0
+    382649n 0
+    382650n 1.8
+    382699n 1.8
+    382700n 0
+    382749n 0
+    382750n 1.8
+    382799n 1.8
+    382800n 0
+    382849n 0
+    382850n 1.8
+    382899n 1.8
+    382900n 0
+    382949n 0
+    382950n 1.8
+    382999n 1.8
+    383000n 0
+    383049n 0
+    383050n 1.8
+    383099n 1.8
+    383100n 0
+    383149n 0
+    383150n 1.8
+    383199n 1.8
+    383200n 0
+    383249n 0
+    383250n 1.8
+    383299n 1.8
+    383300n 0
+    383349n 0
+    383350n 1.8
+    383399n 1.8
+    383400n 0
+    383449n 0
+    383450n 1.8
+    383499n 1.8
+    383500n 0
+    383549n 0
+    383550n 1.8
+    383599n 1.8
+    383600n 0
+    383649n 0
+    383650n 1.8
+    383699n 1.8
+    383700n 0
+    383749n 0
+    383750n 1.8
+    383799n 1.8
+    383800n 0
+    383849n 0
+    383850n 1.8
+    383899n 1.8
+    383900n 0
+    383949n 0
+    383950n 1.8
+    383999n 1.8
+    384000n 0
+    384049n 0
+    384050n 1.8
+    384099n 1.8
+    384100n 0
+    384149n 0
+    384150n 1.8
+    384199n 1.8
+    384200n 0
+    384249n 0
+    384250n 1.8
+    384299n 1.8
+    384300n 0
+    384349n 0
+    384350n 1.8
+    384399n 1.8
+    384400n 0
+    384449n 0
+    384450n 1.8
+    384499n 1.8
+    384500n 0
+    384549n 0
+    384550n 1.8
+    384599n 1.8
+    384600n 0
+    384649n 0
+    384650n 1.8
+    384699n 1.8
+    384700n 0
+    384749n 0
+    384750n 1.8
+    384799n 1.8
+    384800n 0
+    384849n 0
+    384850n 1.8
+    384899n 1.8
+    384900n 0
+    384949n 0
+    384950n 1.8
+    384999n 1.8
+    385000n 0
+    385049n 0
+    385050n 1.8
+    385099n 1.8
+    385100n 0
+    385149n 0
+    385150n 1.8
+    385199n 1.8
+    385200n 0
+    385249n 0
+    385250n 1.8
+    385299n 1.8
+    385300n 0
+    385349n 0
+    385350n 1.8
+    385399n 1.8
+    385400n 0
+    385449n 0
+    385450n 1.8
+    385499n 1.8
+    385500n 0
+    385549n 0
+    385550n 1.8
+    385599n 1.8
+    385600n 0
+    385649n 0
+    385650n 1.8
+    385699n 1.8
+    385700n 0
+    385749n 0
+    385750n 1.8
+    385799n 1.8
+    385800n 0
+    385849n 0
+    385850n 1.8
+    385899n 1.8
+    385900n 0
+    385949n 0
+    385950n 1.8
+    385999n 1.8
+    386000n 0
+    386049n 0
+    386050n 1.8
+    386099n 1.8
+    386100n 0
+    386149n 0
+    386150n 1.8
+    386199n 1.8
+    386200n 0
+    386249n 0
+    386250n 1.8
+    386299n 1.8
+    386300n 0
+    386349n 0
+    386350n 1.8
+    386399n 1.8
+    386400n 0
+    386449n 0
+    386450n 1.8
+    386499n 1.8
+    386500n 0
+    386549n 0
+    386550n 1.8
+    386599n 1.8
+    386600n 0
+    386649n 0
+    386650n 1.8
+    386699n 1.8
+    386700n 0
+    386749n 0
+    386750n 1.8
+    386799n 1.8
+    386800n 0
+    386849n 0
+    386850n 1.8
+    386899n 1.8
+    386900n 0
+    386949n 0
+    386950n 1.8
+    386999n 1.8
+    387000n 0
+    387049n 0
+    387050n 1.8
+    387099n 1.8
+    387100n 0
+    387149n 0
+    387150n 1.8
+    387199n 1.8
+    387200n 0
+    387249n 0
+    387250n 1.8
+    387299n 1.8
+    387300n 0
+    387349n 0
+    387350n 1.8
+    387399n 1.8
+    387400n 0
+    387449n 0
+    387450n 1.8
+    387499n 1.8
+    387500n 0
+    387549n 0
+    387550n 1.8
+    387599n 1.8
+    387600n 0
+    387649n 0
+    387650n 1.8
+    387699n 1.8
+    387700n 0
+    387749n 0
+    387750n 1.8
+    387799n 1.8
+    387800n 0
+    387849n 0
+    387850n 1.8
+    387899n 1.8
+    387900n 0
+    387949n 0
+    387950n 1.8
+    387999n 1.8
+    388000n 0
+    388049n 0
+    388050n 1.8
+    388099n 1.8
+    388100n 0
+    388149n 0
+    388150n 1.8
+    388199n 1.8
+    388200n 0
+    388249n 0
+    388250n 1.8
+    388299n 1.8
+    388300n 0
+    388349n 0
+    388350n 1.8
+    388399n 1.8
+    388400n 0
+    388449n 0
+    388450n 1.8
+    388499n 1.8
+    388500n 0
+    388549n 0
+    388550n 1.8
+    388599n 1.8
+    388600n 0
+    388649n 0
+    388650n 1.8
+    388699n 1.8
+    388700n 0
+    388749n 0
+    388750n 1.8
+    388799n 1.8
+    388800n 0
+    388849n 0
+    388850n 1.8
+    388899n 1.8
+    388900n 0
+    388949n 0
+    388950n 1.8
+    388999n 1.8
+    389000n 0
+    389049n 0
+    389050n 1.8
+    389099n 1.8
+    389100n 0
+    389149n 0
+    389150n 1.8
+    389199n 1.8
+    389200n 0
+    389249n 0
+    389250n 1.8
+    389299n 1.8
+    389300n 0
+    389349n 0
+    389350n 1.8
+    389399n 1.8
+    389400n 0
+    389449n 0
+    389450n 1.8
+    389499n 1.8
+    389500n 0
+    389549n 0
+    389550n 1.8
+    389599n 1.8
+    389600n 0
+    389649n 0
+    389650n 1.8
+    389699n 1.8
+    389700n 0
+    389749n 0
+    389750n 1.8
+    389799n 1.8
+    389800n 0
+    389849n 0
+    389850n 1.8
+    389899n 1.8
+    389900n 0
+    389949n 0
+    389950n 1.8
+    389999n 1.8
+    390000n 0
+    390049n 0
+    390050n 1.8
+    390099n 1.8
+    390100n 0
+    390149n 0
+    390150n 1.8
+    390199n 1.8
+    390200n 0
+    390249n 0
+    390250n 1.8
+    390299n 1.8
+    390300n 0
+    390349n 0
+    390350n 1.8
+    390399n 1.8
+    390400n 0
+    390449n 0
+    390450n 1.8
+    390499n 1.8
+    390500n 0
+    390549n 0
+    390550n 1.8
+    390599n 1.8
+    390600n 0
+    390649n 0
+    390650n 1.8
+    390699n 1.8
+    390700n 0
+    390749n 0
+    390750n 1.8
+    390799n 1.8
+    390800n 0
+    390849n 0
+    390850n 1.8
+    390899n 1.8
+    390900n 0
+    390949n 0
+    390950n 1.8
+    390999n 1.8
+    391000n 0
+    391049n 0
+    391050n 1.8
+    391099n 1.8
+    391100n 0
+    391149n 0
+    391150n 1.8
+    391199n 1.8
+    391200n 0
+    391249n 0
+    391250n 1.8
+    391299n 1.8
+    391300n 0
+    391349n 0
+    391350n 1.8
+    391399n 1.8
+    391400n 0
+    391449n 0
+    391450n 1.8
+    391499n 1.8
+    391500n 0
+    391549n 0
+    391550n 1.8
+    391599n 1.8
+    391600n 0
+    391649n 0
+    391650n 1.8
+    391699n 1.8
+    391700n 0
+    391749n 0
+    391750n 1.8
+    391799n 1.8
+    391800n 0
+    391849n 0
+    391850n 1.8
+    391899n 1.8
+    391900n 0
+    391949n 0
+    391950n 1.8
+    391999n 1.8
+    392000n 0
+    392049n 0
+    392050n 1.8
+    392099n 1.8
+    392100n 0
+    392149n 0
+    392150n 1.8
+    392199n 1.8
+    392200n 0
+    392249n 0
+    392250n 1.8
+    392299n 1.8
+    392300n 0
+    392349n 0
+    392350n 1.8
+    392399n 1.8
+    392400n 0
+    392449n 0
+    392450n 1.8
+    392499n 1.8
+    392500n 0
+    392549n 0
+    392550n 1.8
+    392599n 1.8
+    392600n 0
+    392649n 0
+    392650n 1.8
+    392699n 1.8
+    392700n 0
+    392749n 0
+    392750n 1.8
+    392799n 1.8
+    392800n 0
+    392849n 0
+    392850n 1.8
+    392899n 1.8
+    392900n 0
+    392949n 0
+    392950n 1.8
+    392999n 1.8
+    393000n 0
+    393049n 0
+    393050n 1.8
+    393099n 1.8
+    393100n 0
+    393149n 0
+    393150n 1.8
+    393199n 1.8
+    393200n 0
+    393249n 0
+    393250n 1.8
+    393299n 1.8
+    393300n 0
+    393349n 0
+    393350n 1.8
+    393399n 1.8
+    393400n 0
+    393449n 0
+    393450n 1.8
+    393499n 1.8
+    393500n 0
+    393549n 0
+    393550n 1.8
+    393599n 1.8
+    393600n 0
+    393649n 0
+    393650n 1.8
+    393699n 1.8
+    393700n 0
+    393749n 0
+    393750n 1.8
+    393799n 1.8
+    393800n 0
+    393849n 0
+    393850n 1.8
+    393899n 1.8
+    393900n 0
+    393949n 0
+    393950n 1.8
+    393999n 1.8
+    394000n 0
+    394049n 0
+    394050n 1.8
+    394099n 1.8
+    394100n 0
+    394149n 0
+    394150n 1.8
+    394199n 1.8
+    394200n 0
+    394249n 0
+    394250n 1.8
+    394299n 1.8
+    394300n 0
+    394349n 0
+    394350n 1.8
+    394399n 1.8
+    394400n 0
+    394449n 0
+    394450n 1.8
+    394499n 1.8
+    394500n 0
+    394549n 0
+    394550n 1.8
+    394599n 1.8
+    394600n 0
+    394649n 0
+    394650n 1.8
+    394699n 1.8
+    394700n 0
+    394749n 0
+    394750n 1.8
+    394799n 1.8
+    394800n 0
+    394849n 0
+    394850n 1.8
+    394899n 1.8
+    394900n 0
+    394949n 0
+    394950n 1.8
+    394999n 1.8
+    395000n 0
+    395049n 0
+    395050n 1.8
+    395099n 1.8
+    395100n 0
+    395149n 0
+    395150n 1.8
+    395199n 1.8
+    395200n 0
+    395249n 0
+    395250n 1.8
+    395299n 1.8
+    395300n 0
+    395349n 0
+    395350n 1.8
+    395399n 1.8
+    395400n 0
+    395449n 0
+    395450n 1.8
+    395499n 1.8
+    395500n 0
+    395549n 0
+    395550n 1.8
+    395599n 1.8
+    395600n 0
+    395649n 0
+    395650n 1.8
+    395699n 1.8
+    395700n 0
+    395749n 0
+    395750n 1.8
+    395799n 1.8
+    395800n 0
+    395849n 0
+    395850n 1.8
+    395899n 1.8
+    395900n 0
+    395949n 0
+    395950n 1.8
+    395999n 1.8
+    396000n 0
+    396049n 0
+    396050n 1.8
+    396099n 1.8
+    396100n 0
+    396149n 0
+    396150n 1.8
+    396199n 1.8
+    396200n 0
+    396249n 0
+    396250n 1.8
+    396299n 1.8
+    396300n 0
+    396349n 0
+    396350n 1.8
+    396399n 1.8
+    396400n 0
+    396449n 0
+    396450n 1.8
+    396499n 1.8
+    396500n 0
+    396549n 0
+    396550n 1.8
+    396599n 1.8
+    396600n 0
+    396649n 0
+    396650n 1.8
+    396699n 1.8
+    396700n 0
+    396749n 0
+    396750n 1.8
+    396799n 1.8
+    396800n 0
+    396849n 0
+    396850n 1.8
+    396899n 1.8
+    396900n 0
+    396949n 0
+    396950n 1.8
+    396999n 1.8
+    397000n 0
+    397049n 0
+    397050n 1.8
+    397099n 1.8
+    397100n 0
+    397149n 0
+    397150n 1.8
+    397199n 1.8
+    397200n 0
+    397249n 0
+    397250n 1.8
+    397299n 1.8
+    397300n 0
+    397349n 0
+    397350n 1.8
+    397399n 1.8
+    397400n 0
+    397449n 0
+    397450n 1.8
+    397499n 1.8
+    397500n 0
+    397549n 0
+    397550n 1.8
+    397599n 1.8
+    397600n 0
+    397649n 0
+    397650n 1.8
+    397699n 1.8
+    397700n 0
+    397749n 0
+    397750n 1.8
+    397799n 1.8
+    397800n 0
+    397849n 0
+    397850n 1.8
+    397899n 1.8
+    397900n 0
+    397949n 0
+    397950n 1.8
+    397999n 1.8
+    398000n 0
+    398049n 0
+    398050n 1.8
+    398099n 1.8
+    398100n 0
+    398149n 0
+    398150n 1.8
+    398199n 1.8
+    398200n 0
+    398249n 0
+    398250n 1.8
+    398299n 1.8
+    398300n 0
+    398349n 0
+    398350n 1.8
+    398399n 1.8
+    398400n 0
+    398449n 0
+    398450n 1.8
+    398499n 1.8
+    398500n 0
+    398549n 0
+    398550n 1.8
+    398599n 1.8
+    398600n 0
+    398649n 0
+    398650n 1.8
+    398699n 1.8
+    398700n 0
+    398749n 0
+    398750n 1.8
+    398799n 1.8
+    398800n 0
+    398849n 0
+    398850n 1.8
+    398899n 1.8
+    398900n 0
+    398949n 0
+    398950n 1.8
+    398999n 1.8
+    399000n 0
+    399049n 0
+    399050n 1.8
+    399099n 1.8
+    399100n 0
+    399149n 0
+    399150n 1.8
+    399199n 1.8
+    399200n 0
+    399249n 0
+    399250n 1.8
+    399299n 1.8
+    399300n 0
+    399349n 0
+    399350n 1.8
+    399399n 1.8
+    399400n 0
+    399449n 0
+    399450n 1.8
+    399499n 1.8
+    399500n 0
+    399549n 0
+    399550n 1.8
+    399599n 1.8
+    399600n 0
+    399649n 0
+    399650n 1.8
+    399699n 1.8
+    399700n 0
+    399749n 0
+    399750n 1.8
+    399799n 1.8
+    399800n 0
+    399849n 0
+    399850n 1.8
+    399899n 1.8
+    399900n 0
+    399949n 0
+    399950n 1.8
+    399999n 1.8
+    400000n 0
+    400049n 0
+    400050n 1.8
+    400099n 1.8
+    400100n 0
+    400149n 0
+    400150n 1.8
+    400199n 1.8
+    400200n 0
+    400249n 0
+    400250n 1.8
+    400299n 1.8
+    400300n 0
+    400349n 0
+    400350n 1.8
+    400399n 1.8
+    400400n 0
+    400449n 0
+    400450n 1.8
+    400499n 1.8
+    400500n 0
+    400549n 0
+    400550n 1.8
+    400599n 1.8
+    400600n 0
+    400649n 0
+    400650n 1.8
+    400699n 1.8
+    400700n 0
+    400749n 0
+    400750n 1.8
+    400799n 1.8
+    400800n 0
+    400849n 0
+    400850n 1.8
+    400899n 1.8
+    400900n 0
+    400949n 0
+    400950n 1.8
+    400999n 1.8
+    401000n 0
+    401049n 0
+    401050n 1.8
+    401099n 1.8
+    401100n 0
+    401149n 0
+    401150n 1.8
+    401199n 1.8
+    401200n 0
+    401249n 0
+    401250n 1.8
+    401299n 1.8
+    401300n 0
+    401349n 0
+    401350n 1.8
+    401399n 1.8
+    401400n 0
+    401449n 0
+    401450n 1.8
+    401499n 1.8
+    401500n 0
+    401549n 0
+    401550n 1.8
+    401599n 1.8
+    401600n 0
+    401649n 0
+    401650n 1.8
+    401699n 1.8
+    401700n 0
+    401749n 0
+    401750n 1.8
+    401799n 1.8
+    401800n 0
+    401849n 0
+    401850n 1.8
+    401899n 1.8
+    401900n 0
+    401949n 0
+    401950n 1.8
+    401999n 1.8
+    402000n 0
+    402049n 0
+    402050n 1.8
+    402099n 1.8
+    402100n 0
+    402149n 0
+    402150n 1.8
+    402199n 1.8
+    402200n 0
+    402249n 0
+    402250n 1.8
+    402299n 1.8
+    402300n 0
+    402349n 0
+    402350n 1.8
+    402399n 1.8
+    402400n 0
+    402449n 0
+    402450n 1.8
+    402499n 1.8
+    402500n 0
+    402549n 0
+    402550n 1.8
+    402599n 1.8
+    402600n 0
+    402649n 0
+    402650n 1.8
+    402699n 1.8
+    402700n 0
+    402749n 0
+    402750n 1.8
+    402799n 1.8
+    402800n 0
+    402849n 0
+    402850n 1.8
+    402899n 1.8
+    402900n 0
+    402949n 0
+    402950n 1.8
+    402999n 1.8
+    403000n 0
+    403049n 0
+    403050n 1.8
+    403099n 1.8
+    403100n 0
+    403149n 0
+    403150n 1.8
+    403199n 1.8
+    403200n 0
+    403249n 0
+    403250n 1.8
+    403299n 1.8
+    403300n 0
+    403349n 0
+    403350n 1.8
+    403399n 1.8
+    403400n 0
+    403449n 0
+    403450n 1.8
+    403499n 1.8
+    403500n 0
+    403549n 0
+    403550n 1.8
+    403599n 1.8
+    403600n 0
+    403649n 0
+    403650n 1.8
+    403699n 1.8
+    403700n 0
+    403749n 0
+    403750n 1.8
+    403799n 1.8
+    403800n 0
+    403849n 0
+    403850n 1.8
+    403899n 1.8
+    403900n 0
+    403949n 0
+    403950n 1.8
+    403999n 1.8
+    404000n 0
+    404049n 0
+    404050n 1.8
+    404099n 1.8
+    404100n 0
+    404149n 0
+    404150n 1.8
+    404199n 1.8
+    404200n 0
+    404249n 0
+    404250n 1.8
+    404299n 1.8
+    404300n 0
+    404349n 0
+    404350n 1.8
+    404399n 1.8
+    404400n 0
+    404449n 0
+    404450n 1.8
+    404499n 1.8
+    404500n 0
+    404549n 0
+    404550n 1.8
+    404599n 1.8
+    404600n 0
+    404649n 0
+    404650n 1.8
+    404699n 1.8
+    404700n 0
+    404749n 0
+    404750n 1.8
+    404799n 1.8
+    404800n 0
+    404849n 0
+    404850n 1.8
+    404899n 1.8
+    404900n 0
+    404949n 0
+    404950n 1.8
+    404999n 1.8
+    405000n 0
+    405049n 0
+    405050n 1.8
+    405099n 1.8
+    405100n 0
+    405149n 0
+    405150n 1.8
+    405199n 1.8
+    405200n 0
+    405249n 0
+    405250n 1.8
+    405299n 1.8
+    405300n 0
+    405349n 0
+    405350n 1.8
+    405399n 1.8
+    405400n 0
+    405449n 0
+    405450n 1.8
+    405499n 1.8
+    405500n 0
+    405549n 0
+    405550n 1.8
+    405599n 1.8
+    405600n 0
+    405649n 0
+    405650n 1.8
+    405699n 1.8
+    405700n 0
+    405749n 0
+    405750n 1.8
+    405799n 1.8
+    405800n 0
+    405849n 0
+    405850n 1.8
+    405899n 1.8
+    405900n 0
+    405949n 0
+    405950n 1.8
+    405999n 1.8
+    406000n 0
+    406049n 0
+    406050n 1.8
+    406099n 1.8
+    406100n 0
+    406149n 0
+    406150n 1.8
+    406199n 1.8
+    406200n 0
+    406249n 0
+    406250n 1.8
+    406299n 1.8
+    406300n 0
+    406349n 0
+    406350n 1.8
+    406399n 1.8
+    406400n 0
+    406449n 0
+    406450n 1.8
+    406499n 1.8
+    406500n 0
+    406549n 0
+    406550n 1.8
+    406599n 1.8
+    406600n 0
+    406649n 0
+    406650n 1.8
+    406699n 1.8
+    406700n 0
+    406749n 0
+    406750n 1.8
+    406799n 1.8
+    406800n 0
+    406849n 0
+    406850n 1.8
+    406899n 1.8
+    406900n 0
+    406949n 0
+    406950n 1.8
+    406999n 1.8
+    407000n 0
+    407049n 0
+    407050n 1.8
+    407099n 1.8
+    407100n 0
+    407149n 0
+    407150n 1.8
+    407199n 1.8
+    407200n 0
+    407249n 0
+    407250n 1.8
+    407299n 1.8
+    407300n 0
+    407349n 0
+    407350n 1.8
+    407399n 1.8
+    407400n 0
+    407449n 0
+    407450n 1.8
+    407499n 1.8
+    407500n 0
+    407549n 0
+    407550n 1.8
+    407599n 1.8
+    407600n 0
+    407649n 0
+    407650n 1.8
+    407699n 1.8
+    407700n 0
+    407749n 0
+    407750n 1.8
+    407799n 1.8
+    407800n 0
+    407849n 0
+    407850n 1.8
+    407899n 1.8
+    407900n 0
+    407949n 0
+    407950n 1.8
+    407999n 1.8
+    408000n 0
+    408049n 0
+    408050n 1.8
+    408099n 1.8
+    408100n 0
+    408149n 0
+    408150n 1.8
+    408199n 1.8
+    408200n 0
+    408249n 0
+    408250n 1.8
+    408299n 1.8
+    408300n 0
+    408349n 0
+    408350n 1.8
+    408399n 1.8
+    408400n 0
+    408449n 0
+    408450n 1.8
+    408499n 1.8
+    408500n 0
+    408549n 0
+    408550n 1.8
+    408599n 1.8
+    408600n 0
+    408649n 0
+    408650n 1.8
+    408699n 1.8
+    408700n 0
+    408749n 0
+    408750n 1.8
+    408799n 1.8
+    408800n 0
+    408849n 0
+    408850n 1.8
+    408899n 1.8
+    408900n 0
+    408949n 0
+    408950n 1.8
+    408999n 1.8
+    409000n 0
+    409049n 0
+    409050n 1.8
+    409099n 1.8
+    409100n 0
+    409149n 0
+    409150n 1.8
+    409199n 1.8
+    409200n 0
+    409249n 0
+    409250n 1.8
+    409299n 1.8
+    409300n 0
+    409349n 0
+    409350n 1.8
+    409399n 1.8
+    409400n 0
+    409449n 0
+    409450n 1.8
+    409499n 1.8
+    409500n 0
+    409549n 0
+    409550n 1.8
+    409599n 1.8
+    409600n 0
+    409649n 0
+    409650n 1.8
+    409699n 1.8
+    409700n 0
+    409749n 0
+    409750n 1.8
+    409799n 1.8
+    409800n 0
+    409849n 0
+    409850n 1.8
+    409899n 1.8
+    409900n 0
+    409949n 0
+    409950n 1.8
+    409999n 1.8
+    410000n 0
+    410049n 0
+    410050n 1.8
+    410099n 1.8
+    410100n 0
+    410149n 0
+    410150n 1.8
+    410199n 1.8
+    410200n 0
+    410249n 0
+    410250n 1.8
+    410299n 1.8
+    410300n 0
+    410349n 0
+    410350n 1.8
+    410399n 1.8
+    410400n 0
+    410449n 0
+    410450n 1.8
+    410499n 1.8
+    410500n 0
+    410549n 0
+    410550n 1.8
+    410599n 1.8
+    410600n 0
+    410649n 0
+    410650n 1.8
+    410699n 1.8
+    410700n 0
+    410749n 0
+    410750n 1.8
+    410799n 1.8
+    410800n 0
+    410849n 0
+    410850n 1.8
+    410899n 1.8
+    410900n 0
+    410949n 0
+    410950n 1.8
+    410999n 1.8
+    411000n 0
+    411049n 0
+    411050n 1.8
+    411099n 1.8
+    411100n 0
+    411149n 0
+    411150n 1.8
+    411199n 1.8
+    411200n 0
+    411249n 0
+    411250n 1.8
+    411299n 1.8
+    411300n 0
+    411349n 0
+    411350n 1.8
+    411399n 1.8
+    411400n 0
+    411449n 0
+    411450n 1.8
+    411499n 1.8
+    411500n 0
+    411549n 0
+    411550n 1.8
+    411599n 1.8
+    411600n 0
+    411649n 0
+    411650n 1.8
+    411699n 1.8
+    411700n 0
+    411749n 0
+    411750n 1.8
+    411799n 1.8
+    411800n 0
+    411849n 0
+    411850n 1.8
+    411899n 1.8
+    411900n 0
+    411949n 0
+    411950n 1.8
+    411999n 1.8
+    412000n 0
+    412049n 0
+    412050n 1.8
+    412099n 1.8
+    412100n 0
+    412149n 0
+    412150n 1.8
+    412199n 1.8
+    412200n 0
+    412249n 0
+    412250n 1.8
+    412299n 1.8
+    412300n 0
+    412349n 0
+    412350n 1.8
+    412399n 1.8
+    412400n 0
+    412449n 0
+    412450n 1.8
+    412499n 1.8
+    412500n 0
+    412549n 0
+    412550n 1.8
+    412599n 1.8
+    412600n 0
+    412649n 0
+    412650n 1.8
+    412699n 1.8
+    412700n 0
+    412749n 0
+    412750n 1.8
+    412799n 1.8
+    412800n 0
+    412849n 0
+    412850n 1.8
+    412899n 1.8
+    412900n 0
+    412949n 0
+    412950n 1.8
+    412999n 1.8
+    413000n 0
+    413049n 0
+    413050n 1.8
+    413099n 1.8
+    413100n 0
+    413149n 0
+    413150n 1.8
+    413199n 1.8
+    413200n 0
+    413249n 0
+    413250n 1.8
+    413299n 1.8
+    413300n 0
+    413349n 0
+    413350n 1.8
+    413399n 1.8
+    413400n 0
+    413449n 0
+    413450n 1.8
+    413499n 1.8
+    413500n 0
+    413549n 0
+    413550n 1.8
+    413599n 1.8
+    413600n 0
+    413649n 0
+    413650n 1.8
+    413699n 1.8
+    413700n 0
+    413749n 0
+    413750n 1.8
+    413799n 1.8
+    413800n 0
+    413849n 0
+    413850n 1.8
+    413899n 1.8
+    413900n 0
+    413949n 0
+    413950n 1.8
+    413999n 1.8
+    414000n 0
+    414049n 0
+    414050n 1.8
+    414099n 1.8
+    414100n 0
+    414149n 0
+    414150n 1.8
+    414199n 1.8
+    414200n 0
+    414249n 0
+    414250n 1.8
+    414299n 1.8
+    414300n 0
+    414349n 0
+    414350n 1.8
+    414399n 1.8
+    414400n 0
+    414449n 0
+    414450n 1.8
+    414499n 1.8
+    414500n 0
+    414549n 0
+    414550n 1.8
+    414599n 1.8
+    414600n 0
+    414649n 0
+    414650n 1.8
+    414699n 1.8
+    414700n 0
+    414749n 0
+    414750n 1.8
+    414799n 1.8
+    414800n 0
+    414849n 0
+    414850n 1.8
+    414899n 1.8
+    414900n 0
+    414949n 0
+    414950n 1.8
+    414999n 1.8
+    415000n 0
+    415049n 0
+    415050n 1.8
+    415099n 1.8
+    415100n 0
+    415149n 0
+    415150n 1.8
+    415199n 1.8
+    415200n 0
+    415249n 0
+    415250n 1.8
+    415299n 1.8
+    415300n 0
+    415349n 0
+    415350n 1.8
+    415399n 1.8
+    415400n 0
+    415449n 0
+    415450n 1.8
+    415499n 1.8
+    415500n 0
+    415549n 0
+    415550n 1.8
+    415599n 1.8
+    415600n 0
+    415649n 0
+    415650n 1.8
+    415699n 1.8
+    415700n 0
+    415749n 0
+    415750n 1.8
+    415799n 1.8
+    415800n 0
+    415849n 0
+    415850n 1.8
+    415899n 1.8
+    415900n 0
+    415949n 0
+    415950n 1.8
+    415999n 1.8
+    416000n 0
+    416049n 0
+    416050n 1.8
+    416099n 1.8
+    416100n 0
+    416149n 0
+    416150n 1.8
+    416199n 1.8
+    416200n 0
+    416249n 0
+    416250n 1.8
+    416299n 1.8
+    416300n 0
+    416349n 0
+    416350n 1.8
+    416399n 1.8
+    416400n 0
+    416449n 0
+    416450n 1.8
+    416499n 1.8
+    416500n 0
+    416549n 0
+    416550n 1.8
+    416599n 1.8
+    416600n 0
+    416649n 0
+    416650n 1.8
+    416699n 1.8
+    416700n 0
+    416749n 0
+    416750n 1.8
+    416799n 1.8
+    416800n 0
+    416849n 0
+    416850n 1.8
+    416899n 1.8
+    416900n 0
+    416949n 0
+    416950n 1.8
+    416999n 1.8
+    417000n 0
+    417049n 0
+    417050n 1.8
+    417099n 1.8
+    417100n 0
+    417149n 0
+    417150n 1.8
+    417199n 1.8
+    417200n 0
+    417249n 0
+    417250n 1.8
+    417299n 1.8
+    417300n 0
+    417349n 0
+    417350n 1.8
+    417399n 1.8
+    417400n 0
+    417449n 0
+    417450n 1.8
+    417499n 1.8
+    417500n 0
+    417549n 0
+    417550n 1.8
+    417599n 1.8
+    417600n 0
+    417649n 0
+    417650n 1.8
+    417699n 1.8
+    417700n 0
+    417749n 0
+    417750n 1.8
+    417799n 1.8
+    417800n 0
+    417849n 0
+    417850n 1.8
+    417899n 1.8
+    417900n 0
+    417949n 0
+    417950n 1.8
+    417999n 1.8
+    418000n 0
+    418049n 0
+    418050n 1.8
+    418099n 1.8
+    418100n 0
+    418149n 0
+    418150n 1.8
+    418199n 1.8
+    418200n 0
+    418249n 0
+    418250n 1.8
+    418299n 1.8
+    418300n 0
+    418349n 0
+    418350n 1.8
+    418399n 1.8
+    418400n 0
+    418449n 0
+    418450n 1.8
+    418499n 1.8
+    418500n 0
+    418549n 0
+    418550n 1.8
+    418599n 1.8
+    418600n 0
+    418649n 0
+    418650n 1.8
+    418699n 1.8
+    418700n 0
+    418749n 0
+    418750n 1.8
+    418799n 1.8
+    418800n 0
+    418849n 0
+    418850n 1.8
+    418899n 1.8
+    418900n 0
+    418949n 0
+    418950n 1.8
+    418999n 1.8
+    419000n 0
+    419049n 0
+    419050n 1.8
+    419099n 1.8
+    419100n 0
+    419149n 0
+    419150n 1.8
+    419199n 1.8
+    419200n 0
+    419249n 0
+    419250n 1.8
+    419299n 1.8
+    419300n 0
+    419349n 0
+    419350n 1.8
+    419399n 1.8
+    419400n 0
+    419449n 0
+    419450n 1.8
+    419499n 1.8
+    419500n 0
+    419549n 0
+    419550n 1.8
+    419599n 1.8
+    419600n 0
+    419649n 0
+    419650n 1.8
+    419699n 1.8
+    419700n 0
+    419749n 0
+    419750n 1.8
+    419799n 1.8
+    419800n 0
+    419849n 0
+    419850n 1.8
+    419899n 1.8
+    419900n 0
+    419949n 0
+    419950n 1.8
+    419999n 1.8
+    420000n 0
+    420049n 0
+    420050n 1.8
+    420099n 1.8
+    420100n 0
+    420149n 0
+    420150n 1.8
+    420199n 1.8
+    420200n 0
+    420249n 0
+    420250n 1.8
+    420299n 1.8
+    420300n 0
+    420349n 0
+    420350n 1.8
+    420399n 1.8
+    420400n 0
+    420449n 0
+    420450n 1.8
+    420499n 1.8
+    420500n 0
+    420549n 0
+    420550n 1.8
+    420599n 1.8
+    420600n 0
+    420649n 0
+    420650n 1.8
+    420699n 1.8
+    420700n 0
+    420749n 0
+    420750n 1.8
+    420799n 1.8
+    420800n 0
+    420849n 0
+    420850n 1.8
+    420899n 1.8
+    420900n 0
+    420949n 0
+    420950n 1.8
+    420999n 1.8
+    421000n 0
+    421049n 0
+    421050n 1.8
+    421099n 1.8
+    421100n 0
+    421149n 0
+    421150n 1.8
+    421199n 1.8
+    421200n 0
+    421249n 0
+    421250n 1.8
+    421299n 1.8
+    421300n 0
+    421349n 0
+    421350n 1.8
+    421399n 1.8
+    421400n 0
+    421449n 0
+    421450n 1.8
+    421499n 1.8
+    421500n 0
+    421549n 0
+    421550n 1.8
+    421599n 1.8
+    421600n 0
+    421649n 0
+    421650n 1.8
+    421699n 1.8
+    421700n 0
+    421749n 0
+    421750n 1.8
+    421799n 1.8
+    421800n 0
+    421849n 0
+    421850n 1.8
+    421899n 1.8
+    421900n 0
+    421949n 0
+    421950n 1.8
+    421999n 1.8
+    422000n 0
+    422049n 0
+    422050n 1.8
+    422099n 1.8
+    422100n 0
+    422149n 0
+    422150n 1.8
+    422199n 1.8
+    422200n 0
+    422249n 0
+    422250n 1.8
+    422299n 1.8
+    422300n 0
+    422349n 0
+    422350n 1.8
+    422399n 1.8
+    422400n 0
+    422449n 0
+    422450n 1.8
+    422499n 1.8
+    422500n 0
+    422549n 0
+    422550n 1.8
+    422599n 1.8
+    422600n 0
+    422649n 0
+    422650n 1.8
+    422699n 1.8
+    422700n 0
+    422749n 0
+    422750n 1.8
+    422799n 1.8
+    422800n 0
+    422849n 0
+    422850n 1.8
+    422899n 1.8
+    422900n 0
+    422949n 0
+    422950n 1.8
+    422999n 1.8
+    423000n 0
+    423049n 0
+    423050n 1.8
+    423099n 1.8
+    423100n 0
+    423149n 0
+    423150n 1.8
+    423199n 1.8
+    423200n 0
+    423249n 0
+    423250n 1.8
+    423299n 1.8
+    423300n 0
+    423349n 0
+    423350n 1.8
+    423399n 1.8
+    423400n 0
+    423449n 0
+    423450n 1.8
+    423499n 1.8
+    423500n 0
+    423549n 0
+    423550n 1.8
+    423599n 1.8
+    423600n 0
+    423649n 0
+    423650n 1.8
+    423699n 1.8
+    423700n 0
+    423749n 0
+    423750n 1.8
+    423799n 1.8
+    423800n 0
+    423849n 0
+    423850n 1.8
+    423899n 1.8
+    423900n 0
+    423949n 0
+    423950n 1.8
+    423999n 1.8
+    424000n 0
+    424049n 0
+    424050n 1.8
+    424099n 1.8
+    424100n 0
+    424149n 0
+    424150n 1.8
+    424199n 1.8
+    424200n 0
+    424249n 0
+    424250n 1.8
+    424299n 1.8
+    424300n 0
+    424349n 0
+    424350n 1.8
+    424399n 1.8
+    424400n 0
+    424449n 0
+    424450n 1.8
+    424499n 1.8
+    424500n 0
+    424549n 0
+    424550n 1.8
+    424599n 1.8
+    424600n 0
+    424649n 0
+    424650n 1.8
+    424699n 1.8
+    424700n 0
+    424749n 0
+    424750n 1.8
+    424799n 1.8
+    424800n 0
+    424849n 0
+    424850n 1.8
+    424899n 1.8
+    424900n 0
+    424949n 0
+    424950n 1.8
+    424999n 1.8
+    425000n 0
+    425049n 0
+    425050n 1.8
+    425099n 1.8
+    425100n 0
+    425149n 0
+    425150n 1.8
+    425199n 1.8
+    425200n 0
+    425249n 0
+    425250n 1.8
+    425299n 1.8
+    425300n 0
+    425349n 0
+    425350n 1.8
+    425399n 1.8
+    425400n 0
+    425449n 0
+    425450n 1.8
+    425499n 1.8
+    425500n 0
+    425549n 0
+    425550n 1.8
+    425599n 1.8
+    425600n 0
+    425649n 0
+    425650n 1.8
+    425699n 1.8
+    425700n 0
+    425749n 0
+    425750n 1.8
+    425799n 1.8
+    425800n 0
+    425849n 0
+    425850n 1.8
+    425899n 1.8
+    425900n 0
+    425949n 0
+    425950n 1.8
+    425999n 1.8
+    426000n 0
+    426049n 0
+    426050n 1.8
+    426099n 1.8
+    426100n 0
+    426149n 0
+    426150n 1.8
+    426199n 1.8
+    426200n 0
+    426249n 0
+    426250n 1.8
+    426299n 1.8
+    426300n 0
+    426349n 0
+    426350n 1.8
+    426399n 1.8
+    426400n 0
+    426449n 0
+    426450n 1.8
+    426499n 1.8
+    426500n 0
+    426549n 0
+    426550n 1.8
+    426599n 1.8
+    426600n 0
+    426649n 0
+    426650n 1.8
+    426699n 1.8
+    426700n 0
+    426749n 0
+    426750n 1.8
+    426799n 1.8
+    426800n 0
+    426849n 0
+    426850n 1.8
+    426899n 1.8
+    426900n 0
+    426949n 0
+    426950n 1.8
+    426999n 1.8
+    427000n 0
+    427049n 0
+    427050n 1.8
+    427099n 1.8
+    427100n 0
+    427149n 0
+    427150n 1.8
+    427199n 1.8
+    427200n 0
+    427249n 0
+    427250n 1.8
+    427299n 1.8
+    427300n 0
+    427349n 0
+    427350n 1.8
+    427399n 1.8
+    427400n 0
+    427449n 0
+    427450n 1.8
+    427499n 1.8
+    427500n 0
+    427549n 0
+    427550n 1.8
+    427599n 1.8
+    427600n 0
+    427649n 0
+    427650n 1.8
+    427699n 1.8
+    427700n 0
+    427749n 0
+    427750n 1.8
+    427799n 1.8
+    427800n 0
+    427849n 0
+    427850n 1.8
+    427899n 1.8
+    427900n 0
+    427949n 0
+    427950n 1.8
+    427999n 1.8
+    428000n 0
+    428049n 0
+    428050n 1.8
+    428099n 1.8
+    428100n 0
+    428149n 0
+    428150n 1.8
+    428199n 1.8
+    428200n 0
+    428249n 0
+    428250n 1.8
+    428299n 1.8
+    428300n 0
+    428349n 0
+    428350n 1.8
+    428399n 1.8
+    428400n 0
+    428449n 0
+    428450n 1.8
+    428499n 1.8
+    428500n 0
+    428549n 0
+    428550n 1.8
+    428599n 1.8
+    428600n 0
+    428649n 0
+    428650n 1.8
+    428699n 1.8
+    428700n 0
+    428749n 0
+    428750n 1.8
+    428799n 1.8
+    428800n 0
+    428849n 0
+    428850n 1.8
+    428899n 1.8
+    428900n 0
+    428949n 0
+    428950n 1.8
+    428999n 1.8
+    429000n 0
+    429049n 0
+    429050n 1.8
+    429099n 1.8
+    429100n 0
+    429149n 0
+    429150n 1.8
+    429199n 1.8
+    429200n 0
+    429249n 0
+    429250n 1.8
+    429299n 1.8
+    429300n 0
+    429349n 0
+    429350n 1.8
+    429399n 1.8
+    429400n 0
+    429449n 0
+    429450n 1.8
+    429499n 1.8
+    429500n 0
+    429549n 0
+    429550n 1.8
+    429599n 1.8
+    429600n 0
+    429649n 0
+    429650n 1.8
+    429699n 1.8
+    429700n 0
+    429749n 0
+    429750n 1.8
+    429799n 1.8
+    429800n 0
+    429849n 0
+    429850n 1.8
+    429899n 1.8
+    429900n 0
+    429949n 0
+    429950n 1.8
+    429999n 1.8
+    430000n 0
+    430049n 0
+    430050n 1.8
+    430099n 1.8
+    430100n 0
+    430149n 0
+    430150n 1.8
+    430199n 1.8
+    430200n 0
+    430249n 0
+    430250n 1.8
+    430299n 1.8
+    430300n 0
+    430349n 0
+    430350n 1.8
+    430399n 1.8
+    430400n 0
+    430449n 0
+    430450n 1.8
+    430499n 1.8
+    430500n 0
+    430549n 0
+    430550n 1.8
+    430599n 1.8
+    430600n 0
+    430649n 0
+    430650n 1.8
+    430699n 1.8
+    430700n 0
+    430749n 0
+    430750n 1.8
+    430799n 1.8
+    430800n 0
+    430849n 0
+    430850n 1.8
+    430899n 1.8
+    430900n 0
+    430949n 0
+    430950n 1.8
+    430999n 1.8
+    431000n 0
+    431049n 0
+    431050n 1.8
+    431099n 1.8
+    431100n 0
+    431149n 0
+    431150n 1.8
+    431199n 1.8
+    431200n 0
+    431249n 0
+    431250n 1.8
+    431299n 1.8
+    431300n 0
+    431349n 0
+    431350n 1.8
+    431399n 1.8
+    431400n 0
+    431449n 0
+    431450n 1.8
+    431499n 1.8
+    431500n 0
+    431549n 0
+    431550n 1.8
+    431599n 1.8
+    431600n 0
+    431649n 0
+    431650n 1.8
+    431699n 1.8
+    431700n 0
+    431749n 0
+    431750n 1.8
+    431799n 1.8
+    431800n 0
+    431849n 0
+    431850n 1.8
+    431899n 1.8
+    431900n 0
+    431949n 0
+    431950n 1.8
+    431999n 1.8
+    432000n 0
+    432049n 0
+    432050n 1.8
+    432099n 1.8
+    432100n 0
+    432149n 0
+    432150n 1.8
+    432199n 1.8
+    432200n 0
+    432249n 0
+    432250n 1.8
+    432299n 1.8
+    432300n 0
+    432349n 0
+    432350n 1.8
+    432399n 1.8
+    432400n 0
+    432449n 0
+    432450n 1.8
+    432499n 1.8
+    432500n 0
+    432549n 0
+    432550n 1.8
+    432599n 1.8
+    432600n 0
+    432649n 0
+    432650n 1.8
+    432699n 1.8
+    432700n 0
+    432749n 0
+    432750n 1.8
+    432799n 1.8
+    432800n 0
+    432849n 0
+    432850n 1.8
+    432899n 1.8
+    432900n 0
+    432949n 0
+    432950n 1.8
+    432999n 1.8
+    433000n 0
+    433049n 0
+    433050n 1.8
+    433099n 1.8
+    433100n 0
+    433149n 0
+    433150n 1.8
+    433199n 1.8
+    433200n 0
+    433249n 0
+    433250n 1.8
+    433299n 1.8
+    433300n 0
+    433349n 0
+    433350n 1.8
+    433399n 1.8
+    433400n 0
+    433449n 0
+    433450n 1.8
+    433499n 1.8
+    433500n 0
+    433549n 0
+    433550n 1.8
+    433599n 1.8
+    433600n 0
+    433649n 0
+    433650n 1.8
+    433699n 1.8
+    433700n 0
+    433749n 0
+    433750n 1.8
+    433799n 1.8
+    433800n 0
+    433849n 0
+    433850n 1.8
+    433899n 1.8
+    433900n 0
+    433949n 0
+    433950n 1.8
+    433999n 1.8
+    434000n 0
+    434049n 0
+    434050n 1.8
+    434099n 1.8
+    434100n 0
+    434149n 0
+    434150n 1.8
+    434199n 1.8
+    434200n 0
+    434249n 0
+    434250n 1.8
+    434299n 1.8
+    434300n 0
+    434349n 0
+    434350n 1.8
+    434399n 1.8
+    434400n 0
+    434449n 0
+    434450n 1.8
+    434499n 1.8
+    434500n 0
+    434549n 0
+    434550n 1.8
+    434599n 1.8
+    434600n 0
+    434649n 0
+    434650n 1.8
+    434699n 1.8
+    434700n 0
+    434749n 0
+    434750n 1.8
+    434799n 1.8
+    434800n 0
+    434849n 0
+    434850n 1.8
+    434899n 1.8
+    434900n 0
+    434949n 0
+    434950n 1.8
+    434999n 1.8
+    435000n 0
+    435049n 0
+    435050n 1.8
+    435099n 1.8
+    435100n 0
+    435149n 0
+    435150n 1.8
+    435199n 1.8
+    435200n 0
+    435249n 0
+    435250n 1.8
+    435299n 1.8
+    435300n 0
+    435349n 0
+    435350n 1.8
+    435399n 1.8
+    435400n 0
+    435449n 0
+    435450n 1.8
+    435499n 1.8
+    435500n 0
+    435549n 0
+    435550n 1.8
+    435599n 1.8
+    435600n 0
+    435649n 0
+    435650n 1.8
+    435699n 1.8
+    435700n 0
+    435749n 0
+    435750n 1.8
+    435799n 1.8
+    435800n 0
+    435849n 0
+    435850n 1.8
+    435899n 1.8
+    435900n 0
+    435949n 0
+    435950n 1.8
+    435999n 1.8
+    436000n 0
+    436049n 0
+    436050n 1.8
+    436099n 1.8
+    436100n 0
+    436149n 0
+    436150n 1.8
+    436199n 1.8
+    436200n 0
+    436249n 0
+    436250n 1.8
+    436299n 1.8
+    436300n 0
+    436349n 0
+    436350n 1.8
+    436399n 1.8
+    436400n 0
+    436449n 0
+    436450n 1.8
+    436499n 1.8
+    436500n 0
+    436549n 0
+    436550n 1.8
+    436599n 1.8
+    436600n 0
+    436649n 0
+    436650n 1.8
+    436699n 1.8
+    436700n 0
+    436749n 0
+    436750n 1.8
+    436799n 1.8
+    436800n 0
+    436849n 0
+    436850n 1.8
+    436899n 1.8
+    436900n 0
+    436949n 0
+    436950n 1.8
+    436999n 1.8
+    437000n 0
+    437049n 0
+    437050n 1.8
+    437099n 1.8
+    437100n 0
+    437149n 0
+    437150n 1.8
+    437199n 1.8
+    437200n 0
+    437249n 0
+    437250n 1.8
+    437299n 1.8
+    437300n 0
+    437349n 0
+    437350n 1.8
+    437399n 1.8
+    437400n 0
+    437449n 0
+    437450n 1.8
+    437499n 1.8
+    437500n 0
+    437549n 0
+    437550n 1.8
+    437599n 1.8
+    437600n 0
+    437649n 0
+    437650n 1.8
+    437699n 1.8
+    437700n 0
+    437749n 0
+    437750n 1.8
+    437799n 1.8
+    437800n 0
+    437849n 0
+    437850n 1.8
+    437899n 1.8
+    437900n 0
+    437949n 0
+    437950n 1.8
+    437999n 1.8
+    438000n 0
+    438049n 0
+    438050n 1.8
+    438099n 1.8
+    438100n 0
+    438149n 0
+    438150n 1.8
+    438199n 1.8
+    438200n 0
+    438249n 0
+    438250n 1.8
+    438299n 1.8
+    438300n 0
+    438349n 0
+    438350n 1.8
+    438399n 1.8
+    438400n 0
+    438449n 0
+    438450n 1.8
+    438499n 1.8
+    438500n 0
+    438549n 0
+    438550n 1.8
+    438599n 1.8
+    438600n 0
+    438649n 0
+    438650n 1.8
+    438699n 1.8
+    438700n 0
+    438749n 0
+    438750n 1.8
+    438799n 1.8
+    438800n 0
+    438849n 0
+    438850n 1.8
+    438899n 1.8
+    438900n 0
+    438949n 0
+    438950n 1.8
+    438999n 1.8
+    439000n 0
+    439049n 0
+    439050n 1.8
+    439099n 1.8
+    439100n 0
+    439149n 0
+    439150n 1.8
+    439199n 1.8
+    439200n 0
+    439249n 0
+    439250n 1.8
+    439299n 1.8
+    439300n 0
+    439349n 0
+    439350n 1.8
+    439399n 1.8
+    439400n 0
+    439449n 0
+    439450n 1.8
+    439499n 1.8
+    439500n 0
+    439549n 0
+    439550n 1.8
+    439599n 1.8
+    439600n 0
+    439649n 0
+    439650n 1.8
+    439699n 1.8
+    439700n 0
+    439749n 0
+    439750n 1.8
+    439799n 1.8
+    439800n 0
+    439849n 0
+    439850n 1.8
+    439899n 1.8
+    439900n 0
+    439949n 0
+    439950n 1.8
+    439999n 1.8
+    440000n 0
+    440049n 0
+    440050n 1.8
+    440099n 1.8
+    440100n 0
+    440149n 0
+    440150n 1.8
+    440199n 1.8
+    440200n 0
+    440249n 0
+    440250n 1.8
+    440299n 1.8
+    440300n 0
+    440349n 0
+    440350n 1.8
+    440399n 1.8
+    440400n 0
+    440449n 0
+    440450n 1.8
+    440499n 1.8
+    440500n 0
+    440549n 0
+    440550n 1.8
+    440599n 1.8
+    440600n 0
+    440649n 0
+    440650n 1.8
+    440699n 1.8
+    440700n 0
+    440749n 0
+    440750n 1.8
+    440799n 1.8
+    440800n 0
+    440849n 0
+    440850n 1.8
+    440899n 1.8
+    440900n 0
+    440949n 0
+    440950n 1.8
+    440999n 1.8
+    441000n 0
+    441049n 0
+    441050n 1.8
+    441099n 1.8
+    441100n 0
+    441149n 0
+    441150n 1.8
+    441199n 1.8
+    441200n 0
+    441249n 0
+    441250n 1.8
+    441299n 1.8
+    441300n 0
+    441349n 0
+    441350n 1.8
+    441399n 1.8
+    441400n 0
+    441449n 0
+    441450n 1.8
+    441499n 1.8
+    441500n 0
+    441549n 0
+    441550n 1.8
+    441599n 1.8
+    441600n 0
+    441649n 0
+    441650n 1.8
+    441699n 1.8
+    441700n 0
+    441749n 0
+    441750n 1.8
+    441799n 1.8
+    441800n 0
+    441849n 0
+    441850n 1.8
+    441899n 1.8
+    441900n 0
+    441949n 0
+    441950n 1.8
+    441999n 1.8
+    442000n 0
+    442049n 0
+    442050n 1.8
+    442099n 1.8
+    442100n 0
+    442149n 0
+    442150n 1.8
+    442199n 1.8
+    442200n 0
+    442249n 0
+    442250n 1.8
+    442299n 1.8
+    442300n 0
+    442349n 0
+    442350n 1.8
+    442399n 1.8
+    442400n 0
+    442449n 0
+    442450n 1.8
+    442499n 1.8
+    442500n 0
+    442549n 0
+    442550n 1.8
+    442599n 1.8
+    442600n 0
+    442649n 0
+    442650n 1.8
+    442699n 1.8
+    442700n 0
+    442749n 0
+    442750n 1.8
+    442799n 1.8
+    442800n 0
+    442849n 0
+    442850n 1.8
+    442899n 1.8
+    442900n 0
+    442949n 0
+    442950n 1.8
+    442999n 1.8
+    443000n 0
+    443049n 0
+    443050n 1.8
+    443099n 1.8
+    443100n 0
+    443149n 0
+    443150n 1.8
+    443199n 1.8
+    443200n 0
+    443249n 0
+    443250n 1.8
+    443299n 1.8
+    443300n 0
+    443349n 0
+    443350n 1.8
+    443399n 1.8
+    443400n 0
+    443449n 0
+    443450n 1.8
+    443499n 1.8
+    443500n 0
+    443549n 0
+    443550n 1.8
+    443599n 1.8
+    443600n 0
+    443649n 0
+    443650n 1.8
+    443699n 1.8
+    443700n 0
+    443749n 0
+    443750n 1.8
+    443799n 1.8
+    443800n 0
+    443849n 0
+    443850n 1.8
+    443899n 1.8
+    443900n 0
+    443949n 0
+    443950n 1.8
+    443999n 1.8
+    444000n 0
+    444049n 0
+    444050n 1.8
+    444099n 1.8
+    444100n 0
+    444149n 0
+    444150n 1.8
+    444199n 1.8
+    444200n 0
+    444249n 0
+    444250n 1.8
+    444299n 1.8
+    444300n 0
+    444349n 0
+    444350n 1.8
+    444399n 1.8
+    444400n 0
+    444449n 0
+    444450n 1.8
+    444499n 1.8
+    444500n 0
+    444549n 0
+    444550n 1.8
+    444599n 1.8
+    444600n 0
+    444649n 0
+    444650n 1.8
+    444699n 1.8
+    444700n 0
+    444749n 0
+    444750n 1.8
+    444799n 1.8
+    444800n 0
+    444849n 0
+    444850n 1.8
+    444899n 1.8
+    444900n 0
+    444949n 0
+    444950n 1.8
+    444999n 1.8
+    445000n 0
+    445049n 0
+    445050n 1.8
+    445099n 1.8
+    445100n 0
+    445149n 0
+    445150n 1.8
+    445199n 1.8
+    445200n 0
+    445249n 0
+    445250n 1.8
+    445299n 1.8
+    445300n 0
+    445349n 0
+    445350n 1.8
+    445399n 1.8
+    445400n 0
+    445449n 0
+    445450n 1.8
+    445499n 1.8
+    445500n 0
+    445549n 0
+    445550n 1.8
+    445599n 1.8
+    445600n 0
+    445649n 0
+    445650n 1.8
+    445699n 1.8
+    445700n 0
+    445749n 0
+    445750n 1.8
+    445799n 1.8
+    445800n 0
+    445849n 0
+    445850n 1.8
+    445899n 1.8
+    445900n 0
+    445949n 0
+    445950n 1.8
+    445999n 1.8
+    446000n 0
+    446049n 0
+    446050n 1.8
+    446099n 1.8
+    446100n 0
+    446149n 0
+    446150n 1.8
+    446199n 1.8
+    446200n 0
+    446249n 0
+    446250n 1.8
+    446299n 1.8
+    446300n 0
+    446349n 0
+    446350n 1.8
+    446399n 1.8
+    446400n 0
+    446449n 0
+    446450n 1.8
+    446499n 1.8
+    446500n 0
+    446549n 0
+    446550n 1.8
+    446599n 1.8
+    446600n 0
+    446649n 0
+    446650n 1.8
+    446699n 1.8
+    446700n 0
+    446749n 0
+    446750n 1.8
+    446799n 1.8
+    446800n 0
+    446849n 0
+    446850n 1.8
+    446899n 1.8
+    446900n 0
+    446949n 0
+    446950n 1.8
+    446999n 1.8
+    447000n 0
+    447049n 0
+    447050n 1.8
+    447099n 1.8
+    447100n 0
+    447149n 0
+    447150n 1.8
+    447199n 1.8
+    447200n 0
+    447249n 0
+    447250n 1.8
+    447299n 1.8
+    447300n 0
+    447349n 0
+    447350n 1.8
+    447399n 1.8
+    447400n 0
+    447449n 0
+    447450n 1.8
+    447499n 1.8
+    447500n 0
+    447549n 0
+    447550n 1.8
+    447599n 1.8
+    447600n 0
+    447649n 0
+    447650n 1.8
+    447699n 1.8
+    447700n 0
+    447749n 0
+    447750n 1.8
+    447799n 1.8
+    447800n 0
+    447849n 0
+    447850n 1.8
+    447899n 1.8
+    447900n 0
+    447949n 0
+    447950n 1.8
+    447999n 1.8
+    448000n 0
+    448049n 0
+    448050n 1.8
+    448099n 1.8
+    448100n 0
+    448149n 0
+    448150n 1.8
+    448199n 1.8
+    448200n 0
+    448249n 0
+    448250n 1.8
+    448299n 1.8
+    448300n 0
+    448349n 0
+    448350n 1.8
+    448399n 1.8
+    448400n 0
+    448449n 0
+    448450n 1.8
+    448499n 1.8
+    448500n 0
+    448549n 0
+    448550n 1.8
+    448599n 1.8
+    448600n 0
+    448649n 0
+    448650n 1.8
+    448699n 1.8
+    448700n 0
+    448749n 0
+    448750n 1.8
+    448799n 1.8
+    448800n 0
+    448849n 0
+    448850n 1.8
+    448899n 1.8
+    448900n 0
+    448949n 0
+    448950n 1.8
+    448999n 1.8
+    449000n 0
+    449049n 0
+    449050n 1.8
+    449099n 1.8
+    449100n 0
+    449149n 0
+    449150n 1.8
+    449199n 1.8
+    449200n 0
+    449249n 0
+    449250n 1.8
+    449299n 1.8
+    449300n 0
+    449349n 0
+    449350n 1.8
+    449399n 1.8
+    449400n 0
+    449449n 0
+    449450n 1.8
+    449499n 1.8
+    449500n 0
+    449549n 0
+    449550n 1.8
+    449599n 1.8
+    449600n 0
+    449649n 0
+    449650n 1.8
+    449699n 1.8
+    449700n 0
+    449749n 0
+    449750n 1.8
+    449799n 1.8
+    449800n 0
+    449849n 0
+    449850n 1.8
+    449899n 1.8
+    449900n 0
+    449949n 0
+    449950n 1.8
+    449999n 1.8
+    450000n 0
+    450049n 0
+    450050n 1.8
+    450099n 1.8
+    450100n 0
+    450149n 0
+    450150n 1.8
+    450199n 1.8
+    450200n 0
+    450249n 0
+    450250n 1.8
+    450299n 1.8
+    450300n 0
+    450349n 0
+    450350n 1.8
+    450399n 1.8
+    450400n 0
+    450449n 0
+    450450n 1.8
+    450499n 1.8
+    450500n 0
+    450549n 0
+    450550n 1.8
+    450599n 1.8
+    450600n 0
+    450649n 0
+    450650n 1.8
+    450699n 1.8
+    450700n 0
+    450749n 0
+    450750n 1.8
+    450799n 1.8
+    450800n 0
+    450849n 0
+    450850n 1.8
+    450899n 1.8
+    450900n 0
+    450949n 0
+    450950n 1.8
+    450999n 1.8
+    451000n 0
+    451049n 0
+    451050n 1.8
+    451099n 1.8
+    451100n 0
+    451149n 0
+    451150n 1.8
+    451199n 1.8
+    451200n 0
+    451249n 0
+    451250n 1.8
+    451299n 1.8
+    451300n 0
+    451349n 0
+    451350n 1.8
+    451399n 1.8
+    451400n 0
+    451449n 0
+    451450n 1.8
+    451499n 1.8
+    451500n 0
+    451549n 0
+    451550n 1.8
+    451599n 1.8
+    451600n 0
+    451649n 0
+    451650n 1.8
+    451699n 1.8
+    451700n 0
+    451749n 0
+    451750n 1.8
+    451799n 1.8
+    451800n 0
+    451849n 0
+    451850n 1.8
+    451899n 1.8
+    451900n 0
+    451949n 0
+    451950n 1.8
+    451999n 1.8
+    452000n 0
+    452049n 0
+    452050n 1.8
+    452099n 1.8
+    452100n 0
+    452149n 0
+    452150n 1.8
+    452199n 1.8
+    452200n 0
+    452249n 0
+    452250n 1.8
+    452299n 1.8
+    452300n 0
+    452349n 0
+    452350n 1.8
+    452399n 1.8
+    452400n 0
+    452449n 0
+    452450n 1.8
+    452499n 1.8
+    452500n 0
+    452549n 0
+    452550n 1.8
+    452599n 1.8
+    452600n 0
+    452649n 0
+    452650n 1.8
+    452699n 1.8
+    452700n 0
+    452749n 0
+    452750n 1.8
+    452799n 1.8
+    452800n 0
+    452849n 0
+    452850n 1.8
+    452899n 1.8
+    452900n 0
+    452949n 0
+    452950n 1.8
+    452999n 1.8
+    453000n 0
+    453049n 0
+    453050n 1.8
+    453099n 1.8
+    453100n 0
+    453149n 0
+    453150n 1.8
+    453199n 1.8
+    453200n 0
+    453249n 0
+    453250n 1.8
+    453299n 1.8
+    453300n 0
+    453349n 0
+    453350n 1.8
+    453399n 1.8
+    453400n 0
+    453449n 0
+    453450n 1.8
+    453499n 1.8
+    453500n 0
+    453549n 0
+    453550n 1.8
+    453599n 1.8
+    453600n 0
+    453649n 0
+    453650n 1.8
+    453699n 1.8
+    453700n 0
+    453749n 0
+    453750n 1.8
+    453799n 1.8
+    453800n 0
+    453849n 0
+    453850n 1.8
+    453899n 1.8
+    453900n 0
+    453949n 0
+    453950n 1.8
+    453999n 1.8
+    454000n 0
+    454049n 0
+    454050n 1.8
+    454099n 1.8
+    454100n 0
+    454149n 0
+    454150n 1.8
+    454199n 1.8
+    454200n 0
+    454249n 0
+    454250n 1.8
+    454299n 1.8
+    454300n 0
+    454349n 0
+    454350n 1.8
+    454399n 1.8
+    454400n 0
+    454449n 0
+    454450n 1.8
+    454499n 1.8
+    454500n 0
+    454549n 0
+    454550n 1.8
+    454599n 1.8
+    454600n 0
+    454649n 0
+    454650n 1.8
+    454699n 1.8
+    454700n 0
+    454749n 0
+    454750n 1.8
+    454799n 1.8
+    454800n 0
+    454849n 0
+    454850n 1.8
+    454899n 1.8
+    454900n 0
+    454949n 0
+    454950n 1.8
+    454999n 1.8
+    455000n 0
+    455049n 0
+    455050n 1.8
+    455099n 1.8
+    455100n 0
+    455149n 0
+    455150n 1.8
+    455199n 1.8
+    455200n 0
+    455249n 0
+    455250n 1.8
+    455299n 1.8
+    455300n 0
+    455349n 0
+    455350n 1.8
+    455399n 1.8
+    455400n 0
+    455449n 0
+    455450n 1.8
+    455499n 1.8
+    455500n 0
+    455549n 0
+    455550n 1.8
+    455599n 1.8
+    455600n 0
+    455649n 0
+    455650n 1.8
+    455699n 1.8
+    455700n 0
+    455749n 0
+    455750n 1.8
+    455799n 1.8
+    455800n 0
+    455849n 0
+    455850n 1.8
+    455899n 1.8
+    455900n 0
+    455949n 0
+    455950n 1.8
+    455999n 1.8
+    456000n 0
+    456049n 0
+    456050n 1.8
+    456099n 1.8
+    456100n 0
+    456149n 0
+    456150n 1.8
+    456199n 1.8
+    456200n 0
+    456249n 0
+    456250n 1.8
+    456299n 1.8
+    456300n 0
+    456349n 0
+    456350n 1.8
+    456399n 1.8
+    456400n 0
+    456449n 0
+    456450n 1.8
+    456499n 1.8
+    456500n 0
+    456549n 0
+    456550n 1.8
+    456599n 1.8
+    456600n 0
+    456649n 0
+    456650n 1.8
+    456699n 1.8
+    456700n 0
+    456749n 0
+    456750n 1.8
+    456799n 1.8
+    456800n 0
+    456849n 0
+    456850n 1.8
+    456899n 1.8
+    456900n 0
+    456949n 0
+    456950n 1.8
+    456999n 1.8
+    457000n 0
+    457049n 0
+    457050n 1.8
+    457099n 1.8
+    457100n 0
+    457149n 0
+    457150n 1.8
+    457199n 1.8
+    457200n 0
+    457249n 0
+    457250n 1.8
+    457299n 1.8
+    457300n 0
+    457349n 0
+    457350n 1.8
+    457399n 1.8
+    457400n 0
+    457449n 0
+    457450n 1.8
+    457499n 1.8
+    457500n 0
+    457549n 0
+    457550n 1.8
+    457599n 1.8
+    457600n 0
+    457649n 0
+    457650n 1.8
+    457699n 1.8
+    457700n 0
+    457749n 0
+    457750n 1.8
+    457799n 1.8
+    457800n 0
+    457849n 0
+    457850n 1.8
+    457899n 1.8
+    457900n 0
+    457949n 0
+    457950n 1.8
+    457999n 1.8
+    458000n 0
+    458049n 0
+    458050n 1.8
+    458099n 1.8
+    458100n 0
+    458149n 0
+    458150n 1.8
+    458199n 1.8
+    458200n 0
+    458249n 0
+    458250n 1.8
+    458299n 1.8
+    458300n 0
+    458349n 0
+    458350n 1.8
+    458399n 1.8
+    458400n 0
+    458449n 0
+    458450n 1.8
+    458499n 1.8
+    458500n 0
+    458549n 0
+    458550n 1.8
+    458599n 1.8
+    458600n 0
+    458649n 0
+    458650n 1.8
+    458699n 1.8
+    458700n 0
+    458749n 0
+    458750n 1.8
+    458799n 1.8
+    458800n 0
+    458849n 0
+    458850n 1.8
+    458899n 1.8
+    458900n 0
+    458949n 0
+    458950n 1.8
+    458999n 1.8
+    459000n 0
+    459049n 0
+    459050n 1.8
+    459099n 1.8
+    459100n 0
+    459149n 0
+    459150n 1.8
+    459199n 1.8
+    459200n 0
+    459249n 0
+    459250n 1.8
+    459299n 1.8
+    459300n 0
+    459349n 0
+    459350n 1.8
+    459399n 1.8
+    459400n 0
+    459449n 0
+    459450n 1.8
+    459499n 1.8
+    459500n 0
+    459549n 0
+    459550n 1.8
+    459599n 1.8
+    459600n 0
+    459649n 0
+    459650n 1.8
+    459699n 1.8
+    459700n 0
+    459749n 0
+    459750n 1.8
+    459799n 1.8
+    459800n 0
+    459849n 0
+    459850n 1.8
+    459899n 1.8
+    459900n 0
+    459949n 0
+    459950n 1.8
+    459999n 1.8
+    460000n 0
+    460049n 0
+    460050n 1.8
+    460099n 1.8
+    460100n 0
+    460149n 0
+    460150n 1.8
+    460199n 1.8
+    460200n 0
+    460249n 0
+    460250n 1.8
+    460299n 1.8
+    460300n 0
+    460349n 0
+    460350n 1.8
+    460399n 1.8
+    460400n 0
+    460449n 0
+    460450n 1.8
+    460499n 1.8
+    460500n 0
+    460549n 0
+    460550n 1.8
+    460599n 1.8
+    460600n 0
+    460649n 0
+    460650n 1.8
+    460699n 1.8
+    460700n 0
+    460749n 0
+    460750n 1.8
+    460799n 1.8
+    460800n 0
+    460849n 0
+    460850n 1.8
+    460899n 1.8
+    460900n 0
+    460949n 0
+    460950n 1.8
+    460999n 1.8
+    461000n 0
+    461049n 0
+    461050n 1.8
+    461099n 1.8
+    461100n 0
+    461149n 0
+    461150n 1.8
+    461199n 1.8
+    461200n 0
+    461249n 0
+    461250n 1.8
+    461299n 1.8
+    461300n 0
+    461349n 0
+    461350n 1.8
+    461399n 1.8
+    461400n 0
+    461449n 0
+    461450n 1.8
+    461499n 1.8
+    461500n 0
+    461549n 0
+    461550n 1.8
+    461599n 1.8
+    461600n 0
+    461649n 0
+    461650n 1.8
+    461699n 1.8
+    461700n 0
+    461749n 0
+    461750n 1.8
+    461799n 1.8
+    461800n 0
+    461849n 0
+    461850n 1.8
+    461899n 1.8
+    461900n 0
+    461949n 0
+    461950n 1.8
+    461999n 1.8
+    462000n 0
+    462049n 0
+    462050n 1.8
+    462099n 1.8
+    462100n 0
+    462149n 0
+    462150n 1.8
+    462199n 1.8
+    462200n 0
+    462249n 0
+    462250n 1.8
+    462299n 1.8
+    462300n 0
+    462349n 0
+    462350n 1.8
+    462399n 1.8
+    462400n 0
+    462449n 0
+    462450n 1.8
+    462499n 1.8
+    462500n 0
+    462549n 0
+    462550n 1.8
+    462599n 1.8
+    462600n 0
+    462649n 0
+    462650n 1.8
+    462699n 1.8
+    462700n 0
+    462749n 0
+    462750n 1.8
+    462799n 1.8
+    462800n 0
+    462849n 0
+    462850n 1.8
+    462899n 1.8
+    462900n 0
+    462949n 0
+    462950n 1.8
+    462999n 1.8
+    463000n 0
+    463049n 0
+    463050n 1.8
+    463099n 1.8
+    463100n 0
+    463149n 0
+    463150n 1.8
+    463199n 1.8
+    463200n 0
+    463249n 0
+    463250n 1.8
+    463299n 1.8
+    463300n 0
+    463349n 0
+    463350n 1.8
+    463399n 1.8
+    463400n 0
+    463449n 0
+    463450n 1.8
+    463499n 1.8
+    463500n 0
+    463549n 0
+    463550n 1.8
+    463599n 1.8
+    463600n 0
+    463649n 0
+    463650n 1.8
+    463699n 1.8
+    463700n 0
+    463749n 0
+    463750n 1.8
+    463799n 1.8
+    463800n 0
+    463849n 0
+    463850n 1.8
+    463899n 1.8
+    463900n 0
+    463949n 0
+    463950n 1.8
+    463999n 1.8
+    464000n 0
+    464049n 0
+    464050n 1.8
+    464099n 1.8
+    464100n 0
+    464149n 0
+    464150n 1.8
+    464199n 1.8
+    464200n 0
+    464249n 0
+    464250n 1.8
+    464299n 1.8
+    464300n 0
+    464349n 0
+    464350n 1.8
+    464399n 1.8
+    464400n 0
+    464449n 0
+    464450n 1.8
+    464499n 1.8
+    464500n 0
+    464549n 0
+    464550n 1.8
+    464599n 1.8
+    464600n 0
+    464649n 0
+    464650n 1.8
+    464699n 1.8
+    464700n 0
+    464749n 0
+    464750n 1.8
+    464799n 1.8
+    464800n 0
+    464849n 0
+    464850n 1.8
+    464899n 1.8
+    464900n 0
+    464949n 0
+    464950n 1.8
+    464999n 1.8
+    465000n 0
+    465049n 0
+    465050n 1.8
+    465099n 1.8
+    465100n 0
+    465149n 0
+    465150n 1.8
+    465199n 1.8
+    465200n 0
+    465249n 0
+    465250n 1.8
+    465299n 1.8
+    465300n 0
+    465349n 0
+    465350n 1.8
+    465399n 1.8
+    465400n 0
+    465449n 0
+    465450n 1.8
+    465499n 1.8
+    465500n 0
+    465549n 0
+    465550n 1.8
+    465599n 1.8
+    465600n 0
+    465649n 0
+    465650n 1.8
+    465699n 1.8
+    465700n 0
+    465749n 0
+    465750n 1.8
+    465799n 1.8
+    465800n 0
+    465849n 0
+    465850n 1.8
+    465899n 1.8
+    465900n 0
+    465949n 0
+    465950n 1.8
+    465999n 1.8
+    466000n 0
+    466049n 0
+    466050n 1.8
+    466099n 1.8
+    466100n 0
+    466149n 0
+    466150n 1.8
+    466199n 1.8
+    466200n 0
+    466249n 0
+    466250n 1.8
+    466299n 1.8
+    466300n 0
+    466349n 0
+    466350n 1.8
+    466399n 1.8
+    466400n 0
+    466449n 0
+    466450n 1.8
+    466499n 1.8
+    466500n 0
+    466549n 0
+    466550n 1.8
+    466599n 1.8
+    466600n 0
+    466649n 0
+    466650n 1.8
+    466699n 1.8
+    466700n 0
+    466749n 0
+    466750n 1.8
+    466799n 1.8
+    466800n 0
+    466849n 0
+    466850n 1.8
+    466899n 1.8
+    466900n 0
+    466949n 0
+    466950n 1.8
+    466999n 1.8
+    467000n 0
+    467049n 0
+    467050n 1.8
+    467099n 1.8
+    467100n 0
+    467149n 0
+    467150n 1.8
+    467199n 1.8
+    467200n 0
+    467249n 0
+    467250n 1.8
+    467299n 1.8
+    467300n 0
+    467349n 0
+    467350n 1.8
+    467399n 1.8
+    467400n 0
+    467449n 0
+    467450n 1.8
+    467499n 1.8
+    467500n 0
+    467549n 0
+    467550n 1.8
+    467599n 1.8
+    467600n 0
+    467649n 0
+    467650n 1.8
+    467699n 1.8
+    467700n 0
+    467749n 0
+    467750n 1.8
+    467799n 1.8
+    467800n 0
+    467849n 0
+    467850n 1.8
+    467899n 1.8
+    467900n 0
+    467949n 0
+    467950n 1.8
+    467999n 1.8
+    468000n 0
+    468049n 0
+    468050n 1.8
+    468099n 1.8
+    468100n 0
+    468149n 0
+    468150n 1.8
+    468199n 1.8
+    468200n 0
+    468249n 0
+    468250n 1.8
+    468299n 1.8
+    468300n 0
+    468349n 0
+    468350n 1.8
+    468399n 1.8
+    468400n 0
+    468449n 0
+    468450n 1.8
+    468499n 1.8
+    468500n 0
+    468549n 0
+    468550n 1.8
+    468599n 1.8
+    468600n 0
+    468649n 0
+    468650n 1.8
+    468699n 1.8
+    468700n 0
+    468749n 0
+    468750n 1.8
+    468799n 1.8
+    468800n 0
+    468849n 0
+    468850n 1.8
+    468899n 1.8
+    468900n 0
+    468949n 0
+    468950n 1.8
+    468999n 1.8
+    469000n 0
+    469049n 0
+    469050n 1.8
+    469099n 1.8
+    469100n 0
+    469149n 0
+    469150n 1.8
+    469199n 1.8
+    469200n 0
+    469249n 0
+    469250n 1.8
+    469299n 1.8
+    469300n 0
+    469349n 0
+    469350n 1.8
+    469399n 1.8
+    469400n 0
+    469449n 0
+    469450n 1.8
+    469499n 1.8
+    469500n 0
+    469549n 0
+    469550n 1.8
+    469599n 1.8
+    469600n 0
+    469649n 0
+    469650n 1.8
+    469699n 1.8
+    469700n 0
+    469749n 0
+    469750n 1.8
+    469799n 1.8
+    469800n 0
+    469849n 0
+    469850n 1.8
+    469899n 1.8
+    469900n 0
+    469949n 0
+    469950n 1.8
+    469999n 1.8
+    470000n 0
+    470049n 0
+    470050n 1.8
+    470099n 1.8
+    470100n 0
+    470149n 0
+    470150n 1.8
+    470199n 1.8
+    470200n 0
+    470249n 0
+    470250n 1.8
+    470299n 1.8
+    470300n 0
+    470349n 0
+    470350n 1.8
+    470399n 1.8
+    470400n 0
+    470449n 0
+    470450n 1.8
+    470499n 1.8
+    470500n 0
+    470549n 0
+    470550n 1.8
+    470599n 1.8
+    470600n 0
+    470649n 0
+    470650n 1.8
+    470699n 1.8
+    470700n 0
+    470749n 0
+    470750n 1.8
+    470799n 1.8
+    470800n 0
+    470849n 0
+    470850n 1.8
+    470899n 1.8
+    470900n 0
+    470949n 0
+    470950n 1.8
+    470999n 1.8
+    471000n 0
+    471049n 0
+    471050n 1.8
+    471099n 1.8
+    471100n 0
+    471149n 0
+    471150n 1.8
+    471199n 1.8
+    471200n 0
+    471249n 0
+    471250n 1.8
+    471299n 1.8
+    471300n 0
+    471349n 0
+    471350n 1.8
+    471399n 1.8
+    471400n 0
+    471449n 0
+    471450n 1.8
+    471499n 1.8
+    471500n 0
+    471549n 0
+    471550n 1.8
+    471599n 1.8
+    471600n 0
+    471649n 0
+    471650n 1.8
+    471699n 1.8
+    471700n 0
+    471749n 0
+    471750n 1.8
+    471799n 1.8
+    471800n 0
+    471849n 0
+    471850n 1.8
+    471899n 1.8
+    471900n 0
+    471949n 0
+    471950n 1.8
+    471999n 1.8
+    472000n 0
+    472049n 0
+    472050n 1.8
+    472099n 1.8
+    472100n 0
+    472149n 0
+    472150n 1.8
+    472199n 1.8
+    472200n 0
+    472249n 0
+    472250n 1.8
+    472299n 1.8
+    472300n 0
+    472349n 0
+    472350n 1.8
+    472399n 1.8
+    472400n 0
+    472449n 0
+    472450n 1.8
+    472499n 1.8
+    472500n 0
+    472549n 0
+    472550n 1.8
+    472599n 1.8
+    472600n 0
+    472649n 0
+    472650n 1.8
+    472699n 1.8
+    472700n 0
+    472749n 0
+    472750n 1.8
+    472799n 1.8
+    472800n 0
+    472849n 0
+    472850n 1.8
+    472899n 1.8
+    472900n 0
+    472949n 0
+    472950n 1.8
+    472999n 1.8
+    473000n 0
+    473049n 0
+    473050n 1.8
+    473099n 1.8
+    473100n 0
+    473149n 0
+    473150n 1.8
+    473199n 1.8
+    473200n 0
+    473249n 0
+    473250n 1.8
+    473299n 1.8
+    473300n 0
+    473349n 0
+    473350n 1.8
+    473399n 1.8
+    473400n 0
+    473449n 0
+    473450n 1.8
+    473499n 1.8
+    473500n 0
+    473549n 0
+    473550n 1.8
+    473599n 1.8
+    473600n 0
+    473649n 0
+    473650n 1.8
+    473699n 1.8
+    473700n 0
+    473749n 0
+    473750n 1.8
+    473799n 1.8
+    473800n 0
+    473849n 0
+    473850n 1.8
+    473899n 1.8
+    473900n 0
+    473949n 0
+    473950n 1.8
+    473999n 1.8
+    474000n 0
+    474049n 0
+    474050n 1.8
+    474099n 1.8
+    474100n 0
+    474149n 0
+    474150n 1.8
+    474199n 1.8
+    474200n 0
+    474249n 0
+    474250n 1.8
+    474299n 1.8
+    474300n 0
+    474349n 0
+    474350n 1.8
+    474399n 1.8
+    474400n 0
+    474449n 0
+    474450n 1.8
+    474499n 1.8
+    474500n 0
+    474549n 0
+    474550n 1.8
+    474599n 1.8
+    474600n 0
+    474649n 0
+    474650n 1.8
+    474699n 1.8
+    474700n 0
+    474749n 0
+    474750n 1.8
+    474799n 1.8
+    474800n 0
+    474849n 0
+    474850n 1.8
+    474899n 1.8
+    474900n 0
+    474949n 0
+    474950n 1.8
+    474999n 1.8
+    475000n 0
+    475049n 0
+    475050n 1.8
+    475099n 1.8
+    475100n 0
+    475149n 0
+    475150n 1.8
+    475199n 1.8
+    475200n 0
+    475249n 0
+    475250n 1.8
+    475299n 1.8
+    475300n 0
+    475349n 0
+    475350n 1.8
+    475399n 1.8
+    475400n 0
+    475449n 0
+    475450n 1.8
+    475499n 1.8
+    475500n 0
+    475549n 0
+    475550n 1.8
+    475599n 1.8
+    475600n 0
+    475649n 0
+    475650n 1.8
+    475699n 1.8
+    475700n 0
+    475749n 0
+    475750n 1.8
+    475799n 1.8
+    475800n 0
+    475849n 0
+    475850n 1.8
+    475899n 1.8
+    475900n 0
+    475949n 0
+    475950n 1.8
+    475999n 1.8
+    476000n 0
+    476049n 0
+    476050n 1.8
+    476099n 1.8
+    476100n 0
+    476149n 0
+    476150n 1.8
+    476199n 1.8
+    476200n 0
+    476249n 0
+    476250n 1.8
+    476299n 1.8
+    476300n 0
+    476349n 0
+    476350n 1.8
+    476399n 1.8
+    476400n 0
+    476449n 0
+    476450n 1.8
+    476499n 1.8
+    476500n 0
+    476549n 0
+    476550n 1.8
+    476599n 1.8
+    476600n 0
+    476649n 0
+    476650n 1.8
+    476699n 1.8
+    476700n 0
+    476749n 0
+    476750n 1.8
+    476799n 1.8
+    476800n 0
+    476849n 0
+    476850n 1.8
+    476899n 1.8
+    476900n 0
+    476949n 0
+    476950n 1.8
+    476999n 1.8
+    477000n 0
+    477049n 0
+    477050n 1.8
+    477099n 1.8
+    477100n 0
+    477149n 0
+    477150n 1.8
+    477199n 1.8
+    477200n 0
+    477249n 0
+    477250n 1.8
+    477299n 1.8
+    477300n 0
+    477349n 0
+    477350n 1.8
+    477399n 1.8
+    477400n 0
+    477449n 0
+    477450n 1.8
+    477499n 1.8
+    477500n 0
+    477549n 0
+    477550n 1.8
+    477599n 1.8
+    477600n 0
+    477649n 0
+    477650n 1.8
+    477699n 1.8
+    477700n 0
+    477749n 0
+    477750n 1.8
+    477799n 1.8
+    477800n 0
+    477849n 0
+    477850n 1.8
+    477899n 1.8
+    477900n 0
+    477949n 0
+    477950n 1.8
+    477999n 1.8
+    478000n 0
+    478049n 0
+    478050n 1.8
+    478099n 1.8
+    478100n 0
+    478149n 0
+    478150n 1.8
+    478199n 1.8
+    478200n 0
+    478249n 0
+    478250n 1.8
+    478299n 1.8
+    478300n 0
+    478349n 0
+    478350n 1.8
+    478399n 1.8
+    478400n 0
+    478449n 0
+    478450n 1.8
+    478499n 1.8
+    478500n 0
+    478549n 0
+    478550n 1.8
+    478599n 1.8
+    478600n 0
+    478649n 0
+    478650n 1.8
+    478699n 1.8
+    478700n 0
+    478749n 0
+    478750n 1.8
+    478799n 1.8
+    478800n 0
+    478849n 0
+    478850n 1.8
+    478899n 1.8
+    478900n 0
+    478949n 0
+    478950n 1.8
+    478999n 1.8
+    479000n 0
+    479049n 0
+    479050n 1.8
+    479099n 1.8
+    479100n 0
+    479149n 0
+    479150n 1.8
+    479199n 1.8
+    479200n 0
+    479249n 0
+    479250n 1.8
+    479299n 1.8
+    479300n 0
+    479349n 0
+    479350n 1.8
+    479399n 1.8
+    479400n 0
+    479449n 0
+    479450n 1.8
+    479499n 1.8
+    479500n 0
+    479549n 0
+    479550n 1.8
+    479599n 1.8
+    479600n 0
+    479649n 0
+    479650n 1.8
+    479699n 1.8
+    479700n 0
+    479749n 0
+    479750n 1.8
+    479799n 1.8
+    479800n 0
+    479849n 0
+    479850n 1.8
+    479899n 1.8
+    479900n 0
+    479949n 0
+    479950n 1.8
+    479999n 1.8
+    480000n 0
+    480049n 0
+    480050n 1.8
+    480099n 1.8
+    480100n 0
+    480149n 0
+    480150n 1.8
+    480199n 1.8
+    480200n 0
+    480249n 0
+    480250n 1.8
+    480299n 1.8
+    480300n 0
+    480349n 0
+    480350n 1.8
+    480399n 1.8
+    480400n 0
+    480449n 0
+    480450n 1.8
+    480499n 1.8
+    480500n 0
+    480549n 0
+    480550n 1.8
+    480599n 1.8
+    480600n 0
+    480649n 0
+    480650n 1.8
+    480699n 1.8
+    480700n 0
+    480749n 0
+    480750n 1.8
+    480799n 1.8
+    480800n 0
+    480849n 0
+    480850n 1.8
+    480899n 1.8
+    480900n 0
+    480949n 0
+    480950n 1.8
+    480999n 1.8
+    481000n 0
+    481049n 0
+    481050n 1.8
+    481099n 1.8
+    481100n 0
+    481149n 0
+    481150n 1.8
+    481199n 1.8
+    481200n 0
+    481249n 0
+    481250n 1.8
+    481299n 1.8
+    481300n 0
+    481349n 0
+    481350n 1.8
+    481399n 1.8
+    481400n 0
+    481449n 0
+    481450n 1.8
+    481499n 1.8
+    481500n 0
+    481549n 0
+    481550n 1.8
+    481599n 1.8
+    481600n 0
+    481649n 0
+    481650n 1.8
+    481699n 1.8
+    481700n 0
+    481749n 0
+    481750n 1.8
+    481799n 1.8
+    481800n 0
+    481849n 0
+    481850n 1.8
+    481899n 1.8
+    481900n 0
+    481949n 0
+    481950n 1.8
+    481999n 1.8
+    482000n 0
+    482049n 0
+    482050n 1.8
+    482099n 1.8
+    482100n 0
+    482149n 0
+    482150n 1.8
+    482199n 1.8
+    482200n 0
+    482249n 0
+    482250n 1.8
+    482299n 1.8
+    482300n 0
+    482349n 0
+    482350n 1.8
+    482399n 1.8
+    482400n 0
+    482449n 0
+    482450n 1.8
+    482499n 1.8
+    482500n 0
+    482549n 0
+    482550n 1.8
+    482599n 1.8
+    482600n 0
+    482649n 0
+    482650n 1.8
+    482699n 1.8
+    482700n 0
+    482749n 0
+    482750n 1.8
+    482799n 1.8
+    482800n 0
+    482849n 0
+    482850n 1.8
+    482899n 1.8
+    482900n 0
+    482949n 0
+    482950n 1.8
+    482999n 1.8
+    483000n 0
+    483049n 0
+    483050n 1.8
+    483099n 1.8
+    483100n 0
+    483149n 0
+    483150n 1.8
+    483199n 1.8
+    483200n 0
+    483249n 0
+    483250n 1.8
+    483299n 1.8
+    483300n 0
+    483349n 0
+    483350n 1.8
+    483399n 1.8
+    483400n 0
+    483449n 0
+    483450n 1.8
+    483499n 1.8
+    483500n 0
+    483549n 0
+    483550n 1.8
+    483599n 1.8
+    483600n 0
+    483649n 0
+    483650n 1.8
+    483699n 1.8
+    483700n 0
+    483749n 0
+    483750n 1.8
+    483799n 1.8
+    483800n 0
+    483849n 0
+    483850n 1.8
+    483899n 1.8
+    483900n 0
+    483949n 0
+    483950n 1.8
+    483999n 1.8
+    484000n 0
+    484049n 0
+    484050n 1.8
+    484099n 1.8
+    484100n 0
+    484149n 0
+    484150n 1.8
+    484199n 1.8
+    484200n 0
+    484249n 0
+    484250n 1.8
+    484299n 1.8
+    484300n 0
+    484349n 0
+    484350n 1.8
+    484399n 1.8
+    484400n 0
+    484449n 0
+    484450n 1.8
+    484499n 1.8
+    484500n 0
+    484549n 0
+    484550n 1.8
+    484599n 1.8
+    484600n 0
+    484649n 0
+    484650n 1.8
+    484699n 1.8
+    484700n 0
+    484749n 0
+    484750n 1.8
+    484799n 1.8
+    484800n 0
+    484849n 0
+    484850n 1.8
+    484899n 1.8
+    484900n 0
+    484949n 0
+    484950n 1.8
+    484999n 1.8
+    485000n 0
+    485049n 0
+    485050n 1.8
+    485099n 1.8
+    485100n 0
+    485149n 0
+    485150n 1.8
+    485199n 1.8
+    485200n 0
+    485249n 0
+    485250n 1.8
+    485299n 1.8
+    485300n 0
+    485349n 0
+    485350n 1.8
+    485399n 1.8
+    485400n 0
+    485449n 0
+    485450n 1.8
+    485499n 1.8
+    485500n 0
+    485549n 0
+    485550n 1.8
+    485599n 1.8
+    485600n 0
+    485649n 0
+    485650n 1.8
+    485699n 1.8
+    485700n 0
+    485749n 0
+    485750n 1.8
+    485799n 1.8
+    485800n 0
+    485849n 0
+    485850n 1.8
+    485899n 1.8
+    485900n 0
+    485949n 0
+    485950n 1.8
+    485999n 1.8
+    486000n 0
+    486049n 0
+    486050n 1.8
+    486099n 1.8
+    486100n 0
+    486149n 0
+    486150n 1.8
+    486199n 1.8
+    486200n 0
+    486249n 0
+    486250n 1.8
+    486299n 1.8
+    486300n 0
+    486349n 0
+    486350n 1.8
+    486399n 1.8
+    486400n 0
+    486449n 0
+    486450n 1.8
+    486499n 1.8
+    486500n 0
+    486549n 0
+    486550n 1.8
+    486599n 1.8
+    486600n 0
+    486649n 0
+    486650n 1.8
+    486699n 1.8
+    486700n 0
+    486749n 0
+    486750n 1.8
+    486799n 1.8
+    486800n 0
+    486849n 0
+    486850n 1.8
+    486899n 1.8
+    486900n 0
+    486949n 0
+    486950n 1.8
+    486999n 1.8
+    487000n 0
+    487049n 0
+    487050n 1.8
+    487099n 1.8
+    487100n 0
+    487149n 0
+    487150n 1.8
+    487199n 1.8
+    487200n 0
+    487249n 0
+    487250n 1.8
+    487299n 1.8
+    487300n 0
+    487349n 0
+    487350n 1.8
+    487399n 1.8
+    487400n 0
+    487449n 0
+    487450n 1.8
+    487499n 1.8
+    487500n 0
+    487549n 0
+    487550n 1.8
+    487599n 1.8
+    487600n 0
+    487649n 0
+    487650n 1.8
+    487699n 1.8
+    487700n 0
+    487749n 0
+    487750n 1.8
+    487799n 1.8
+    487800n 0
+    487849n 0
+    487850n 1.8
+    487899n 1.8
+    487900n 0
+    487949n 0
+    487950n 1.8
+    487999n 1.8
+    488000n 0
+    488049n 0
+    488050n 1.8
+    488099n 1.8
+    488100n 0
+    488149n 0
+    488150n 1.8
+    488199n 1.8
+    488200n 0
+    488249n 0
+    488250n 1.8
+    488299n 1.8
+    488300n 0
+    488349n 0
+    488350n 1.8
+    488399n 1.8
+    488400n 0
+    488449n 0
+    488450n 1.8
+    488499n 1.8
+    488500n 0
+    488549n 0
+    488550n 1.8
+    488599n 1.8
+    488600n 0
+    488649n 0
+    488650n 1.8
+    488699n 1.8
+    488700n 0
+    488749n 0
+    488750n 1.8
+    488799n 1.8
+    488800n 0
+    488849n 0
+    488850n 1.8
+    488899n 1.8
+    488900n 0
+    488949n 0
+    488950n 1.8
+    488999n 1.8
+    489000n 0
+    489049n 0
+    489050n 1.8
+    489099n 1.8
+    489100n 0
+    489149n 0
+    489150n 1.8
+    489199n 1.8
+    489200n 0
+    489249n 0
+    489250n 1.8
+    489299n 1.8
+    489300n 0
+    489349n 0
+    489350n 1.8
+    489399n 1.8
+    489400n 0
+    489449n 0
+    489450n 1.8
+    489499n 1.8
+    489500n 0
+    489549n 0
+    489550n 1.8
+    489599n 1.8
+    489600n 0
+    489649n 0
+    489650n 1.8
+    489699n 1.8
+    489700n 0
+    489749n 0
+    489750n 1.8
+    489799n 1.8
+    489800n 0
+    489849n 0
+    489850n 1.8
+    489899n 1.8
+    489900n 0
+    489949n 0
+    489950n 1.8
+    489999n 1.8
+    490000n 0
+    490049n 0
+    490050n 1.8
+    490099n 1.8
+    490100n 0
+    490149n 0
+    490150n 1.8
+    490199n 1.8
+    490200n 0
+    490249n 0
+    490250n 1.8
+    490299n 1.8
+    490300n 0
+    490349n 0
+    490350n 1.8
+    490399n 1.8
+    490400n 0
+    490449n 0
+    490450n 1.8
+    490499n 1.8
+    490500n 0
+    490549n 0
+    490550n 1.8
+    490599n 1.8
+    490600n 0
+    490649n 0
+    490650n 1.8
+    490699n 1.8
+    490700n 0
+    490749n 0
+    490750n 1.8
+    490799n 1.8
+    490800n 0
+    490849n 0
+    490850n 1.8
+    490899n 1.8
+    490900n 0
+    490949n 0
+    490950n 1.8
+    490999n 1.8
+    491000n 0
+    491049n 0
+    491050n 1.8
+    491099n 1.8
+    491100n 0
+    491149n 0
+    491150n 1.8
+    491199n 1.8
+    491200n 0
+    491249n 0
+    491250n 1.8
+    491299n 1.8
+    491300n 0
+    491349n 0
+    491350n 1.8
+    491399n 1.8
+    491400n 0
+    491449n 0
+    491450n 1.8
+    491499n 1.8
+    491500n 0
+    491549n 0
+    491550n 1.8
+    491599n 1.8
+    491600n 0
+    491649n 0
+    491650n 1.8
+    491699n 1.8
+    491700n 0
+    491749n 0
+    491750n 1.8
+    491799n 1.8
+    491800n 0
+    491849n 0
+    491850n 1.8
+    491899n 1.8
+    491900n 0
+    491949n 0
+    491950n 1.8
+    491999n 1.8
+    492000n 0
+    492049n 0
+    492050n 1.8
+    492099n 1.8
+    492100n 0
+    492149n 0
+    492150n 1.8
+    492199n 1.8
+    492200n 0
+    492249n 0
+    492250n 1.8
+    492299n 1.8
+    492300n 0
+    492349n 0
+    492350n 1.8
+    492399n 1.8
+    492400n 0
+    492449n 0
+    492450n 1.8
+    492499n 1.8
+    492500n 0
+    492549n 0
+    492550n 1.8
+    492599n 1.8
+    492600n 0
+    492649n 0
+    492650n 1.8
+    492699n 1.8
+    492700n 0
+    492749n 0
+    492750n 1.8
+    492799n 1.8
+    492800n 0
+    492849n 0
+    492850n 1.8
+    492899n 1.8
+    492900n 0
+    492949n 0
+    492950n 1.8
+    492999n 1.8
+    493000n 0
+    493049n 0
+    493050n 1.8
+    493099n 1.8
+    493100n 0
+    493149n 0
+    493150n 1.8
+    493199n 1.8
+    493200n 0
+    493249n 0
+    493250n 1.8
+    493299n 1.8
+    493300n 0
+    493349n 0
+    493350n 1.8
+    493399n 1.8
+    493400n 0
+    493449n 0
+    493450n 1.8
+    493499n 1.8
+    493500n 0
+    493549n 0
+    493550n 1.8
+    493599n 1.8
+    493600n 0
+    493649n 0
+    493650n 1.8
+    493699n 1.8
+    493700n 0
+    493749n 0
+    493750n 1.8
+    493799n 1.8
+    493800n 0
+    493849n 0
+    493850n 1.8
+    493899n 1.8
+    493900n 0
+    493949n 0
+    493950n 1.8
+    493999n 1.8
+    494000n 0
+    494049n 0
+    494050n 1.8
+    494099n 1.8
+    494100n 0
+    494149n 0
+    494150n 1.8
+    494199n 1.8
+    494200n 0
+    494249n 0
+    494250n 1.8
+    494299n 1.8
+    494300n 0
+    494349n 0
+    494350n 1.8
+    494399n 1.8
+    494400n 0
+    494449n 0
+    494450n 1.8
+    494499n 1.8
+    494500n 0
+    494549n 0
+    494550n 1.8
+    494599n 1.8
+    494600n 0
+    494649n 0
+    494650n 1.8
+    494699n 1.8
+    494700n 0
+    494749n 0
+    494750n 1.8
+    494799n 1.8
+    494800n 0
+    494849n 0
+    494850n 1.8
+    494899n 1.8
+    494900n 0
+    494949n 0
+    494950n 1.8
+    494999n 1.8
+    495000n 0
+    495049n 0
+    495050n 1.8
+    495099n 1.8
+    495100n 0
+    495149n 0
+    495150n 1.8
+    495199n 1.8
+    495200n 0
+    495249n 0
+    495250n 1.8
+    495299n 1.8
+    495300n 0
+    495349n 0
+    495350n 1.8
+    495399n 1.8
+    495400n 0
+    495449n 0
+    495450n 1.8
+    495499n 1.8
+    495500n 0
+    495549n 0
+    495550n 1.8
+    495599n 1.8
+    495600n 0
+    495649n 0
+    495650n 1.8
+    495699n 1.8
+    495700n 0
+    495749n 0
+    495750n 1.8
+    495799n 1.8
+    495800n 0
+    495849n 0
+    495850n 1.8
+    495899n 1.8
+    495900n 0
+    495949n 0
+    495950n 1.8
+    495999n 1.8
+    496000n 0
+    496049n 0
+    496050n 1.8
+    496099n 1.8
+    496100n 0
+    496149n 0
+    496150n 1.8
+    496199n 1.8
+    496200n 0
+    496249n 0
+    496250n 1.8
+    496299n 1.8
+    496300n 0
+    496349n 0
+    496350n 1.8
+    496399n 1.8
+    496400n 0
+    496449n 0
+    496450n 1.8
+    496499n 1.8
+    496500n 0
+    496549n 0
+    496550n 1.8
+    496599n 1.8
+    496600n 0
+    496649n 0
+    496650n 1.8
+    496699n 1.8
+    496700n 0
+    496749n 0
+    496750n 1.8
+    496799n 1.8
+    496800n 0
+    496849n 0
+    496850n 1.8
+    496899n 1.8
+    496900n 0
+    496949n 0
+    496950n 1.8
+    496999n 1.8
+    497000n 0
+    497049n 0
+    497050n 1.8
+    497099n 1.8
+    497100n 0
+    497149n 0
+    497150n 1.8
+    497199n 1.8
+    497200n 0
+    497249n 0
+    497250n 1.8
+    497299n 1.8
+    497300n 0
+    497349n 0
+    497350n 1.8
+    497399n 1.8
+    497400n 0
+    497449n 0
+    497450n 1.8
+    497499n 1.8
+    497500n 0
+    497549n 0
+    497550n 1.8
+    497599n 1.8
+    497600n 0
+    497649n 0
+    497650n 1.8
+    497699n 1.8
+    497700n 0
+    497749n 0
+    497750n 1.8
+    497799n 1.8
+    497800n 0
+    497849n 0
+    497850n 1.8
+    497899n 1.8
+    497900n 0
+    497949n 0
+    497950n 1.8
+    497999n 1.8
+    498000n 0
+    498049n 0
+    498050n 1.8
+    498099n 1.8
+    498100n 0
+    498149n 0
+    498150n 1.8
+    498199n 1.8
+    498200n 0
+    498249n 0
+    498250n 1.8
+    498299n 1.8
+    498300n 0
+    498349n 0
+    498350n 1.8
+    498399n 1.8
+    498400n 0
+    498449n 0
+    498450n 1.8
+    498499n 1.8
+    498500n 0
+    498549n 0
+    498550n 1.8
+    498599n 1.8
+    498600n 0
+    498649n 0
+    498650n 1.8
+    498699n 1.8
+    498700n 0
+    498749n 0
+    498750n 1.8
+    498799n 1.8
+    498800n 0
+    498849n 0
+    498850n 1.8
+    498899n 1.8
+    498900n 0
+    498949n 0
+    498950n 1.8
+    498999n 1.8
+    499000n 0
+    499049n 0
+    499050n 1.8
+    499099n 1.8
+    499100n 0
+    499149n 0
+    499150n 1.8
+    499199n 1.8
+    499200n 0
+    499249n 0
+    499250n 1.8
+    499299n 1.8
+    499300n 0
+    499349n 0
+    499350n 1.8
+    499399n 1.8
+    499400n 0
+    499449n 0
+    499450n 1.8
+    499499n 1.8
+    499500n 0
+    499549n 0
+    499550n 1.8
+    499599n 1.8
+    499600n 0
+    499649n 0
+    499650n 1.8
+    499699n 1.8
+    499700n 0
+    499749n 0
+    499750n 1.8
+    499799n 1.8
+    499800n 0
+    499849n 0
+    499850n 1.8
+    499899n 1.8
+    499900n 0
+    499949n 0
+    499950n 1.8
+    499999n 1.8
+    500000n 0
+    500049n 0
+    500050n 1.8
+    500099n 1.8
+    500100n 0
+    500149n 0
+    500150n 1.8
+    500199n 1.8
+    500200n 0
+    500249n 0
+    500250n 1.8
+    500299n 1.8
+    500300n 0
+    500349n 0
+    500350n 1.8
+    500399n 1.8
+    500400n 0
+    500449n 0
+    500450n 1.8
+    500499n 1.8
+    500500n 0
+    500549n 0
+    500550n 1.8
+    500599n 1.8
+    500600n 0
+    500649n 0
+    500650n 1.8
+    500699n 1.8
+    500700n 0
+    500749n 0
+    500750n 1.8
+    500799n 1.8
+    500800n 0
+    500849n 0
+    500850n 1.8
+    500899n 1.8
+    500900n 0
+    500949n 0
+    500950n 1.8
+    500999n 1.8
+    501000n 0
+    501049n 0
+    501050n 1.8
+    501099n 1.8
+    501100n 0
+    501149n 0
+    501150n 1.8
+    501199n 1.8
+    501200n 0
+    501249n 0
+    501250n 1.8
+    501299n 1.8
+    501300n 0
+    501349n 0
+    501350n 1.8
+    501399n 1.8
+    501400n 0
+    501449n 0
+    501450n 1.8
+    501499n 1.8
+    501500n 0
+    501549n 0
+    501550n 1.8
+    501599n 1.8
+    501600n 0
+    501649n 0
+    501650n 1.8
+    501699n 1.8
+    501700n 0
+    501749n 0
+    501750n 1.8
+    501799n 1.8
+    501800n 0
+    501849n 0
+    501850n 1.8
+    501899n 1.8
+    501900n 0
+    501949n 0
+    501950n 1.8
+    501999n 1.8
+    502000n 0
+    502049n 0
+    502050n 1.8
+    502099n 1.8
+    502100n 0
+    502149n 0
+    502150n 1.8
+    502199n 1.8
+    502200n 0
+    502249n 0
+    502250n 1.8
+    502299n 1.8
+    502300n 0
+    502349n 0
+    502350n 1.8
+    502399n 1.8
+    502400n 0
+    502449n 0
+    502450n 1.8
+    502499n 1.8
+    502500n 0
+    502549n 0
+    502550n 1.8
+    502599n 1.8
+    502600n 0
+    502649n 0
+    502650n 1.8
+    502699n 1.8
+    502700n 0
+    502749n 0
+    502750n 1.8
+    502799n 1.8
+    502800n 0
+    502849n 0
+    502850n 1.8
+    502899n 1.8
+    502900n 0
+    502949n 0
+    502950n 1.8
+    502999n 1.8
+    503000n 0
+    503049n 0
+    503050n 1.8
+    503099n 1.8
+    503100n 0
+    503149n 0
+    503150n 1.8
+    503199n 1.8
+    503200n 0
+    503249n 0
+    503250n 1.8
+    503299n 1.8
+    503300n 0
+    503349n 0
+    503350n 1.8
+    503399n 1.8
+    503400n 0
+    503449n 0
+    503450n 1.8
+    503499n 1.8
+    503500n 0
+    503549n 0
+    503550n 1.8
+    503599n 1.8
+    503600n 0
+    503649n 0
+    503650n 1.8
+    503699n 1.8
+    503700n 0
+    503749n 0
+    503750n 1.8
+    503799n 1.8
+    503800n 0
+    503849n 0
+    503850n 1.8
+    503899n 1.8
+    503900n 0
+    503949n 0
+    503950n 1.8
+    503999n 1.8
+    504000n 0
+    504049n 0
+    504050n 1.8
+    504099n 1.8
+    504100n 0
+    504149n 0
+    504150n 1.8
+    504199n 1.8
+    504200n 0
+    504249n 0
+    504250n 1.8
+    504299n 1.8
+    504300n 0
+    504349n 0
+    504350n 1.8
+    504399n 1.8
+    504400n 0
+    504449n 0
+    504450n 1.8
+    504499n 1.8
+    504500n 0
+    504549n 0
+    504550n 1.8
+    504599n 1.8
+    504600n 0
+    504649n 0
+    504650n 1.8
+    504699n 1.8
+    504700n 0
+    504749n 0
+    504750n 1.8
+    504799n 1.8
+    504800n 0
+    504849n 0
+    504850n 1.8
+    504899n 1.8
+    504900n 0
+    504949n 0
+    504950n 1.8
+    504999n 1.8
+    505000n 0
+    505049n 0
+    505050n 1.8
+    505099n 1.8
+    505100n 0
+    505149n 0
+    505150n 1.8
+    505199n 1.8
+    505200n 0
+    505249n 0
+    505250n 1.8
+    505299n 1.8
+    505300n 0
+    505349n 0
+    505350n 1.8
+    505399n 1.8
+    505400n 0
+    505449n 0
+    505450n 1.8
+    505499n 1.8
+    505500n 0
+    505549n 0
+    505550n 1.8
+    505599n 1.8
+    505600n 0
+    505649n 0
+    505650n 1.8
+    505699n 1.8
+    505700n 0
+    505749n 0
+    505750n 1.8
+    505799n 1.8
+    505800n 0
+    505849n 0
+    505850n 1.8
+    505899n 1.8
+    505900n 0
+    505949n 0
+    505950n 1.8
+    505999n 1.8
+    506000n 0
+    506049n 0
+    506050n 1.8
+    506099n 1.8
+    506100n 0
+    506149n 0
+    506150n 1.8
+    506199n 1.8
+    506200n 0
+    506249n 0
+    506250n 1.8
+    506299n 1.8
+    506300n 0
+    506349n 0
+    506350n 1.8
+    506399n 1.8
+    506400n 0
+    506449n 0
+    506450n 1.8
+    506499n 1.8
+    506500n 0
+    506549n 0
+    506550n 1.8
+    506599n 1.8
+    506600n 0
+    506649n 0
+    506650n 1.8
+    506699n 1.8
+    506700n 0
+    506749n 0
+    506750n 1.8
+    506799n 1.8
+    506800n 0
+    506849n 0
+    506850n 1.8
+    506899n 1.8
+    506900n 0
+    506949n 0
+    506950n 1.8
+    506999n 1.8
+    507000n 0
+    507049n 0
+    507050n 1.8
+    507099n 1.8
+    507100n 0
+    507149n 0
+    507150n 1.8
+    507199n 1.8
+    507200n 0
+    507249n 0
+    507250n 1.8
+    507299n 1.8
+    507300n 0
+    507349n 0
+    507350n 1.8
+    507399n 1.8
+    507400n 0
+    507449n 0
+    507450n 1.8
+    507499n 1.8
+    507500n 0
+    507549n 0
+    507550n 1.8
+    507599n 1.8
+    507600n 0
+    507649n 0
+    507650n 1.8
+    507699n 1.8
+    507700n 0
+    507749n 0
+    507750n 1.8
+    507799n 1.8
+    507800n 0
+    507849n 0
+    507850n 1.8
+    507899n 1.8
+    507900n 0
+    507949n 0
+    507950n 1.8
+    507999n 1.8
+    508000n 0
+    508049n 0
+    508050n 1.8
+    508099n 1.8
+    508100n 0
+    508149n 0
+    508150n 1.8
+    508199n 1.8
+    508200n 0
+    508249n 0
+    508250n 1.8
+    508299n 1.8
+    508300n 0
+    508349n 0
+    508350n 1.8
+    508399n 1.8
+    508400n 0
+    508449n 0
+    508450n 1.8
+    508499n 1.8
+    508500n 0
+    508549n 0
+    508550n 1.8
+    508599n 1.8
+    508600n 0
+    508649n 0
+    508650n 1.8
+    508699n 1.8
+    508700n 0
+    508749n 0
+    508750n 1.8
+    508799n 1.8
+    508800n 0
+    508849n 0
+    508850n 1.8
+    508899n 1.8
+    508900n 0
+    508949n 0
+    508950n 1.8
+    508999n 1.8
+    509000n 0
+    509049n 0
+    509050n 1.8
+    509099n 1.8
+    509100n 0
+    509149n 0
+    509150n 1.8
+    509199n 1.8
+    509200n 0
+    509249n 0
+    509250n 1.8
+    509299n 1.8
+    509300n 0
+    509349n 0
+    509350n 1.8
+    509399n 1.8
+    509400n 0
+    509449n 0
+    509450n 1.8
+    509499n 1.8
+    509500n 0
+    509549n 0
+    509550n 1.8
+    509599n 1.8
+    509600n 0
+    509649n 0
+    509650n 1.8
+    509699n 1.8
+    509700n 0
+    509749n 0
+    509750n 1.8
+    509799n 1.8
+    509800n 0
+    509849n 0
+    509850n 1.8
+    509899n 1.8
+    509900n 0
+    509949n 0
+    509950n 1.8
+    509999n 1.8
+    510000n 0
+    510049n 0
+    510050n 1.8
+    510099n 1.8
+    510100n 0
+    510149n 0
+    510150n 1.8
+    510199n 1.8
+    510200n 0
+    510249n 0
+    510250n 1.8
+    510299n 1.8
+    510300n 0
+    510349n 0
+    510350n 1.8
+    510399n 1.8
+    510400n 0
+    510449n 0
+    510450n 1.8
+    510499n 1.8
+    510500n 0
+    510549n 0
+    510550n 1.8
+    510599n 1.8
+    510600n 0
+    510649n 0
+    510650n 1.8
+    510699n 1.8
+    510700n 0
+    510749n 0
+    510750n 1.8
+    510799n 1.8
+    510800n 0
+    510849n 0
+    510850n 1.8
+    510899n 1.8
+    510900n 0
+    510949n 0
+    510950n 1.8
+    510999n 1.8
+    511000n 0
+    511049n 0
+    511050n 1.8
+    511099n 1.8
+    511100n 0
+    511149n 0
+    511150n 1.8
+    511199n 1.8
+    511200n 0
+    511249n 0
+    511250n 1.8
+    511299n 1.8
+    511300n 0
+    511349n 0
+    511350n 1.8
+    511399n 1.8
+    511400n 0
+    511449n 0
+    511450n 1.8
+    511499n 1.8
+    511500n 0
+    511549n 0
+    511550n 1.8
+    511599n 1.8
+    511600n 0
+    511649n 0
+    511650n 1.8
+    511699n 1.8
+    511700n 0
+    511749n 0
+    511750n 1.8
+    511799n 1.8
+    511800n 0
+    511849n 0
+    511850n 1.8
+    511899n 1.8
+    511900n 0
+    511949n 0
+    511950n 1.8
+    511999n 1.8
+    512000n 0
+    512049n 0
+    512050n 1.8
+    512099n 1.8
+    512100n 0
+    512149n 0
+    512150n 1.8
+    512199n 1.8
+    512200n 0
+    512249n 0
+    512250n 1.8
+    512299n 1.8
+    512300n 0
+    512349n 0
+    512350n 1.8
+    512399n 1.8
+    512400n 0
+    512449n 0
+    512450n 1.8
+    512499n 1.8
+    512500n 0
+    512549n 0
+    512550n 1.8
+    512599n 1.8
+    512600n 0
+    512649n 0
+    512650n 1.8
+    512699n 1.8
+    512700n 0
+    512749n 0
+    512750n 1.8
+    512799n 1.8
+    512800n 0
+    512849n 0
+    512850n 1.8
+    512899n 1.8
+    512900n 0
+    512949n 0
+    512950n 1.8
+    512999n 1.8
+    513000n 0
+    513049n 0
+    513050n 1.8
+    513099n 1.8
+    513100n 0
+    513149n 0
+    513150n 1.8
+    513199n 1.8
+    513200n 0
+    513249n 0
+    513250n 1.8
+    513299n 1.8
+    513300n 0
+    513349n 0
+    513350n 1.8
+    513399n 1.8
+    513400n 0
+    513449n 0
+    513450n 1.8
+    513499n 1.8
+    513500n 0
+    513549n 0
+    513550n 1.8
+    513599n 1.8
+    513600n 0
+    513649n 0
+    513650n 1.8
+    513699n 1.8
+    513700n 0
+    513749n 0
+    513750n 1.8
+    513799n 1.8
+    513800n 0
+    513849n 0
+    513850n 1.8
+    513899n 1.8
+    513900n 0
+    513949n 0
+    513950n 1.8
+    513999n 1.8
+    514000n 0
+    514049n 0
+    514050n 1.8
+    514099n 1.8
+    514100n 0
+    514149n 0
+    514150n 1.8
+    514199n 1.8
+    514200n 0
+    514249n 0
+    514250n 1.8
+    514299n 1.8
+    514300n 0
+    514349n 0
+    514350n 1.8
+    514399n 1.8
+    514400n 0
+    514449n 0
+    514450n 1.8
+    514499n 1.8
+    514500n 0
+    514549n 0
+    514550n 1.8
+    514599n 1.8
+    514600n 0
+    514649n 0
+    514650n 1.8
+    514699n 1.8
+    514700n 0
+    514749n 0
+    514750n 1.8
+    514799n 1.8
+    514800n 0
+    514849n 0
+    514850n 1.8
+    514899n 1.8
+    514900n 0
+    514949n 0
+    514950n 1.8
+    514999n 1.8
+    515000n 0
+    515049n 0
+    515050n 1.8
+    515099n 1.8
+    515100n 0
+    515149n 0
+    515150n 1.8
+    515199n 1.8
+    515200n 0
+    515249n 0
+    515250n 1.8
+    515299n 1.8
+    515300n 0
+    515349n 0
+    515350n 1.8
+    515399n 1.8
+    515400n 0
+    515449n 0
+    515450n 1.8
+    515499n 1.8
+    515500n 0
+    515549n 0
+    515550n 1.8
+    515599n 1.8
+    515600n 0
+    515649n 0
+    515650n 1.8
+    515699n 1.8
+    515700n 0
+    515749n 0
+    515750n 1.8
+    515799n 1.8
+    515800n 0
+    515849n 0
+    515850n 1.8
+    515899n 1.8
+    515900n 0
+    515949n 0
+    515950n 1.8
+    515999n 1.8
+    516000n 0
+    516049n 0
+    516050n 1.8
+    516099n 1.8
+    516100n 0
+    516149n 0
+    516150n 1.8
+    516199n 1.8
+    516200n 0
+    516249n 0
+    516250n 1.8
+    516299n 1.8
+    516300n 0
+    516349n 0
+    516350n 1.8
+    516399n 1.8
+    516400n 0
+    516449n 0
+    516450n 1.8
+    516499n 1.8
+    516500n 0
+    516549n 0
+    516550n 1.8
+    516599n 1.8
+    516600n 0
+    516649n 0
+    516650n 1.8
+    516699n 1.8
+    516700n 0
+    516749n 0
+    516750n 1.8
+    516799n 1.8
+    516800n 0
+    516849n 0
+    516850n 1.8
+    516899n 1.8
+    516900n 0
+    516949n 0
+    516950n 1.8
+    516999n 1.8
+    517000n 0
+    517049n 0
+    517050n 1.8
+    517099n 1.8
+    517100n 0
+    517149n 0
+    517150n 1.8
+    517199n 1.8
+    517200n 0
+    517249n 0
+    517250n 1.8
+    517299n 1.8
+    517300n 0
+    517349n 0
+    517350n 1.8
+    517399n 1.8
+    517400n 0
+    517449n 0
+    517450n 1.8
+    517499n 1.8
+    517500n 0
+    517549n 0
+    517550n 1.8
+    517599n 1.8
+    517600n 0
+    517649n 0
+    517650n 1.8
+    517699n 1.8
+    517700n 0
+    517749n 0
+    517750n 1.8
+    517799n 1.8
+    517800n 0
+    517849n 0
+    517850n 1.8
+    517899n 1.8
+    517900n 0
+    517949n 0
+    517950n 1.8
+    517999n 1.8
+    518000n 0
+    518049n 0
+    518050n 1.8
+    518099n 1.8
+    518100n 0
+    518149n 0
+    518150n 1.8
+    518199n 1.8
+    518200n 0
+    518249n 0
+    518250n 1.8
+    518299n 1.8
+    518300n 0
+    518349n 0
+    518350n 1.8
+    518399n 1.8
+    518400n 0
+    518449n 0
+    518450n 1.8
+    518499n 1.8
+    518500n 0
+    518549n 0
+    518550n 1.8
+    518599n 1.8
+    518600n 0
+    518649n 0
+    518650n 1.8
+    518699n 1.8
+    518700n 0
+    518749n 0
+    518750n 1.8
+    518799n 1.8
+    518800n 0
+    518849n 0
+    518850n 1.8
+    518899n 1.8
+    518900n 0
+    518949n 0
+    518950n 1.8
+    518999n 1.8
+    519000n 0
+    519049n 0
+    519050n 1.8
+    519099n 1.8
+    519100n 0
+    519149n 0
+    519150n 1.8
+    519199n 1.8
+    519200n 0
+    519249n 0
+    519250n 1.8
+    519299n 1.8
+    519300n 0
+    519349n 0
+    519350n 1.8
+    519399n 1.8
+    519400n 0
+    519449n 0
+    519450n 1.8
+    519499n 1.8
+    519500n 0
+    519549n 0
+    519550n 1.8
+    519599n 1.8
+    519600n 0
+    519649n 0
+    519650n 1.8
+    519699n 1.8
+    519700n 0
+    519749n 0
+    519750n 1.8
+    519799n 1.8
+    519800n 0
+    519849n 0
+    519850n 1.8
+    519899n 1.8
+    519900n 0
+    519949n 0
+    519950n 1.8
+    519999n 1.8
+    520000n 0
+    520049n 0
+    520050n 1.8
+    520099n 1.8
+    520100n 0
+    520149n 0
+    520150n 1.8
+    520199n 1.8
+    520200n 0
+    520249n 0
+    520250n 1.8
+    520299n 1.8
+    520300n 0
+    520349n 0
+    520350n 1.8
+    520399n 1.8
+    520400n 0
+    520449n 0
+    520450n 1.8
+    520499n 1.8
+    520500n 0
+    520549n 0
+    520550n 1.8
+    520599n 1.8
+    520600n 0
+    520649n 0
+    520650n 1.8
+    520699n 1.8
+    520700n 0
+    520749n 0
+    520750n 1.8
+    520799n 1.8
+    520800n 0
+    520849n 0
+    520850n 1.8
+    520899n 1.8
+    520900n 0
+    520949n 0
+    520950n 1.8
+    520999n 1.8
+    521000n 0
+    521049n 0
+    521050n 1.8
+    521099n 1.8
+    521100n 0
+    521149n 0
+    521150n 1.8
+    521199n 1.8
+    521200n 0
+    521249n 0
+    521250n 1.8
+    521299n 1.8
+    521300n 0
+    521349n 0
+    521350n 1.8
+    521399n 1.8
+    521400n 0
+    521449n 0
+    521450n 1.8
+    521499n 1.8
+    521500n 0
+    521549n 0
+    521550n 1.8
+    521599n 1.8
+    521600n 0
+    521649n 0
+    521650n 1.8
+    521699n 1.8
+    521700n 0
+    521749n 0
+    521750n 1.8
+    521799n 1.8
+    521800n 0
+    521849n 0
+    521850n 1.8
+    521899n 1.8
+    521900n 0
+    521949n 0
+    521950n 1.8
+    521999n 1.8
+    522000n 0
+    522049n 0
+    522050n 1.8
+    522099n 1.8
+    522100n 0
+    522149n 0
+    522150n 1.8
+    522199n 1.8
+    522200n 0
+    522249n 0
+    522250n 1.8
+    522299n 1.8
+    522300n 0
+    522349n 0
+    522350n 1.8
+    522399n 1.8
+    522400n 0
+    522449n 0
+    522450n 1.8
+    522499n 1.8
+    522500n 0
+    522549n 0
+    522550n 1.8
+    522599n 1.8
+    522600n 0
+    522649n 0
+    522650n 1.8
+    522699n 1.8
+    522700n 0
+    522749n 0
+    522750n 1.8
+    522799n 1.8
+    522800n 0
+    522849n 0
+    522850n 1.8
+    522899n 1.8
+    522900n 0
+    522949n 0
+    522950n 1.8
+    522999n 1.8
+    523000n 0
+    523049n 0
+    523050n 1.8
+    523099n 1.8
+    523100n 0
+    523149n 0
+    523150n 1.8
+    523199n 1.8
+    523200n 0
+    523249n 0
+    523250n 1.8
+    523299n 1.8
+    523300n 0
+    523349n 0
+    523350n 1.8
+    523399n 1.8
+    523400n 0
+    523449n 0
+    523450n 1.8
+    523499n 1.8
+    523500n 0
+    523549n 0
+    523550n 1.8
+    523599n 1.8
+    523600n 0
+    523649n 0
+    523650n 1.8
+    523699n 1.8
+    523700n 0
+    523749n 0
+    523750n 1.8
+    523799n 1.8
+    523800n 0
+    523849n 0
+    523850n 1.8
+    523899n 1.8
+    523900n 0
+    523949n 0
+    523950n 1.8
+    523999n 1.8
+    524000n 0
+    524049n 0
+    524050n 1.8
+    524099n 1.8
+    524100n 0
+    524149n 0
+    524150n 1.8
+    524199n 1.8
+    524200n 0
+    524249n 0
+    524250n 1.8
+    524299n 1.8
+    524300n 0
+    524349n 0
+    524350n 1.8
+    524399n 1.8
+    524400n 0
+    524449n 0
+    524450n 1.8
+    524499n 1.8
+    524500n 0
+    524549n 0
+    524550n 1.8
+    524599n 1.8
+    524600n 0
+    524649n 0
+    524650n 1.8
+    524699n 1.8
+    524700n 0
+    524749n 0
+    524750n 1.8
+    524799n 1.8
+    524800n 0
+    524849n 0
+    524850n 1.8
+    524899n 1.8
+    524900n 0
+    524949n 0
+    524950n 1.8
+    524999n 1.8
+    525000n 0
+    525049n 0
+    525050n 1.8
+    525099n 1.8
+    525100n 0
+    525149n 0
+    525150n 1.8
+    525199n 1.8
+    525200n 0
+    525249n 0
+    525250n 1.8
+    525299n 1.8
+    525300n 0
+    525349n 0
+    525350n 1.8
+    525399n 1.8
+    525400n 0
+    525449n 0
+    525450n 1.8
+    525499n 1.8
+    525500n 0
+    525549n 0
+    525550n 1.8
+    525599n 1.8
+    525600n 0
+    525649n 0
+    525650n 1.8
+    525699n 1.8
+    525700n 0
+    525749n 0
+    525750n 1.8
+    525799n 1.8
+    525800n 0
+    525849n 0
+    525850n 1.8
+    525899n 1.8
+    525900n 0
+    525949n 0
+    525950n 1.8
+    525999n 1.8
+    526000n 0
+    526049n 0
+    526050n 1.8
+    526099n 1.8
+    526100n 0
+    526149n 0
+    526150n 1.8
+    526199n 1.8
+    526200n 0
+    526249n 0
+    526250n 1.8
+    526299n 1.8
+    526300n 0
+    526349n 0
+    526350n 1.8
+    526399n 1.8
+    526400n 0
+    526449n 0
+    526450n 1.8
+    526499n 1.8
+    526500n 0
+    526549n 0
+    526550n 1.8
+    526599n 1.8
+    526600n 0
+    526649n 0
+    526650n 1.8
+    526699n 1.8
+    526700n 0
+    526749n 0
+    526750n 1.8
+    526799n 1.8
+    526800n 0
+    526849n 0
+    526850n 1.8
+    526899n 1.8
+    526900n 0
+    526949n 0
+    526950n 1.8
+    526999n 1.8
+    527000n 0
+    527049n 0
+    527050n 1.8
+    527099n 1.8
+    527100n 0
+    527149n 0
+    527150n 1.8
+    527199n 1.8
+    527200n 0
+    527249n 0
+    527250n 1.8
+    527299n 1.8
+    527300n 0
+    527349n 0
+    527350n 1.8
+    527399n 1.8
+    527400n 0
+    527449n 0
+    527450n 1.8
+    527499n 1.8
+    527500n 0
+    527549n 0
+    527550n 1.8
+    527599n 1.8
+    527600n 0
+    527649n 0
+    527650n 1.8
+    527699n 1.8
+    527700n 0
+    527749n 0
+    527750n 1.8
+    527799n 1.8
+    527800n 0
+    527849n 0
+    527850n 1.8
+    527899n 1.8
+    527900n 0
+    527949n 0
+    527950n 1.8
+    527999n 1.8
+    528000n 0
+    528049n 0
+    528050n 1.8
+    528099n 1.8
+    528100n 0
+    528149n 0
+    528150n 1.8
+    528199n 1.8
+    528200n 0
+    528249n 0
+    528250n 1.8
+    528299n 1.8
+    528300n 0
+    528349n 0
+    528350n 1.8
+    528399n 1.8
+    528400n 0
+    528449n 0
+    528450n 1.8
+    528499n 1.8
+    528500n 0
+    528549n 0
+    528550n 1.8
+    528599n 1.8
+    528600n 0
+    528649n 0
+    528650n 1.8
+    528699n 1.8
+    528700n 0
+    528749n 0
+    528750n 1.8
+    528799n 1.8
+    528800n 0
+    528849n 0
+    528850n 1.8
+    528899n 1.8
+    528900n 0
+    528949n 0
+    528950n 1.8
+    528999n 1.8
+    529000n 0
+    529049n 0
+    529050n 1.8
+    529099n 1.8
+    529100n 0
+    529149n 0
+    529150n 1.8
+    529199n 1.8
+    529200n 0
+    529249n 0
+    529250n 1.8
+    529299n 1.8
+    529300n 0
+    529349n 0
+    529350n 1.8
+    529399n 1.8
+    529400n 0
+    529449n 0
+    529450n 1.8
+    529499n 1.8
+    529500n 0
+    529549n 0
+    529550n 1.8
+    529599n 1.8
+    529600n 0
+    529649n 0
+    529650n 1.8
+    529699n 1.8
+    529700n 0
+    529749n 0
+    529750n 1.8
+    529799n 1.8
+    529800n 0
+    529849n 0
+    529850n 1.8
+    529899n 1.8
+    529900n 0
+    529949n 0
+    529950n 1.8
+    529999n 1.8
+    530000n 0
+    530049n 0
+    530050n 1.8
+    530099n 1.8
+    530100n 0
+    530149n 0
+    530150n 1.8
+    530199n 1.8
+    530200n 0
+    530249n 0
+    530250n 1.8
+    530299n 1.8
+    530300n 0
+    530349n 0
+    530350n 1.8
+    530399n 1.8
+    530400n 0
+    530449n 0
+    530450n 1.8
+    530499n 1.8
+    530500n 0
+    530549n 0
+    530550n 1.8
+    530599n 1.8
+    530600n 0
+    530649n 0
+    530650n 1.8
+    530699n 1.8
+    530700n 0
+    530749n 0
+    530750n 1.8
+    530799n 1.8
+    530800n 0
+    530849n 0
+    530850n 1.8
+    530899n 1.8
+    530900n 0
+    530949n 0
+    530950n 1.8
+    530999n 1.8
+    531000n 0
+    531049n 0
+    531050n 1.8
+    531099n 1.8
+    531100n 0
+    531149n 0
+    531150n 1.8
+    531199n 1.8
+    531200n 0
+    531249n 0
+    531250n 1.8
+    531299n 1.8
+    531300n 0
+    531349n 0
+    531350n 1.8
+    531399n 1.8
+    531400n 0
+    531449n 0
+    531450n 1.8
+    531499n 1.8
+    531500n 0
+    531549n 0
+    531550n 1.8
+    531599n 1.8
+    531600n 0
+    531649n 0
+    531650n 1.8
+    531699n 1.8
+    531700n 0
+    531749n 0
+    531750n 1.8
+    531799n 1.8
+    531800n 0
+    531849n 0
+    531850n 1.8
+    531899n 1.8
+    531900n 0
+    531949n 0
+    531950n 1.8
+    531999n 1.8
+    532000n 0
+    532049n 0
+    532050n 1.8
+    532099n 1.8
+    532100n 0
+    532149n 0
+    532150n 1.8
+    532199n 1.8
+    532200n 0
+    532249n 0
+    532250n 1.8
+    532299n 1.8
+    532300n 0
+    532349n 0
+    532350n 1.8
+    532399n 1.8
+    532400n 0
+    532449n 0
+    532450n 1.8
+    532499n 1.8
+    532500n 0
+    532549n 0
+    532550n 1.8
+    532599n 1.8
+    532600n 0
+    532649n 0
+    532650n 1.8
+    532699n 1.8
+    532700n 0
+    532749n 0
+    532750n 1.8
+    532799n 1.8
+    532800n 0
+    532849n 0
+    532850n 1.8
+    532899n 1.8
+    532900n 0
+    532949n 0
+    532950n 1.8
+    532999n 1.8
+    533000n 0
+    533049n 0
+    533050n 1.8
+    533099n 1.8
+    533100n 0
+    533149n 0
+    533150n 1.8
+    533199n 1.8
+    533200n 0
+    533249n 0
+    533250n 1.8
+    533299n 1.8
+    533300n 0
+    533349n 0
+    533350n 1.8
+    533399n 1.8
+    533400n 0
+    533449n 0
+    533450n 1.8
+    533499n 1.8
+    533500n 0
+    533549n 0
+    533550n 1.8
+    533599n 1.8
+    533600n 0
+    533649n 0
+    533650n 1.8
+    533699n 1.8
+    533700n 0
+    533749n 0
+    533750n 1.8
+    533799n 1.8
+    533800n 0
+    533849n 0
+    533850n 1.8
+    533899n 1.8
+    533900n 0
+    533949n 0
+    533950n 1.8
+    533999n 1.8
+    534000n 0
+    534049n 0
+    534050n 1.8
+    534099n 1.8
+    534100n 0
+    534149n 0
+    534150n 1.8
+    534199n 1.8
+    534200n 0
+    534249n 0
+    534250n 1.8
+    534299n 1.8
+    534300n 0
+    534349n 0
+    534350n 1.8
+    534399n 1.8
+    534400n 0
+    534449n 0
+    534450n 1.8
+    534499n 1.8
+    534500n 0
+    534549n 0
+    534550n 1.8
+    534599n 1.8
+    534600n 0
+    534649n 0
+    534650n 1.8
+    534699n 1.8
+    534700n 0
+    534749n 0
+    534750n 1.8
+    534799n 1.8
+    534800n 0
+    534849n 0
+    534850n 1.8
+    534899n 1.8
+    534900n 0
+    534949n 0
+    534950n 1.8
+    534999n 1.8
+    535000n 0
+    535049n 0
+    535050n 1.8
+    535099n 1.8
+    535100n 0
+    535149n 0
+    535150n 1.8
+    535199n 1.8
+    535200n 0
+    535249n 0
+    535250n 1.8
+    535299n 1.8
+    535300n 0
+    535349n 0
+    535350n 1.8
+    535399n 1.8
+    535400n 0
+    535449n 0
+    535450n 1.8
+    535499n 1.8
+    535500n 0
+    535549n 0
+    535550n 1.8
+    535599n 1.8
+    535600n 0
+    535649n 0
+    535650n 1.8
+    535699n 1.8
+    535700n 0
+    535749n 0
+    535750n 1.8
+    535799n 1.8
+    535800n 0
+    535849n 0
+    535850n 1.8
+    535899n 1.8
+    535900n 0
+    535949n 0
+    535950n 1.8
+    535999n 1.8
+    536000n 0
+    536049n 0
+    536050n 1.8
+    536099n 1.8
+    536100n 0
+    536149n 0
+    536150n 1.8
+    536199n 1.8
+    536200n 0
+    536249n 0
+    536250n 1.8
+    536299n 1.8
+    536300n 0
+    536349n 0
+    536350n 1.8
+    536399n 1.8
+    536400n 0
+    536449n 0
+    536450n 1.8
+    536499n 1.8
+    536500n 0
+    536549n 0
+    536550n 1.8
+    536599n 1.8
+    536600n 0
+    536649n 0
+    536650n 1.8
+    536699n 1.8
+    536700n 0
+    536749n 0
+    536750n 1.8
+    536799n 1.8
+    536800n 0
+    536849n 0
+    536850n 1.8
+    536899n 1.8
+    536900n 0
+    536949n 0
+    536950n 1.8
+    536999n 1.8
+    537000n 0
+    537049n 0
+    537050n 1.8
+    537099n 1.8
+    537100n 0
+    537149n 0
+    537150n 1.8
+    537199n 1.8
+    537200n 0
+    537249n 0
+    537250n 1.8
+    537299n 1.8
+    537300n 0
+    537349n 0
+    537350n 1.8
+    537399n 1.8
+    537400n 0
+    537449n 0
+    537450n 1.8
+    537499n 1.8
+    537500n 0
+    537549n 0
+    537550n 1.8
+    537599n 1.8
+    537600n 0
+    537649n 0
+    537650n 1.8
+    537699n 1.8
+    537700n 0
+    537749n 0
+    537750n 1.8
+    537799n 1.8
+    537800n 0
+    537849n 0
+    537850n 1.8
+    537899n 1.8
+    537900n 0
+    537949n 0
+    537950n 1.8
+    537999n 1.8
+    538000n 0
+    538049n 0
+    538050n 1.8
+    538099n 1.8
+    538100n 0
+    538149n 0
+    538150n 1.8
+    538199n 1.8
+    538200n 0
+    538249n 0
+    538250n 1.8
+    538299n 1.8
+    538300n 0
+    538349n 0
+    538350n 1.8
+    538399n 1.8
+    538400n 0
+    538449n 0
+    538450n 1.8
+    538499n 1.8
+    538500n 0
+    538549n 0
+    538550n 1.8
+    538599n 1.8
+    538600n 0
+    538649n 0
+    538650n 1.8
+    538699n 1.8
+    538700n 0
+    538749n 0
+    538750n 1.8
+    538799n 1.8
+    538800n 0
+    538849n 0
+    538850n 1.8
+    538899n 1.8
+    538900n 0
+    538949n 0
+    538950n 1.8
+    538999n 1.8
+    539000n 0
+    539049n 0
+    539050n 1.8
+    539099n 1.8
+    539100n 0
+    539149n 0
+    539150n 1.8
+    539199n 1.8
+    539200n 0
+    539249n 0
+    539250n 1.8
+    539299n 1.8
+    539300n 0
+    539349n 0
+    539350n 1.8
+    539399n 1.8
+    539400n 0
+    539449n 0
+    539450n 1.8
+    539499n 1.8
+    539500n 0
+    539549n 0
+    539550n 1.8
+    539599n 1.8
+    539600n 0
+    539649n 0
+    539650n 1.8
+    539699n 1.8
+    539700n 0
+    539749n 0
+    539750n 1.8
+    539799n 1.8
+    539800n 0
+    539849n 0
+    539850n 1.8
+    539899n 1.8
+    539900n 0
+    539949n 0
+    539950n 1.8
+    539999n 1.8
+    540000n 0
+    540049n 0
+    540050n 1.8
+    540099n 1.8
+    540100n 0
+    540149n 0
+    540150n 1.8
+    540199n 1.8
+    540200n 0
+    540249n 0
+    540250n 1.8
+    540299n 1.8
+    540300n 0
+    540349n 0
+    540350n 1.8
+    540399n 1.8
+    540400n 0
+    540449n 0
+    540450n 1.8
+    540499n 1.8
+    540500n 0
+    540549n 0
+    540550n 1.8
+    540599n 1.8
+    540600n 0
+    540649n 0
+    540650n 1.8
+    540699n 1.8
+    540700n 0
+    540749n 0
+    540750n 1.8
+    540799n 1.8
+    540800n 0
+    540849n 0
+    540850n 1.8
+    540899n 1.8
+    540900n 0
+    540949n 0
+    540950n 1.8
+    540999n 1.8
+    541000n 0
+    541049n 0
+    541050n 1.8
+    541099n 1.8
+    541100n 0
+    541149n 0
+    541150n 1.8
+    541199n 1.8
+    541200n 0
+    541249n 0
+    541250n 1.8
+    541299n 1.8
+    541300n 0
+    541349n 0
+    541350n 1.8
+    541399n 1.8
+    541400n 0
+    541449n 0
+    541450n 1.8
+    541499n 1.8
+    541500n 0
+    541549n 0
+    541550n 1.8
+    541599n 1.8
+    541600n 0
+    541649n 0
+    541650n 1.8
+    541699n 1.8
+    541700n 0
+    541749n 0
+    541750n 1.8
+    541799n 1.8
+    541800n 0
+    541849n 0
+    541850n 1.8
+    541899n 1.8
+    541900n 0
+    541949n 0
+    541950n 1.8
+    541999n 1.8
+    542000n 0
+    542049n 0
+    542050n 1.8
+    542099n 1.8
+    542100n 0
+    542149n 0
+    542150n 1.8
+    542199n 1.8
+    542200n 0
+    542249n 0
+    542250n 1.8
+    542299n 1.8
+    542300n 0
+    542349n 0
+    542350n 1.8
+    542399n 1.8
+    542400n 0
+    542449n 0
+    542450n 1.8
+    542499n 1.8
+    542500n 0
+    542549n 0
+    542550n 1.8
+    542599n 1.8
+    542600n 0
+    542649n 0
+    542650n 1.8
+    542699n 1.8
+    542700n 0
+    542749n 0
+    542750n 1.8
+    542799n 1.8
+    542800n 0
+    542849n 0
+    542850n 1.8
+    542899n 1.8
+    542900n 0
+    542949n 0
+    542950n 1.8
+    542999n 1.8
+    543000n 0
+    543049n 0
+    543050n 1.8
+    543099n 1.8
+    543100n 0
+    543149n 0
+    543150n 1.8
+    543199n 1.8
+    543200n 0
+    543249n 0
+    543250n 1.8
+    543299n 1.8
+    543300n 0
+    543349n 0
+    543350n 1.8
+    543399n 1.8
+    543400n 0
+    543449n 0
+    543450n 1.8
+    543499n 1.8
+    543500n 0
+    543549n 0
+    543550n 1.8
+    543599n 1.8
+    543600n 0
+    543649n 0
+    543650n 1.8
+    543699n 1.8
+    543700n 0
+    543749n 0
+    543750n 1.8
+    543799n 1.8
+    543800n 0
+    543849n 0
+    543850n 1.8
+    543899n 1.8
+    543900n 0
+    543949n 0
+    543950n 1.8
+    543999n 1.8
+    544000n 0
+    544049n 0
+    544050n 1.8
+    544099n 1.8
+    544100n 0
+    544149n 0
+    544150n 1.8
+    544199n 1.8
+    544200n 0
+    544249n 0
+    544250n 1.8
+    544299n 1.8
+    544300n 0
+    544349n 0
+    544350n 1.8
+    544399n 1.8
+    544400n 0
+    544449n 0
+    544450n 1.8
+    544499n 1.8
+    544500n 0
+    544549n 0
+    544550n 1.8
+    544599n 1.8
+    544600n 0
+    544649n 0
+    544650n 1.8
+    544699n 1.8
+    544700n 0
+    544749n 0
+    544750n 1.8
+    544799n 1.8
+    544800n 0
+    544849n 0
+    544850n 1.8
+    544899n 1.8
+    544900n 0
+    544949n 0
+    544950n 1.8
+    544999n 1.8
+    545000n 0
+    545049n 0
+    545050n 1.8
+    545099n 1.8
+    545100n 0
+    545149n 0
+    545150n 1.8
+    545199n 1.8
+    545200n 0
+    545249n 0
+    545250n 1.8
+    545299n 1.8
+    545300n 0
+    545349n 0
+    545350n 1.8
+    545399n 1.8
+    545400n 0
+    545449n 0
+    545450n 1.8
+    545499n 1.8
+    545500n 0
+    545549n 0
+    545550n 1.8
+    545599n 1.8
+    545600n 0
+    545649n 0
+    545650n 1.8
+    545699n 1.8
+    545700n 0
+    545749n 0
+    545750n 1.8
+    545799n 1.8
+    545800n 0
+    545849n 0
+    545850n 1.8
+    545899n 1.8
+    545900n 0
+    545949n 0
+    545950n 1.8
+    545999n 1.8
+    546000n 0
+    546049n 0
+    546050n 1.8
+    546099n 1.8
+    546100n 0
+    546149n 0
+    546150n 1.8
+    546199n 1.8
+    546200n 0
+    546249n 0
+    546250n 1.8
+    546299n 1.8
+    546300n 0
+    546349n 0
+    546350n 1.8
+    546399n 1.8
+    546400n 0
+    546449n 0
+    546450n 1.8
+    546499n 1.8
+    546500n 0
+    546549n 0
+    546550n 1.8
+    546599n 1.8
+    546600n 0
+    546649n 0
+    546650n 1.8
+    546699n 1.8
+    546700n 0
+    546749n 0
+    546750n 1.8
+    546799n 1.8
+    546800n 0
+    546849n 0
+    546850n 1.8
+    546899n 1.8
+    546900n 0
+    546949n 0
+    546950n 1.8
+    546999n 1.8
+    547000n 0
+    547049n 0
+    547050n 1.8
+    547099n 1.8
+    547100n 0
+    547149n 0
+    547150n 1.8
+    547199n 1.8
+    547200n 0
+    547249n 0
+    547250n 1.8
+    547299n 1.8
+    547300n 0
+    547349n 0
+    547350n 1.8
+    547399n 1.8
+    547400n 0
+    547449n 0
+    547450n 1.8
+    547499n 1.8
+    547500n 0
+    547549n 0
+    547550n 1.8
+    547599n 1.8
+    547600n 0
+    547649n 0
+    547650n 1.8
+    547699n 1.8
+    547700n 0
+    547749n 0
+    547750n 1.8
+    547799n 1.8
+    547800n 0
+    547849n 0
+    547850n 1.8
+    547899n 1.8
+    547900n 0
+    547949n 0
+    547950n 1.8
+    547999n 1.8
+    548000n 0
+    548049n 0
+    548050n 1.8
+    548099n 1.8
+    548100n 0
+    548149n 0
+    548150n 1.8
+    548199n 1.8
+    548200n 0
+    548249n 0
+    548250n 1.8
+    548299n 1.8
+    548300n 0
+    548349n 0
+    548350n 1.8
+    548399n 1.8
+    548400n 0
+    548449n 0
+    548450n 1.8
+    548499n 1.8
+    548500n 0
+    548549n 0
+    548550n 1.8
+    548599n 1.8
+    548600n 0
+    548649n 0
+    548650n 1.8
+    548699n 1.8
+    548700n 0
+    548749n 0
+    548750n 1.8
+    548799n 1.8
+    548800n 0
+    548849n 0
+    548850n 1.8
+    548899n 1.8
+    548900n 0
+    548949n 0
+    548950n 1.8
+    548999n 1.8
+    549000n 0
+    549049n 0
+    549050n 1.8
+    549099n 1.8
+    549100n 0
+    549149n 0
+    549150n 1.8
+    549199n 1.8
+    549200n 0
+    549249n 0
+    549250n 1.8
+    549299n 1.8
+    549300n 0
+    549349n 0
+    549350n 1.8
+    549399n 1.8
+    549400n 0
+    549449n 0
+    549450n 1.8
+    549499n 1.8
+    549500n 0
+    549549n 0
+    549550n 1.8
+    549599n 1.8
+    549600n 0
+    549649n 0
+    549650n 1.8
+    549699n 1.8
+    549700n 0
+    549749n 0
+    549750n 1.8
+    549799n 1.8
+    549800n 0
+    549849n 0
+    549850n 1.8
+    549899n 1.8
+    549900n 0
+    549949n 0
+    549950n 1.8
+    549999n 1.8
+    550000n 0
+    550049n 0
+    550050n 1.8
+    550099n 1.8
+    550100n 0
+    550149n 0
+    550150n 1.8
+    550199n 1.8
+    550200n 0
+    550249n 0
+    550250n 1.8
+    550299n 1.8
+    550300n 0
+    550349n 0
+    550350n 1.8
+    550399n 1.8
+    550400n 0
+    550449n 0
+    550450n 1.8
+    550499n 1.8
+    550500n 0
+    550549n 0
+    550550n 1.8
+    550599n 1.8
+    550600n 0
+    550649n 0
+    550650n 1.8
+    550699n 1.8
+    550700n 0
+    550749n 0
+    550750n 1.8
+    550799n 1.8
+    550800n 0
+    550849n 0
+    550850n 1.8
+    550899n 1.8
+    550900n 0
+    550949n 0
+    550950n 1.8
+    550999n 1.8
+    551000n 0
+    551049n 0
+    551050n 1.8
+    551099n 1.8
+    551100n 0
+    551149n 0
+    551150n 1.8
+    551199n 1.8
+    551200n 0
+    551249n 0
+    551250n 1.8
+    551299n 1.8
+    551300n 0
+    551349n 0
+    551350n 1.8
+    551399n 1.8
+    551400n 0
+    551449n 0
+    551450n 1.8
+    551499n 1.8
+    551500n 0
+    551549n 0
+    551550n 1.8
+    551599n 1.8
+    551600n 0
+    551649n 0
+    551650n 1.8
+    551699n 1.8
+    551700n 0
+    551749n 0
+    551750n 1.8
+    551799n 1.8
+    551800n 0
+    551849n 0
+    551850n 1.8
+    551899n 1.8
+    551900n 0
+    551949n 0
+    551950n 1.8
+    551999n 1.8
+    552000n 0
+    552049n 0
+    552050n 1.8
+    552099n 1.8
+    552100n 0
+    552149n 0
+    552150n 1.8
+    552199n 1.8
+    552200n 0
+    552249n 0
+    552250n 1.8
+    552299n 1.8
+    552300n 0
+    552349n 0
+    552350n 1.8
+    552399n 1.8
+    552400n 0
+    552449n 0
+    552450n 1.8
+    552499n 1.8
+    552500n 0
+    552549n 0
+    552550n 1.8
+    552599n 1.8
+    552600n 0
+    552649n 0
+    552650n 1.8
+    552699n 1.8
+    552700n 0
+    552749n 0
+    552750n 1.8
+    552799n 1.8
+    552800n 0
+    552849n 0
+    552850n 1.8
+    552899n 1.8
+    552900n 0
+    552949n 0
+    552950n 1.8
+    552999n 1.8
+    553000n 0
+    553049n 0
+    553050n 1.8
+    553099n 1.8
+    553100n 0
+    553149n 0
+    553150n 1.8
+    553199n 1.8
+    553200n 0
+    553249n 0
+    553250n 1.8
+    553299n 1.8
+    553300n 0
+    553349n 0
+    553350n 1.8
+    553399n 1.8
+    553400n 0
+    553449n 0
+    553450n 1.8
+    553499n 1.8
+    553500n 0
+    553549n 0
+    553550n 1.8
+    553599n 1.8
+    553600n 0
+    553649n 0
+    553650n 1.8
+    553699n 1.8
+    553700n 0
+    553749n 0
+    553750n 1.8
+    553799n 1.8
+    553800n 0
+    553849n 0
+    553850n 1.8
+    553899n 1.8
+    553900n 0
+    553949n 0
+    553950n 1.8
+    553999n 1.8
+    554000n 0
+    554049n 0
+    554050n 1.8
+    554099n 1.8
+    554100n 0
+    554149n 0
+    554150n 1.8
+    554199n 1.8
+    554200n 0
+    554249n 0
+    554250n 1.8
+    554299n 1.8
+    554300n 0
+    554349n 0
+    554350n 1.8
+    554399n 1.8
+    554400n 0
+    554449n 0
+    554450n 1.8
+    554499n 1.8
+    554500n 0
+    554549n 0
+    554550n 1.8
+    554599n 1.8
+    554600n 0
+    554649n 0
+    554650n 1.8
+    554699n 1.8
+    554700n 0
+    554749n 0
+    554750n 1.8
+    554799n 1.8
+    554800n 0
+    554849n 0
+    554850n 1.8
+    554899n 1.8
+    554900n 0
+    554949n 0
+    554950n 1.8
+    554999n 1.8
+    555000n 0
+    555049n 0
+    555050n 1.8
+    555099n 1.8
+    555100n 0
+    555149n 0
+    555150n 1.8
+    555199n 1.8
+    555200n 0
+    555249n 0
+    555250n 1.8
+    555299n 1.8
+    555300n 0
+    555349n 0
+    555350n 1.8
+    555399n 1.8
+    555400n 0
+    555449n 0
+    555450n 1.8
+    555499n 1.8
+    555500n 0
+    555549n 0
+    555550n 1.8
+    555599n 1.8
+    555600n 0
+    555649n 0
+    555650n 1.8
+    555699n 1.8
+    555700n 0
+    555749n 0
+    555750n 1.8
+    555799n 1.8
+    555800n 0
+    555849n 0
+    555850n 1.8
+    555899n 1.8
+    555900n 0
+    555949n 0
+    555950n 1.8
+    555999n 1.8
+    556000n 0
+    556049n 0
+    556050n 1.8
+    556099n 1.8
+    556100n 0
+    556149n 0
+    556150n 1.8
+    556199n 1.8
+    556200n 0
+    556249n 0
+    556250n 1.8
+    556299n 1.8
+    556300n 0
+    556349n 0
+    556350n 1.8
+    556399n 1.8
+    556400n 0
+    556449n 0
+    556450n 1.8
+    556499n 1.8
+    556500n 0
+    556549n 0
+    556550n 1.8
+    556599n 1.8
+    556600n 0
+    556649n 0
+    556650n 1.8
+    556699n 1.8
+    556700n 0
+    556749n 0
+    556750n 1.8
+    556799n 1.8
+    556800n 0
+    556849n 0
+    556850n 1.8
+    556899n 1.8
+    556900n 0
+    556949n 0
+    556950n 1.8
+    556999n 1.8
+    557000n 0
+    557049n 0
+    557050n 1.8
+    557099n 1.8
+    557100n 0
+    557149n 0
+    557150n 1.8
+    557199n 1.8
+    557200n 0
+    557249n 0
+    557250n 1.8
+    557299n 1.8
+    557300n 0
+    557349n 0
+    557350n 1.8
+    557399n 1.8
+    557400n 0
+    557449n 0
+    557450n 1.8
+    557499n 1.8
+    557500n 0
+    557549n 0
+    557550n 1.8
+    557599n 1.8
+    557600n 0
+    557649n 0
+    557650n 1.8
+    557699n 1.8
+    557700n 0
+    557749n 0
+    557750n 1.8
+    557799n 1.8
+    557800n 0
+    557849n 0
+    557850n 1.8
+    557899n 1.8
+    557900n 0
+    557949n 0
+    557950n 1.8
+    557999n 1.8
+    558000n 0
+    558049n 0
+    558050n 1.8
+    558099n 1.8
+    558100n 0
+    558149n 0
+    558150n 1.8
+    558199n 1.8
+    558200n 0
+    558249n 0
+    558250n 1.8
+    558299n 1.8
+    558300n 0
+    558349n 0
+    558350n 1.8
+    558399n 1.8
+    558400n 0
+    558449n 0
+    558450n 1.8
+    558499n 1.8
+    558500n 0
+    558549n 0
+    558550n 1.8
+    558599n 1.8
+    558600n 0
+    558649n 0
+    558650n 1.8
+    558699n 1.8
+    558700n 0
+    558749n 0
+    558750n 1.8
+    558799n 1.8
+    558800n 0
+    558849n 0
+    558850n 1.8
+    558899n 1.8
+    558900n 0
+    558949n 0
+    558950n 1.8
+    558999n 1.8
+    559000n 0
+    559049n 0
+    559050n 1.8
+    559099n 1.8
+    559100n 0
+    559149n 0
+    559150n 1.8
+    559199n 1.8
+    559200n 0
+    559249n 0
+    559250n 1.8
+    559299n 1.8
+    559300n 0
+    559349n 0
+    559350n 1.8
+    559399n 1.8
+    559400n 0
+    559449n 0
+    559450n 1.8
+    559499n 1.8
+    559500n 0
+    559549n 0
+    559550n 1.8
+    559599n 1.8
+    559600n 0
+    559649n 0
+    559650n 1.8
+    559699n 1.8
+    559700n 0
+    559749n 0
+    559750n 1.8
+    559799n 1.8
+    559800n 0
+    559849n 0
+    559850n 1.8
+    559899n 1.8
+    559900n 0
+    559949n 0
+    559950n 1.8
+    559999n 1.8
+    560000n 0
+    560049n 0
+    560050n 1.8
+    560099n 1.8
+    560100n 0
+    560149n 0
+    560150n 1.8
+    560199n 1.8
+    560200n 0
+    560249n 0
+    560250n 1.8
+    560299n 1.8
+    560300n 0
+    560349n 0
+    560350n 1.8
+    560399n 1.8
+    560400n 0
+    560449n 0
+    560450n 1.8
+    560499n 1.8
+    560500n 0
+    560549n 0
+    560550n 1.8
+    560599n 1.8
+    560600n 0
+    560649n 0
+    560650n 1.8
+    560699n 1.8
+    560700n 0
+    560749n 0
+    560750n 1.8
+    560799n 1.8
+    560800n 0
+    560849n 0
+    560850n 1.8
+    560899n 1.8
+    560900n 0
+    560949n 0
+    560950n 1.8
+    560999n 1.8
+    561000n 0
+    561049n 0
+    561050n 1.8
+    561099n 1.8
+    561100n 0
+    561149n 0
+    561150n 1.8
+    561199n 1.8
+    561200n 0
+    561249n 0
+    561250n 1.8
+    561299n 1.8
+    561300n 0
+    561349n 0
+    561350n 1.8
+    561399n 1.8
+    561400n 0
+    561449n 0
+    561450n 1.8
+    561499n 1.8
+    561500n 0
+    561549n 0
+    561550n 1.8
+    561599n 1.8
+    561600n 0
+    561649n 0
+    561650n 1.8
+    561699n 1.8
+    561700n 0
+    561749n 0
+    561750n 1.8
+    561799n 1.8
+    561800n 0
+    561849n 0
+    561850n 1.8
+    561899n 1.8
+    561900n 0
+    561949n 0
+    561950n 1.8
+    561999n 1.8
+    562000n 0
+    562049n 0
+    562050n 1.8
+    562099n 1.8
+    562100n 0
+    562149n 0
+    562150n 1.8
+    562199n 1.8
+    562200n 0
+    562249n 0
+    562250n 1.8
+    562299n 1.8
+    562300n 0
+    562349n 0
+    562350n 1.8
+    562399n 1.8
+    562400n 0
+    562449n 0
+    562450n 1.8
+    562499n 1.8
+    562500n 0
+    562549n 0
+    562550n 1.8
+    562599n 1.8
+    562600n 0
+    562649n 0
+    562650n 1.8
+    562699n 1.8
+    562700n 0
+    562749n 0
+    562750n 1.8
+    562799n 1.8
+    562800n 0
+    562849n 0
+    562850n 1.8
+    562899n 1.8
+    562900n 0
+    562949n 0
+    562950n 1.8
+    562999n 1.8
+    563000n 0
+    563049n 0
+    563050n 1.8
+    563099n 1.8
+    563100n 0
+    563149n 0
+    563150n 1.8
+    563199n 1.8
+    563200n 0
+    563249n 0
+    563250n 1.8
+    563299n 1.8
+    563300n 0
+    563349n 0
+    563350n 1.8
+    563399n 1.8
+    563400n 0
+    563449n 0
+    563450n 1.8
+    563499n 1.8
+    563500n 0
+    563549n 0
+    563550n 1.8
+    563599n 1.8
+    563600n 0
+    563649n 0
+    563650n 1.8
+    563699n 1.8
+    563700n 0
+    563749n 0
+    563750n 1.8
+    563799n 1.8
+    563800n 0
+    563849n 0
+    563850n 1.8
+    563899n 1.8
+    563900n 0
+    563949n 0
+    563950n 1.8
+    563999n 1.8
+    564000n 0
+    564049n 0
+    564050n 1.8
+    564099n 1.8
+    564100n 0
+    564149n 0
+    564150n 1.8
+    564199n 1.8
+    564200n 0
+    564249n 0
+    564250n 1.8
+    564299n 1.8
+    564300n 0
+    564349n 0
+    564350n 1.8
+    564399n 1.8
+    564400n 0
+    564449n 0
+    564450n 1.8
+    564499n 1.8
+    564500n 0
+    564549n 0
+    564550n 1.8
+    564599n 1.8
+    564600n 0
+    564649n 0
+    564650n 1.8
+    564699n 1.8
+    564700n 0
+    564749n 0
+    564750n 1.8
+    564799n 1.8
+    564800n 0
+    564849n 0
+    564850n 1.8
+    564899n 1.8
+    564900n 0
+    564949n 0
+    564950n 1.8
+    564999n 1.8
+    565000n 0
+    565049n 0
+    565050n 1.8
+    565099n 1.8
+    565100n 0
+    565149n 0
+    565150n 1.8
+    565199n 1.8
+    565200n 0
+    565249n 0
+    565250n 1.8
+    565299n 1.8
+    565300n 0
+    565349n 0
+    565350n 1.8
+    565399n 1.8
+    565400n 0
+    565449n 0
+    565450n 1.8
+    565499n 1.8
+    565500n 0
+    565549n 0
+    565550n 1.8
+    565599n 1.8
+    565600n 0
+    565649n 0
+    565650n 1.8
+    565699n 1.8
+    565700n 0
+    565749n 0
+    565750n 1.8
+    565799n 1.8
+    565800n 0
+    565849n 0
+    565850n 1.8
+    565899n 1.8
+    565900n 0
+    565949n 0
+    565950n 1.8
+    565999n 1.8
+    566000n 0
+    566049n 0
+    566050n 1.8
+    566099n 1.8
+    566100n 0
+    566149n 0
+    566150n 1.8
+    566199n 1.8
+    566200n 0
+    566249n 0
+    566250n 1.8
+    566299n 1.8
+    566300n 0
+    566349n 0
+    566350n 1.8
+    566399n 1.8
+    566400n 0
+    566449n 0
+    566450n 1.8
+    566499n 1.8
+    566500n 0
+    566549n 0
+    566550n 1.8
+    566599n 1.8
+    566600n 0
+    566649n 0
+    566650n 1.8
+    566699n 1.8
+    566700n 0
+    566749n 0
+    566750n 1.8
+    566799n 1.8
+    566800n 0
+    566849n 0
+    566850n 1.8
+    566899n 1.8
+    566900n 0
+    566949n 0
+    566950n 1.8
+    566999n 1.8
+    567000n 0
+    567049n 0
+    567050n 1.8
+    567099n 1.8
+    567100n 0
+    567149n 0
+    567150n 1.8
+    567199n 1.8
+    567200n 0
+    567249n 0
+    567250n 1.8
+    567299n 1.8
+    567300n 0
+    567349n 0
+    567350n 1.8
+    567399n 1.8
+    567400n 0
+    567449n 0
+    567450n 1.8
+    567499n 1.8
+    567500n 0
+    567549n 0
+    567550n 1.8
+    567599n 1.8
+    567600n 0
+    567649n 0
+    567650n 1.8
+    567699n 1.8
+    567700n 0
+    567749n 0
+    567750n 1.8
+    567799n 1.8
+    567800n 0
+    567849n 0
+    567850n 1.8
+    567899n 1.8
+    567900n 0
+    567949n 0
+    567950n 1.8
+    567999n 1.8
+    568000n 0
+    568049n 0
+    568050n 1.8
+    568099n 1.8
+    568100n 0
+    568149n 0
+    568150n 1.8
+    568199n 1.8
+    568200n 0
+    568249n 0
+    568250n 1.8
+    568299n 1.8
+    568300n 0
+    568349n 0
+    568350n 1.8
+    568399n 1.8
+    568400n 0
+    568449n 0
+    568450n 1.8
+    568499n 1.8
+    568500n 0
+    568549n 0
+    568550n 1.8
+    568599n 1.8
+    568600n 0
+    568649n 0
+    568650n 1.8
+    568699n 1.8
+    568700n 0
+    568749n 0
+    568750n 1.8
+    568799n 1.8
+    568800n 0
+    568849n 0
+    568850n 1.8
+    568899n 1.8
+    568900n 0
+    568949n 0
+    568950n 1.8
+    568999n 1.8
+    569000n 0
+    569049n 0
+    569050n 1.8
+    569099n 1.8
+    569100n 0
+    569149n 0
+    569150n 1.8
+    569199n 1.8
+    569200n 0
+    569249n 0
+    569250n 1.8
+    569299n 1.8
+    569300n 0
+    569349n 0
+    569350n 1.8
+    569399n 1.8
+    569400n 0
+    569449n 0
+    569450n 1.8
+    569499n 1.8
+    569500n 0
+    569549n 0
+    569550n 1.8
+    569599n 1.8
+    569600n 0
+    569649n 0
+    569650n 1.8
+    569699n 1.8
+    569700n 0
+    569749n 0
+    569750n 1.8
+    569799n 1.8
+    569800n 0
+    569849n 0
+    569850n 1.8
+    569899n 1.8
+    569900n 0
+    569949n 0
+    569950n 1.8
+    569999n 1.8
+    570000n 0
+    570049n 0
+    570050n 1.8
+    570099n 1.8
+    570100n 0
+    570149n 0
+    570150n 1.8
+    570199n 1.8
+    570200n 0
+    570249n 0
+    570250n 1.8
+    570299n 1.8
+    570300n 0
+    570349n 0
+    570350n 1.8
+    570399n 1.8
+    570400n 0
+    570449n 0
+    570450n 1.8
+    570499n 1.8
+    570500n 0
+    570549n 0
+    570550n 1.8
+    570599n 1.8
+    570600n 0
+    570649n 0
+    570650n 1.8
+    570699n 1.8
+    570700n 0
+    570749n 0
+    570750n 1.8
+    570799n 1.8
+    570800n 0
+    570849n 0
+    570850n 1.8
+    570899n 1.8
+    570900n 0
+    570949n 0
+    570950n 1.8
+    570999n 1.8
+    571000n 0
+    571049n 0
+    571050n 1.8
+    571099n 1.8
+    571100n 0
+    571149n 0
+    571150n 1.8
+    571199n 1.8
+    571200n 0
+    571249n 0
+    571250n 1.8
+    571299n 1.8
+    571300n 0
+    571349n 0
+    571350n 1.8
+    571399n 1.8
+    571400n 0
+    571449n 0
+    571450n 1.8
+    571499n 1.8
+    571500n 0
+    571549n 0
+    571550n 1.8
+    571599n 1.8
+    571600n 0
+    571649n 0
+    571650n 1.8
+    571699n 1.8
+    571700n 0
+    571749n 0
+    571750n 1.8
+    571799n 1.8
+    571800n 0
+    571849n 0
+    571850n 1.8
+    571899n 1.8
+    571900n 0
+    571949n 0
+    571950n 1.8
+    571999n 1.8
+    572000n 0
+    572049n 0
+    572050n 1.8
+    572099n 1.8
+    572100n 0
+    572149n 0
+    572150n 1.8
+    572199n 1.8
+    572200n 0
+    572249n 0
+    572250n 1.8
+    572299n 1.8
+    572300n 0
+    572349n 0
+    572350n 1.8
+    572399n 1.8
+    572400n 0
+    572449n 0
+    572450n 1.8
+    572499n 1.8
+    572500n 0
+    572549n 0
+    572550n 1.8
+    572599n 1.8
+    572600n 0
+    572649n 0
+    572650n 1.8
+    572699n 1.8
+    572700n 0
+    572749n 0
+    572750n 1.8
+    572799n 1.8
+    572800n 0
+    572849n 0
+    572850n 1.8
+    572899n 1.8
+    572900n 0
+    572949n 0
+    572950n 1.8
+    572999n 1.8
+    573000n 0
+    573049n 0
+    573050n 1.8
+    573099n 1.8
+    573100n 0
+    573149n 0
+    573150n 1.8
+    573199n 1.8
+    573200n 0
+    573249n 0
+    573250n 1.8
+    573299n 1.8
+    573300n 0
+    573349n 0
+    573350n 1.8
+    573399n 1.8
+    573400n 0
+    573449n 0
+    573450n 1.8
+    573499n 1.8
+    573500n 0
+    573549n 0
+    573550n 1.8
+    573599n 1.8
+    573600n 0
+    573649n 0
+    573650n 1.8
+    573699n 1.8
+    573700n 0
+    573749n 0
+    573750n 1.8
+    573799n 1.8
+    573800n 0
+    573849n 0
+    573850n 1.8
+    573899n 1.8
+    573900n 0
+    573949n 0
+    573950n 1.8
+    573999n 1.8
+    574000n 0
+    574049n 0
+    574050n 1.8
+    574099n 1.8
+    574100n 0
+    574149n 0
+    574150n 1.8
+    574199n 1.8
+    574200n 0
+    574249n 0
+    574250n 1.8
+    574299n 1.8
+    574300n 0
+    574349n 0
+    574350n 1.8
+    574399n 1.8
+    574400n 0
+    574449n 0
+    574450n 1.8
+    574499n 1.8
+    574500n 0
+    574549n 0
+    574550n 1.8
+    574599n 1.8
+    574600n 0
+    574649n 0
+    574650n 1.8
+    574699n 1.8
+    574700n 0
+    574749n 0
+    574750n 1.8
+    574799n 1.8
+    574800n 0
+    574849n 0
+    574850n 1.8
+    574899n 1.8
+    574900n 0
+    574949n 0
+    574950n 1.8
+    574999n 1.8
+    575000n 0
+    575049n 0
+    575050n 1.8
+    575099n 1.8
+    575100n 0
+    575149n 0
+    575150n 1.8
+    575199n 1.8
+    575200n 0
+    575249n 0
+    575250n 1.8
+    575299n 1.8
+    575300n 0
+    575349n 0
+    575350n 1.8
+    575399n 1.8
+    575400n 0
+    575449n 0
+    575450n 1.8
+    575499n 1.8
+    575500n 0
+    575549n 0
+    575550n 1.8
+    575599n 1.8
+    575600n 0
+    575649n 0
+    575650n 1.8
+    575699n 1.8
+    575700n 0
+    575749n 0
+    575750n 1.8
+    575799n 1.8
+    575800n 0
+    575849n 0
+    575850n 1.8
+    575899n 1.8
+    575900n 0
+    575949n 0
+    575950n 1.8
+    575999n 1.8
+    576000n 0
+    576049n 0
+    576050n 1.8
+    576099n 1.8
+    576100n 0
+    576149n 0
+    576150n 1.8
+    576199n 1.8
+    576200n 0
+    576249n 0
+    576250n 1.8
+    576299n 1.8
+    576300n 0
+    576349n 0
+    576350n 1.8
+    576399n 1.8
+    576400n 0
+    576449n 0
+    576450n 1.8
+    576499n 1.8
+    576500n 0
+    576549n 0
+    576550n 1.8
+    576599n 1.8
+    576600n 0
+    576649n 0
+    576650n 1.8
+    576699n 1.8
+    576700n 0
+    576749n 0
+    576750n 1.8
+    576799n 1.8
+    576800n 0
+    576849n 0
+    576850n 1.8
+    576899n 1.8
+    576900n 0
+    576949n 0
+    576950n 1.8
+    576999n 1.8
+    577000n 0
+    577049n 0
+    577050n 1.8
+    577099n 1.8
+    577100n 0
+    577149n 0
+    577150n 1.8
+    577199n 1.8
+    577200n 0
+    577249n 0
+    577250n 1.8
+    577299n 1.8
+    577300n 0
+    577349n 0
+    577350n 1.8
+    577399n 1.8
+    577400n 0
+    577449n 0
+    577450n 1.8
+    577499n 1.8
+    577500n 0
+    577549n 0
+    577550n 1.8
+    577599n 1.8
+    577600n 0
+    577649n 0
+    577650n 1.8
+    577699n 1.8
+    577700n 0
+    577749n 0
+    577750n 1.8
+    577799n 1.8
+    577800n 0
+    577849n 0
+    577850n 1.8
+    577899n 1.8
+    577900n 0
+    577949n 0
+    577950n 1.8
+    577999n 1.8
+    578000n 0
+    578049n 0
+    578050n 1.8
+    578099n 1.8
+    578100n 0
+    578149n 0
+    578150n 1.8
+    578199n 1.8
+    578200n 0
+    578249n 0
+    578250n 1.8
+    578299n 1.8
+    578300n 0
+    578349n 0
+    578350n 1.8
+    578399n 1.8
+    578400n 0
+    578449n 0
+    578450n 1.8
+    578499n 1.8
+    578500n 0
+    578549n 0
+    578550n 1.8
+    578599n 1.8
+    578600n 0
+    578649n 0
+    578650n 1.8
+    578699n 1.8
+    578700n 0
+    578749n 0
+    578750n 1.8
+    578799n 1.8
+    578800n 0
+    578849n 0
+    578850n 1.8
+    578899n 1.8
+    578900n 0
+    578949n 0
+    578950n 1.8
+    578999n 1.8
+    579000n 0
+    579049n 0
+    579050n 1.8
+    579099n 1.8
+    579100n 0
+    579149n 0
+    579150n 1.8
+    579199n 1.8
+    579200n 0
+    579249n 0
+    579250n 1.8
+    579299n 1.8
+    579300n 0
+    579349n 0
+    579350n 1.8
+    579399n 1.8
+    579400n 0
+    579449n 0
+    579450n 1.8
+    579499n 1.8
+    579500n 0
+    579549n 0
+    579550n 1.8
+    579599n 1.8
+    579600n 0
+    579649n 0
+    579650n 1.8
+    579699n 1.8
+    579700n 0
+    579749n 0
+    579750n 1.8
+    579799n 1.8
+    579800n 0
+    579849n 0
+    579850n 1.8
+    579899n 1.8
+    579900n 0
+    579949n 0
+    579950n 1.8
+    579999n 1.8
+    580000n 0
+    580049n 0
+    580050n 1.8
+    580099n 1.8
+    580100n 0
+    580149n 0
+    580150n 1.8
+    580199n 1.8
+    580200n 0
+    580249n 0
+    580250n 1.8
+    580299n 1.8
+    580300n 0
+    580349n 0
+    580350n 1.8
+    580399n 1.8
+    580400n 0
+    580449n 0
+    580450n 1.8
+    580499n 1.8
+    580500n 0
+    580549n 0
+    580550n 1.8
+    580599n 1.8
+    580600n 0
+    580649n 0
+    580650n 1.8
+    580699n 1.8
+    580700n 0
+    580749n 0
+    580750n 1.8
+    580799n 1.8
+    580800n 0
+    580849n 0
+    580850n 1.8
+    580899n 1.8
+    580900n 0
+    580949n 0
+    580950n 1.8
+    580999n 1.8
+    581000n 0
+    581049n 0
+    581050n 1.8
+    581099n 1.8
+    581100n 0
+    581149n 0
+    581150n 1.8
+    581199n 1.8
+    581200n 0
+    581249n 0
+    581250n 1.8
+    581299n 1.8
+    581300n 0
+    581349n 0
+    581350n 1.8
+    581399n 1.8
+    581400n 0
+    581449n 0
+    581450n 1.8
+    581499n 1.8
+    581500n 0
+    581549n 0
+    581550n 1.8
+    581599n 1.8
+    581600n 0
+    581649n 0
+    581650n 1.8
+    581699n 1.8
+    581700n 0
+    581749n 0
+    581750n 1.8
+    581799n 1.8
+    581800n 0
+    581849n 0
+    581850n 1.8
+    581899n 1.8
+    581900n 0
+    581949n 0
+    581950n 1.8
+    581999n 1.8
+    582000n 0
+    582049n 0
+    582050n 1.8
+    582099n 1.8
+    582100n 0
+    582149n 0
+    582150n 1.8
+    582199n 1.8
+    582200n 0
+    582249n 0
+    582250n 1.8
+    582299n 1.8
+    582300n 0
+    582349n 0
+    582350n 1.8
+    582399n 1.8
+    582400n 0
+    582449n 0
+    582450n 1.8
+    582499n 1.8
+    582500n 0
+    582549n 0
+    582550n 1.8
+    582599n 1.8
+    582600n 0
+    582649n 0
+    582650n 1.8
+    582699n 1.8
+    582700n 0
+    582749n 0
+    582750n 1.8
+    582799n 1.8
+    582800n 0
+    582849n 0
+    582850n 1.8
+    582899n 1.8
+    582900n 0
+    582949n 0
+    582950n 1.8
+    582999n 1.8
+    583000n 0
+    583049n 0
+    583050n 1.8
+    583099n 1.8
+    583100n 0
+    583149n 0
+    583150n 1.8
+    583199n 1.8
+    583200n 0
+    583249n 0
+    583250n 1.8
+    583299n 1.8
+    583300n 0
+    583349n 0
+    583350n 1.8
+    583399n 1.8
+    583400n 0
+    583449n 0
+    583450n 1.8
+    583499n 1.8
+    583500n 0
+    583549n 0
+    583550n 1.8
+    583599n 1.8
+    583600n 0
+    583649n 0
+    583650n 1.8
+    583699n 1.8
+    583700n 0
+    583749n 0
+    583750n 1.8
+    583799n 1.8
+    583800n 0
+    583849n 0
+    583850n 1.8
+    583899n 1.8
+    583900n 0
+    583949n 0
+    583950n 1.8
+    583999n 1.8
+    584000n 0
+    584049n 0
+    584050n 1.8
+    584099n 1.8
+    584100n 0
+    584149n 0
+    584150n 1.8
+    584199n 1.8
+    584200n 0
+    584249n 0
+    584250n 1.8
+    584299n 1.8
+    584300n 0
+    584349n 0
+    584350n 1.8
+    584399n 1.8
+    584400n 0
+    584449n 0
+    584450n 1.8
+    584499n 1.8
+    584500n 0
+    584549n 0
+    584550n 1.8
+    584599n 1.8
+    584600n 0
+    584649n 0
+    584650n 1.8
+    584699n 1.8
+    584700n 0
+    584749n 0
+    584750n 1.8
+    584799n 1.8
+    584800n 0
+    584849n 0
+    584850n 1.8
+    584899n 1.8
+    584900n 0
+    584949n 0
+    584950n 1.8
+    584999n 1.8
+    585000n 0
+    585049n 0
+    585050n 1.8
+    585099n 1.8
+    585100n 0
+    585149n 0
+    585150n 1.8
+    585199n 1.8
+    585200n 0
+    585249n 0
+    585250n 1.8
+    585299n 1.8
+    585300n 0
+    585349n 0
+    585350n 1.8
+    585399n 1.8
+    585400n 0
+    585449n 0
+    585450n 1.8
+    585499n 1.8
+    585500n 0
+    585549n 0
+    585550n 1.8
+    585599n 1.8
+    585600n 0
+    585649n 0
+    585650n 1.8
+    585699n 1.8
+    585700n 0
+    585749n 0
+    585750n 1.8
+    585799n 1.8
+    585800n 0
+    585849n 0
+    585850n 1.8
+    585899n 1.8
+    585900n 0
+    585949n 0
+    585950n 1.8
+    585999n 1.8
+    586000n 0
+    586049n 0
+    586050n 1.8
+    586099n 1.8
+    586100n 0
+    586149n 0
+    586150n 1.8
+    586199n 1.8
+    586200n 0
+    586249n 0
+    586250n 1.8
+    586299n 1.8
+    586300n 0
+    586349n 0
+    586350n 1.8
+    586399n 1.8
+    586400n 0
+    586449n 0
+    586450n 1.8
+    586499n 1.8
+    586500n 0
+    586549n 0
+    586550n 1.8
+    586599n 1.8
+    586600n 0
+    586649n 0
+    586650n 1.8
+    586699n 1.8
+    586700n 0
+    586749n 0
+    586750n 1.8
+    586799n 1.8
+    586800n 0
+    586849n 0
+    586850n 1.8
+    586899n 1.8
+    586900n 0
+    586949n 0
+    586950n 1.8
+    586999n 1.8
+    587000n 0
+    587049n 0
+    587050n 1.8
+    587099n 1.8
+    587100n 0
+    587149n 0
+    587150n 1.8
+    587199n 1.8
+    587200n 0
+    587249n 0
+    587250n 1.8
+    587299n 1.8
+    587300n 0
+    587349n 0
+    587350n 1.8
+    587399n 1.8
+    587400n 0
+    587449n 0
+    587450n 1.8
+    587499n 1.8
+    587500n 0
+    587549n 0
+    587550n 1.8
+    587599n 1.8
+    587600n 0
+    587649n 0
+    587650n 1.8
+    587699n 1.8
+    587700n 0
+    587749n 0
+    587750n 1.8
+    587799n 1.8
+    587800n 0
+    587849n 0
+    587850n 1.8
+    587899n 1.8
+    587900n 0
+    587949n 0
+    587950n 1.8
+    587999n 1.8
+    588000n 0
+    588049n 0
+    588050n 1.8
+    588099n 1.8
+    588100n 0
+    588149n 0
+    588150n 1.8
+    588199n 1.8
+    588200n 0
+    588249n 0
+    588250n 1.8
+    588299n 1.8
+    588300n 0
+    588349n 0
+    588350n 1.8
+    588399n 1.8
+    588400n 0
+    588449n 0
+    588450n 1.8
+    588499n 1.8
+    588500n 0
+    588549n 0
+    588550n 1.8
+    588599n 1.8
+    588600n 0
+    588649n 0
+    588650n 1.8
+    588699n 1.8
+    588700n 0
+    588749n 0
+    588750n 1.8
+    588799n 1.8
+    588800n 0
+    588849n 0
+    588850n 1.8
+    588899n 1.8
+    588900n 0
+    588949n 0
+    588950n 1.8
+    588999n 1.8
+    589000n 0
+    589049n 0
+    589050n 1.8
+    589099n 1.8
+    589100n 0
+    589149n 0
+    589150n 1.8
+    589199n 1.8
+    589200n 0
+    589249n 0
+    589250n 1.8
+    589299n 1.8
+    589300n 0
+    589349n 0
+    589350n 1.8
+    589399n 1.8
+    589400n 0
+    589449n 0
+    589450n 1.8
+    589499n 1.8
+    589500n 0
+    589549n 0
+    589550n 1.8
+    589599n 1.8
+    589600n 0
+    589649n 0
+    589650n 1.8
+    589699n 1.8
+    589700n 0
+    589749n 0
+    589750n 1.8
+    589799n 1.8
+    589800n 0
+    589849n 0
+    589850n 1.8
+    589899n 1.8
+    589900n 0
+    589949n 0
+    589950n 1.8
+    589999n 1.8
+    590000n 0
+    590049n 0
+    590050n 1.8
+    590099n 1.8
+    590100n 0
+    590149n 0
+    590150n 1.8
+    590199n 1.8
+    590200n 0
+    590249n 0
+    590250n 1.8
+    590299n 1.8
+    590300n 0
+    590349n 0
+    590350n 1.8
+    590399n 1.8
+    590400n 0
+    590449n 0
+    590450n 1.8
+    590499n 1.8
+    590500n 0
+    590549n 0
+    590550n 1.8
+    590599n 1.8
+    590600n 0
+    590649n 0
+    590650n 1.8
+    590699n 1.8
+    590700n 0
+    590749n 0
+    590750n 1.8
+    590799n 1.8
+    590800n 0
+    590849n 0
+    590850n 1.8
+    590899n 1.8
+    590900n 0
+    590949n 0
+    590950n 1.8
+    590999n 1.8
+    591000n 0
+    591049n 0
+    591050n 1.8
+    591099n 1.8
+    591100n 0
+    591149n 0
+    591150n 1.8
+    591199n 1.8
+    591200n 0
+    591249n 0
+    591250n 1.8
+    591299n 1.8
+    591300n 0
+    591349n 0
+    591350n 1.8
+    591399n 1.8
+    591400n 0
+    591449n 0
+    591450n 1.8
+    591499n 1.8
+    591500n 0
+    591549n 0
+    591550n 1.8
+    591599n 1.8
+    591600n 0
+    591649n 0
+    591650n 1.8
+    591699n 1.8
+    591700n 0
+    591749n 0
+    591750n 1.8
+    591799n 1.8
+    591800n 0
+    591849n 0
+    591850n 1.8
+    591899n 1.8
+    591900n 0
+    591949n 0
+    591950n 1.8
+    591999n 1.8
+    592000n 0
+    592049n 0
+    592050n 1.8
+    592099n 1.8
+    592100n 0
+    592149n 0
+    592150n 1.8
+    592199n 1.8
+    592200n 0
+    592249n 0
+    592250n 1.8
+    592299n 1.8
+    592300n 0
+    592349n 0
+    592350n 1.8
+    592399n 1.8
+    592400n 0
+    592449n 0
+    592450n 1.8
+    592499n 1.8
+    592500n 0
+    592549n 0
+    592550n 1.8
+    592599n 1.8
+    592600n 0
+    592649n 0
+    592650n 1.8
+    592699n 1.8
+    592700n 0
+    592749n 0
+    592750n 1.8
+    592799n 1.8
+    592800n 0
+    592849n 0
+    592850n 1.8
+    592899n 1.8
+    592900n 0
+    592949n 0
+    592950n 1.8
+    592999n 1.8
+    593000n 0
+    593049n 0
+    593050n 1.8
+    593099n 1.8
+    593100n 0
+    593149n 0
+    593150n 1.8
+    593199n 1.8
+    593200n 0
+    593249n 0
+    593250n 1.8
+    593299n 1.8
+    593300n 0
+    593349n 0
+    593350n 1.8
+    593399n 1.8
+    593400n 0
+    593449n 0
+    593450n 1.8
+    593499n 1.8
+    593500n 0
+    593549n 0
+    593550n 1.8
+    593599n 1.8
+    593600n 0
+    593649n 0
+    593650n 1.8
+    593699n 1.8
+    593700n 0
+    593749n 0
+    593750n 1.8
+    593799n 1.8
+    593800n 0
+    593849n 0
+    593850n 1.8
+    593899n 1.8
+    593900n 0
+    593949n 0
+    593950n 1.8
+    593999n 1.8
+    594000n 0
+    594049n 0
+    594050n 1.8
+    594099n 1.8
+    594100n 0
+    594149n 0
+    594150n 1.8
+    594199n 1.8
+    594200n 0
+    594249n 0
+    594250n 1.8
+    594299n 1.8
+    594300n 0
+    594349n 0
+    594350n 1.8
+    594399n 1.8
+    594400n 0
+    594449n 0
+    594450n 1.8
+    594499n 1.8
+    594500n 0
+    594549n 0
+    594550n 1.8
+    594599n 1.8
+    594600n 0
+    594649n 0
+    594650n 1.8
+    594699n 1.8
+    594700n 0
+    594749n 0
+    594750n 1.8
+    594799n 1.8
+    594800n 0
+    594849n 0
+    594850n 1.8
+    594899n 1.8
+    594900n 0
+    594949n 0
+    594950n 1.8
+    594999n 1.8
+    595000n 0
+    595049n 0
+    595050n 1.8
+    595099n 1.8
+    595100n 0
+    595149n 0
+    595150n 1.8
+    595199n 1.8
+    595200n 0
+    595249n 0
+    595250n 1.8
+    595299n 1.8
+    595300n 0
+    595349n 0
+    595350n 1.8
+    595399n 1.8
+    595400n 0
+    595449n 0
+    595450n 1.8
+    595499n 1.8
+    595500n 0
+    595549n 0
+    595550n 1.8
+    595599n 1.8
+    595600n 0
+    595649n 0
+    595650n 1.8
+    595699n 1.8
+    595700n 0
+    595749n 0
+    595750n 1.8
+    595799n 1.8
+    595800n 0
+    595849n 0
+    595850n 1.8
+    595899n 1.8
+    595900n 0
+    595949n 0
+    595950n 1.8
+    595999n 1.8
+    596000n 0
+    596049n 0
+    596050n 1.8
+    596099n 1.8
+    596100n 0
+    596149n 0
+    596150n 1.8
+    596199n 1.8
+    596200n 0
+    596249n 0
+    596250n 1.8
+    596299n 1.8
+    596300n 0
+    596349n 0
+    596350n 1.8
+    596399n 1.8
+    596400n 0
+    596449n 0
+    596450n 1.8
+    596499n 1.8
+    596500n 0
+    596549n 0
+    596550n 1.8
+    596599n 1.8
+    596600n 0
+    596649n 0
+    596650n 1.8
+    596699n 1.8
+    596700n 0
+    596749n 0
+    596750n 1.8
+    596799n 1.8
+    596800n 0
+    596849n 0
+    596850n 1.8
+    596899n 1.8
+    596900n 0
+    596949n 0
+    596950n 1.8
+    596999n 1.8
+    597000n 0
+    597049n 0
+    597050n 1.8
+    597099n 1.8
+    597100n 0
+    597149n 0
+    597150n 1.8
+    597199n 1.8
+    597200n 0
+    597249n 0
+    597250n 1.8
+    597299n 1.8
+    597300n 0
+    597349n 0
+    597350n 1.8
+    597399n 1.8
+    597400n 0
+    597449n 0
+    597450n 1.8
+    597499n 1.8
+    597500n 0
+    597549n 0
+    597550n 1.8
+    597599n 1.8
+    597600n 0
+    597649n 0
+    597650n 1.8
+    597699n 1.8
+    597700n 0
+    597749n 0
+    597750n 1.8
+    597799n 1.8
+    597800n 0
+    597849n 0
+    597850n 1.8
+    597899n 1.8
+    597900n 0
+    597949n 0
+    597950n 1.8
+    597999n 1.8
+    598000n 0
+    598049n 0
+    598050n 1.8
+    598099n 1.8
+    598100n 0
+    598149n 0
+    598150n 1.8
+    598199n 1.8
+    598200n 0
+    598249n 0
+    598250n 1.8
+    598299n 1.8
+    598300n 0
+    598349n 0
+    598350n 1.8
+    598399n 1.8
+    598400n 0
+    598449n 0
+    598450n 1.8
+    598499n 1.8
+    598500n 0
+    598549n 0
+    598550n 1.8
+    598599n 1.8
+    598600n 0
+    598649n 0
+    598650n 1.8
+    598699n 1.8
+    598700n 0
+    598749n 0
+    598750n 1.8
+    598799n 1.8
+    598800n 0
+    598849n 0
+    598850n 1.8
+    598899n 1.8
+    598900n 0
+    598949n 0
+    598950n 1.8
+    598999n 1.8
+    599000n 0
+    599049n 0
+    599050n 1.8
+    599099n 1.8
+    599100n 0
+    599149n 0
+    599150n 1.8
+    599199n 1.8
+    599200n 0
+    599249n 0
+    599250n 1.8
+    599299n 1.8
+    599300n 0
+    599349n 0
+    599350n 1.8
+    599399n 1.8
+    599400n 0
+    599449n 0
+    599450n 1.8
+    599499n 1.8
+    599500n 0
+    599549n 0
+    599550n 1.8
+    599599n 1.8
+    599600n 0
+    599649n 0
+    599650n 1.8
+    599699n 1.8
+    599700n 0
+    599749n 0
+    599750n 1.8
+    599799n 1.8
+    599800n 0
+    599849n 0
+    599850n 1.8
+    599899n 1.8
+    599900n 0
+    599949n 0
+    599950n 1.8
+    599999n 1.8
+    600000n 0
+    600049n 0
+    600050n 1.8
+    600099n 1.8
+    600100n 0
+    600149n 0
+    600150n 1.8
+    600199n 1.8
+    600200n 0
+    600249n 0
+    600250n 1.8
+    600299n 1.8
+    600300n 0
+    600349n 0
+    600350n 1.8
+    600399n 1.8
+    600400n 0
+    600449n 0
+    600450n 1.8
+    600499n 1.8
+    600500n 0
+    600549n 0
+    600550n 1.8
+    600599n 1.8
+    600600n 0
+    600649n 0
+    600650n 1.8
+    600699n 1.8
+    600700n 0
+    600749n 0
+    600750n 1.8
+    600799n 1.8
+    600800n 0
+    600849n 0
+    600850n 1.8
+    600899n 1.8
+    600900n 0
+    600949n 0
+    600950n 1.8
+    600999n 1.8
+    601000n 0
+    601049n 0
+    601050n 1.8
+    601099n 1.8
+    601100n 0
+    601149n 0
+    601150n 1.8
+    601199n 1.8
+    601200n 0
+    601249n 0
+    601250n 1.8
+    601299n 1.8
+    601300n 0
+    601349n 0
+    601350n 1.8
+    601399n 1.8
+    601400n 0
+    601449n 0
+    601450n 1.8
+    601499n 1.8
+    601500n 0
+    601549n 0
+    601550n 1.8
+    601599n 1.8
+    601600n 0
+    601649n 0
+    601650n 1.8
+    601699n 1.8
+    601700n 0
+    601749n 0
+    601750n 1.8
+    601799n 1.8
+    601800n 0
+    601849n 0
+    601850n 1.8
+    601899n 1.8
+    601900n 0
+    601949n 0
+    601950n 1.8
+    601999n 1.8
+    602000n 0
+    602049n 0
+    602050n 1.8
+    602099n 1.8
+    602100n 0
+    602149n 0
+    602150n 1.8
+    602199n 1.8
+    602200n 0
+    602249n 0
+    602250n 1.8
+    602299n 1.8
+    602300n 0
+    602349n 0
+    602350n 1.8
+    602399n 1.8
+    602400n 0
+    602449n 0
+    602450n 1.8
+    602499n 1.8
+    602500n 0
+    602549n 0
+    602550n 1.8
+    602599n 1.8
+    602600n 0
+    602649n 0
+    602650n 1.8
+    602699n 1.8
+    602700n 0
+    602749n 0
+    602750n 1.8
+    602799n 1.8
+    602800n 0
+    602849n 0
+    602850n 1.8
+    602899n 1.8
+    602900n 0
+    602949n 0
+    602950n 1.8
+    602999n 1.8
+    603000n 0
+    603049n 0
+    603050n 1.8
+    603099n 1.8
+    603100n 0
+    603149n 0
+    603150n 1.8
+    603199n 1.8
+    603200n 0
+    603249n 0
+    603250n 1.8
+    603299n 1.8
+    603300n 0
+    603349n 0
+    603350n 1.8
+    603399n 1.8
+    603400n 0
+    603449n 0
+    603450n 1.8
+    603499n 1.8
+    603500n 0
+    603549n 0
+    603550n 1.8
+    603599n 1.8
+    603600n 0
+    603649n 0
+    603650n 1.8
+    603699n 1.8
+    603700n 0
+    603749n 0
+    603750n 1.8
+    603799n 1.8
+    603800n 0
+    603849n 0
+    603850n 1.8
+    603899n 1.8
+    603900n 0
+    603949n 0
+    603950n 1.8
+    603999n 1.8
+    604000n 0
+    604049n 0
+    604050n 1.8
+    604099n 1.8
+    604100n 0
+    604149n 0
+    604150n 1.8
+    604199n 1.8
+    604200n 0
+    604249n 0
+    604250n 1.8
+    604299n 1.8
+    604300n 0
+    604349n 0
+    604350n 1.8
+    604399n 1.8
+    604400n 0
+    604449n 0
+    604450n 1.8
+    604499n 1.8
+    604500n 0
+    604549n 0
+    604550n 1.8
+    604599n 1.8
+    604600n 0
+    604649n 0
+    604650n 1.8
+    604699n 1.8
+    604700n 0
+    604749n 0
+    604750n 1.8
+    604799n 1.8
+    604800n 0
+    604849n 0
+    604850n 1.8
+    604899n 1.8
+    604900n 0
+    604949n 0
+    604950n 1.8
+    604999n 1.8
+    605000n 0
+    605049n 0
+    605050n 1.8
+    605099n 1.8
+    605100n 0
+    605149n 0
+    605150n 1.8
+    605199n 1.8
+    605200n 0
+    605249n 0
+    605250n 1.8
+    605299n 1.8
+    605300n 0
+    605349n 0
+    605350n 1.8
+    605399n 1.8
+    605400n 0
+    605449n 0
+    605450n 1.8
+    605499n 1.8
+    605500n 0
+    605549n 0
+    605550n 1.8
+    605599n 1.8
+    605600n 0
+    605649n 0
+    605650n 1.8
+    605699n 1.8
+    605700n 0
+    605749n 0
+    605750n 1.8
+    605799n 1.8
+    605800n 0
+    605849n 0
+    605850n 1.8
+    605899n 1.8
+    605900n 0
+    605949n 0
+    605950n 1.8
+    605999n 1.8
+    606000n 0
+    606049n 0
+    606050n 1.8
+    606099n 1.8
+    606100n 0
+    606149n 0
+    606150n 1.8
+    606199n 1.8
+    606200n 0
+    606249n 0
+    606250n 1.8
+    606299n 1.8
+    606300n 0
+    606349n 0
+    606350n 1.8
+    606399n 1.8
+    606400n 0
+    606449n 0
+    606450n 1.8
+    606499n 1.8
+    606500n 0
+    606549n 0
+    606550n 1.8
+    606599n 1.8
+    606600n 0
+    606649n 0
+    606650n 1.8
+    606699n 1.8
+    606700n 0
+    606749n 0
+    606750n 1.8
+    606799n 1.8
+    606800n 0
+    606849n 0
+    606850n 1.8
+    606899n 1.8
+    606900n 0
+    606949n 0
+    606950n 1.8
+    606999n 1.8
+    607000n 0
+    607049n 0
+    607050n 1.8
+    607099n 1.8
+    607100n 0
+    607149n 0
+    607150n 1.8
+    607199n 1.8
+    607200n 0
+    607249n 0
+    607250n 1.8
+    607299n 1.8
+    607300n 0
+    607349n 0
+    607350n 1.8
+    607399n 1.8
+    607400n 0
+    607449n 0
+    607450n 1.8
+    607499n 1.8
+    607500n 0
+    607549n 0
+    607550n 1.8
+    607599n 1.8
+    607600n 0
+    607649n 0
+    607650n 1.8
+    607699n 1.8
+    607700n 0
+    607749n 0
+    607750n 1.8
+    607799n 1.8
+    607800n 0
+    607849n 0
+    607850n 1.8
+    607899n 1.8
+    607900n 0
+    607949n 0
+    607950n 1.8
+    607999n 1.8
+    608000n 0
+    608049n 0
+    608050n 1.8
+    608099n 1.8
+    608100n 0
+    608149n 0
+    608150n 1.8
+    608199n 1.8
+    608200n 0
+    608249n 0
+    608250n 1.8
+    608299n 1.8
+    608300n 0
+    608349n 0
+    608350n 1.8
+    608399n 1.8
+    608400n 0
+    608449n 0
+    608450n 1.8
+    608499n 1.8
+    608500n 0
+    608549n 0
+    608550n 1.8
+    608599n 1.8
+    608600n 0
+    608649n 0
+    608650n 1.8
+    608699n 1.8
+    608700n 0
+    608749n 0
+    608750n 1.8
+    608799n 1.8
+    608800n 0
+    608849n 0
+    608850n 1.8
+    608899n 1.8
+    608900n 0
+    608949n 0
+    608950n 1.8
+    608999n 1.8
+    609000n 0
+    609049n 0
+    609050n 1.8
+    609099n 1.8
+    609100n 0
+    609149n 0
+    609150n 1.8
+    609199n 1.8
+    609200n 0
+    609249n 0
+    609250n 1.8
+    609299n 1.8
+    609300n 0
+    609349n 0
+    609350n 1.8
+    609399n 1.8
+    609400n 0
+    609449n 0
+    609450n 1.8
+    609499n 1.8
+    609500n 0
+    609549n 0
+    609550n 1.8
+    609599n 1.8
+    609600n 0
+    609649n 0
+    609650n 1.8
+    609699n 1.8
+    609700n 0
+    609749n 0
+    609750n 1.8
+    609799n 1.8
+    609800n 0
+    609849n 0
+    609850n 1.8
+    609899n 1.8
+    609900n 0
+    609949n 0
+    609950n 1.8
+    609999n 1.8
+    610000n 0
+    610049n 0
+    610050n 1.8
+    610099n 1.8
+    610100n 0
+    610149n 0
+    610150n 1.8
+    610199n 1.8
+    610200n 0
+    610249n 0
+    610250n 1.8
+    610299n 1.8
+    610300n 0
+    610349n 0
+    610350n 1.8
+    610399n 1.8
+    610400n 0
+    610449n 0
+    610450n 1.8
+    610499n 1.8
+    610500n 0
+    610549n 0
+    610550n 1.8
+    610599n 1.8
+    610600n 0
+    610649n 0
+    610650n 1.8
+    610699n 1.8
+    610700n 0
+    610749n 0
+    610750n 1.8
+    610799n 1.8
+    610800n 0
+    610849n 0
+    610850n 1.8
+    610899n 1.8
+    610900n 0
+    610949n 0
+    610950n 1.8
+    610999n 1.8
+    611000n 0
+    611049n 0
+    611050n 1.8
+    611099n 1.8
+    611100n 0
+    611149n 0
+    611150n 1.8
+    611199n 1.8
+    611200n 0
+    611249n 0
+    611250n 1.8
+    611299n 1.8
+    611300n 0
+    611349n 0
+    611350n 1.8
+    611399n 1.8
+    611400n 0
+    611449n 0
+    611450n 1.8
+    611499n 1.8
+    611500n 0
+    611549n 0
+    611550n 1.8
+    611599n 1.8
+    611600n 0
+    611649n 0
+    611650n 1.8
+    611699n 1.8
+    611700n 0
+    611749n 0
+    611750n 1.8
+    611799n 1.8
+    611800n 0
+    611849n 0
+    611850n 1.8
+    611899n 1.8
+    611900n 0
+    611949n 0
+    611950n 1.8
+    611999n 1.8
+    612000n 0
+    612049n 0
+    612050n 1.8
+    612099n 1.8
+    612100n 0
+    612149n 0
+    612150n 1.8
+    612199n 1.8
+    612200n 0
+    612249n 0
+    612250n 1.8
+    612299n 1.8
+    612300n 0
+    612349n 0
+    612350n 1.8
+    612399n 1.8
+    612400n 0
+    612449n 0
+    612450n 1.8
+    612499n 1.8
+    612500n 0
+    612549n 0
+    612550n 1.8
+    612599n 1.8
+    612600n 0
+    612649n 0
+    612650n 1.8
+    612699n 1.8
+    612700n 0
+    612749n 0
+    612750n 1.8
+    612799n 1.8
+    612800n 0
+    612849n 0
+    612850n 1.8
+    612899n 1.8
+    612900n 0
+    612949n 0
+    612950n 1.8
+    612999n 1.8
+    613000n 0
+    613049n 0
+    613050n 1.8
+    613099n 1.8
+    613100n 0
+    613149n 0
+    613150n 1.8
+    613199n 1.8
+    613200n 0
+    613249n 0
+    613250n 1.8
+    613299n 1.8
+    613300n 0
+    613349n 0
+    613350n 1.8
+    613399n 1.8
+    613400n 0
+    613449n 0
+    613450n 1.8
+    613499n 1.8
+    613500n 0
+    613549n 0
+    613550n 1.8
+    613599n 1.8
+    613600n 0
+    613649n 0
+    613650n 1.8
+    613699n 1.8
+    613700n 0
+    613749n 0
+    613750n 1.8
+    613799n 1.8
+    613800n 0
+    613849n 0
+    613850n 1.8
+    613899n 1.8
+    613900n 0
+    613949n 0
+    613950n 1.8
+    613999n 1.8
+    614000n 0
+    614049n 0
+    614050n 1.8
+    614099n 1.8
+    614100n 0
+    614149n 0
+    614150n 1.8
+    614199n 1.8
+    614200n 0
+    614249n 0
+    614250n 1.8
+    614299n 1.8
+    614300n 0
+    614349n 0
+    614350n 1.8
+    614399n 1.8
+    614400n 0
+    614449n 0
+    614450n 1.8
+    614499n 1.8
+    614500n 0
+    614549n 0
+    614550n 1.8
+    614599n 1.8
+    614600n 0
+    614649n 0
+    614650n 1.8
+    614699n 1.8
+    614700n 0
+    614749n 0
+    614750n 1.8
+    614799n 1.8
+    614800n 0
+    614849n 0
+    614850n 1.8
+    614899n 1.8
+    614900n 0
+    614949n 0
+    614950n 1.8
+    614999n 1.8
+    615000n 0
+    615049n 0
+    615050n 1.8
+    615099n 1.8
+    615100n 0
+    615149n 0
+    615150n 1.8
+    615199n 1.8
+    615200n 0
+    615249n 0
+    615250n 1.8
+    615299n 1.8
+    615300n 0
+    615349n 0
+    615350n 1.8
+    615399n 1.8
+    615400n 0
+    615449n 0
+    615450n 1.8
+    615499n 1.8
+    615500n 0
+    615549n 0
+    615550n 1.8
+    615599n 1.8
+    615600n 0
+    615649n 0
+    615650n 1.8
+    615699n 1.8
+    615700n 0
+    615749n 0
+    615750n 1.8
+    615799n 1.8
+    615800n 0
+    615849n 0
+    615850n 1.8
+    615899n 1.8
+    615900n 0
+    615949n 0
+    615950n 1.8
+    615999n 1.8
+    616000n 0
+    616049n 0
+    616050n 1.8
+    616099n 1.8
+    616100n 0
+    616149n 0
+    616150n 1.8
+    616199n 1.8
+    616200n 0
+    616249n 0
+    616250n 1.8
+    616299n 1.8
+    616300n 0
+    616349n 0
+    616350n 1.8
+    616399n 1.8
+    616400n 0
+    616449n 0
+    616450n 1.8
+    616499n 1.8
+    616500n 0
+    616549n 0
+    616550n 1.8
+    616599n 1.8
+    616600n 0
+    616649n 0
+    616650n 1.8
+    616699n 1.8
+    616700n 0
+    616749n 0
+    616750n 1.8
+    616799n 1.8
+    616800n 0
+    616849n 0
+    616850n 1.8
+    616899n 1.8
+    616900n 0
+    616949n 0
+    616950n 1.8
+    616999n 1.8
+    617000n 0
+    617049n 0
+    617050n 1.8
+    617099n 1.8
+    617100n 0
+    617149n 0
+    617150n 1.8
+    617199n 1.8
+    617200n 0
+    617249n 0
+    617250n 1.8
+    617299n 1.8
+    617300n 0
+    617349n 0
+    617350n 1.8
+    617399n 1.8
+    617400n 0
+    617449n 0
+    617450n 1.8
+    617499n 1.8
+    617500n 0
+    617549n 0
+    617550n 1.8
+    617599n 1.8
+    617600n 0
+    617649n 0
+    617650n 1.8
+    617699n 1.8
+    617700n 0
+    617749n 0
+    617750n 1.8
+    617799n 1.8
+    617800n 0
+    617849n 0
+    617850n 1.8
+    617899n 1.8
+    617900n 0
+    617949n 0
+    617950n 1.8
+    617999n 1.8
+    618000n 0
+    618049n 0
+    618050n 1.8
+    618099n 1.8
+    618100n 0
+    618149n 0
+    618150n 1.8
+    618199n 1.8
+    618200n 0
+    618249n 0
+    618250n 1.8
+    618299n 1.8
+    618300n 0
+    618349n 0
+    618350n 1.8
+    618399n 1.8
+    618400n 0
+    618449n 0
+    618450n 1.8
+    618499n 1.8
+    618500n 0
+    618549n 0
+    618550n 1.8
+    618599n 1.8
+    618600n 0
+    618649n 0
+    618650n 1.8
+    618699n 1.8
+    618700n 0
+    618749n 0
+    618750n 1.8
+    618799n 1.8
+    618800n 0
+    618849n 0
+    618850n 1.8
+    618899n 1.8
+    618900n 0
+    618949n 0
+    618950n 1.8
+    618999n 1.8
+    619000n 0
+    619049n 0
+    619050n 1.8
+    619099n 1.8
+    619100n 0
+    619149n 0
+    619150n 1.8
+    619199n 1.8
+    619200n 0
+    619249n 0
+    619250n 1.8
+    619299n 1.8
+    619300n 0
+    619349n 0
+    619350n 1.8
+    619399n 1.8
+    619400n 0
+    619449n 0
+    619450n 1.8
+    619499n 1.8
+    619500n 0
+    619549n 0
+    619550n 1.8
+    619599n 1.8
+    619600n 0
+    619649n 0
+    619650n 1.8
+    619699n 1.8
+    619700n 0
+    619749n 0
+    619750n 1.8
+    619799n 1.8
+    619800n 0
+    619849n 0
+    619850n 1.8
+    619899n 1.8
+    619900n 0
+    619949n 0
+    619950n 1.8
+    619999n 1.8
+    620000n 0
+    620049n 0
+    620050n 1.8
+    620099n 1.8
+    620100n 0
+    620149n 0
+    620150n 1.8
+    620199n 1.8
+    620200n 0
+    620249n 0
+    620250n 1.8
+    620299n 1.8
+    620300n 0
+    620349n 0
+    620350n 1.8
+    620399n 1.8
+    620400n 0
+    620449n 0
+    620450n 1.8
+    620499n 1.8
+    620500n 0
+    620549n 0
+    620550n 1.8
+    620599n 1.8
+    620600n 0
+    620649n 0
+    620650n 1.8
+    620699n 1.8
+    620700n 0
+    620749n 0
+    620750n 1.8
+    620799n 1.8
+    620800n 0
+    620849n 0
+    620850n 1.8
+    620899n 1.8
+    620900n 0
+    620949n 0
+    620950n 1.8
+    620999n 1.8
+    621000n 0
+    621049n 0
+    621050n 1.8
+    621099n 1.8
+    621100n 0
+    621149n 0
+    621150n 1.8
+    621199n 1.8
+    621200n 0
+    621249n 0
+    621250n 1.8
+    621299n 1.8
+    621300n 0
+    621349n 0
+    621350n 1.8
+    621399n 1.8
+    621400n 0
+    621449n 0
+    621450n 1.8
+    621499n 1.8
+    621500n 0
+    621549n 0
+    621550n 1.8
+    621599n 1.8
+    621600n 0
+    621649n 0
+    621650n 1.8
+    621699n 1.8
+    621700n 0
+    621749n 0
+    621750n 1.8
+    621799n 1.8
+    621800n 0
+    621849n 0
+    621850n 1.8
+    621899n 1.8
+    621900n 0
+    621949n 0
+    621950n 1.8
+    621999n 1.8
+    622000n 0
+    622049n 0
+    622050n 1.8
+    622099n 1.8
+    622100n 0
+    622149n 0
+    622150n 1.8
+    622199n 1.8
+    622200n 0
+    622249n 0
+    622250n 1.8
+    622299n 1.8
+    622300n 0
+    622349n 0
+    622350n 1.8
+    622399n 1.8
+    622400n 0
+    622449n 0
+    622450n 1.8
+    622499n 1.8
+    622500n 0
+    622549n 0
+    622550n 1.8
+    622599n 1.8
+    622600n 0
+    622649n 0
+    622650n 1.8
+    622699n 1.8
+    622700n 0
+    622749n 0
+    622750n 1.8
+    622799n 1.8
+    622800n 0
+    622849n 0
+    622850n 1.8
+    622899n 1.8
+    622900n 0
+    622949n 0
+    622950n 1.8
+    622999n 1.8
+    623000n 0
+    623049n 0
+    623050n 1.8
+    623099n 1.8
+    623100n 0
+    623149n 0
+    623150n 1.8
+    623199n 1.8
+    623200n 0
+    623249n 0
+    623250n 1.8
+    623299n 1.8
+    623300n 0
+    623349n 0
+    623350n 1.8
+    623399n 1.8
+    623400n 0
+    623449n 0
+    623450n 1.8
+    623499n 1.8
+    623500n 0
+    623549n 0
+    623550n 1.8
+    623599n 1.8
+    623600n 0
+    623649n 0
+    623650n 1.8
+    623699n 1.8
+    623700n 0
+    623749n 0
+    623750n 1.8
+    623799n 1.8
+    623800n 0
+    623849n 0
+    623850n 1.8
+    623899n 1.8
+    623900n 0
+    623949n 0
+    623950n 1.8
+    623999n 1.8
+    624000n 0
+    624049n 0
+    624050n 1.8
+    624099n 1.8
+    624100n 0
+    624149n 0
+    624150n 1.8
+    624199n 1.8
+    624200n 0
+    624249n 0
+    624250n 1.8
+    624299n 1.8
+    624300n 0
+    624349n 0
+    624350n 1.8
+    624399n 1.8
+    624400n 0
+    624449n 0
+    624450n 1.8
+    624499n 1.8
+    624500n 0
+    624549n 0
+    624550n 1.8
+    624599n 1.8
+    624600n 0
+    624649n 0
+    624650n 1.8
+    624699n 1.8
+    624700n 0
+    624749n 0
+    624750n 1.8
+    624799n 1.8
+    624800n 0
+    624849n 0
+    624850n 1.8
+    624899n 1.8
+    624900n 0
+    624949n 0
+    624950n 1.8
+    624999n 1.8
+    625000n 0
+    625049n 0
+    625050n 1.8
+    625099n 1.8
+    625100n 0
+    625149n 0
+    625150n 1.8
+    625199n 1.8
+    625200n 0
+    625249n 0
+    625250n 1.8
+    625299n 1.8
+    625300n 0
+    625349n 0
+    625350n 1.8
+    625399n 1.8
+    625400n 0
+    625449n 0
+    625450n 1.8
+    625499n 1.8
+    625500n 0
+    625549n 0
+    625550n 1.8
+    625599n 1.8
+    625600n 0
+    625649n 0
+    625650n 1.8
+    625699n 1.8
+    625700n 0
+    625749n 0
+    625750n 1.8
+    625799n 1.8
+    625800n 0
+    625849n 0
+    625850n 1.8
+    625899n 1.8
+    625900n 0
+    625949n 0
+    625950n 1.8
+    625999n 1.8
+    626000n 0
+    626049n 0
+    626050n 1.8
+    626099n 1.8
+    626100n 0
+    626149n 0
+    626150n 1.8
+    626199n 1.8
+    626200n 0
+    626249n 0
+    626250n 1.8
+    626299n 1.8
+    626300n 0
+    626349n 0
+    626350n 1.8
+    626399n 1.8
+    626400n 0
+    626449n 0
+    626450n 1.8
+    626499n 1.8
+    626500n 0
+    626549n 0
+    626550n 1.8
+    626599n 1.8
+    626600n 0
+    626649n 0
+    626650n 1.8
+    626699n 1.8
+    626700n 0
+    626749n 0
+    626750n 1.8
+    626799n 1.8
+    626800n 0
+    626849n 0
+    626850n 1.8
+    626899n 1.8
+    626900n 0
+    626949n 0
+    626950n 1.8
+    626999n 1.8
+    627000n 0
+    627049n 0
+    627050n 1.8
+    627099n 1.8
+    627100n 0
+    627149n 0
+    627150n 1.8
+    627199n 1.8
+    627200n 0
+    627249n 0
+    627250n 1.8
+    627299n 1.8
+    627300n 0
+    627349n 0
+    627350n 1.8
+    627399n 1.8
+    627400n 0
+    627449n 0
+    627450n 1.8
+    627499n 1.8
+    627500n 0
+    627549n 0
+    627550n 1.8
+    627599n 1.8
+    627600n 0
+    627649n 0
+    627650n 1.8
+    627699n 1.8
+    627700n 0
+    627749n 0
+    627750n 1.8
+    627799n 1.8
+    627800n 0
+    627849n 0
+    627850n 1.8
+    627899n 1.8
+    627900n 0
+    627949n 0
+    627950n 1.8
+    627999n 1.8
+    628000n 0
+    628049n 0
+    628050n 1.8
+    628099n 1.8
+    628100n 0
+    628149n 0
+    628150n 1.8
+    628199n 1.8
+    628200n 0
+    628249n 0
+    628250n 1.8
+    628299n 1.8
+    628300n 0
+    628349n 0
+    628350n 1.8
+    628399n 1.8
+    628400n 0
+    628449n 0
+    628450n 1.8
+    628499n 1.8
+    628500n 0
+    628549n 0
+    628550n 1.8
+    628599n 1.8
+    628600n 0
+    628649n 0
+    628650n 1.8
+    628699n 1.8
+    628700n 0
+    628749n 0
+    628750n 1.8
+    628799n 1.8
+    628800n 0
+    628849n 0
+    628850n 1.8
+    628899n 1.8
+    628900n 0
+    628949n 0
+    628950n 1.8
+    628999n 1.8
+    629000n 0
+    629049n 0
+    629050n 1.8
+    629099n 1.8
+    629100n 0
+    629149n 0
+    629150n 1.8
+    629199n 1.8
+    629200n 0
+    629249n 0
+    629250n 1.8
+    629299n 1.8
+    629300n 0
+    629349n 0
+    629350n 1.8
+    629399n 1.8
+    629400n 0
+    629449n 0
+    629450n 1.8
+    629499n 1.8
+    629500n 0
+    629549n 0
+    629550n 1.8
+    629599n 1.8
+    629600n 0
+    629649n 0
+    629650n 1.8
+    629699n 1.8
+    629700n 0
+    629749n 0
+    629750n 1.8
+    629799n 1.8
+    629800n 0
+    629849n 0
+    629850n 1.8
+    629899n 1.8
+    629900n 0
+    629949n 0
+    629950n 1.8
+    629999n 1.8
+    630000n 0
+    630049n 0
+    630050n 1.8
+    630099n 1.8
+    630100n 0
+    630149n 0
+    630150n 1.8
+    630199n 1.8
+    630200n 0
+    630249n 0
+    630250n 1.8
+    630299n 1.8
+    630300n 0
+    630349n 0
+    630350n 1.8
+    630399n 1.8
+    630400n 0
+    630449n 0
+    630450n 1.8
+    630499n 1.8
+    630500n 0
+    630549n 0
+    630550n 1.8
+    630599n 1.8
+    630600n 0
+    630649n 0
+    630650n 1.8
+    630699n 1.8
+    630700n 0
+    630749n 0
+    630750n 1.8
+    630799n 1.8
+    630800n 0
+    630849n 0
+    630850n 1.8
+    630899n 1.8
+    630900n 0
+    630949n 0
+    630950n 1.8
+    630999n 1.8
+    631000n 0
+    631049n 0
+    631050n 1.8
+    631099n 1.8
+    631100n 0
+    631149n 0
+    631150n 1.8
+    631199n 1.8
+    631200n 0
+    631249n 0
+    631250n 1.8
+    631299n 1.8
+    631300n 0
+    631349n 0
+    631350n 1.8
+    631399n 1.8
+    631400n 0
+    631449n 0
+    631450n 1.8
+    631499n 1.8
+    631500n 0
+    631549n 0
+    631550n 1.8
+    631599n 1.8
+    631600n 0
+    631649n 0
+    631650n 1.8
+    631699n 1.8
+    631700n 0
+    631749n 0
+    631750n 1.8
+    631799n 1.8
+    631800n 0
+    631849n 0
+    631850n 1.8
+    631899n 1.8
+    631900n 0
+    631949n 0
+    631950n 1.8
+    631999n 1.8
+    632000n 0
+    632049n 0
+    632050n 1.8
+    632099n 1.8
+    632100n 0
+    632149n 0
+    632150n 1.8
+    632199n 1.8
+    632200n 0
+    632249n 0
+    632250n 1.8
+    632299n 1.8
+    632300n 0
+    632349n 0
+    632350n 1.8
+    632399n 1.8
+    632400n 0
+    632449n 0
+    632450n 1.8
+    632499n 1.8
+    632500n 0
+    632549n 0
+    632550n 1.8
+    632599n 1.8
+    632600n 0
+    632649n 0
+    632650n 1.8
+    632699n 1.8
+    632700n 0
+    632749n 0
+    632750n 1.8
+    632799n 1.8
+    632800n 0
+    632849n 0
+    632850n 1.8
+    632899n 1.8
+    632900n 0
+    632949n 0
+    632950n 1.8
+    632999n 1.8
+    633000n 0
+    633049n 0
+    633050n 1.8
+    633099n 1.8
+    633100n 0
+    633149n 0
+    633150n 1.8
+    633199n 1.8
+    633200n 0
+    633249n 0
+    633250n 1.8
+    633299n 1.8
+    633300n 0
+    633349n 0
+    633350n 1.8
+    633399n 1.8
+    633400n 0
+    633449n 0
+    633450n 1.8
+    633499n 1.8
+    633500n 0
+    633549n 0
+    633550n 1.8
+    633599n 1.8
+    633600n 0
+    633649n 0
+    633650n 1.8
+    633699n 1.8
+    633700n 0
+    633749n 0
+    633750n 1.8
+    633799n 1.8
+    633800n 0
+    633849n 0
+    633850n 1.8
+    633899n 1.8
+    633900n 0
+    633949n 0
+    633950n 1.8
+    633999n 1.8
+    634000n 0
+    634049n 0
+    634050n 1.8
+    634099n 1.8
+    634100n 0
+    634149n 0
+    634150n 1.8
+    634199n 1.8
+    634200n 0
+    634249n 0
+    634250n 1.8
+    634299n 1.8
+    634300n 0
+    634349n 0
+    634350n 1.8
+    634399n 1.8
+    634400n 0
+    634449n 0
+    634450n 1.8
+    634499n 1.8
+    634500n 0
+    634549n 0
+    634550n 1.8
+    634599n 1.8
+    634600n 0
+    634649n 0
+    634650n 1.8
+    634699n 1.8
+    634700n 0
+    634749n 0
+    634750n 1.8
+    634799n 1.8
+    634800n 0
+    634849n 0
+    634850n 1.8
+    634899n 1.8
+    634900n 0
+    634949n 0
+    634950n 1.8
+    634999n 1.8
+    635000n 0
+    635049n 0
+    635050n 1.8
+    635099n 1.8
+    635100n 0
+    635149n 0
+    635150n 1.8
+    635199n 1.8
+    635200n 0
+    635249n 0
+    635250n 1.8
+    635299n 1.8
+    635300n 0
+    635349n 0
+    635350n 1.8
+    635399n 1.8
+    635400n 0
+    635449n 0
+    635450n 1.8
+    635499n 1.8
+    635500n 0
+    635549n 0
+    635550n 1.8
+    635599n 1.8
+    635600n 0
+    635649n 0
+    635650n 1.8
+    635699n 1.8
+    635700n 0
+    635749n 0
+    635750n 1.8
+    635799n 1.8
+    635800n 0
+    635849n 0
+    635850n 1.8
+    635899n 1.8
+    635900n 0
+    635949n 0
+    635950n 1.8
+    635999n 1.8
+    636000n 0
+    636049n 0
+    636050n 1.8
+    636099n 1.8
+    636100n 0
+    636149n 0
+    636150n 1.8
+    636199n 1.8
+    636200n 0
+    636249n 0
+    636250n 1.8
+    636299n 1.8
+    636300n 0
+    636349n 0
+    636350n 1.8
+    636399n 1.8
+    636400n 0
+    636449n 0
+    636450n 1.8
+    636499n 1.8
+    636500n 0
+    636549n 0
+    636550n 1.8
+    636599n 1.8
+    636600n 0
+    636649n 0
+    636650n 1.8
+    636699n 1.8
+    636700n 0
+    636749n 0
+    636750n 1.8
+    636799n 1.8
+    636800n 0
+    636849n 0
+    636850n 1.8
+    636899n 1.8
+    636900n 0
+    636949n 0
+    636950n 1.8
+    636999n 1.8
+    637000n 0
+    637049n 0
+    637050n 1.8
+    637099n 1.8
+    637100n 0
+    637149n 0
+    637150n 1.8
+    637199n 1.8
+    637200n 0
+    637249n 0
+    637250n 1.8
+    637299n 1.8
+    637300n 0
+    637349n 0
+    637350n 1.8
+    637399n 1.8
+    637400n 0
+    637449n 0
+    637450n 1.8
+    637499n 1.8
+    637500n 0
+    637549n 0
+    637550n 1.8
+    637599n 1.8
+    637600n 0
+    637649n 0
+    637650n 1.8
+    637699n 1.8
+    637700n 0
+    637749n 0
+    637750n 1.8
+    637799n 1.8
+    637800n 0
+    637849n 0
+    637850n 1.8
+    637899n 1.8
+    637900n 0
+    637949n 0
+    637950n 1.8
+    637999n 1.8
+    638000n 0
+    638049n 0
+    638050n 1.8
+    638099n 1.8
+    638100n 0
+    638149n 0
+    638150n 1.8
+    638199n 1.8
+    638200n 0
+    638249n 0
+    638250n 1.8
+    638299n 1.8
+    638300n 0
+    638349n 0
+    638350n 1.8
+    638399n 1.8
+    638400n 0
+    638449n 0
+    638450n 1.8
+    638499n 1.8
+    638500n 0
+    638549n 0
+    638550n 1.8
+    638599n 1.8
+    638600n 0
+    638649n 0
+    638650n 1.8
+    638699n 1.8
+    638700n 0
+    638749n 0
+    638750n 1.8
+    638799n 1.8
+    638800n 0
+    638849n 0
+    638850n 1.8
+    638899n 1.8
+    638900n 0
+    638949n 0
+    638950n 1.8
+    638999n 1.8
+    639000n 0
+    639049n 0
+    639050n 1.8
+    639099n 1.8
+    639100n 0
+    639149n 0
+    639150n 1.8
+    639199n 1.8
+    639200n 0
+    639249n 0
+    639250n 1.8
+    639299n 1.8
+    639300n 0
+    639349n 0
+    639350n 1.8
+    639399n 1.8
+    639400n 0
+    639449n 0
+    639450n 1.8
+    639499n 1.8
+    639500n 0
+    639549n 0
+    639550n 1.8
+    639599n 1.8
+    639600n 0
+    639649n 0
+    639650n 1.8
+    639699n 1.8
+    639700n 0
+    639749n 0
+    639750n 1.8
+    639799n 1.8
+    639800n 0
+    639849n 0
+    639850n 1.8
+    639899n 1.8
+    639900n 0
+    639949n 0
+    639950n 1.8
+    639999n 1.8
+    640000n 0
+    640049n 0
+    640050n 1.8
+    640099n 1.8
+    640100n 0
+    640149n 0
+    640150n 1.8
+    640199n 1.8
+    640200n 0
+    640249n 0
+    640250n 1.8
+    640299n 1.8
+    640300n 0
+    640349n 0
+    640350n 1.8
+    640399n 1.8
+    640400n 0
+    640449n 0
+    640450n 1.8
+    640499n 1.8
+    640500n 0
+    640549n 0
+    640550n 1.8
+    640599n 1.8
+    640600n 0
+    640649n 0
+    640650n 1.8
+    640699n 1.8
+    640700n 0
+    640749n 0
+    640750n 1.8
+    640799n 1.8
+    640800n 0
+    640849n 0
+    640850n 1.8
+    640899n 1.8
+    640900n 0
+    640949n 0
+    640950n 1.8
+    640999n 1.8
+    641000n 0
+    641049n 0
+    641050n 1.8
+    641099n 1.8
+    641100n 0
+    641149n 0
+    641150n 1.8
+    641199n 1.8
+    641200n 0
+    641249n 0
+    641250n 1.8
+    641299n 1.8
+    641300n 0
+    641349n 0
+    641350n 1.8
+    641399n 1.8
+    641400n 0
+    641449n 0
+    641450n 1.8
+    641499n 1.8
+    641500n 0
+    641549n 0
+    641550n 1.8
+    641599n 1.8
+    641600n 0
+    641649n 0
+    641650n 1.8
+    641699n 1.8
+    641700n 0
+    641749n 0
+    641750n 1.8
+    641799n 1.8
+    641800n 0
+    641849n 0
+    641850n 1.8
+    641899n 1.8
+    641900n 0
+    641949n 0
+    641950n 1.8
+    641999n 1.8
+    642000n 0
+    642049n 0
+    642050n 1.8
+    642099n 1.8
+    642100n 0
+    642149n 0
+    642150n 1.8
+    642199n 1.8
+    642200n 0
+    642249n 0
+    642250n 1.8
+    642299n 1.8
+    642300n 0
+    642349n 0
+    642350n 1.8
+    642399n 1.8
+    642400n 0
+    642449n 0
+    642450n 1.8
+    642499n 1.8
+    642500n 0
+    642549n 0
+    642550n 1.8
+    642599n 1.8
+    642600n 0
+    642649n 0
+    642650n 1.8
+    642699n 1.8
+    642700n 0
+    642749n 0
+    642750n 1.8
+    642799n 1.8
+    642800n 0
+    642849n 0
+    642850n 1.8
+    642899n 1.8
+    642900n 0
+    642949n 0
+    642950n 1.8
+    642999n 1.8
+    643000n 0
+    643049n 0
+    643050n 1.8
+    643099n 1.8
+    643100n 0
+    643149n 0
+    643150n 1.8
+    643199n 1.8
+    643200n 0
+    643249n 0
+    643250n 1.8
+    643299n 1.8
+    643300n 0
+    643349n 0
+    643350n 1.8
+    643399n 1.8
+    643400n 0
+    643449n 0
+    643450n 1.8
+    643499n 1.8
+    643500n 0
+    643549n 0
+    643550n 1.8
+    643599n 1.8
+    643600n 0
+    643649n 0
+    643650n 1.8
+    643699n 1.8
+    643700n 0
+    643749n 0
+    643750n 1.8
+    643799n 1.8
+    643800n 0
+    643849n 0
+    643850n 1.8
+    643899n 1.8
+    643900n 0
+    643949n 0
+    643950n 1.8
+    643999n 1.8
+    644000n 0
+    644049n 0
+    644050n 1.8
+    644099n 1.8
+    644100n 0
+    644149n 0
+    644150n 1.8
+    644199n 1.8
+    644200n 0
+    644249n 0
+    644250n 1.8
+    644299n 1.8
+    644300n 0
+    644349n 0
+    644350n 1.8
+    644399n 1.8
+    644400n 0
+    644449n 0
+    644450n 1.8
+    644499n 1.8
+    644500n 0
+    644549n 0
+    644550n 1.8
+    644599n 1.8
+    644600n 0
+    644649n 0
+    644650n 1.8
+    644699n 1.8
+    644700n 0
+    644749n 0
+    644750n 1.8
+    644799n 1.8
+    644800n 0
+    644849n 0
+    644850n 1.8
+    644899n 1.8
+    644900n 0
+    644949n 0
+    644950n 1.8
+    644999n 1.8
+    645000n 0
+    645049n 0
+    645050n 1.8
+    645099n 1.8
+    645100n 0
+    645149n 0
+    645150n 1.8
+    645199n 1.8
+    645200n 0
+    645249n 0
+    645250n 1.8
+    645299n 1.8
+    645300n 0
+    645349n 0
+    645350n 1.8
+    645399n 1.8
+    645400n 0
+    645449n 0
+    645450n 1.8
+    645499n 1.8
+    645500n 0
+    645549n 0
+    645550n 1.8
+    645599n 1.8
+    645600n 0
+    645649n 0
+    645650n 1.8
+    645699n 1.8
+    645700n 0
+    645749n 0
+    645750n 1.8
+    645799n 1.8
+    645800n 0
+    645849n 0
+    645850n 1.8
+    645899n 1.8
+    645900n 0
+    645949n 0
+    645950n 1.8
+    645999n 1.8
+    646000n 0
+    646049n 0
+    646050n 1.8
+    646099n 1.8
+    646100n 0
+    646149n 0
+    646150n 1.8
+    646199n 1.8
+    646200n 0
+    646249n 0
+    646250n 1.8
+    646299n 1.8
+    646300n 0
+    646349n 0
+    646350n 1.8
+    646399n 1.8
+    646400n 0
+    646449n 0
+    646450n 1.8
+    646499n 1.8
+    646500n 0
+    646549n 0
+    646550n 1.8
+    646599n 1.8
+    646600n 0
+    646649n 0
+    646650n 1.8
+    646699n 1.8
+    646700n 0
+    646749n 0
+    646750n 1.8
+    646799n 1.8
+    646800n 0
+    646849n 0
+    646850n 1.8
+    646899n 1.8
+    646900n 0
+    646949n 0
+    646950n 1.8
+    646999n 1.8
+    647000n 0
+    647049n 0
+    647050n 1.8
+    647099n 1.8
+    647100n 0
+    647149n 0
+    647150n 1.8
+    647199n 1.8
+    647200n 0
+    647249n 0
+    647250n 1.8
+    647299n 1.8
+    647300n 0
+    647349n 0
+    647350n 1.8
+    647399n 1.8
+    647400n 0
+    647449n 0
+    647450n 1.8
+    647499n 1.8
+    647500n 0
+    647549n 0
+    647550n 1.8
+    647599n 1.8
+    647600n 0
+    647649n 0
+    647650n 1.8
+    647699n 1.8
+    647700n 0
+    647749n 0
+    647750n 1.8
+    647799n 1.8
+    647800n 0
+    647849n 0
+    647850n 1.8
+    647899n 1.8
+    647900n 0
+    647949n 0
+    647950n 1.8
+    647999n 1.8
+    648000n 0
+    648049n 0
+    648050n 1.8
+    648099n 1.8
+    648100n 0
+    648149n 0
+    648150n 1.8
+    648199n 1.8
+    648200n 0
+    648249n 0
+    648250n 1.8
+    648299n 1.8
+    648300n 0
+    648349n 0
+    648350n 1.8
+    648399n 1.8
+    648400n 0
+    648449n 0
+    648450n 1.8
+    648499n 1.8
+    648500n 0
+    648549n 0
+    648550n 1.8
+    648599n 1.8
+    648600n 0
+    648649n 0
+    648650n 1.8
+    648699n 1.8
+    648700n 0
+    648749n 0
+    648750n 1.8
+    648799n 1.8
+    648800n 0
+    648849n 0
+    648850n 1.8
+    648899n 1.8
+    648900n 0
+    648949n 0
+    648950n 1.8
+    648999n 1.8
+    649000n 0
+    649049n 0
+    649050n 1.8
+    649099n 1.8
+    649100n 0
+    649149n 0
+    649150n 1.8
+    649199n 1.8
+    649200n 0
+    649249n 0
+    649250n 1.8
+    649299n 1.8
+    649300n 0
+    649349n 0
+    649350n 1.8
+    649399n 1.8
+    649400n 0
+    649449n 0
+    649450n 1.8
+    649499n 1.8
+    649500n 0
+    649549n 0
+    649550n 1.8
+    649599n 1.8
+    649600n 0
+    649649n 0
+    649650n 1.8
+    649699n 1.8
+    649700n 0
+    649749n 0
+    649750n 1.8
+    649799n 1.8
+    649800n 0
+    649849n 0
+    649850n 1.8
+    649899n 1.8
+    649900n 0
+    649949n 0
+    649950n 1.8
+    649999n 1.8
+    650000n 0
+    650049n 0
+    650050n 1.8
+    650099n 1.8
+    650100n 0
+    650149n 0
+    650150n 1.8
+    650199n 1.8
+    650200n 0
+    650249n 0
+    650250n 1.8
+    650299n 1.8
+    650300n 0
+    650349n 0
+    650350n 1.8
+    650399n 1.8
+    650400n 0
+    650449n 0
+    650450n 1.8
+    650499n 1.8
+    650500n 0
+    650549n 0
+    650550n 1.8
+    650599n 1.8
+    650600n 0
+    650649n 0
+    650650n 1.8
+    650699n 1.8
+    650700n 0
+    650749n 0
+    650750n 1.8
+    650799n 1.8
+    650800n 0
+    650849n 0
+    650850n 1.8
+    650899n 1.8
+    650900n 0
+    650949n 0
+    650950n 1.8
+    650999n 1.8
+    651000n 0
+    651049n 0
+    651050n 1.8
+    651099n 1.8
+    651100n 0
+    651149n 0
+    651150n 1.8
+    651199n 1.8
+    651200n 0
+    651249n 0
+    651250n 1.8
+    651299n 1.8
+    651300n 0
+    651349n 0
+    651350n 1.8
+    651399n 1.8
+    651400n 0
+    651449n 0
+    651450n 1.8
+    651499n 1.8
+    651500n 0
+    651549n 0
+    651550n 1.8
+    651599n 1.8
+    651600n 0
+    651649n 0
+    651650n 1.8
+    651699n 1.8
+    651700n 0
+    651749n 0
+    651750n 1.8
+    651799n 1.8
+    651800n 0
+    651849n 0
+    651850n 1.8
+    651899n 1.8
+    651900n 0
+    651949n 0
+    651950n 1.8
+    651999n 1.8
+    652000n 0
+    652049n 0
+    652050n 1.8
+    652099n 1.8
+    652100n 0
+    652149n 0
+    652150n 1.8
+    652199n 1.8
+    652200n 0
+    652249n 0
+    652250n 1.8
+    652299n 1.8
+    652300n 0
+    652349n 0
+    652350n 1.8
+    652399n 1.8
+    652400n 0
+    652449n 0
+    652450n 1.8
+    652499n 1.8
+    652500n 0
+    652549n 0
+    652550n 1.8
+    652599n 1.8
+    652600n 0
+    652649n 0
+    652650n 1.8
+    652699n 1.8
+    652700n 0
+    652749n 0
+    652750n 1.8
+    652799n 1.8
+    652800n 0
+    652849n 0
+    652850n 1.8
+    652899n 1.8
+    652900n 0
+    652949n 0
+    652950n 1.8
+    652999n 1.8
+    653000n 0
+    653049n 0
+    653050n 1.8
+    653099n 1.8
+    653100n 0
+    653149n 0
+    653150n 1.8
+    653199n 1.8
+    653200n 0
+    653249n 0
+    653250n 1.8
+    653299n 1.8
+    653300n 0
+    653349n 0
+    653350n 1.8
+    653399n 1.8
+    653400n 0
+    653449n 0
+    653450n 1.8
+    653499n 1.8
+    653500n 0
+    653549n 0
+    653550n 1.8
+    653599n 1.8
+    653600n 0
+    653649n 0
+    653650n 1.8
+    653699n 1.8
+    653700n 0
+    653749n 0
+    653750n 1.8
+    653799n 1.8
+    653800n 0
+    653849n 0
+    653850n 1.8
+    653899n 1.8
+    653900n 0
+    653949n 0
+    653950n 1.8
+    653999n 1.8
+    654000n 0
+    654049n 0
+    654050n 1.8
+    654099n 1.8
+    654100n 0
+    654149n 0
+    654150n 1.8
+    654199n 1.8
+    654200n 0
+    654249n 0
+    654250n 1.8
+    654299n 1.8
+    654300n 0
+    654349n 0
+    654350n 1.8
+    654399n 1.8
+    654400n 0
+    654449n 0
+    654450n 1.8
+    654499n 1.8
+    654500n 0
+    654549n 0
+    654550n 1.8
+    654599n 1.8
+    654600n 0
+    654649n 0
+    654650n 1.8
+    654699n 1.8
+    654700n 0
+    654749n 0
+    654750n 1.8
+    654799n 1.8
+    654800n 0
+    654849n 0
+    654850n 1.8
+    654899n 1.8
+    654900n 0
+    654949n 0
+    654950n 1.8
+    654999n 1.8
+    655000n 0
+    655049n 0
+    655050n 1.8
+    655099n 1.8
+    655100n 0
+    655149n 0
+    655150n 1.8
+    655199n 1.8
+    655200n 0
+    655249n 0
+    655250n 1.8
+    655299n 1.8
+    655300n 0
+    655349n 0
+    655350n 1.8
+    655399n 1.8
+    655400n 0
+    655449n 0
+    655450n 1.8
+    655499n 1.8
+    655500n 0
+    655549n 0
+    655550n 1.8
+    655599n 1.8
+    655600n 0
+    655649n 0
+    655650n 1.8
+    655699n 1.8
+    655700n 0
+    655749n 0
+    655750n 1.8
+    655799n 1.8
+    655800n 0
+    655849n 0
+    655850n 1.8
+    655899n 1.8
+    655900n 0
+    655949n 0
+    655950n 1.8
+    655999n 1.8
+    656000n 0
+    656049n 0
+    656050n 1.8
+    656099n 1.8
+    656100n 0
+    656149n 0
+    656150n 1.8
+    656199n 1.8
+    656200n 0
+    656249n 0
+    656250n 1.8
+    656299n 1.8
+    656300n 0
+    656349n 0
+    656350n 1.8
+    656399n 1.8
+    656400n 0
+    656449n 0
+    656450n 1.8
+    656499n 1.8
+    656500n 0
+    656549n 0
+    656550n 1.8
+    656599n 1.8
+    656600n 0
+    656649n 0
+    656650n 1.8
+    656699n 1.8
+    656700n 0
+    656749n 0
+    656750n 1.8
+    656799n 1.8
+    656800n 0
+    656849n 0
+    656850n 1.8
+    656899n 1.8
+    656900n 0
+    656949n 0
+    656950n 1.8
+    656999n 1.8
+    657000n 0
+    657049n 0
+    657050n 1.8
+    657099n 1.8
+    657100n 0
+    657149n 0
+    657150n 1.8
+    657199n 1.8
+    657200n 0
+    657249n 0
+    657250n 1.8
+    657299n 1.8
+    657300n 0
+    657349n 0
+    657350n 1.8
+    657399n 1.8
+    657400n 0
+    657449n 0
+    657450n 1.8
+    657499n 1.8
+    657500n 0
+    657549n 0
+    657550n 1.8
+    657599n 1.8
+    657600n 0
+    657649n 0
+    657650n 1.8
+    657699n 1.8
+    657700n 0
+    657749n 0
+    657750n 1.8
+    657799n 1.8
+    657800n 0
+    657849n 0
+    657850n 1.8
+    657899n 1.8
+    657900n 0
+    657949n 0
+    657950n 1.8
+    657999n 1.8
+    658000n 0
+    658049n 0
+    658050n 1.8
+    658099n 1.8
+    658100n 0
+    658149n 0
+    658150n 1.8
+    658199n 1.8
+    658200n 0
+    658249n 0
+    658250n 1.8
+    658299n 1.8
+    658300n 0
+    658349n 0
+    658350n 1.8
+    658399n 1.8
+    658400n 0
+    658449n 0
+    658450n 1.8
+    658499n 1.8
+    658500n 0
+    658549n 0
+    658550n 1.8
+    658599n 1.8
+    658600n 0
+    658649n 0
+    658650n 1.8
+    658699n 1.8
+    658700n 0
+    658749n 0
+    658750n 1.8
+    658799n 1.8
+    658800n 0
+    658849n 0
+    658850n 1.8
+    658899n 1.8
+    658900n 0
+    658949n 0
+    658950n 1.8
+    658999n 1.8
+    659000n 0
+    659049n 0
+    659050n 1.8
+    659099n 1.8
+    659100n 0
+    659149n 0
+    659150n 1.8
+    659199n 1.8
+    659200n 0
+    659249n 0
+    659250n 1.8
+    659299n 1.8
+    659300n 0
+    659349n 0
+    659350n 1.8
+    659399n 1.8
+    659400n 0
+    659449n 0
+    659450n 1.8
+    659499n 1.8
+    659500n 0
+    659549n 0
+    659550n 1.8
+    659599n 1.8
+    659600n 0
+    659649n 0
+    659650n 1.8
+    659699n 1.8
+    659700n 0
+    659749n 0
+    659750n 1.8
+    659799n 1.8
+    659800n 0
+    659849n 0
+    659850n 1.8
+    659899n 1.8
+    659900n 0
+    659949n 0
+    659950n 1.8
+    659999n 1.8
+    660000n 0
+    660049n 0
+    660050n 1.8
+    660099n 1.8
+    660100n 0
+    660149n 0
+    660150n 1.8
+    660199n 1.8
+    660200n 0
+    660249n 0
+    660250n 1.8
+    660299n 1.8
+    660300n 0
+    660349n 0
+    660350n 1.8
+    660399n 1.8
+    660400n 0
+    660449n 0
+    660450n 1.8
+    660499n 1.8
+    660500n 0
+    660549n 0
+    660550n 1.8
+    660599n 1.8
+    660600n 0
+    660649n 0
+    660650n 1.8
+    660699n 1.8
+    660700n 0
+    660749n 0
+    660750n 1.8
+    660799n 1.8
+    660800n 0
+    660849n 0
+    660850n 1.8
+    660899n 1.8
+    660900n 0
+    660949n 0
+    660950n 1.8
+    660999n 1.8
+    661000n 0
+    661049n 0
+    661050n 1.8
+    661099n 1.8
+    661100n 0
+    661149n 0
+    661150n 1.8
+    661199n 1.8
+    661200n 0
+    661249n 0
+    661250n 1.8
+    661299n 1.8
+    661300n 0
+    661349n 0
+    661350n 1.8
+    661399n 1.8
+    661400n 0
+    661449n 0
+    661450n 1.8
+    661499n 1.8
+    661500n 0
+    661549n 0
+    661550n 1.8
+    661599n 1.8
+    661600n 0
+    661649n 0
+    661650n 1.8
+    661699n 1.8
+    661700n 0
+    661749n 0
+    661750n 1.8
+    661799n 1.8
+    661800n 0
+    661849n 0
+    661850n 1.8
+    661899n 1.8
+    661900n 0
+    661949n 0
+    661950n 1.8
+    661999n 1.8
+    662000n 0
+    662049n 0
+    662050n 1.8
+    662099n 1.8
+    662100n 0
+    662149n 0
+    662150n 1.8
+    662199n 1.8
+    662200n 0
+    662249n 0
+    662250n 1.8
+    662299n 1.8
+    662300n 0
+    662349n 0
+    662350n 1.8
+    662399n 1.8
+    662400n 0
+    662449n 0
+    662450n 1.8
+    662499n 1.8
+    662500n 0
+    662549n 0
+    662550n 1.8
+    662599n 1.8
+    662600n 0
+    662649n 0
+    662650n 1.8
+    662699n 1.8
+    662700n 0
+    662749n 0
+    662750n 1.8
+    662799n 1.8
+    662800n 0
+    662849n 0
+    662850n 1.8
+    662899n 1.8
+    662900n 0
+    662949n 0
+    662950n 1.8
+    662999n 1.8
+    663000n 0
+    663049n 0
+    663050n 1.8
+    663099n 1.8
+    663100n 0
+    663149n 0
+    663150n 1.8
+    663199n 1.8
+    663200n 0
+    663249n 0
+    663250n 1.8
+    663299n 1.8
+    663300n 0
+    663349n 0
+    663350n 1.8
+    663399n 1.8
+    663400n 0
+    663449n 0
+    663450n 1.8
+    663499n 1.8
+    663500n 0
+    663549n 0
+    663550n 1.8
+    663599n 1.8
+    663600n 0
+    663649n 0
+    663650n 1.8
+    663699n 1.8
+    663700n 0
+    663749n 0
+    663750n 1.8
+    663799n 1.8
+    663800n 0
+    663849n 0
+    663850n 1.8
+    663899n 1.8
+    663900n 0
+    663949n 0
+    663950n 1.8
+    663999n 1.8
+    664000n 0
+    664049n 0
+    664050n 1.8
+    664099n 1.8
+    664100n 0
+    664149n 0
+    664150n 1.8
+    664199n 1.8
+    664200n 0
+    664249n 0
+    664250n 1.8
+    664299n 1.8
+    664300n 0
+    664349n 0
+    664350n 1.8
+    664399n 1.8
+    664400n 0
+    664449n 0
+    664450n 1.8
+    664499n 1.8
+    664500n 0
+    664549n 0
+    664550n 1.8
+    664599n 1.8
+    664600n 0
+    664649n 0
+    664650n 1.8
+    664699n 1.8
+    664700n 0
+    664749n 0
+    664750n 1.8
+    664799n 1.8
+    664800n 0
+    664849n 0
+    664850n 1.8
+    664899n 1.8
+    664900n 0
+    664949n 0
+    664950n 1.8
+    664999n 1.8
+    665000n 0
+    665049n 0
+    665050n 1.8
+    665099n 1.8
+    665100n 0
+    665149n 0
+    665150n 1.8
+    665199n 1.8
+    665200n 0
+    665249n 0
+    665250n 1.8
+    665299n 1.8
+    665300n 0
+    665349n 0
+    665350n 1.8
+    665399n 1.8
+    665400n 0
+    665449n 0
+    665450n 1.8
+    665499n 1.8
+    665500n 0
+    665549n 0
+    665550n 1.8
+    665599n 1.8
+    665600n 0
+    665649n 0
+    665650n 1.8
+    665699n 1.8
+    665700n 0
+    665749n 0
+    665750n 1.8
+    665799n 1.8
+    665800n 0
+    665849n 0
+    665850n 1.8
+    665899n 1.8
+    665900n 0
+    665949n 0
+    665950n 1.8
+    665999n 1.8
+    666000n 0
+    666049n 0
+    666050n 1.8
+    666099n 1.8
+    666100n 0
+    666149n 0
+    666150n 1.8
+    666199n 1.8
+    666200n 0
+    666249n 0
+    666250n 1.8
+    666299n 1.8
+    666300n 0
+    666349n 0
+    666350n 1.8
+    666399n 1.8
+    666400n 0
+    666449n 0
+    666450n 1.8
+    666499n 1.8
+    666500n 0
+    666549n 0
+    666550n 1.8
+    666599n 1.8
+    666600n 0
+    666649n 0
+    666650n 1.8
+    666699n 1.8
+    666700n 0
+    666749n 0
+    666750n 1.8
+    666799n 1.8
+    666800n 0
+    666849n 0
+    666850n 1.8
+    666899n 1.8
+    666900n 0
+    666949n 0
+    666950n 1.8
+    666999n 1.8
+    667000n 0
+    667049n 0
+    667050n 1.8
+    667099n 1.8
+    667100n 0
+    667149n 0
+    667150n 1.8
+    667199n 1.8
+    667200n 0
+    667249n 0
+    667250n 1.8
+    667299n 1.8
+    667300n 0
+    667349n 0
+    667350n 1.8
+    667399n 1.8
+    667400n 0
+    667449n 0
+    667450n 1.8
+    667499n 1.8
+    667500n 0
+    667549n 0
+    667550n 1.8
+    667599n 1.8
+    667600n 0
+    667649n 0
+    667650n 1.8
+    667699n 1.8
+    667700n 0
+    667749n 0
+    667750n 1.8
+    667799n 1.8
+    667800n 0
+    667849n 0
+    667850n 1.8
+    667899n 1.8
+    667900n 0
+    667949n 0
+    667950n 1.8
+    667999n 1.8
+    668000n 0
+    668049n 0
+    668050n 1.8
+    668099n 1.8
+    668100n 0
+    668149n 0
+    668150n 1.8
+    668199n 1.8
+    668200n 0
+    668249n 0
+    668250n 1.8
+    668299n 1.8
+    668300n 0
+    668349n 0
+    668350n 1.8
+    668399n 1.8
+    668400n 0
+    668449n 0
+    668450n 1.8
+    668499n 1.8
+    668500n 0
+    668549n 0
+    668550n 1.8
+    668599n 1.8
+    668600n 0
+    668649n 0
+    668650n 1.8
+    668699n 1.8
+    668700n 0
+    668749n 0
+    668750n 1.8
+    668799n 1.8
+    668800n 0
+    668849n 0
+    668850n 1.8
+    668899n 1.8
+    668900n 0
+    668949n 0
+    668950n 1.8
+    668999n 1.8
+    669000n 0
+    669049n 0
+    669050n 1.8
+    669099n 1.8
+    669100n 0
+    669149n 0
+    669150n 1.8
+    669199n 1.8
+    669200n 0
+    669249n 0
+    669250n 1.8
+    669299n 1.8
+    669300n 0
+    669349n 0
+    669350n 1.8
+    669399n 1.8
+    669400n 0
+    669449n 0
+    669450n 1.8
+    669499n 1.8
+    669500n 0
+    669549n 0
+    669550n 1.8
+    669599n 1.8
+    669600n 0
+    669649n 0
+    669650n 1.8
+    669699n 1.8
+    669700n 0
+    669749n 0
+    669750n 1.8
+    669799n 1.8
+    669800n 0
+    669849n 0
+    669850n 1.8
+    669899n 1.8
+    669900n 0
+    669949n 0
+    669950n 1.8
+    669999n 1.8
+    670000n 0
+    670049n 0
+    670050n 1.8
+    670099n 1.8
+    670100n 0
+    670149n 0
+    670150n 1.8
+    670199n 1.8
+    670200n 0
+    670249n 0
+    670250n 1.8
+    670299n 1.8
+    670300n 0
+    670349n 0
+    670350n 1.8
+    670399n 1.8
+    670400n 0
+    670449n 0
+    670450n 1.8
+    670499n 1.8
+    670500n 0
+    670549n 0
+    670550n 1.8
+    670599n 1.8
+    670600n 0
+    670649n 0
+    670650n 1.8
+    670699n 1.8
+    670700n 0
+    670749n 0
+    670750n 1.8
+    670799n 1.8
+    670800n 0
+    670849n 0
+    670850n 1.8
+    670899n 1.8
+    670900n 0
+    670949n 0
+    670950n 1.8
+    670999n 1.8
+    671000n 0
+    671049n 0
+    671050n 1.8
+    671099n 1.8
+    671100n 0
+    671149n 0
+    671150n 1.8
+    671199n 1.8
+    671200n 0
+    671249n 0
+    671250n 1.8
+    671299n 1.8
+    671300n 0
+    671349n 0
+    671350n 1.8
+    671399n 1.8
+    671400n 0
+    671449n 0
+    671450n 1.8
+    671499n 1.8
+    671500n 0
+    671549n 0
+    671550n 1.8
+    671599n 1.8
+    671600n 0
+    671649n 0
+    671650n 1.8
+    671699n 1.8
+    671700n 0
+    671749n 0
+    671750n 1.8
+    671799n 1.8
+    671800n 0
+    671849n 0
+    671850n 1.8
+    671899n 1.8
+    671900n 0
+    671949n 0
+    671950n 1.8
+    671999n 1.8
+    672000n 0
+    672049n 0
+    672050n 1.8
+    672099n 1.8
+    672100n 0
+    672149n 0
+    672150n 1.8
+    672199n 1.8
+    672200n 0
+    672249n 0
+    672250n 1.8
+    672299n 1.8
+    672300n 0
+    672349n 0
+    672350n 1.8
+    672399n 1.8
+    672400n 0
+    672449n 0
+    672450n 1.8
+    672499n 1.8
+    672500n 0
+    672549n 0
+    672550n 1.8
+    672599n 1.8
+    672600n 0
+    672649n 0
+    672650n 1.8
+    672699n 1.8
+    672700n 0
+    672749n 0
+    672750n 1.8
+    672799n 1.8
+    672800n 0
+    672849n 0
+    672850n 1.8
+    672899n 1.8
+    672900n 0
+    672949n 0
+    672950n 1.8
+    672999n 1.8
+    673000n 0
+    673049n 0
+    673050n 1.8
+    673099n 1.8
+    673100n 0
+    673149n 0
+    673150n 1.8
+    673199n 1.8
+    673200n 0
+    673249n 0
+    673250n 1.8
+    673299n 1.8
+    673300n 0
+    673349n 0
+    673350n 1.8
+    673399n 1.8
+    673400n 0
+    673449n 0
+    673450n 1.8
+    673499n 1.8
+    673500n 0
+    673549n 0
+    673550n 1.8
+    673599n 1.8
+    673600n 0
+    673649n 0
+    673650n 1.8
+    673699n 1.8
+    673700n 0
+    673749n 0
+    673750n 1.8
+    673799n 1.8
+    673800n 0
+    673849n 0
+    673850n 1.8
+    673899n 1.8
+    673900n 0
+    673949n 0
+    673950n 1.8
+    673999n 1.8
+    674000n 0
+    674049n 0
+    674050n 1.8
+    674099n 1.8
+    674100n 0
+    674149n 0
+    674150n 1.8
+    674199n 1.8
+    674200n 0
+    674249n 0
+    674250n 1.8
+    674299n 1.8
+    674300n 0
+    674349n 0
+    674350n 1.8
+    674399n 1.8
+    674400n 0
+    674449n 0
+    674450n 1.8
+    674499n 1.8
+    674500n 0
+    674549n 0
+    674550n 1.8
+    674599n 1.8
+    674600n 0
+    674649n 0
+    674650n 1.8
+    674699n 1.8
+    674700n 0
+    674749n 0
+    674750n 1.8
+    674799n 1.8
+    674800n 0
+    674849n 0
+    674850n 1.8
+    674899n 1.8
+    674900n 0
+    674949n 0
+    674950n 1.8
+    674999n 1.8
+    675000n 0
+    675049n 0
+    675050n 1.8
+    675099n 1.8
+    675100n 0
+    675149n 0
+    675150n 1.8
+    675199n 1.8
+    675200n 0
+    675249n 0
+    675250n 1.8
+    675299n 1.8
+    675300n 0
+    675349n 0
+    675350n 1.8
+    675399n 1.8
+    675400n 0
+    675449n 0
+    675450n 1.8
+    675499n 1.8
+    675500n 0
+    675549n 0
+    675550n 1.8
+    675599n 1.8
+    675600n 0
+    675649n 0
+    675650n 1.8
+    675699n 1.8
+    675700n 0
+    675749n 0
+    675750n 1.8
+    675799n 1.8
+    675800n 0
+    675849n 0
+    675850n 1.8
+    675899n 1.8
+    675900n 0
+    675949n 0
+    675950n 1.8
+    675999n 1.8
+    676000n 0
+    676049n 0
+    676050n 1.8
+    676099n 1.8
+    676100n 0
+    676149n 0
+    676150n 1.8
+    676199n 1.8
+    676200n 0
+    676249n 0
+    676250n 1.8
+    676299n 1.8
+    676300n 0
+    676349n 0
+    676350n 1.8
+    676399n 1.8
+    676400n 0
+    676449n 0
+    676450n 1.8
+    676499n 1.8
+    676500n 0
+    676549n 0
+    676550n 1.8
+    676599n 1.8
+    676600n 0
+    676649n 0
+    676650n 1.8
+    676699n 1.8
+    676700n 0
+    676749n 0
+    676750n 1.8
+    676799n 1.8
+    676800n 0
+    676849n 0
+    676850n 1.8
+    676899n 1.8
+    676900n 0
+    676949n 0
+    676950n 1.8
+    676999n 1.8
+    677000n 0
+    677049n 0
+    677050n 1.8
+    677099n 1.8
+    677100n 0
+    677149n 0
+    677150n 1.8
+    677199n 1.8
+    677200n 0
+    677249n 0
+    677250n 1.8
+    677299n 1.8
+    677300n 0
+    677349n 0
+    677350n 1.8
+    677399n 1.8
+    677400n 0
+    677449n 0
+    677450n 1.8
+    677499n 1.8
+    677500n 0
+    677549n 0
+    677550n 1.8
+    677599n 1.8
+    677600n 0
+    677649n 0
+    677650n 1.8
+    677699n 1.8
+    677700n 0
+    677749n 0
+    677750n 1.8
+    677799n 1.8
+    677800n 0
+    677849n 0
+    677850n 1.8
+    677899n 1.8
+    677900n 0
+    677949n 0
+    677950n 1.8
+    677999n 1.8
+    678000n 0
+    678049n 0
+    678050n 1.8
+    678099n 1.8
+    678100n 0
+    678149n 0
+    678150n 1.8
+    678199n 1.8
+    678200n 0
+    678249n 0
+    678250n 1.8
+    678299n 1.8
+    678300n 0
+    678349n 0
+    678350n 1.8
+    678399n 1.8
+    678400n 0
+    678449n 0
+    678450n 1.8
+    678499n 1.8
+    678500n 0
+    678549n 0
+    678550n 1.8
+    678599n 1.8
+    678600n 0
+    678649n 0
+    678650n 1.8
+    678699n 1.8
+    678700n 0
+    678749n 0
+    678750n 1.8
+    678799n 1.8
+    678800n 0
+    678849n 0
+    678850n 1.8
+    678899n 1.8
+    678900n 0
+    678949n 0
+    678950n 1.8
+    678999n 1.8
+    679000n 0
+    679049n 0
+    679050n 1.8
+    679099n 1.8
+    679100n 0
+    679149n 0
+    679150n 1.8
+    679199n 1.8
+    679200n 0
+    679249n 0
+    679250n 1.8
+    679299n 1.8
+    679300n 0
+    679349n 0
+    679350n 1.8
+    679399n 1.8
+    679400n 0
+    679449n 0
+    679450n 1.8
+    679499n 1.8
+    679500n 0
+    679549n 0
+    679550n 1.8
+    679599n 1.8
+    679600n 0
+    679649n 0
+    679650n 1.8
+    679699n 1.8
+    679700n 0
+    679749n 0
+    679750n 1.8
+    679799n 1.8
+    679800n 0
+    679849n 0
+    679850n 1.8
+    679899n 1.8
+    679900n 0
+    679949n 0
+    679950n 1.8
+    679999n 1.8
+    680000n 0
+    680049n 0
+    680050n 1.8
+    680099n 1.8
+    680100n 0
+    680149n 0
+    680150n 1.8
+    680199n 1.8
+    680200n 0
+    680249n 0
+    680250n 1.8
+    680299n 1.8
+    680300n 0
+    680349n 0
+    680350n 1.8
+    680399n 1.8
+    680400n 0
+    680449n 0
+    680450n 1.8
+    680499n 1.8
+    680500n 0
+    680549n 0
+    680550n 1.8
+    680599n 1.8
+    680600n 0
+    680649n 0
+    680650n 1.8
+    680699n 1.8
+    680700n 0
+    680749n 0
+    680750n 1.8
+    680799n 1.8
+    680800n 0
+    680849n 0
+    680850n 1.8
+    680899n 1.8
+    680900n 0
+    680949n 0
+    680950n 1.8
+    680999n 1.8
+    681000n 0
+    681049n 0
+    681050n 1.8
+    681099n 1.8
+    681100n 0
+    681149n 0
+    681150n 1.8
+    681199n 1.8
+    681200n 0
+    681249n 0
+    681250n 1.8
+    681299n 1.8
+    681300n 0
+    681349n 0
+    681350n 1.8
+    681399n 1.8
+    681400n 0
+    681449n 0
+    681450n 1.8
+    681499n 1.8
+    681500n 0
+    681549n 0
+    681550n 1.8
+    681599n 1.8
+    681600n 0
+    681649n 0
+    681650n 1.8
+    681699n 1.8
+    681700n 0
+    681749n 0
+    681750n 1.8
+    681799n 1.8
+    681800n 0
+    681849n 0
+    681850n 1.8
+    681899n 1.8
+    681900n 0
+    681949n 0
+    681950n 1.8
+    681999n 1.8
+    682000n 0
+    682049n 0
+    682050n 1.8
+    682099n 1.8
+    682100n 0
+    682149n 0
+    682150n 1.8
+    682199n 1.8
+    682200n 0
+    682249n 0
+    682250n 1.8
+    682299n 1.8
+    682300n 0
+    682349n 0
+    682350n 1.8
+    682399n 1.8
+    682400n 0
+    682449n 0
+    682450n 1.8
+    682499n 1.8
+    682500n 0
+    682549n 0
+    682550n 1.8
+    682599n 1.8
+    682600n 0
+    682649n 0
+    682650n 1.8
+    682699n 1.8
+    682700n 0
+    682749n 0
+    682750n 1.8
+    682799n 1.8
+    682800n 0
+    682849n 0
+    682850n 1.8
+    682899n 1.8
+    682900n 0
+    682949n 0
+    682950n 1.8
+    682999n 1.8
+    683000n 0
+    683049n 0
+    683050n 1.8
+    683099n 1.8
+    683100n 0
+    683149n 0
+    683150n 1.8
+    683199n 1.8
+    683200n 0
+    683249n 0
+    683250n 1.8
+    683299n 1.8
+    683300n 0
+    683349n 0
+    683350n 1.8
+    683399n 1.8
+    683400n 0
+    683449n 0
+    683450n 1.8
+    683499n 1.8
+    683500n 0
+    683549n 0
+    683550n 1.8
+    683599n 1.8
+    683600n 0
+    683649n 0
+    683650n 1.8
+    683699n 1.8
+    683700n 0
+    683749n 0
+    683750n 1.8
+    683799n 1.8
+    683800n 0
+    683849n 0
+    683850n 1.8
+    683899n 1.8
+    683900n 0
+    683949n 0
+    683950n 1.8
+    683999n 1.8
+    684000n 0
+    684049n 0
+    684050n 1.8
+    684099n 1.8
+    684100n 0
+    684149n 0
+    684150n 1.8
+    684199n 1.8
+    684200n 0
+    684249n 0
+    684250n 1.8
+    684299n 1.8
+    684300n 0
+    684349n 0
+    684350n 1.8
+    684399n 1.8
+    684400n 0
+    684449n 0
+    684450n 1.8
+    684499n 1.8
+    684500n 0
+    684549n 0
+    684550n 1.8
+    684599n 1.8
+    684600n 0
+    684649n 0
+    684650n 1.8
+    684699n 1.8
+    684700n 0
+    684749n 0
+    684750n 1.8
+    684799n 1.8
+    684800n 0
+    684849n 0
+    684850n 1.8
+    684899n 1.8
+    684900n 0
+    684949n 0
+    684950n 1.8
+    684999n 1.8
+    685000n 0
+    685049n 0
+    685050n 1.8
+    685099n 1.8
+    685100n 0
+    685149n 0
+    685150n 1.8
+    685199n 1.8
+    685200n 0
+    685249n 0
+    685250n 1.8
+    685299n 1.8
+    685300n 0
+    685349n 0
+    685350n 1.8
+    685399n 1.8
+    685400n 0
+    685449n 0
+    685450n 1.8
+    685499n 1.8
+    685500n 0
+    685549n 0
+    685550n 1.8
+    685599n 1.8
+    685600n 0
+    685649n 0
+    685650n 1.8
+    685699n 1.8
+    685700n 0
+    685749n 0
+    685750n 1.8
+    685799n 1.8
+    685800n 0
+    685849n 0
+    685850n 1.8
+    685899n 1.8
+    685900n 0
+    685949n 0
+    685950n 1.8
+    685999n 1.8
+    686000n 0
+    686049n 0
+    686050n 1.8
+    686099n 1.8
+    686100n 0
+    686149n 0
+    686150n 1.8
+    686199n 1.8
+    686200n 0
+    686249n 0
+    686250n 1.8
+    686299n 1.8
+    686300n 0
+    686349n 0
+    686350n 1.8
+    686399n 1.8
+    686400n 0
+    686449n 0
+    686450n 1.8
+    686499n 1.8
+    686500n 0
+    686549n 0
+    686550n 1.8
+    686599n 1.8
+    686600n 0
+    686649n 0
+    686650n 1.8
+    686699n 1.8
+    686700n 0
+    686749n 0
+    686750n 1.8
+    686799n 1.8
+    686800n 0
+    686849n 0
+    686850n 1.8
+    686899n 1.8
+    686900n 0
+    686949n 0
+    686950n 1.8
+    686999n 1.8
+    687000n 0
+    687049n 0
+    687050n 1.8
+    687099n 1.8
+    687100n 0
+    687149n 0
+    687150n 1.8
+    687199n 1.8
+    687200n 0
+    687249n 0
+    687250n 1.8
+    687299n 1.8
+    687300n 0
+    687349n 0
+    687350n 1.8
+    687399n 1.8
+    687400n 0
+    687449n 0
+    687450n 1.8
+    687499n 1.8
+    687500n 0
+    687549n 0
+    687550n 1.8
+    687599n 1.8
+    687600n 0
+    687649n 0
+    687650n 1.8
+    687699n 1.8
+    687700n 0
+    687749n 0
+    687750n 1.8
+    687799n 1.8
+    687800n 0
+    687849n 0
+    687850n 1.8
+    687899n 1.8
+    687900n 0
+    687949n 0
+    687950n 1.8
+    687999n 1.8
+    688000n 0
+    688049n 0
+    688050n 1.8
+    688099n 1.8
+    688100n 0
+    688149n 0
+    688150n 1.8
+    688199n 1.8
+    688200n 0
+    688249n 0
+    688250n 1.8
+    688299n 1.8
+    688300n 0
+    688349n 0
+    688350n 1.8
+    688399n 1.8
+    688400n 0
+    688449n 0
+    688450n 1.8
+    688499n 1.8
+    688500n 0
+    688549n 0
+    688550n 1.8
+    688599n 1.8
+    688600n 0
+    688649n 0
+    688650n 1.8
+    688699n 1.8
+    688700n 0
+    688749n 0
+    688750n 1.8
+    688799n 1.8
+    688800n 0
+    688849n 0
+    688850n 1.8
+    688899n 1.8
+    688900n 0
+    688949n 0
+    688950n 1.8
+    688999n 1.8
+    689000n 0
+    689049n 0
+    689050n 1.8
+    689099n 1.8
+    689100n 0
+    689149n 0
+    689150n 1.8
+    689199n 1.8
+    689200n 0
+    689249n 0
+    689250n 1.8
+    689299n 1.8
+    689300n 0
+    689349n 0
+    689350n 1.8
+    689399n 1.8
+    689400n 0
+    689449n 0
+    689450n 1.8
+    689499n 1.8
+    689500n 0
+    689549n 0
+    689550n 1.8
+    689599n 1.8
+    689600n 0
+    689649n 0
+    689650n 1.8
+    689699n 1.8
+    689700n 0
+    689749n 0
+    689750n 1.8
+    689799n 1.8
+    689800n 0
+    689849n 0
+    689850n 1.8
+    689899n 1.8
+    689900n 0
+    689949n 0
+    689950n 1.8
+    689999n 1.8
+    690000n 0
+    690049n 0
+    690050n 1.8
+    690099n 1.8
+    690100n 0
+    690149n 0
+    690150n 1.8
+    690199n 1.8
+    690200n 0
+    690249n 0
+    690250n 1.8
+    690299n 1.8
+    690300n 0
+    690349n 0
+    690350n 1.8
+    690399n 1.8
+    690400n 0
+    690449n 0
+    690450n 1.8
+    690499n 1.8
+    690500n 0
+    690549n 0
+    690550n 1.8
+    690599n 1.8
+    690600n 0
+    690649n 0
+    690650n 1.8
+    690699n 1.8
+    690700n 0
+    690749n 0
+    690750n 1.8
+    690799n 1.8
+    690800n 0
+    690849n 0
+    690850n 1.8
+    690899n 1.8
+    690900n 0
+    690949n 0
+    690950n 1.8
+    690999n 1.8
+    691000n 0
+    691049n 0
+    691050n 1.8
+    691099n 1.8
+    691100n 0
+    691149n 0
+    691150n 1.8
+    691199n 1.8
+    691200n 0
+    691249n 0
+    691250n 1.8
+    691299n 1.8
+    691300n 0
+    691349n 0
+    691350n 1.8
+    691399n 1.8
+    691400n 0
+    691449n 0
+    691450n 1.8
+    691499n 1.8
+    691500n 0
+    691549n 0
+    691550n 1.8
+    691599n 1.8
+    691600n 0
+    691649n 0
+    691650n 1.8
+    691699n 1.8
+    691700n 0
+    691749n 0
+    691750n 1.8
+    691799n 1.8
+    691800n 0
+    691849n 0
+    691850n 1.8
+    691899n 1.8
+    691900n 0
+    691949n 0
+    691950n 1.8
+    691999n 1.8
+    692000n 0
+    692049n 0
+    692050n 1.8
+    692099n 1.8
+    692100n 0
+    692149n 0
+    692150n 1.8
+    692199n 1.8
+    692200n 0
+    692249n 0
+    692250n 1.8
+    692299n 1.8
+    692300n 0
+    692349n 0
+    692350n 1.8
+    692399n 1.8
+    692400n 0
+    692449n 0
+    692450n 1.8
+    692499n 1.8
+    692500n 0
+    692549n 0
+    692550n 1.8
+    692599n 1.8
+    692600n 0
+    692649n 0
+    692650n 1.8
+    692699n 1.8
+    692700n 0
+    692749n 0
+    692750n 1.8
+    692799n 1.8
+    692800n 0
+    692849n 0
+    692850n 1.8
+    692899n 1.8
+    692900n 0
+    692949n 0
+    692950n 1.8
+    692999n 1.8
+    693000n 0
+    693049n 0
+    693050n 1.8
+    693099n 1.8
+    693100n 0
+    693149n 0
+    693150n 1.8
+    693199n 1.8
+    693200n 0
+    693249n 0
+    693250n 1.8
+    693299n 1.8
+    693300n 0
+    693349n 0
+    693350n 1.8
+    693399n 1.8
+    693400n 0
+    693449n 0
+    693450n 1.8
+    693499n 1.8
+    693500n 0
+    693549n 0
+    693550n 1.8
+    693599n 1.8
+    693600n 0
+    693649n 0
+    693650n 1.8
+    693699n 1.8
+    693700n 0
+    693749n 0
+    693750n 1.8
+    693799n 1.8
+    693800n 0
+    693849n 0
+    693850n 1.8
+    693899n 1.8
+    693900n 0
+    693949n 0
+    693950n 1.8
+    693999n 1.8
+    694000n 0
+    694049n 0
+    694050n 1.8
+    694099n 1.8
+    694100n 0
+    694149n 0
+    694150n 1.8
+    694199n 1.8
+    694200n 0
+    694249n 0
+    694250n 1.8
+    694299n 1.8
+    694300n 0
+    694349n 0
+    694350n 1.8
+    694399n 1.8
+    694400n 0
+    694449n 0
+    694450n 1.8
+    694499n 1.8
+    694500n 0
+    694549n 0
+    694550n 1.8
+    694599n 1.8
+    694600n 0
+    694649n 0
+    694650n 1.8
+    694699n 1.8
+    694700n 0
+    694749n 0
+    694750n 1.8
+    694799n 1.8
+    694800n 0
+    694849n 0
+    694850n 1.8
+    694899n 1.8
+    694900n 0
+    694949n 0
+    694950n 1.8
+    694999n 1.8
+    695000n 0
+    695049n 0
+    695050n 1.8
+    695099n 1.8
+    695100n 0
+    695149n 0
+    695150n 1.8
+    695199n 1.8
+    695200n 0
+    695249n 0
+    695250n 1.8
+    695299n 1.8
+    695300n 0
+    695349n 0
+    695350n 1.8
+    695399n 1.8
+    695400n 0
+    695449n 0
+    695450n 1.8
+    695499n 1.8
+    695500n 0
+    695549n 0
+    695550n 1.8
+    695599n 1.8
+    695600n 0
+    695649n 0
+    695650n 1.8
+    695699n 1.8
+    695700n 0
+    695749n 0
+    695750n 1.8
+    695799n 1.8
+    695800n 0
+    695849n 0
+    695850n 1.8
+    695899n 1.8
+    695900n 0
+    695949n 0
+    695950n 1.8
+    695999n 1.8
+    696000n 0
+    696049n 0
+    696050n 1.8
+    696099n 1.8
+    696100n 0
+    696149n 0
+    696150n 1.8
+    696199n 1.8
+    696200n 0
+    696249n 0
+    696250n 1.8
+    696299n 1.8
+    696300n 0
+    696349n 0
+    696350n 1.8
+    696399n 1.8
+    696400n 0
+    696449n 0
+    696450n 1.8
+    696499n 1.8
+    696500n 0
+    696549n 0
+    696550n 1.8
+    696599n 1.8
+    696600n 0
+    696649n 0
+    696650n 1.8
+    696699n 1.8
+    696700n 0
+    696749n 0
+    696750n 1.8
+    696799n 1.8
+    696800n 0
+    696849n 0
+    696850n 1.8
+    696899n 1.8
+    696900n 0
+    696949n 0
+    696950n 1.8
+    696999n 1.8
+    697000n 0
+    697049n 0
+    697050n 1.8
+    697099n 1.8
+    697100n 0
+    697149n 0
+    697150n 1.8
+    697199n 1.8
+    697200n 0
+    697249n 0
+    697250n 1.8
+    697299n 1.8
+    697300n 0
+    697349n 0
+    697350n 1.8
+    697399n 1.8
+    697400n 0
+    697449n 0
+    697450n 1.8
+    697499n 1.8
+    697500n 0
+    697549n 0
+    697550n 1.8
+    697599n 1.8
+    697600n 0
+    697649n 0
+    697650n 1.8
+    697699n 1.8
+    697700n 0
+    697749n 0
+    697750n 1.8
+    697799n 1.8
+    697800n 0
+    697849n 0
+    697850n 1.8
+    697899n 1.8
+    697900n 0
+    697949n 0
+    697950n 1.8
+    697999n 1.8
+    698000n 0
+    698049n 0
+    698050n 1.8
+    698099n 1.8
+    698100n 0
+    698149n 0
+    698150n 1.8
+    698199n 1.8
+    698200n 0
+    698249n 0
+    698250n 1.8
+    698299n 1.8
+    698300n 0
+    698349n 0
+    698350n 1.8
+    698399n 1.8
+    698400n 0
+    698449n 0
+    698450n 1.8
+    698499n 1.8
+    698500n 0
+    698549n 0
+    698550n 1.8
+    698599n 1.8
+    698600n 0
+    698649n 0
+    698650n 1.8
+    698699n 1.8
+    698700n 0
+    698749n 0
+    698750n 1.8
+    698799n 1.8
+    698800n 0
+    698849n 0
+    698850n 1.8
+    698899n 1.8
+    698900n 0
+    698949n 0
+    698950n 1.8
+    698999n 1.8
+    699000n 0
+    699049n 0
+    699050n 1.8
+    699099n 1.8
+    699100n 0
+    699149n 0
+    699150n 1.8
+    699199n 1.8
+    699200n 0
+    699249n 0
+    699250n 1.8
+    699299n 1.8
+    699300n 0
+    699349n 0
+    699350n 1.8
+    699399n 1.8
+    699400n 0
+    699449n 0
+    699450n 1.8
+    699499n 1.8
+    699500n 0
+    699549n 0
+    699550n 1.8
+    699599n 1.8
+    699600n 0
+    699649n 0
+    699650n 1.8
+    699699n 1.8
+    699700n 0
+    699749n 0
+    699750n 1.8
+    699799n 1.8
+    699800n 0
+    699849n 0
+    699850n 1.8
+    699899n 1.8
+    699900n 0
+    699949n 0
+    699950n 1.8
+    699999n 1.8
+    700000n 0
+    700049n 0
+    700050n 1.8
+    700099n 1.8
+    700100n 0
+    700149n 0
+    700150n 1.8
+    700199n 1.8
+    700200n 0
+    700249n 0
+    700250n 1.8
+    700299n 1.8
+    700300n 0
+    700349n 0
+    700350n 1.8
+    700399n 1.8
+    700400n 0
+    700449n 0
+    700450n 1.8
+    700499n 1.8
+    700500n 0
+    700549n 0
+    700550n 1.8
+    700599n 1.8
+    700600n 0
+    700649n 0
+    700650n 1.8
+    700699n 1.8
+    700700n 0
+    700749n 0
+    700750n 1.8
+    700799n 1.8
+    700800n 0
+    700849n 0
+    700850n 1.8
+    700899n 1.8
+    700900n 0
+    700949n 0
+    700950n 1.8
+    700999n 1.8
+    701000n 0
+    701049n 0
+    701050n 1.8
+    701099n 1.8
+    701100n 0
+    701149n 0
+    701150n 1.8
+    701199n 1.8
+    701200n 0
+    701249n 0
+    701250n 1.8
+    701299n 1.8
+    701300n 0
+    701349n 0
+    701350n 1.8
+    701399n 1.8
+    701400n 0
+    701449n 0
+    701450n 1.8
+    701499n 1.8
+    701500n 0
+    701549n 0
+    701550n 1.8
+    701599n 1.8
+    701600n 0
+    701649n 0
+    701650n 1.8
+    701699n 1.8
+    701700n 0
+    701749n 0
+    701750n 1.8
+    701799n 1.8
+    701800n 0
+    701849n 0
+    701850n 1.8
+    701899n 1.8
+    701900n 0
+    701949n 0
+    701950n 1.8
+    701999n 1.8
+    702000n 0
+    702049n 0
+    702050n 1.8
+    702099n 1.8
+    702100n 0
+    702149n 0
+    702150n 1.8
+    702199n 1.8
+    702200n 0
+    702249n 0
+    702250n 1.8
+    702299n 1.8
+    702300n 0
+    702349n 0
+    702350n 1.8
+    702399n 1.8
+    702400n 0
+    702449n 0
+    702450n 1.8
+    702499n 1.8
+    702500n 0
+    702549n 0
+    702550n 1.8
+    702599n 1.8
+    702600n 0
+    702649n 0
+    702650n 1.8
+    702699n 1.8
+    702700n 0
+    702749n 0
+    702750n 1.8
+    702799n 1.8
+    702800n 0
+    702849n 0
+    702850n 1.8
+    702899n 1.8
+    702900n 0
+    702949n 0
+    702950n 1.8
+    702999n 1.8
+    703000n 0
+    703049n 0
+    703050n 1.8
+    703099n 1.8
+    703100n 0
+    703149n 0
+    703150n 1.8
+    703199n 1.8
+    703200n 0
+    703249n 0
+    703250n 1.8
+    703299n 1.8
+    703300n 0
+    703349n 0
+    703350n 1.8
+    703399n 1.8
+    703400n 0
+    703449n 0
+    703450n 1.8
+    703499n 1.8
+    703500n 0
+    703549n 0
+    703550n 1.8
+    703599n 1.8
+    703600n 0
+    703649n 0
+    703650n 1.8
+    703699n 1.8
+    703700n 0
+    703749n 0
+    703750n 1.8
+    703799n 1.8
+    703800n 0
+    703849n 0
+    703850n 1.8
+    703899n 1.8
+    703900n 0
+    703949n 0
+    703950n 1.8
+    703999n 1.8
+    704000n 0
+    704049n 0
+    704050n 1.8
+    704099n 1.8
+    704100n 0
+    704149n 0
+    704150n 1.8
+    704199n 1.8
+    704200n 0
+    704249n 0
+    704250n 1.8
+    704299n 1.8
+    704300n 0
+    704349n 0
+    704350n 1.8
+    704399n 1.8
+    704400n 0
+    704449n 0
+    704450n 1.8
+    704499n 1.8
+    704500n 0
+    704549n 0
+    704550n 1.8
+    704599n 1.8
+    704600n 0
+    704649n 0
+    704650n 1.8
+    704699n 1.8
+    704700n 0
+    704749n 0
+    704750n 1.8
+    704799n 1.8
+    704800n 0
+    704849n 0
+    704850n 1.8
+    704899n 1.8
+    704900n 0
+    704949n 0
+    704950n 1.8
+    704999n 1.8
+    705000n 0
+    705049n 0
+    705050n 1.8
+    705099n 1.8
+    705100n 0
+    705149n 0
+    705150n 1.8
+    705199n 1.8
+    705200n 0
+    705249n 0
+    705250n 1.8
+    705299n 1.8
+    705300n 0
+    705349n 0
+    705350n 1.8
+    705399n 1.8
+    705400n 0
+    705449n 0
+    705450n 1.8
+    705499n 1.8
+    705500n 0
+    705549n 0
+    705550n 1.8
+    705599n 1.8
+    705600n 0
+    705649n 0
+    705650n 1.8
+    705699n 1.8
+    705700n 0
+    705749n 0
+    705750n 1.8
+    705799n 1.8
+    705800n 0
+    705849n 0
+    705850n 1.8
+    705899n 1.8
+    705900n 0
+    705949n 0
+    705950n 1.8
+    705999n 1.8
+    706000n 0
+    706049n 0
+    706050n 1.8
+    706099n 1.8
+    706100n 0
+    706149n 0
+    706150n 1.8
+    706199n 1.8
+    706200n 0
+    706249n 0
+    706250n 1.8
+    706299n 1.8
+    706300n 0
+    706349n 0
+    706350n 1.8
+    706399n 1.8
+    706400n 0
+    706449n 0
+    706450n 1.8
+    706499n 1.8
+    706500n 0
+    706549n 0
+    706550n 1.8
+    706599n 1.8
+    706600n 0
+    706649n 0
+    706650n 1.8
+    706699n 1.8
+    706700n 0
+    706749n 0
+    706750n 1.8
+    706799n 1.8
+    706800n 0
+    706849n 0
+    706850n 1.8
+    706899n 1.8
+    706900n 0
+    706949n 0
+    706950n 1.8
+    706999n 1.8
+    707000n 0
+    707049n 0
+    707050n 1.8
+    707099n 1.8
+    707100n 0
+    707149n 0
+    707150n 1.8
+    707199n 1.8
+    707200n 0
+    707249n 0
+    707250n 1.8
+    707299n 1.8
+    707300n 0
+    707349n 0
+    707350n 1.8
+    707399n 1.8
+    707400n 0
+    707449n 0
+    707450n 1.8
+    707499n 1.8
+    707500n 0
+    707549n 0
+    707550n 1.8
+    707599n 1.8
+    707600n 0
+    707649n 0
+    707650n 1.8
+    707699n 1.8
+    707700n 0
+    707749n 0
+    707750n 1.8
+    707799n 1.8
+    707800n 0
+    707849n 0
+    707850n 1.8
+    707899n 1.8
+    707900n 0
+    707949n 0
+    707950n 1.8
+    707999n 1.8
+    708000n 0
+    708049n 0
+    708050n 1.8
+    708099n 1.8
+    708100n 0
+    708149n 0
+    708150n 1.8
+    708199n 1.8
+    708200n 0
+    708249n 0
+    708250n 1.8
+    708299n 1.8
+    708300n 0
+    708349n 0
+    708350n 1.8
+    708399n 1.8
+    708400n 0
+    708449n 0
+    708450n 1.8
+    708499n 1.8
+    708500n 0
+    708549n 0
+    708550n 1.8
+    708599n 1.8
+    708600n 0
+    708649n 0
+    708650n 1.8
+    708699n 1.8
+    708700n 0
+    708749n 0
+    708750n 1.8
+    708799n 1.8
+    708800n 0
+    708849n 0
+    708850n 1.8
+    708899n 1.8
+    708900n 0
+    708949n 0
+    708950n 1.8
+    708999n 1.8
+    709000n 0
+    709049n 0
+    709050n 1.8
+    709099n 1.8
+    709100n 0
+    709149n 0
+    709150n 1.8
+    709199n 1.8
+    709200n 0
+    709249n 0
+    709250n 1.8
+    709299n 1.8
+    709300n 0
+    709349n 0
+    709350n 1.8
+    709399n 1.8
+    709400n 0
+    709449n 0
+    709450n 1.8
+    709499n 1.8
+    709500n 0
+    709549n 0
+    709550n 1.8
+    709599n 1.8
+    709600n 0
+    709649n 0
+    709650n 1.8
+    709699n 1.8
+    709700n 0
+    709749n 0
+    709750n 1.8
+    709799n 1.8
+    709800n 0
+    709849n 0
+    709850n 1.8
+    709899n 1.8
+    709900n 0
+    709949n 0
+    709950n 1.8
+    709999n 1.8
+    710000n 0
+    710049n 0
+    710050n 1.8
+    710099n 1.8
+    710100n 0
+    710149n 0
+    710150n 1.8
+    710199n 1.8
+    710200n 0
+    710249n 0
+    710250n 1.8
+    710299n 1.8
+    710300n 0
+    710349n 0
+    710350n 1.8
+    710399n 1.8
+    710400n 0
+    710449n 0
+    710450n 1.8
+    710499n 1.8
+    710500n 0
+    710549n 0
+    710550n 1.8
+    710599n 1.8
+    710600n 0
+    710649n 0
+    710650n 1.8
+    710699n 1.8
+    710700n 0
+    710749n 0
+    710750n 1.8
+    710799n 1.8
+    710800n 0
+    710849n 0
+    710850n 1.8
+    710899n 1.8
+    710900n 0
+    710949n 0
+    710950n 1.8
+    710999n 1.8
+    711000n 0
+    711049n 0
+    711050n 1.8
+    711099n 1.8
+    711100n 0
+    711149n 0
+    711150n 1.8
+    711199n 1.8
+    711200n 0
+    711249n 0
+    711250n 1.8
+    711299n 1.8
+    711300n 0
+    711349n 0
+    711350n 1.8
+    711399n 1.8
+    711400n 0
+    711449n 0
+    711450n 1.8
+    711499n 1.8
+    711500n 0
+    711549n 0
+    711550n 1.8
+    711599n 1.8
+    711600n 0
+    711649n 0
+    711650n 1.8
+    711699n 1.8
+    711700n 0
+    711749n 0
+    711750n 1.8
+    711799n 1.8
+    711800n 0
+    711849n 0
+    711850n 1.8
+    711899n 1.8
+    711900n 0
+    711949n 0
+    711950n 1.8
+    711999n 1.8
+    712000n 0
+    712049n 0
+    712050n 1.8
+    712099n 1.8
+    712100n 0
+    712149n 0
+    712150n 1.8
+    712199n 1.8
+    712200n 0
+    712249n 0
+    712250n 1.8
+    712299n 1.8
+    712300n 0
+    712349n 0
+    712350n 1.8
+    712399n 1.8
+    712400n 0
+    712449n 0
+    712450n 1.8
+    712499n 1.8
+    712500n 0
+    712549n 0
+    712550n 1.8
+    712599n 1.8
+    712600n 0
+    712649n 0
+    712650n 1.8
+    712699n 1.8
+    712700n 0
+    712749n 0
+    712750n 1.8
+    712799n 1.8
+    712800n 0
+    712849n 0
+    712850n 1.8
+    712899n 1.8
+    712900n 0
+    712949n 0
+    712950n 1.8
+    712999n 1.8
+    713000n 0
+    713049n 0
+    713050n 1.8
+    713099n 1.8
+    713100n 0
+    713149n 0
+    713150n 1.8
+    713199n 1.8
+    713200n 0
+    713249n 0
+    713250n 1.8
+    713299n 1.8
+    713300n 0
+    713349n 0
+    713350n 1.8
+    713399n 1.8
+    713400n 0
+    713449n 0
+    713450n 1.8
+    713499n 1.8
+    713500n 0
+    713549n 0
+    713550n 1.8
+    713599n 1.8
+    713600n 0
+    713649n 0
+    713650n 1.8
+    713699n 1.8
+    713700n 0
+    713749n 0
+    713750n 1.8
+    713799n 1.8
+    713800n 0
+    713849n 0
+    713850n 1.8
+    713899n 1.8
+    713900n 0
+    713949n 0
+    713950n 1.8
+    713999n 1.8
+    714000n 0
+    714049n 0
+    714050n 1.8
+    714099n 1.8
+    714100n 0
+    714149n 0
+    714150n 1.8
+    714199n 1.8
+    714200n 0
+    714249n 0
+    714250n 1.8
+    714299n 1.8
+    714300n 0
+    714349n 0
+    714350n 1.8
+    714399n 1.8
+    714400n 0
+    714449n 0
+    714450n 1.8
+    714499n 1.8
+    714500n 0
+    714549n 0
+    714550n 1.8
+    714599n 1.8
+    714600n 0
+    714649n 0
+    714650n 1.8
+    714699n 1.8
+    714700n 0
+    714749n 0
+    714750n 1.8
+    714799n 1.8
+    714800n 0
+    714849n 0
+    714850n 1.8
+    714899n 1.8
+    714900n 0
+    714949n 0
+    714950n 1.8
+    714999n 1.8
+    715000n 0
+    715049n 0
+    715050n 1.8
+    715099n 1.8
+    715100n 0
+    715149n 0
+    715150n 1.8
+    715199n 1.8
+    715200n 0
+    715249n 0
+    715250n 1.8
+    715299n 1.8
+    715300n 0
+    715349n 0
+    715350n 1.8
+    715399n 1.8
+    715400n 0
+    715449n 0
+    715450n 1.8
+    715499n 1.8
+    715500n 0
+    715549n 0
+    715550n 1.8
+    715599n 1.8
+    715600n 0
+    715649n 0
+    715650n 1.8
+    715699n 1.8
+    715700n 0
+    715749n 0
+    715750n 1.8
+    715799n 1.8
+    715800n 0
+    715849n 0
+    715850n 1.8
+    715899n 1.8
+    715900n 0
+    715949n 0
+    715950n 1.8
+    715999n 1.8
+    716000n 0
+    716049n 0
+    716050n 1.8
+    716099n 1.8
+    716100n 0
+    716149n 0
+    716150n 1.8
+    716199n 1.8
+    716200n 0
+    716249n 0
+    716250n 1.8
+    716299n 1.8
+    716300n 0
+    716349n 0
+    716350n 1.8
+    716399n 1.8
+    716400n 0
+    716449n 0
+    716450n 1.8
+    716499n 1.8
+    716500n 0
+    716549n 0
+    716550n 1.8
+    716599n 1.8
+    716600n 0
+    716649n 0
+    716650n 1.8
+    716699n 1.8
+    716700n 0
+    716749n 0
+    716750n 1.8
+    716799n 1.8
+    716800n 0
+    716849n 0
+    716850n 1.8
+    716899n 1.8
+    716900n 0
+    716949n 0
+    716950n 1.8
+    716999n 1.8
+    717000n 0
+    717049n 0
+    717050n 1.8
+    717099n 1.8
+    717100n 0
+    717149n 0
+    717150n 1.8
+    717199n 1.8
+    717200n 0
+    717249n 0
+    717250n 1.8
+    717299n 1.8
+    717300n 0
+    717349n 0
+    717350n 1.8
+    717399n 1.8
+    717400n 0
+    717449n 0
+    717450n 1.8
+    717499n 1.8
+    717500n 0
+    717549n 0
+    717550n 1.8
+    717599n 1.8
+    717600n 0
+    717649n 0
+    717650n 1.8
+    717699n 1.8
+    717700n 0
+    717749n 0
+    717750n 1.8
+    717799n 1.8
+    717800n 0
+    717849n 0
+    717850n 1.8
+    717899n 1.8
+    717900n 0
+    717949n 0
+    717950n 1.8
+    717999n 1.8
+    718000n 0
+    718049n 0
+    718050n 1.8
+    718099n 1.8
+    718100n 0
+    718149n 0
+    718150n 1.8
+    718199n 1.8
+    718200n 0
+    718249n 0
+    718250n 1.8
+    718299n 1.8
+    718300n 0
+    718349n 0
+    718350n 1.8
+    718399n 1.8
+    718400n 0
+    718449n 0
+    718450n 1.8
+    718499n 1.8
+    718500n 0
+    718549n 0
+    718550n 1.8
+    718599n 1.8
+    718600n 0
+    718649n 0
+    718650n 1.8
+    718699n 1.8
+    718700n 0
+    718749n 0
+    718750n 1.8
+    718799n 1.8
+    718800n 0
+    718849n 0
+    718850n 1.8
+    718899n 1.8
+    718900n 0
+    718949n 0
+    718950n 1.8
+    718999n 1.8
+    719000n 0
+    719049n 0
+    719050n 1.8
+    719099n 1.8
+    719100n 0
+    719149n 0
+    719150n 1.8
+    719199n 1.8
+    719200n 0
+    719249n 0
+    719250n 1.8
+    719299n 1.8
+    719300n 0
+    719349n 0
+    719350n 1.8
+    719399n 1.8
+    719400n 0
+    719449n 0
+    719450n 1.8
+    719499n 1.8
+    719500n 0
+    719549n 0
+    719550n 1.8
+    719599n 1.8
+    719600n 0
+    719649n 0
+    719650n 1.8
+    719699n 1.8
+    719700n 0
+    719749n 0
+    719750n 1.8
+    719799n 1.8
+    719800n 0
+    719849n 0
+    719850n 1.8
+    719899n 1.8
+    719900n 0
+    719949n 0
+    719950n 1.8
+    719999n 1.8
+    720000n 0
+    720049n 0
+    720050n 1.8
+    720099n 1.8
+    720100n 0
+    720149n 0
+    720150n 1.8
+    720199n 1.8
+    720200n 0
+    720249n 0
+    720250n 1.8
+    720299n 1.8
+    720300n 0
+    720349n 0
+    720350n 1.8
+    720399n 1.8
+    720400n 0
+    720449n 0
+    720450n 1.8
+    720499n 1.8
+    720500n 0
+    720549n 0
+    720550n 1.8
+    720599n 1.8
+    720600n 0
+    720649n 0
+    720650n 1.8
+    720699n 1.8
+    720700n 0
+    720749n 0
+    720750n 1.8
+    720799n 1.8
+    720800n 0
+    720849n 0
+    720850n 1.8
+    720899n 1.8
+    720900n 0
+    720949n 0
+    720950n 1.8
+    720999n 1.8
+    721000n 0
+    721049n 0
+    721050n 1.8
+    721099n 1.8
+    721100n 0
+    721149n 0
+    721150n 1.8
+    721199n 1.8
+    721200n 0
+    721249n 0
+    721250n 1.8
+    721299n 1.8
+    721300n 0
+    721349n 0
+    721350n 1.8
+    721399n 1.8
+    721400n 0
+    721449n 0
+    721450n 1.8
+    721499n 1.8
+    721500n 0
+    721549n 0
+    721550n 1.8
+    721599n 1.8
+    721600n 0
+    721649n 0
+    721650n 1.8
+    721699n 1.8
+    721700n 0
+    721749n 0
+    721750n 1.8
+    721799n 1.8
+    721800n 0
+    721849n 0
+    721850n 1.8
+    721899n 1.8
+    721900n 0
+    721949n 0
+    721950n 1.8
+    721999n 1.8
+    722000n 0
+    722049n 0
+    722050n 1.8
+    722099n 1.8
+    722100n 0
+    722149n 0
+    722150n 1.8
+    722199n 1.8
+    722200n 0
+    722249n 0
+    722250n 1.8
+    722299n 1.8
+    722300n 0
+    722349n 0
+    722350n 1.8
+    722399n 1.8
+    722400n 0
+    722449n 0
+    722450n 1.8
+    722499n 1.8
+    722500n 0
+    722549n 0
+    722550n 1.8
+    722599n 1.8
+    722600n 0
+    722649n 0
+    722650n 1.8
+    722699n 1.8
+    722700n 0
+    722749n 0
+    722750n 1.8
+    722799n 1.8
+    722800n 0
+    722849n 0
+    722850n 1.8
+    722899n 1.8
+    722900n 0
+    722949n 0
+    722950n 1.8
+    722999n 1.8
+    723000n 0
+    723049n 0
+    723050n 1.8
+    723099n 1.8
+    723100n 0
+    723149n 0
+    723150n 1.8
+    723199n 1.8
+    723200n 0
+    723249n 0
+    723250n 1.8
+    723299n 1.8
+    723300n 0
+    723349n 0
+    723350n 1.8
+    723399n 1.8
+    723400n 0
+    723449n 0
+    723450n 1.8
+    723499n 1.8
+    723500n 0
+    723549n 0
+    723550n 1.8
+    723599n 1.8
+    723600n 0
+    723649n 0
+    723650n 1.8
+    723699n 1.8
+    723700n 0
+    723749n 0
+    723750n 1.8
+    723799n 1.8
+    723800n 0
+    723849n 0
+    723850n 1.8
+    723899n 1.8
+    723900n 0
+    723949n 0
+    723950n 1.8
+    723999n 1.8
+    724000n 0
+    724049n 0
+    724050n 1.8
+    724099n 1.8
+    724100n 0
+    724149n 0
+    724150n 1.8
+    724199n 1.8
+    724200n 0
+    724249n 0
+    724250n 1.8
+    724299n 1.8
+    724300n 0
+    724349n 0
+    724350n 1.8
+    724399n 1.8
+    724400n 0
+    724449n 0
+    724450n 1.8
+    724499n 1.8
+    724500n 0
+    724549n 0
+    724550n 1.8
+    724599n 1.8
+    724600n 0
+    724649n 0
+    724650n 1.8
+    724699n 1.8
+    724700n 0
+    724749n 0
+    724750n 1.8
+    724799n 1.8
+    724800n 0
+    724849n 0
+    724850n 1.8
+    724899n 1.8
+    724900n 0
+    724949n 0
+    724950n 1.8
+    724999n 1.8
+    725000n 0
+    725049n 0
+    725050n 1.8
+    725099n 1.8
+    725100n 0
+    725149n 0
+    725150n 1.8
+    725199n 1.8
+    725200n 0
+    725249n 0
+    725250n 1.8
+    725299n 1.8
+    725300n 0
+    725349n 0
+    725350n 1.8
+    725399n 1.8
+    725400n 0
+    725449n 0
+    725450n 1.8
+    725499n 1.8
+    725500n 0
+    725549n 0
+    725550n 1.8
+    725599n 1.8
+    725600n 0
+    725649n 0
+    725650n 1.8
+    725699n 1.8
+    725700n 0
+    725749n 0
+    725750n 1.8
+    725799n 1.8
+    725800n 0
+    725849n 0
+    725850n 1.8
+    725899n 1.8
+    725900n 0
+    725949n 0
+    725950n 1.8
+    725999n 1.8
+    726000n 0
+    726049n 0
+    726050n 1.8
+    726099n 1.8
+    726100n 0
+    726149n 0
+    726150n 1.8
+    726199n 1.8
+    726200n 0
+    726249n 0
+    726250n 1.8
+    726299n 1.8
+    726300n 0
+    726349n 0
+    726350n 1.8
+    726399n 1.8
+    726400n 0
+    726449n 0
+    726450n 1.8
+    726499n 1.8
+    726500n 0
+    726549n 0
+    726550n 1.8
+    726599n 1.8
+    726600n 0
+    726649n 0
+    726650n 1.8
+    726699n 1.8
+    726700n 0
+    726749n 0
+    726750n 1.8
+    726799n 1.8
+    726800n 0
+    726849n 0
+    726850n 1.8
+    726899n 1.8
+    726900n 0
+    726949n 0
+    726950n 1.8
+    726999n 1.8
+    727000n 0
+    727049n 0
+    727050n 1.8
+    727099n 1.8
+    727100n 0
+    727149n 0
+    727150n 1.8
+    727199n 1.8
+    727200n 0
+    727249n 0
+    727250n 1.8
+    727299n 1.8
+    727300n 0
+    727349n 0
+    727350n 1.8
+    727399n 1.8
+    727400n 0
+    727449n 0
+    727450n 1.8
+    727499n 1.8
+    727500n 0
+    727549n 0
+    727550n 1.8
+    727599n 1.8
+    727600n 0
+    727649n 0
+    727650n 1.8
+    727699n 1.8
+    727700n 0
+    727749n 0
+    727750n 1.8
+    727799n 1.8
+    727800n 0
+    727849n 0
+    727850n 1.8
+    727899n 1.8
+    727900n 0
+    727949n 0
+    727950n 1.8
+    727999n 1.8
+    728000n 0
+    728049n 0
+    728050n 1.8
+    728099n 1.8
+    728100n 0
+    728149n 0
+    728150n 1.8
+    728199n 1.8
+    728200n 0
+    728249n 0
+    728250n 1.8
+    728299n 1.8
+    728300n 0
+    728349n 0
+    728350n 1.8
+    728399n 1.8
+    728400n 0
+    728449n 0
+    728450n 1.8
+    728499n 1.8
+    728500n 0
+    728549n 0
+    728550n 1.8
+    728599n 1.8
+    728600n 0
+    728649n 0
+    728650n 1.8
+    728699n 1.8
+    728700n 0
+    728749n 0
+    728750n 1.8
+    728799n 1.8
+    728800n 0
+    728849n 0
+    728850n 1.8
+    728899n 1.8
+    728900n 0
+    728949n 0
+    728950n 1.8
+    728999n 1.8
+    729000n 0
+    729049n 0
+    729050n 1.8
+    729099n 1.8
+    729100n 0
+    729149n 0
+    729150n 1.8
+    729199n 1.8
+    729200n 0
+    729249n 0
+    729250n 1.8
+    729299n 1.8
+    729300n 0
+    729349n 0
+    729350n 1.8
+    729399n 1.8
+    729400n 0
+    729449n 0
+    729450n 1.8
+    729499n 1.8
+    729500n 0
+    729549n 0
+    729550n 1.8
+    729599n 1.8
+    729600n 0
+    729649n 0
+    729650n 1.8
+    729699n 1.8
+    729700n 0
+    729749n 0
+    729750n 1.8
+    729799n 1.8
+    729800n 0
+    729849n 0
+    729850n 1.8
+    729899n 1.8
+    729900n 0
+    729949n 0
+    729950n 1.8
+    729999n 1.8
+    730000n 0
+    730049n 0
+    730050n 1.8
+    730099n 1.8
+    730100n 0
+    730149n 0
+    730150n 1.8
+    730199n 1.8
+    730200n 0
+    730249n 0
+    730250n 1.8
+    730299n 1.8
+    730300n 0
+    730349n 0
+    730350n 1.8
+    730399n 1.8
+    730400n 0
+    730449n 0
+    730450n 1.8
+    730499n 1.8
+    730500n 0
+    730549n 0
+    730550n 1.8
+    730599n 1.8
+    730600n 0
+    730649n 0
+    730650n 1.8
+    730699n 1.8
+    730700n 0
+    730749n 0
+    730750n 1.8
+    730799n 1.8
+    730800n 0
+    730849n 0
+    730850n 1.8
+    730899n 1.8
+    730900n 0
+    730949n 0
+    730950n 1.8
+    730999n 1.8
+    731000n 0
+    731049n 0
+    731050n 1.8
+    731099n 1.8
+    731100n 0
+    731149n 0
+    731150n 1.8
+    731199n 1.8
+    731200n 0
+    731249n 0
+    731250n 1.8
+    731299n 1.8
+    731300n 0
+    731349n 0
+    731350n 1.8
+    731399n 1.8
+    731400n 0
+    731449n 0
+    731450n 1.8
+    731499n 1.8
+    731500n 0
+    731549n 0
+    731550n 1.8
+    731599n 1.8
+    731600n 0
+    731649n 0
+    731650n 1.8
+    731699n 1.8
+    731700n 0
+    731749n 0
+    731750n 1.8
+    731799n 1.8
+    731800n 0
+    731849n 0
+    731850n 1.8
+    731899n 1.8
+    731900n 0
+    731949n 0
+    731950n 1.8
+    731999n 1.8
+    732000n 0
+    732049n 0
+    732050n 1.8
+    732099n 1.8
+    732100n 0
+    732149n 0
+    732150n 1.8
+    732199n 1.8
+    732200n 0
+    732249n 0
+    732250n 1.8
+    732299n 1.8
+    732300n 0
+    732349n 0
+    732350n 1.8
+    732399n 1.8
+    732400n 0
+    732449n 0
+    732450n 1.8
+    732499n 1.8
+    732500n 0
+    732549n 0
+    732550n 1.8
+    732599n 1.8
+    732600n 0
+    732649n 0
+    732650n 1.8
+    732699n 1.8
+    732700n 0
+    732749n 0
+    732750n 1.8
+    732799n 1.8
+    732800n 0
+    732849n 0
+    732850n 1.8
+    732899n 1.8
+    732900n 0
+    732949n 0
+    732950n 1.8
+    732999n 1.8
+    733000n 0
+    733049n 0
+    733050n 1.8
+    733099n 1.8
+    733100n 0
+    733149n 0
+    733150n 1.8
+    733199n 1.8
+    733200n 0
+    733249n 0
+    733250n 1.8
+    733299n 1.8
+    733300n 0
+    733349n 0
+    733350n 1.8
+    733399n 1.8
+    733400n 0
+    733449n 0
+    733450n 1.8
+    733499n 1.8
+    733500n 0
+    733549n 0
+    733550n 1.8
+    733599n 1.8
+    733600n 0
+    733649n 0
+    733650n 1.8
+    733699n 1.8
+    733700n 0
+    733749n 0
+    733750n 1.8
+    733799n 1.8
+    733800n 0
+    733849n 0
+    733850n 1.8
+    733899n 1.8
+    733900n 0
+    733949n 0
+    733950n 1.8
+    733999n 1.8
+    734000n 0
+    734049n 0
+    734050n 1.8
+    734099n 1.8
+    734100n 0
+    734149n 0
+    734150n 1.8
+    734199n 1.8
+    734200n 0
+    734249n 0
+    734250n 1.8
+    734299n 1.8
+    734300n 0
+    734349n 0
+    734350n 1.8
+    734399n 1.8
+    734400n 0
+    734449n 0
+    734450n 1.8
+    734499n 1.8
+    734500n 0
+    734549n 0
+    734550n 1.8
+    734599n 1.8
+    734600n 0
+    734649n 0
+    734650n 1.8
+    734699n 1.8
+    734700n 0
+    734749n 0
+    734750n 1.8
+    734799n 1.8
+    734800n 0
+    734849n 0
+    734850n 1.8
+    734899n 1.8
+    734900n 0
+    734949n 0
+    734950n 1.8
+    734999n 1.8
+    735000n 0
+    735049n 0
+    735050n 1.8
+    735099n 1.8
+    735100n 0
+    735149n 0
+    735150n 1.8
+    735199n 1.8
+    735200n 0
+    735249n 0
+    735250n 1.8
+    735299n 1.8
+    735300n 0
+    735349n 0
+    735350n 1.8
+    735399n 1.8
+    735400n 0
+    735449n 0
+    735450n 1.8
+    735499n 1.8
+    735500n 0
+    735549n 0
+    735550n 1.8
+    735599n 1.8
+    735600n 0
+    735649n 0
+    735650n 1.8
+    735699n 1.8
+    735700n 0
+    735749n 0
+    735750n 1.8
+    735799n 1.8
+    735800n 0
+    735849n 0
+    735850n 1.8
+    735899n 1.8
+    735900n 0
+    735949n 0
+    735950n 1.8
+    735999n 1.8
+    736000n 0
+    736049n 0
+    736050n 1.8
+    736099n 1.8
+    736100n 0
+    736149n 0
+    736150n 1.8
+    736199n 1.8
+    736200n 0
+    736249n 0
+    736250n 1.8
+    736299n 1.8
+    736300n 0
+    736349n 0
+    736350n 1.8
+    736399n 1.8
+    736400n 0
+    736449n 0
+    736450n 1.8
+    736499n 1.8
+    736500n 0
+    736549n 0
+    736550n 1.8
+    736599n 1.8
+    736600n 0
+    736649n 0
+    736650n 1.8
+    736699n 1.8
+    736700n 0
+    736749n 0
+    736750n 1.8
+    736799n 1.8
+    736800n 0
+    736849n 0
+    736850n 1.8
+    736899n 1.8
+    736900n 0
+    736949n 0
+    736950n 1.8
+    736999n 1.8
+    737000n 0
+    737049n 0
+    737050n 1.8
+    737099n 1.8
+    737100n 0
+    737149n 0
+    737150n 1.8
+    737199n 1.8
+    737200n 0
+    737249n 0
+    737250n 1.8
+    737299n 1.8
+    737300n 0
+    737349n 0
+    737350n 1.8
+    737399n 1.8
+    737400n 0
+    737449n 0
+    737450n 1.8
+    737499n 1.8
+    737500n 0
+    737549n 0
+    737550n 1.8
+    737599n 1.8
+    737600n 0
+    737649n 0
+    737650n 1.8
+    737699n 1.8
+    737700n 0
+    737749n 0
+    737750n 1.8
+    737799n 1.8
+    737800n 0
+    737849n 0
+    737850n 1.8
+    737899n 1.8
+    737900n 0
+    737949n 0
+    737950n 1.8
+    737999n 1.8
+    738000n 0
+    738049n 0
+    738050n 1.8
+    738099n 1.8
+    738100n 0
+    738149n 0
+    738150n 1.8
+    738199n 1.8
+    738200n 0
+    738249n 0
+    738250n 1.8
+    738299n 1.8
+    738300n 0
+    738349n 0
+    738350n 1.8
+    738399n 1.8
+    738400n 0
+    738449n 0
+    738450n 1.8
+    738499n 1.8
+    738500n 0
+    738549n 0
+    738550n 1.8
+    738599n 1.8
+    738600n 0
+    738649n 0
+    738650n 1.8
+    738699n 1.8
+    738700n 0
+    738749n 0
+    738750n 1.8
+    738799n 1.8
+    738800n 0
+    738849n 0
+    738850n 1.8
+    738899n 1.8
+    738900n 0
+    738949n 0
+    738950n 1.8
+    738999n 1.8
+    739000n 0
+    739049n 0
+    739050n 1.8
+    739099n 1.8
+    739100n 0
+    739149n 0
+    739150n 1.8
+    739199n 1.8
+    739200n 0
+    739249n 0
+    739250n 1.8
+    739299n 1.8
+    739300n 0
+    739349n 0
+    739350n 1.8
+    739399n 1.8
+    739400n 0
+    739449n 0
+    739450n 1.8
+    739499n 1.8
+    739500n 0
+    739549n 0
+    739550n 1.8
+    739599n 1.8
+    739600n 0
+    739649n 0
+    739650n 1.8
+    739699n 1.8
+    739700n 0
+    739749n 0
+    739750n 1.8
+    739799n 1.8
+    739800n 0
+    739849n 0
+    739850n 1.8
+    739899n 1.8
+    739900n 0
+    739949n 0
+    739950n 1.8
+    739999n 1.8
+    740000n 0
+    740049n 0
+    740050n 1.8
+    740099n 1.8
+    740100n 0
+    740149n 0
+    740150n 1.8
+    740199n 1.8
+    740200n 0
+    740249n 0
+    740250n 1.8
+    740299n 1.8
+    740300n 0
+    740349n 0
+    740350n 1.8
+    740399n 1.8
+    740400n 0
+    740449n 0
+    740450n 1.8
+    740499n 1.8
+    740500n 0
+    740549n 0
+    740550n 1.8
+    740599n 1.8
+    740600n 0
+    740649n 0
+    740650n 1.8
+    740699n 1.8
+    740700n 0
+    740749n 0
+    740750n 1.8
+    740799n 1.8
+    740800n 0
+    740849n 0
+    740850n 1.8
+    740899n 1.8
+    740900n 0
+    740949n 0
+    740950n 1.8
+    740999n 1.8
+    741000n 0
+    741049n 0
+    741050n 1.8
+    741099n 1.8
+    741100n 0
+    741149n 0
+    741150n 1.8
+    741199n 1.8
+    741200n 0
+    741249n 0
+    741250n 1.8
+    741299n 1.8
+    741300n 0
+    741349n 0
+    741350n 1.8
+    741399n 1.8
+    741400n 0
+    741449n 0
+    741450n 1.8
+    741499n 1.8
+    741500n 0
+    741549n 0
+    741550n 1.8
+    741599n 1.8
+    741600n 0
+    741649n 0
+    741650n 1.8
+    741699n 1.8
+    741700n 0
+    741749n 0
+    741750n 1.8
+    741799n 1.8
+    741800n 0
+    741849n 0
+    741850n 1.8
+    741899n 1.8
+    741900n 0
+    741949n 0
+    741950n 1.8
+    741999n 1.8
+    742000n 0
+    742049n 0
+    742050n 1.8
+    742099n 1.8
+    742100n 0
+    742149n 0
+    742150n 1.8
+    742199n 1.8
+    742200n 0
+    742249n 0
+    742250n 1.8
+    742299n 1.8
+    742300n 0
+    742349n 0
+    742350n 1.8
+    742399n 1.8
+    742400n 0
+    742449n 0
+    742450n 1.8
+    742499n 1.8
+    742500n 0
+    742549n 0
+    742550n 1.8
+    742599n 1.8
+    742600n 0
+    742649n 0
+    742650n 1.8
+    742699n 1.8
+    742700n 0
+    742749n 0
+    742750n 1.8
+    742799n 1.8
+    742800n 0
+    742849n 0
+    742850n 1.8
+    742899n 1.8
+    742900n 0
+    742949n 0
+    742950n 1.8
+    742999n 1.8
+    743000n 0
+    743049n 0
+    743050n 1.8
+    743099n 1.8
+    743100n 0
+    743149n 0
+    743150n 1.8
+    743199n 1.8
+    743200n 0
+    743249n 0
+    743250n 1.8
+    743299n 1.8
+    743300n 0
+    743349n 0
+    743350n 1.8
+    743399n 1.8
+    743400n 0
+    743449n 0
+    743450n 1.8
+    743499n 1.8
+    743500n 0
+    743549n 0
+    743550n 1.8
+    743599n 1.8
+    743600n 0
+    743649n 0
+    743650n 1.8
+    743699n 1.8
+    743700n 0
+    743749n 0
+    743750n 1.8
+    743799n 1.8
+    743800n 0
+    743849n 0
+    743850n 1.8
+    743899n 1.8
+    743900n 0
+    743949n 0
+    743950n 1.8
+    743999n 1.8
+    744000n 0
+    744049n 0
+    744050n 1.8
+    744099n 1.8
+    744100n 0
+    744149n 0
+    744150n 1.8
+    744199n 1.8
+    744200n 0
+    744249n 0
+    744250n 1.8
+    744299n 1.8
+    744300n 0
+    744349n 0
+    744350n 1.8
+    744399n 1.8
+    744400n 0
+    744449n 0
+    744450n 1.8
+    744499n 1.8
+    744500n 0
+    744549n 0
+    744550n 1.8
+    744599n 1.8
+    744600n 0
+    744649n 0
+    744650n 1.8
+    744699n 1.8
+    744700n 0
+    744749n 0
+    744750n 1.8
+    744799n 1.8
+    744800n 0
+    744849n 0
+    744850n 1.8
+    744899n 1.8
+    744900n 0
+    744949n 0
+    744950n 1.8
+    744999n 1.8
+    745000n 0
+    745049n 0
+    745050n 1.8
+    745099n 1.8
+    745100n 0
+    745149n 0
+    745150n 1.8
+    745199n 1.8
+    745200n 0
+    745249n 0
+    745250n 1.8
+    745299n 1.8
+    745300n 0
+    745349n 0
+    745350n 1.8
+    745399n 1.8
+    745400n 0
+    745449n 0
+    745450n 1.8
+    745499n 1.8
+    745500n 0
+    745549n 0
+    745550n 1.8
+    745599n 1.8
+    745600n 0
+    745649n 0
+    745650n 1.8
+    745699n 1.8
+    745700n 0
+    745749n 0
+    745750n 1.8
+    745799n 1.8
+    745800n 0
+    745849n 0
+    745850n 1.8
+    745899n 1.8
+    745900n 0
+    745949n 0
+    745950n 1.8
+    745999n 1.8
+    746000n 0
+    746049n 0
+    746050n 1.8
+    746099n 1.8
+    746100n 0
+    746149n 0
+    746150n 1.8
+    746199n 1.8
+    746200n 0
+    746249n 0
+    746250n 1.8
+    746299n 1.8
+    746300n 0
+    746349n 0
+    746350n 1.8
+    746399n 1.8
+    746400n 0
+    746449n 0
+    746450n 1.8
+    746499n 1.8
+    746500n 0
+    746549n 0
+    746550n 1.8
+    746599n 1.8
+    746600n 0
+    746649n 0
+    746650n 1.8
+    746699n 1.8
+    746700n 0
+    746749n 0
+    746750n 1.8
+    746799n 1.8
+    746800n 0
+    746849n 0
+    746850n 1.8
+    746899n 1.8
+    746900n 0
+    746949n 0
+    746950n 1.8
+    746999n 1.8
+    747000n 0
+    747049n 0
+    747050n 1.8
+    747099n 1.8
+    747100n 0
+    747149n 0
+    747150n 1.8
+    747199n 1.8
+    747200n 0
+    747249n 0
+    747250n 1.8
+    747299n 1.8
+    747300n 0
+    747349n 0
+    747350n 1.8
+    747399n 1.8
+    747400n 0
+    747449n 0
+    747450n 1.8
+    747499n 1.8
+    747500n 0
+    747549n 0
+    747550n 1.8
+    747599n 1.8
+    747600n 0
+    747649n 0
+    747650n 1.8
+    747699n 1.8
+    747700n 0
+    747749n 0
+    747750n 1.8
+    747799n 1.8
+    747800n 0
+    747849n 0
+    747850n 1.8
+    747899n 1.8
+    747900n 0
+    747949n 0
+    747950n 1.8
+    747999n 1.8
+    748000n 0
+    748049n 0
+    748050n 1.8
+    748099n 1.8
+    748100n 0
+    748149n 0
+    748150n 1.8
+    748199n 1.8
+    748200n 0
+    748249n 0
+    748250n 1.8
+    748299n 1.8
+    748300n 0
+    748349n 0
+    748350n 1.8
+    748399n 1.8
+    748400n 0
+    748449n 0
+    748450n 1.8
+    748499n 1.8
+    748500n 0
+    748549n 0
+    748550n 1.8
+    748599n 1.8
+    748600n 0
+    748649n 0
+    748650n 1.8
+    748699n 1.8
+    748700n 0
+    748749n 0
+    748750n 1.8
+    748799n 1.8
+    748800n 0
+    748849n 0
+    748850n 1.8
+    748899n 1.8
+    748900n 0
+    748949n 0
+    748950n 1.8
+    748999n 1.8
+    749000n 0
+    749049n 0
+    749050n 1.8
+    749099n 1.8
+    749100n 0
+    749149n 0
+    749150n 1.8
+    749199n 1.8
+    749200n 0
+    749249n 0
+    749250n 1.8
+    749299n 1.8
+    749300n 0
+    749349n 0
+    749350n 1.8
+    749399n 1.8
+    749400n 0
+    749449n 0
+    749450n 1.8
+    749499n 1.8
+    749500n 0
+    749549n 0
+    749550n 1.8
+    749599n 1.8
+    749600n 0
+    749649n 0
+    749650n 1.8
+    749699n 1.8
+    749700n 0
+    749749n 0
+    749750n 1.8
+    749799n 1.8
+    749800n 0
+    749849n 0
+    749850n 1.8
+    749899n 1.8
+    749900n 0
+    749949n 0
+    749950n 1.8
+    749999n 1.8
+    750000n 0
+    750049n 0
+    750050n 1.8
+    750099n 1.8
+    750100n 0
+    750149n 0
+    750150n 1.8
+    750199n 1.8
+    750200n 0
+    750249n 0
+    750250n 1.8
+    750299n 1.8
+    750300n 0
+    750349n 0
+    750350n 1.8
+    750399n 1.8
+    750400n 0
+    750449n 0
+    750450n 1.8
+    750499n 1.8
+    750500n 0
+    750549n 0
+    750550n 1.8
+    750599n 1.8
+    750600n 0
+    750649n 0
+    750650n 1.8
+    750699n 1.8
+    750700n 0
+    750749n 0
+    750750n 1.8
+    750799n 1.8
+    750800n 0
+    750849n 0
+    750850n 1.8
+    750899n 1.8
+    750900n 0
+    750949n 0
+    750950n 1.8
+    750999n 1.8
+    751000n 0
+    751049n 0
+    751050n 1.8
+    751099n 1.8
+    751100n 0
+    751149n 0
+    751150n 1.8
+    751199n 1.8
+    751200n 0
+    751249n 0
+    751250n 1.8
+    751299n 1.8
+    751300n 0
+    751349n 0
+    751350n 1.8
+    751399n 1.8
+    751400n 0
+    751449n 0
+    751450n 1.8
+    751499n 1.8
+    751500n 0
+    751549n 0
+    751550n 1.8
+    751599n 1.8
+    751600n 0
+    751649n 0
+    751650n 1.8
+    751699n 1.8
+    751700n 0
+    751749n 0
+    751750n 1.8
+    751799n 1.8
+    751800n 0
+    751849n 0
+    751850n 1.8
+    751899n 1.8
+    751900n 0
+    751949n 0
+    751950n 1.8
+    751999n 1.8
+    752000n 0
+    752049n 0
+    752050n 1.8
+    752099n 1.8
+    752100n 0
+    752149n 0
+    752150n 1.8
+    752199n 1.8
+    752200n 0
+    752249n 0
+    752250n 1.8
+    752299n 1.8
+    752300n 0
+    752349n 0
+    752350n 1.8
+    752399n 1.8
+    752400n 0
+    752449n 0
+    752450n 1.8
+    752499n 1.8
+    752500n 0
+    752549n 0
+    752550n 1.8
+    752599n 1.8
+    752600n 0
+    752649n 0
+    752650n 1.8
+    752699n 1.8
+    752700n 0
+    752749n 0
+    752750n 1.8
+    752799n 1.8
+    752800n 0
+    752849n 0
+    752850n 1.8
+    752899n 1.8
+    752900n 0
+    752949n 0
+    752950n 1.8
+    752999n 1.8
+    753000n 0
+    753049n 0
+    753050n 1.8
+    753099n 1.8
+    753100n 0
+    753149n 0
+    753150n 1.8
+    753199n 1.8
+    753200n 0
+    753249n 0
+    753250n 1.8
+    753299n 1.8
+    753300n 0
+    753349n 0
+    753350n 1.8
+    753399n 1.8
+    753400n 0
+    753449n 0
+    753450n 1.8
+    753499n 1.8
+    753500n 0
+    753549n 0
+    753550n 1.8
+    753599n 1.8
+    753600n 0
+    753649n 0
+    753650n 1.8
+    753699n 1.8
+    753700n 0
+    753749n 0
+    753750n 1.8
+    753799n 1.8
+    753800n 0
+    753849n 0
+    753850n 1.8
+    753899n 1.8
+    753900n 0
+    753949n 0
+    753950n 1.8
+    753999n 1.8
+    754000n 0
+    754049n 0
+    754050n 1.8
+    754099n 1.8
+    754100n 0
+    754149n 0
+    754150n 1.8
+    754199n 1.8
+    754200n 0
+    754249n 0
+    754250n 1.8
+    754299n 1.8
+    754300n 0
+    754349n 0
+    754350n 1.8
+    754399n 1.8
+    754400n 0
+    754449n 0
+    754450n 1.8
+    754499n 1.8
+    754500n 0
+    754549n 0
+    754550n 1.8
+    754599n 1.8
+    754600n 0
+    754649n 0
+    754650n 1.8
+    754699n 1.8
+    754700n 0
+    754749n 0
+    754750n 1.8
+    754799n 1.8
+    754800n 0
+    754849n 0
+    754850n 1.8
+    754899n 1.8
+    754900n 0
+    754949n 0
+    754950n 1.8
+    754999n 1.8
+    755000n 0
+    755049n 0
+    755050n 1.8
+    755099n 1.8
+    755100n 0
+    755149n 0
+    755150n 1.8
+    755199n 1.8
+    755200n 0
+    755249n 0
+    755250n 1.8
+    755299n 1.8
+    755300n 0
+    755349n 0
+    755350n 1.8
+    755399n 1.8
+    755400n 0
+    755449n 0
+    755450n 1.8
+    755499n 1.8
+    755500n 0
+    755549n 0
+    755550n 1.8
+    755599n 1.8
+    755600n 0
+    755649n 0
+    755650n 1.8
+    755699n 1.8
+    755700n 0
+    755749n 0
+    755750n 1.8
+    755799n 1.8
+    755800n 0
+    755849n 0
+    755850n 1.8
+    755899n 1.8
+    755900n 0
+    755949n 0
+    755950n 1.8
+    755999n 1.8
+    756000n 0
+    756049n 0
+    756050n 1.8
+    756099n 1.8
+    756100n 0
+    756149n 0
+    756150n 1.8
+    756199n 1.8
+    756200n 0
+    756249n 0
+    756250n 1.8
+    756299n 1.8
+    756300n 0
+    756349n 0
+    756350n 1.8
+    756399n 1.8
+    756400n 0
+    756449n 0
+    756450n 1.8
+    756499n 1.8
+    756500n 0
+    756549n 0
+    756550n 1.8
+    756599n 1.8
+    756600n 0
+    756649n 0
+    756650n 1.8
+    756699n 1.8
+    756700n 0
+    756749n 0
+    756750n 1.8
+    756799n 1.8
+    756800n 0
+    756849n 0
+    756850n 1.8
+    756899n 1.8
+    756900n 0
+    756949n 0
+    756950n 1.8
+    756999n 1.8
+    757000n 0
+    757049n 0
+    757050n 1.8
+    757099n 1.8
+    757100n 0
+    757149n 0
+    757150n 1.8
+    757199n 1.8
+    757200n 0
+    757249n 0
+    757250n 1.8
+    757299n 1.8
+    757300n 0
+    757349n 0
+    757350n 1.8
+    757399n 1.8
+    757400n 0
+    757449n 0
+    757450n 1.8
+    757499n 1.8
+    757500n 0
+    757549n 0
+    757550n 1.8
+    757599n 1.8
+    757600n 0
+    757649n 0
+    757650n 1.8
+    757699n 1.8
+    757700n 0
+    757749n 0
+    757750n 1.8
+    757799n 1.8
+    757800n 0
+    757849n 0
+    757850n 1.8
+    757899n 1.8
+    757900n 0
+    757949n 0
+    757950n 1.8
+    757999n 1.8
+    758000n 0
+    758049n 0
+    758050n 1.8
+    758099n 1.8
+    758100n 0
+    758149n 0
+    758150n 1.8
+    758199n 1.8
+    758200n 0
+    758249n 0
+    758250n 1.8
+    758299n 1.8
+    758300n 0
+    758349n 0
+    758350n 1.8
+    758399n 1.8
+    758400n 0
+    758449n 0
+    758450n 1.8
+    758499n 1.8
+    758500n 0
+    758549n 0
+    758550n 1.8
+    758599n 1.8
+    758600n 0
+    758649n 0
+    758650n 1.8
+    758699n 1.8
+    758700n 0
+    758749n 0
+    758750n 1.8
+    758799n 1.8
+    758800n 0
+    758849n 0
+    758850n 1.8
+    758899n 1.8
+    758900n 0
+    758949n 0
+    758950n 1.8
+    758999n 1.8
+    759000n 0
+    759049n 0
+    759050n 1.8
+    759099n 1.8
+    759100n 0
+    759149n 0
+    759150n 1.8
+    759199n 1.8
+    759200n 0
+    759249n 0
+    759250n 1.8
+    759299n 1.8
+    759300n 0
+    759349n 0
+    759350n 1.8
+    759399n 1.8
+    759400n 0
+    759449n 0
+    759450n 1.8
+    759499n 1.8
+    759500n 0
+    759549n 0
+    759550n 1.8
+    759599n 1.8
+    759600n 0
+    759649n 0
+    759650n 1.8
+    759699n 1.8
+    759700n 0
+    759749n 0
+    759750n 1.8
+    759799n 1.8
+    759800n 0
+    759849n 0
+    759850n 1.8
+    759899n 1.8
+    759900n 0
+    759949n 0
+    759950n 1.8
+    759999n 1.8
+    760000n 0
+    760049n 0
+    760050n 1.8
+    760099n 1.8
+    760100n 0
+    760149n 0
+    760150n 1.8
+    760199n 1.8
+    760200n 0
+    760249n 0
+    760250n 1.8
+    760299n 1.8
+    760300n 0
+    760349n 0
+    760350n 1.8
+    760399n 1.8
+    760400n 0
+    760449n 0
+    760450n 1.8
+    760499n 1.8
+    760500n 0
+    760549n 0
+    760550n 1.8
+    760599n 1.8
+    760600n 0
+    760649n 0
+    760650n 1.8
+    760699n 1.8
+    760700n 0
+    760749n 0
+    760750n 1.8
+    760799n 1.8
+    760800n 0
+    760849n 0
+    760850n 1.8
+    760899n 1.8
+    760900n 0
+    760949n 0
+    760950n 1.8
+    760999n 1.8
+    761000n 0
+    761049n 0
+    761050n 1.8
+    761099n 1.8
+    761100n 0
+    761149n 0
+    761150n 1.8
+    761199n 1.8
+    761200n 0
+    761249n 0
+    761250n 1.8
+    761299n 1.8
+    761300n 0
+    761349n 0
+    761350n 1.8
+    761399n 1.8
+    761400n 0
+    761449n 0
+    761450n 1.8
+    761499n 1.8
+    761500n 0
+    761549n 0
+    761550n 1.8
+    761599n 1.8
+    761600n 0
+    761649n 0
+    761650n 1.8
+    761699n 1.8
+    761700n 0
+    761749n 0
+    761750n 1.8
+    761799n 1.8
+    761800n 0
+    761849n 0
+    761850n 1.8
+    761899n 1.8
+    761900n 0
+    761949n 0
+    761950n 1.8
+    761999n 1.8
+    762000n 0
+    762049n 0
+    762050n 1.8
+    762099n 1.8
+    762100n 0
+    762149n 0
+    762150n 1.8
+    762199n 1.8
+    762200n 0
+    762249n 0
+    762250n 1.8
+    762299n 1.8
+    762300n 0
+    762349n 0
+    762350n 1.8
+    762399n 1.8
+    762400n 0
+    762449n 0
+    762450n 1.8
+    762499n 1.8
+    762500n 0
+    762549n 0
+    762550n 1.8
+    762599n 1.8
+    762600n 0
+    762649n 0
+    762650n 1.8
+    762699n 1.8
+    762700n 0
+    762749n 0
+    762750n 1.8
+    762799n 1.8
+    762800n 0
+    762849n 0
+    762850n 1.8
+    762899n 1.8
+    762900n 0
+    762949n 0
+    762950n 1.8
+    762999n 1.8
+    763000n 0
+    763049n 0
+    763050n 1.8
+    763099n 1.8
+    763100n 0
+    763149n 0
+    763150n 1.8
+    763199n 1.8
+    763200n 0
+    763249n 0
+    763250n 1.8
+    763299n 1.8
+    763300n 0
+    763349n 0
+    763350n 1.8
+    763399n 1.8
+    763400n 0
+    763449n 0
+    763450n 1.8
+    763499n 1.8
+    763500n 0
+    763549n 0
+    763550n 1.8
+    763599n 1.8
+    763600n 0
+    763649n 0
+    763650n 1.8
+    763699n 1.8
+    763700n 0
+    763749n 0
+    763750n 1.8
+    763799n 1.8
+    763800n 0
+    763849n 0
+    763850n 1.8
+    763899n 1.8
+    763900n 0
+    763949n 0
+    763950n 1.8
+    763999n 1.8
+    764000n 0
+    764049n 0
+    764050n 1.8
+    764099n 1.8
+    764100n 0
+    764149n 0
+    764150n 1.8
+    764199n 1.8
+    764200n 0
+    764249n 0
+    764250n 1.8
+    764299n 1.8
+    764300n 0
+    764349n 0
+    764350n 1.8
+    764399n 1.8
+    764400n 0
+    764449n 0
+    764450n 1.8
+    764499n 1.8
+    764500n 0
+    764549n 0
+    764550n 1.8
+    764599n 1.8
+    764600n 0
+    764649n 0
+    764650n 1.8
+    764699n 1.8
+    764700n 0
+    764749n 0
+    764750n 1.8
+    764799n 1.8
+    764800n 0
+    764849n 0
+    764850n 1.8
+    764899n 1.8
+    764900n 0
+    764949n 0
+    764950n 1.8
+    764999n 1.8
+    765000n 0
+    765049n 0
+    765050n 1.8
+    765099n 1.8
+    765100n 0
+    765149n 0
+    765150n 1.8
+    765199n 1.8
+    765200n 0
+    765249n 0
+    765250n 1.8
+    765299n 1.8
+    765300n 0
+    765349n 0
+    765350n 1.8
+    765399n 1.8
+    765400n 0
+    765449n 0
+    765450n 1.8
+    765499n 1.8
+    765500n 0
+    765549n 0
+    765550n 1.8
+    765599n 1.8
+    765600n 0
+    765649n 0
+    765650n 1.8
+    765699n 1.8
+    765700n 0
+    765749n 0
+    765750n 1.8
+    765799n 1.8
+    765800n 0
+    765849n 0
+    765850n 1.8
+    765899n 1.8
+    765900n 0
+    765949n 0
+    765950n 1.8
+    765999n 1.8
+    766000n 0
+    766049n 0
+    766050n 1.8
+    766099n 1.8
+    766100n 0
+    766149n 0
+    766150n 1.8
+    766199n 1.8
+    766200n 0
+    766249n 0
+    766250n 1.8
+    766299n 1.8
+    766300n 0
+    766349n 0
+    766350n 1.8
+    766399n 1.8
+    766400n 0
+    766449n 0
+    766450n 1.8
+    766499n 1.8
+    766500n 0
+    766549n 0
+    766550n 1.8
+    766599n 1.8
+    766600n 0
+    766649n 0
+    766650n 1.8
+    766699n 1.8
+    766700n 0
+    766749n 0
+    766750n 1.8
+    766799n 1.8
+    766800n 0
+    766849n 0
+    766850n 1.8
+    766899n 1.8
+    766900n 0
+    766949n 0
+    766950n 1.8
+    766999n 1.8
+    767000n 0
+    767049n 0
+    767050n 1.8
+    767099n 1.8
+    767100n 0
+    767149n 0
+    767150n 1.8
+    767199n 1.8
+    767200n 0
+    767249n 0
+    767250n 1.8
+    767299n 1.8
+    767300n 0
+    767349n 0
+    767350n 1.8
+    767399n 1.8
+    767400n 0
+    767449n 0
+    767450n 1.8
+    767499n 1.8
+    767500n 0
+    767549n 0
+    767550n 1.8
+    767599n 1.8
+    767600n 0
+    767649n 0
+    767650n 1.8
+    767699n 1.8
+    767700n 0
+    767749n 0
+    767750n 1.8
+    767799n 1.8
+    767800n 0
+    767849n 0
+    767850n 1.8
+    767899n 1.8
+    767900n 0
+    767949n 0
+    767950n 1.8
+    767999n 1.8
+    768000n 0
+    768049n 0
+    768050n 1.8
+    768099n 1.8
+    768100n 0
+    768149n 0
+    768150n 1.8
+    768199n 1.8
+    768200n 0
+    768249n 0
+    768250n 1.8
+    768299n 1.8
+    768300n 0
+    768349n 0
+    768350n 1.8
+    768399n 1.8
+    768400n 0
+    768449n 0
+    768450n 1.8
+    768499n 1.8
+    768500n 0
+    768549n 0
+    768550n 1.8
+    768599n 1.8
+    768600n 0
+    768649n 0
+    768650n 1.8
+    768699n 1.8
+    768700n 0
+    768749n 0
+    768750n 1.8
+    768799n 1.8
+    768800n 0
+    768849n 0
+    768850n 1.8
+    768899n 1.8
+    768900n 0
+    768949n 0
+    768950n 1.8
+    768999n 1.8
+    769000n 0
+    769049n 0
+    769050n 1.8
+    769099n 1.8
+    769100n 0
+    769149n 0
+    769150n 1.8
+    769199n 1.8
+    769200n 0
+    769249n 0
+    769250n 1.8
+    769299n 1.8
+    769300n 0
+    769349n 0
+    769350n 1.8
+    769399n 1.8
+    769400n 0
+    769449n 0
+    769450n 1.8
+    769499n 1.8
+    769500n 0
+    769549n 0
+    769550n 1.8
+    769599n 1.8
+    769600n 0
+    769649n 0
+    769650n 1.8
+    769699n 1.8
+    769700n 0
+    769749n 0
+    769750n 1.8
+    769799n 1.8
+    769800n 0
+    769849n 0
+    769850n 1.8
+    769899n 1.8
+    769900n 0
+    769949n 0
+    769950n 1.8
+    769999n 1.8
+    770000n 0
+    770049n 0
+    770050n 1.8
+    770099n 1.8
+    770100n 0
+    770149n 0
+    770150n 1.8
+    770199n 1.8
+    770200n 0
+    770249n 0
+    770250n 1.8
+    770299n 1.8
+    770300n 0
+    770349n 0
+    770350n 1.8
+    770399n 1.8
+    770400n 0
+    770449n 0
+    770450n 1.8
+    770499n 1.8
+    770500n 0
+    770549n 0
+    770550n 1.8
+    770599n 1.8
+    770600n 0
+    770649n 0
+    770650n 1.8
+    770699n 1.8
+    770700n 0
+    770749n 0
+    770750n 1.8
+    770799n 1.8
+    770800n 0
+    770849n 0
+    770850n 1.8
+    770899n 1.8
+    770900n 0
+    770949n 0
+    770950n 1.8
+    770999n 1.8
+    771000n 0
+    771049n 0
+    771050n 1.8
+    771099n 1.8
+    771100n 0
+    771149n 0
+    771150n 1.8
+    771199n 1.8
+    771200n 0
+    771249n 0
+    771250n 1.8
+    771299n 1.8
+    771300n 0
+    771349n 0
+    771350n 1.8
+    771399n 1.8
+    771400n 0
+    771449n 0
+    771450n 1.8
+    771499n 1.8
+    771500n 0
+    771549n 0
+    771550n 1.8
+    771599n 1.8
+    771600n 0
+    771649n 0
+    771650n 1.8
+    771699n 1.8
+    771700n 0
+    771749n 0
+    771750n 1.8
+    771799n 1.8
+    771800n 0
+    771849n 0
+    771850n 1.8
+    771899n 1.8
+    771900n 0
+    771949n 0
+    771950n 1.8
+    771999n 1.8
+    772000n 0
+    772049n 0
+    772050n 1.8
+    772099n 1.8
+    772100n 0
+    772149n 0
+    772150n 1.8
+    772199n 1.8
+    772200n 0
+    772249n 0
+    772250n 1.8
+    772299n 1.8
+    772300n 0
+    772349n 0
+    772350n 1.8
+    772399n 1.8
+    772400n 0
+    772449n 0
+    772450n 1.8
+    772499n 1.8
+    772500n 0
+    772549n 0
+    772550n 1.8
+    772599n 1.8
+    772600n 0
+    772649n 0
+    772650n 1.8
+    772699n 1.8
+    772700n 0
+    772749n 0
+    772750n 1.8
+    772799n 1.8
+    772800n 0
+    772849n 0
+    772850n 1.8
+    772899n 1.8
+    772900n 0
+    772949n 0
+    772950n 1.8
+    772999n 1.8
+    773000n 0
+    773049n 0
+    773050n 1.8
+    773099n 1.8
+    773100n 0
+    773149n 0
+    773150n 1.8
+    773199n 1.8
+    773200n 0
+    773249n 0
+    773250n 1.8
+    773299n 1.8
+    773300n 0
+    773349n 0
+    773350n 1.8
+    773399n 1.8
+    773400n 0
+    773449n 0
+    773450n 1.8
+    773499n 1.8
+    773500n 0
+    773549n 0
+    773550n 1.8
+    773599n 1.8
+    773600n 0
+    773649n 0
+    773650n 1.8
+    773699n 1.8
+    773700n 0
+    773749n 0
+    773750n 1.8
+    773799n 1.8
+    773800n 0
+    773849n 0
+    773850n 1.8
+    773899n 1.8
+    773900n 0
+    773949n 0
+    773950n 1.8
+    773999n 1.8
+    774000n 0
+    774049n 0
+    774050n 1.8
+    774099n 1.8
+    774100n 0
+    774149n 0
+    774150n 1.8
+    774199n 1.8
+    774200n 0
+    774249n 0
+    774250n 1.8
+    774299n 1.8
+    774300n 0
+    774349n 0
+    774350n 1.8
+    774399n 1.8
+    774400n 0
+    774449n 0
+    774450n 1.8
+    774499n 1.8
+    774500n 0
+    774549n 0
+    774550n 1.8
+    774599n 1.8
+    774600n 0
+    774649n 0
+    774650n 1.8
+    774699n 1.8
+    774700n 0
+    774749n 0
+    774750n 1.8
+    774799n 1.8
+    774800n 0
+    774849n 0
+    774850n 1.8
+    774899n 1.8
+    774900n 0
+    774949n 0
+    774950n 1.8
+    774999n 1.8
+    775000n 0
+    775049n 0
+    775050n 1.8
+    775099n 1.8
+    775100n 0
+    775149n 0
+    775150n 1.8
+    775199n 1.8
+    775200n 0
+    775249n 0
+    775250n 1.8
+    775299n 1.8
+    775300n 0
+    775349n 0
+    775350n 1.8
+    775399n 1.8
+    775400n 0
+    775449n 0
+    775450n 1.8
+    775499n 1.8
+    775500n 0
+    775549n 0
+    775550n 1.8
+    775599n 1.8
+    775600n 0
+    775649n 0
+    775650n 1.8
+    775699n 1.8
+    775700n 0
+    775749n 0
+    775750n 1.8
+    775799n 1.8
+    775800n 0
+    775849n 0
+    775850n 1.8
+    775899n 1.8
+    775900n 0
+    775949n 0
+    775950n 1.8
+    775999n 1.8
+    776000n 0
+    776049n 0
+    776050n 1.8
+    776099n 1.8
+    776100n 0
+    776149n 0
+    776150n 1.8
+    776199n 1.8
+    776200n 0
+    776249n 0
+    776250n 1.8
+    776299n 1.8
+    776300n 0
+    776349n 0
+    776350n 1.8
+    776399n 1.8
+    776400n 0
+    776449n 0
+    776450n 1.8
+    776499n 1.8
+    776500n 0
+    776549n 0
+    776550n 1.8
+    776599n 1.8
+    776600n 0
+    776649n 0
+    776650n 1.8
+    776699n 1.8
+    776700n 0
+    776749n 0
+    776750n 1.8
+    776799n 1.8
+    776800n 0
+    776849n 0
+    776850n 1.8
+    776899n 1.8
+    776900n 0
+    776949n 0
+    776950n 1.8
+    776999n 1.8
+    777000n 0
+    777049n 0
+    777050n 1.8
+    777099n 1.8
+    777100n 0
+    777149n 0
+    777150n 1.8
+    777199n 1.8
+    777200n 0
+    777249n 0
+    777250n 1.8
+    777299n 1.8
+    777300n 0
+    777349n 0
+    777350n 1.8
+    777399n 1.8
+    777400n 0
+    777449n 0
+    777450n 1.8
+    777499n 1.8
+    777500n 0
+    777549n 0
+    777550n 1.8
+    777599n 1.8
+    777600n 0
+    777649n 0
+    777650n 1.8
+    777699n 1.8
+    777700n 0
+    777749n 0
+    777750n 1.8
+    777799n 1.8
+    777800n 0
+    777849n 0
+    777850n 1.8
+    777899n 1.8
+    777900n 0
+    777949n 0
+    777950n 1.8
+    777999n 1.8
+    778000n 0
+    778049n 0
+    778050n 1.8
+    778099n 1.8
+    778100n 0
+    778149n 0
+    778150n 1.8
+    778199n 1.8
+    778200n 0
+    778249n 0
+    778250n 1.8
+    778299n 1.8
+    778300n 0
+    778349n 0
+    778350n 1.8
+    778399n 1.8
+    778400n 0
+    778449n 0
+    778450n 1.8
+    778499n 1.8
+    778500n 0
+    778549n 0
+    778550n 1.8
+    778599n 1.8
+    778600n 0
+    778649n 0
+    778650n 1.8
+    778699n 1.8
+    778700n 0
+    778749n 0
+    778750n 1.8
+    778799n 1.8
+    778800n 0
+    778849n 0
+    778850n 1.8
+    778899n 1.8
+    778900n 0
+    778949n 0
+    778950n 1.8
+    778999n 1.8
+    779000n 0
+    779049n 0
+    779050n 1.8
+    779099n 1.8
+    779100n 0
+    779149n 0
+    779150n 1.8
+    779199n 1.8
+    779200n 0
+    779249n 0
+    779250n 1.8
+    779299n 1.8
+    779300n 0
+    779349n 0
+    779350n 1.8
+    779399n 1.8
+    779400n 0
+    779449n 0
+    779450n 1.8
+    779499n 1.8
+    779500n 0
+    779549n 0
+    779550n 1.8
+    779599n 1.8
+    779600n 0
+    779649n 0
+    779650n 1.8
+    779699n 1.8
+    779700n 0
+    779749n 0
+    779750n 1.8
+    779799n 1.8
+    779800n 0
+    779849n 0
+    779850n 1.8
+    779899n 1.8
+    779900n 0
+    779949n 0
+    779950n 1.8
+    779999n 1.8
+    780000n 0
+    780049n 0
+    780050n 1.8
+    780099n 1.8
+    780100n 0
+    780149n 0
+    780150n 1.8
+    780199n 1.8
+    780200n 0
+    780249n 0
+    780250n 1.8
+    780299n 1.8
+    780300n 0
+    780349n 0
+    780350n 1.8
+    780399n 1.8
+    780400n 0
+    780449n 0
+    780450n 1.8
+    780499n 1.8
+    780500n 0
+    780549n 0
+    780550n 1.8
+    780599n 1.8
+    780600n 0
+    780649n 0
+    780650n 1.8
+    780699n 1.8
+    780700n 0
+    780749n 0
+    780750n 1.8
+    780799n 1.8
+    780800n 0
+    780849n 0
+    780850n 1.8
+    780899n 1.8
+    780900n 0
+    780949n 0
+    780950n 1.8
+    780999n 1.8
+    781000n 0
+    781049n 0
+    781050n 1.8
+    781099n 1.8
+    781100n 0
+    781149n 0
+    781150n 1.8
+    781199n 1.8
+    781200n 0
+    781249n 0
+    781250n 1.8
+    781299n 1.8
+    781300n 0
+    781349n 0
+    781350n 1.8
+    781399n 1.8
+    781400n 0
+    781449n 0
+    781450n 1.8
+    781499n 1.8
+    781500n 0
+    781549n 0
+    781550n 1.8
+    781599n 1.8
+    781600n 0
+    781649n 0
+    781650n 1.8
+    781699n 1.8
+    781700n 0
+    781749n 0
+    781750n 1.8
+    781799n 1.8
+    781800n 0
+    781849n 0
+    781850n 1.8
+    781899n 1.8
+    781900n 0
+    781949n 0
+    781950n 1.8
+    781999n 1.8
+    782000n 0
+    782049n 0
+    782050n 1.8
+    782099n 1.8
+    782100n 0
+    782149n 0
+    782150n 1.8
+    782199n 1.8
+    782200n 0
+    782249n 0
+    782250n 1.8
+    782299n 1.8
+    782300n 0
+    782349n 0
+    782350n 1.8
+    782399n 1.8
+    782400n 0
+    782449n 0
+    782450n 1.8
+    782499n 1.8
+    782500n 0
+    782549n 0
+    782550n 1.8
+    782599n 1.8
+    782600n 0
+    782649n 0
+    782650n 1.8
+    782699n 1.8
+    782700n 0
+    782749n 0
+    782750n 1.8
+    782799n 1.8
+    782800n 0
+    782849n 0
+    782850n 1.8
+    782899n 1.8
+    782900n 0
+    782949n 0
+    782950n 1.8
+    782999n 1.8
+    783000n 0
+    783049n 0
+    783050n 1.8
+    783099n 1.8
+    783100n 0
+    783149n 0
+    783150n 1.8
+    783199n 1.8
+    783200n 0
+    783249n 0
+    783250n 1.8
+    783299n 1.8
+    783300n 0
+    783349n 0
+    783350n 1.8
+    783399n 1.8
+    783400n 0
+    783449n 0
+    783450n 1.8
+    783499n 1.8
+    783500n 0
+    783549n 0
+    783550n 1.8
+    783599n 1.8
+    783600n 0
+    783649n 0
+    783650n 1.8
+    783699n 1.8
+    783700n 0
+    783749n 0
+    783750n 1.8
+    783799n 1.8
+    783800n 0
+    783849n 0
+    783850n 1.8
+    783899n 1.8
+    783900n 0
+    783949n 0
+    783950n 1.8
+    783999n 1.8
+    784000n 0
+    784049n 0
+    784050n 1.8
+    784099n 1.8
+    784100n 0
+    784149n 0
+    784150n 1.8
+    784199n 1.8
+    784200n 0
+    784249n 0
+    784250n 1.8
+    784299n 1.8
+    784300n 0
+    784349n 0
+    784350n 1.8
+    784399n 1.8
+    784400n 0
+    784449n 0
+    784450n 1.8
+    784499n 1.8
+    784500n 0
+    784549n 0
+    784550n 1.8
+    784599n 1.8
+    784600n 0
+    784649n 0
+    784650n 1.8
+    784699n 1.8
+    784700n 0
+    784749n 0
+    784750n 1.8
+    784799n 1.8
+    784800n 0
+    784849n 0
+    784850n 1.8
+    784899n 1.8
+    784900n 0
+    784949n 0
+    784950n 1.8
+    784999n 1.8
+    785000n 0
+    785049n 0
+    785050n 1.8
+    785099n 1.8
+    785100n 0
+    785149n 0
+    785150n 1.8
+    785199n 1.8
+    785200n 0
+    785249n 0
+    785250n 1.8
+    785299n 1.8
+    785300n 0
+    785349n 0
+    785350n 1.8
+    785399n 1.8
+    785400n 0
+    785449n 0
+    785450n 1.8
+    785499n 1.8
+    785500n 0
+    785549n 0
+    785550n 1.8
+    785599n 1.8
+    785600n 0
+    785649n 0
+    785650n 1.8
+    785699n 1.8
+    785700n 0
+    785749n 0
+    785750n 1.8
+    785799n 1.8
+    785800n 0
+    785849n 0
+    785850n 1.8
+    785899n 1.8
+    785900n 0
+    785949n 0
+    785950n 1.8
+    785999n 1.8
+    786000n 0
+    786049n 0
+    786050n 1.8
+    786099n 1.8
+    786100n 0
+    786149n 0
+    786150n 1.8
+    786199n 1.8
+    786200n 0
+    786249n 0
+    786250n 1.8
+    786299n 1.8
+    786300n 0
+    786349n 0
+    786350n 1.8
+    786399n 1.8
+    786400n 0
+    786449n 0
+    786450n 1.8
+    786499n 1.8
+    786500n 0
+    786549n 0
+    786550n 1.8
+    786599n 1.8
+    786600n 0
+    786649n 0
+    786650n 1.8
+    786699n 1.8
+    786700n 0
+    786749n 0
+    786750n 1.8
+    786799n 1.8
+    786800n 0
+    786849n 0
+    786850n 1.8
+    786899n 1.8
+    786900n 0
+    786949n 0
+    786950n 1.8
+    786999n 1.8
+    787000n 0
+    787049n 0
+    787050n 1.8
+    787099n 1.8
+    787100n 0
+    787149n 0
+    787150n 1.8
+    787199n 1.8
+    787200n 0
+    787249n 0
+    787250n 1.8
+    787299n 1.8
+    787300n 0
+    787349n 0
+    787350n 1.8
+    787399n 1.8
+    787400n 0
+    787449n 0
+    787450n 1.8
+    787499n 1.8
+    787500n 0
+    787549n 0
+    787550n 1.8
+    787599n 1.8
+    787600n 0
+    787649n 0
+    787650n 1.8
+    787699n 1.8
+    787700n 0
+    787749n 0
+    787750n 1.8
+    787799n 1.8
+    787800n 0
+    787849n 0
+    787850n 1.8
+    787899n 1.8
+    787900n 0
+    787949n 0
+    787950n 1.8
+    787999n 1.8
+    788000n 0
+    788049n 0
+    788050n 1.8
+    788099n 1.8
+    788100n 0
+    788149n 0
+    788150n 1.8
+    788199n 1.8
+    788200n 0
+    788249n 0
+    788250n 1.8
+    788299n 1.8
+    788300n 0
+    788349n 0
+    788350n 1.8
+    788399n 1.8
+    788400n 0
+    788449n 0
+    788450n 1.8
+    788499n 1.8
+    788500n 0
+    788549n 0
+    788550n 1.8
+    788599n 1.8
+    788600n 0
+    788649n 0
+    788650n 1.8
+    788699n 1.8
+    788700n 0
+    788749n 0
+    788750n 1.8
+    788799n 1.8
+    788800n 0
+    788849n 0
+    788850n 1.8
+    788899n 1.8
+    788900n 0
+    788949n 0
+    788950n 1.8
+    788999n 1.8
+    789000n 0
+    789049n 0
+    789050n 1.8
+    789099n 1.8
+    789100n 0
+    789149n 0
+    789150n 1.8
+    789199n 1.8
+    789200n 0
+    789249n 0
+    789250n 1.8
+    789299n 1.8
+    789300n 0
+    789349n 0
+    789350n 1.8
+    789399n 1.8
+    789400n 0
+    789449n 0
+    789450n 1.8
+    789499n 1.8
+    789500n 0
+    789549n 0
+    789550n 1.8
+    789599n 1.8
+    789600n 0
+    789649n 0
+    789650n 1.8
+    789699n 1.8
+    789700n 0
+    789749n 0
+    789750n 1.8
+    789799n 1.8
+    789800n 0
+    789849n 0
+    789850n 1.8
+    789899n 1.8
+    789900n 0
+    789949n 0
+    789950n 1.8
+    789999n 1.8
+    790000n 0
+    790049n 0
+    790050n 1.8
+    790099n 1.8
+    790100n 0
+    790149n 0
+    790150n 1.8
+    790199n 1.8
+    790200n 0
+    790249n 0
+    790250n 1.8
+    790299n 1.8
+    790300n 0
+    790349n 0
+    790350n 1.8
+    790399n 1.8
+    790400n 0
+    790449n 0
+    790450n 1.8
+    790499n 1.8
+    790500n 0
+    790549n 0
+    790550n 1.8
+    790599n 1.8
+    790600n 0
+    790649n 0
+    790650n 1.8
+    790699n 1.8
+    790700n 0
+    790749n 0
+    790750n 1.8
+    790799n 1.8
+    790800n 0
+    790849n 0
+    790850n 1.8
+    790899n 1.8
+    790900n 0
+    790949n 0
+    790950n 1.8
+    790999n 1.8
+    791000n 0
+    791049n 0
+    791050n 1.8
+    791099n 1.8
+    791100n 0
+    791149n 0
+    791150n 1.8
+    791199n 1.8
+    791200n 0
+    791249n 0
+    791250n 1.8
+    791299n 1.8
+    791300n 0
+    791349n 0
+    791350n 1.8
+    791399n 1.8
+    791400n 0
+    791449n 0
+    791450n 1.8
+    791499n 1.8
+    791500n 0
+    791549n 0
+    791550n 1.8
+    791599n 1.8
+    791600n 0
+    791649n 0
+    791650n 1.8
+    791699n 1.8
+    791700n 0
+    791749n 0
+    791750n 1.8
+    791799n 1.8
+    791800n 0
+    791849n 0
+    791850n 1.8
+    791899n 1.8
+    791900n 0
+    791949n 0
+    791950n 1.8
+    791999n 1.8
+    792000n 0
+    792049n 0
+    792050n 1.8
+    792099n 1.8
+    792100n 0
+    792149n 0
+    792150n 1.8
+    792199n 1.8
+    792200n 0
+    792249n 0
+    792250n 1.8
+    792299n 1.8
+    792300n 0
+    792349n 0
+    792350n 1.8
+    792399n 1.8
+    792400n 0
+    792449n 0
+    792450n 1.8
+    792499n 1.8
+    792500n 0
+    792549n 0
+    792550n 1.8
+    792599n 1.8
+    792600n 0
+    792649n 0
+    792650n 1.8
+    792699n 1.8
+    792700n 0
+    792749n 0
+    792750n 1.8
+    792799n 1.8
+    792800n 0
+    792849n 0
+    792850n 1.8
+    792899n 1.8
+    792900n 0
+    792949n 0
+    792950n 1.8
+    792999n 1.8
+    793000n 0
+    793049n 0
+    793050n 1.8
+    793099n 1.8
+    793100n 0
+    793149n 0
+    793150n 1.8
+    793199n 1.8
+    793200n 0
+    793249n 0
+    793250n 1.8
+    793299n 1.8
+    793300n 0
+    793349n 0
+    793350n 1.8
+    793399n 1.8
+    793400n 0
+    793449n 0
+    793450n 1.8
+    793499n 1.8
+    793500n 0
+    793549n 0
+    793550n 1.8
+    793599n 1.8
+    793600n 0
+    793649n 0
+    793650n 1.8
+    793699n 1.8
+    793700n 0
+    793749n 0
+    793750n 1.8
+    793799n 1.8
+    793800n 0
+    793849n 0
+    793850n 1.8
+    793899n 1.8
+    793900n 0
+    793949n 0
+    793950n 1.8
+    793999n 1.8
+    794000n 0
+    794049n 0
+    794050n 1.8
+    794099n 1.8
+    794100n 0
+    794149n 0
+    794150n 1.8
+    794199n 1.8
+    794200n 0
+    794249n 0
+    794250n 1.8
+    794299n 1.8
+    794300n 0
+    794349n 0
+    794350n 1.8
+    794399n 1.8
+    794400n 0
+    794449n 0
+    794450n 1.8
+    794499n 1.8
+    794500n 0
+    794549n 0
+    794550n 1.8
+    794599n 1.8
+    794600n 0
+    794649n 0
+    794650n 1.8
+    794699n 1.8
+    794700n 0
+    794749n 0
+    794750n 1.8
+    794799n 1.8
+    794800n 0
+    794849n 0
+    794850n 1.8
+    794899n 1.8
+    794900n 0
+    794949n 0
+    794950n 1.8
+    794999n 1.8
+    795000n 0
+    795049n 0
+    795050n 1.8
+    795099n 1.8
+    795100n 0
+    795149n 0
+    795150n 1.8
+    795199n 1.8
+    795200n 0
+    795249n 0
+    795250n 1.8
+    795299n 1.8
+    795300n 0
+    795349n 0
+    795350n 1.8
+    795399n 1.8
+    795400n 0
+    795449n 0
+    795450n 1.8
+    795499n 1.8
+    795500n 0
+    795549n 0
+    795550n 1.8
+    795599n 1.8
+    795600n 0
+    795649n 0
+    795650n 1.8
+    795699n 1.8
+    795700n 0
+    795749n 0
+    795750n 1.8
+    795799n 1.8
+    795800n 0
+    795849n 0
+    795850n 1.8
+    795899n 1.8
+    795900n 0
+    795949n 0
+    795950n 1.8
+    795999n 1.8
+    796000n 0
+    796049n 0
+    796050n 1.8
+    796099n 1.8
+    796100n 0
+    796149n 0
+    796150n 1.8
+    796199n 1.8
+    796200n 0
+    796249n 0
+    796250n 1.8
+    796299n 1.8
+    796300n 0
+    796349n 0
+    796350n 1.8
+    796399n 1.8
+    796400n 0
+    796449n 0
+    796450n 1.8
+    796499n 1.8
+    796500n 0
+    796549n 0
+    796550n 1.8
+    796599n 1.8
+    796600n 0
+    796649n 0
+    796650n 1.8
+    796699n 1.8
+    796700n 0
+    796749n 0
+    796750n 1.8
+    796799n 1.8
+    796800n 0
+    796849n 0
+    796850n 1.8
+    796899n 1.8
+    796900n 0
+    796949n 0
+    796950n 1.8
+    796999n 1.8
+    797000n 0
+    797049n 0
+    797050n 1.8
+    797099n 1.8
+    797100n 0
+    797149n 0
+    797150n 1.8
+    797199n 1.8
+    797200n 0
+    797249n 0
+    797250n 1.8
+    797299n 1.8
+    797300n 0
+    797349n 0
+    797350n 1.8
+    797399n 1.8
+    797400n 0
+    797449n 0
+    797450n 1.8
+    797499n 1.8
+    797500n 0
+    797549n 0
+    797550n 1.8
+    797599n 1.8
+    797600n 0
+    797649n 0
+    797650n 1.8
+    797699n 1.8
+    797700n 0
+    797749n 0
+    797750n 1.8
+    797799n 1.8
+    797800n 0
+    797849n 0
+    797850n 1.8
+    797899n 1.8
+    797900n 0
+    797949n 0
+    797950n 1.8
+    797999n 1.8
+    798000n 0
+    798049n 0
+    798050n 1.8
+    798099n 1.8
+    798100n 0
+    798149n 0
+    798150n 1.8
+    798199n 1.8
+    798200n 0
+    798249n 0
+    798250n 1.8
+    798299n 1.8
+    798300n 0
+    798349n 0
+    798350n 1.8
+    798399n 1.8
+    798400n 0
+    798449n 0
+    798450n 1.8
+    798499n 1.8
+    798500n 0
+    798549n 0
+    798550n 1.8
+    798599n 1.8
+    798600n 0
+    798649n 0
+    798650n 1.8
+    798699n 1.8
+    798700n 0
+    798749n 0
+    798750n 1.8
+    798799n 1.8
+    798800n 0
+    798849n 0
+    798850n 1.8
+    798899n 1.8
+    798900n 0
+    798949n 0
+    798950n 1.8
+    798999n 1.8
+    799000n 0
+    799049n 0
+    799050n 1.8
+    799099n 1.8
+    799100n 0
+    799149n 0
+    799150n 1.8
+    799199n 1.8
+    799200n 0
+    799249n 0
+    799250n 1.8
+    799299n 1.8
+    799300n 0
+    799349n 0
+    799350n 1.8
+    799399n 1.8
+    799400n 0
+    799449n 0
+    799450n 1.8
+    799499n 1.8
+    799500n 0
+    799549n 0
+    799550n 1.8
+    799599n 1.8
+    799600n 0
+    799649n 0
+    799650n 1.8
+    799699n 1.8
+    799700n 0
+    799749n 0
+    799750n 1.8
+    799799n 1.8
+    799800n 0
+    799849n 0
+    799850n 1.8
+    799899n 1.8
+    799900n 0
+    799949n 0
+    799950n 1.8
+    799999n 1.8
+    800000n 0
+    800049n 0
+    800050n 1.8
+    800099n 1.8
+    800100n 0
+    800149n 0
+    800150n 1.8
+    800199n 1.8
+    800200n 0
+    800249n 0
+    800250n 1.8
+    800299n 1.8
+    800300n 0
+    800349n 0
+    800350n 1.8
+    800399n 1.8
+    800400n 0
+    800449n 0
+    800450n 1.8
+    800499n 1.8
+    800500n 0
+    800549n 0
+    800550n 1.8
+    800599n 1.8
+    800600n 0
+    800649n 0
+    800650n 1.8
+    800699n 1.8
+    800700n 0
+    800749n 0
+    800750n 1.8
+    800799n 1.8
+    800800n 0
+    800849n 0
+    800850n 1.8
+    800899n 1.8
+    800900n 0
+    800949n 0
+    800950n 1.8
+    800999n 1.8
+    801000n 0
+    801049n 0
+    801050n 1.8
+    801099n 1.8
+    801100n 0
+    801149n 0
+    801150n 1.8
+    801199n 1.8
+    801200n 0
+    801249n 0
+    801250n 1.8
+    801299n 1.8
+    801300n 0
+    801349n 0
+    801350n 1.8
+    801399n 1.8
+    801400n 0
+    801449n 0
+    801450n 1.8
+    801499n 1.8
+    801500n 0
+    801549n 0
+    801550n 1.8
+    801599n 1.8
+    801600n 0
+    801649n 0
+    801650n 1.8
+    801699n 1.8
+    801700n 0
+    801749n 0
+    801750n 1.8
+    801799n 1.8
+    801800n 0
+    801849n 0
+    801850n 1.8
+    801899n 1.8
+    801900n 0
+    801949n 0
+    801950n 1.8
+    801999n 1.8
+    802000n 0
+    802049n 0
+    802050n 1.8
+    802099n 1.8
+    802100n 0
+    802149n 0
+    802150n 1.8
+    802199n 1.8
+    802200n 0
+    802249n 0
+    802250n 1.8
+    802299n 1.8
+    802300n 0
+    802349n 0
+    802350n 1.8
+    802399n 1.8
+    802400n 0
+    802449n 0
+    802450n 1.8
+    802499n 1.8
+    802500n 0
+    802549n 0
+    802550n 1.8
+    802599n 1.8
+    802600n 0
+    802649n 0
+    802650n 1.8
+    802699n 1.8
+    802700n 0
+    802749n 0
+    802750n 1.8
+    802799n 1.8
+    802800n 0
+    802849n 0
+    802850n 1.8
+    802899n 1.8
+    802900n 0
+    802949n 0
+    802950n 1.8
+    802999n 1.8
+    803000n 0
+    803049n 0
+    803050n 1.8
+    803099n 1.8
+    803100n 0
+    803149n 0
+    803150n 1.8
+    803199n 1.8
+    803200n 0
+    803249n 0
+    803250n 1.8
+    803299n 1.8
+    803300n 0
+    803349n 0
+    803350n 1.8
+    803399n 1.8
+    803400n 0
+    803449n 0
+    803450n 1.8
+    803499n 1.8
+    803500n 0
+    803549n 0
+    803550n 1.8
+    803599n 1.8
+    803600n 0
+    803649n 0
+    803650n 1.8
+    803699n 1.8
+    803700n 0
+    803749n 0
+    803750n 1.8
+    803799n 1.8
+    803800n 0
+    803849n 0
+    803850n 1.8
+    803899n 1.8
+    803900n 0
+    803949n 0
+    803950n 1.8
+    803999n 1.8
+    804000n 0
+    804049n 0
+    804050n 1.8
+    804099n 1.8
+    804100n 0
+    804149n 0
+    804150n 1.8
+    804199n 1.8
+    804200n 0
+    804249n 0
+    804250n 1.8
+    804299n 1.8
+    804300n 0
+    804349n 0
+    804350n 1.8
+    804399n 1.8
+    804400n 0
+    804449n 0
+    804450n 1.8
+    804499n 1.8
+    804500n 0
+    804549n 0
+    804550n 1.8
+    804599n 1.8
+    804600n 0
+    804649n 0
+    804650n 1.8
+    804699n 1.8
+    804700n 0
+    804749n 0
+    804750n 1.8
+    804799n 1.8
+    804800n 0
+    804849n 0
+    804850n 1.8
+    804899n 1.8
+    804900n 0
+    804949n 0
+    804950n 1.8
+    804999n 1.8
+    805000n 0
+    805049n 0
+    805050n 1.8
+    805099n 1.8
+    805100n 0
+    805149n 0
+    805150n 1.8
+    805199n 1.8
+    805200n 0
+    805249n 0
+    805250n 1.8
+    805299n 1.8
+    805300n 0
+    805349n 0
+    805350n 1.8
+    805399n 1.8
+    805400n 0
+    805449n 0
+    805450n 1.8
+    805499n 1.8
+    805500n 0
+    805549n 0
+    805550n 1.8
+    805599n 1.8
+    805600n 0
+    805649n 0
+    805650n 1.8
+    805699n 1.8
+    805700n 0
+    805749n 0
+    805750n 1.8
+    805799n 1.8
+    805800n 0
+    805849n 0
+    805850n 1.8
+    805899n 1.8
+    805900n 0
+    805949n 0
+    805950n 1.8
+    805999n 1.8
+    806000n 0
+    806049n 0
+    806050n 1.8
+    806099n 1.8
+    806100n 0
+    806149n 0
+    806150n 1.8
+    806199n 1.8
+    806200n 0
+    806249n 0
+    806250n 1.8
+    806299n 1.8
+    806300n 0
+    806349n 0
+    806350n 1.8
+    806399n 1.8
+    806400n 0
+    806449n 0
+    806450n 1.8
+    806499n 1.8
+    806500n 0
+    806549n 0
+    806550n 1.8
+    806599n 1.8
+    806600n 0
+    806649n 0
+    806650n 1.8
+    806699n 1.8
+    806700n 0
+    806749n 0
+    806750n 1.8
+    806799n 1.8
+    806800n 0
+    806849n 0
+    806850n 1.8
+    806899n 1.8
+    806900n 0
+    806949n 0
+    806950n 1.8
+    806999n 1.8
+    807000n 0
+    807049n 0
+    807050n 1.8
+    807099n 1.8
+    807100n 0
+    807149n 0
+    807150n 1.8
+    807199n 1.8
+    807200n 0
+    807249n 0
+    807250n 1.8
+    807299n 1.8
+    807300n 0
+    807349n 0
+    807350n 1.8
+    807399n 1.8
+    807400n 0
+    807449n 0
+    807450n 1.8
+    807499n 1.8
+    807500n 0
+    807549n 0
+    807550n 1.8
+    807599n 1.8
+    807600n 0
+    807649n 0
+    807650n 1.8
+    807699n 1.8
+    807700n 0
+    807749n 0
+    807750n 1.8
+    807799n 1.8
+    807800n 0
+    807849n 0
+    807850n 1.8
+    807899n 1.8
+    807900n 0
+    807949n 0
+    807950n 1.8
+    807999n 1.8
+    808000n 0
+    808049n 0
+    808050n 1.8
+    808099n 1.8
+    808100n 0
+    808149n 0
+    808150n 1.8
+    808199n 1.8
+    808200n 0
+    808249n 0
+    808250n 1.8
+    808299n 1.8
+    808300n 0
+    808349n 0
+    808350n 1.8
+    808399n 1.8
+    808400n 0
+    808449n 0
+    808450n 1.8
+    808499n 1.8
+    808500n 0
+    808549n 0
+    808550n 1.8
+    808599n 1.8
+    808600n 0
+    808649n 0
+    808650n 1.8
+    808699n 1.8
+    808700n 0
+    808749n 0
+    808750n 1.8
+    808799n 1.8
+    808800n 0
+    808849n 0
+    808850n 1.8
+    808899n 1.8
+    808900n 0
+    808949n 0
+    808950n 1.8
+    808999n 1.8
+    809000n 0
+    809049n 0
+    809050n 1.8
+    809099n 1.8
+    809100n 0
+    809149n 0
+    809150n 1.8
+    809199n 1.8
+    809200n 0
+    809249n 0
+    809250n 1.8
+    809299n 1.8
+    809300n 0
+    809349n 0
+    809350n 1.8
+    809399n 1.8
+    809400n 0
+    809449n 0
+    809450n 1.8
+    809499n 1.8
+    809500n 0
+    809549n 0
+    809550n 1.8
+    809599n 1.8
+    809600n 0
+    809649n 0
+    809650n 1.8
+    809699n 1.8
+    809700n 0
+    809749n 0
+    809750n 1.8
+    809799n 1.8
+    809800n 0
+    809849n 0
+    809850n 1.8
+    809899n 1.8
+    809900n 0
+    809949n 0
+    809950n 1.8
+    809999n 1.8
+    810000n 0
+    810049n 0
+    810050n 1.8
+    810099n 1.8
+    810100n 0
+    810149n 0
+    810150n 1.8
+    810199n 1.8
+    810200n 0
+    810249n 0
+    810250n 1.8
+    810299n 1.8
+    810300n 0
+    810349n 0
+    810350n 1.8
+    810399n 1.8
+    810400n 0
+    810449n 0
+    810450n 1.8
+    810499n 1.8
+    810500n 0
+    810549n 0
+    810550n 1.8
+    810599n 1.8
+    810600n 0
+    810649n 0
+    810650n 1.8
+    810699n 1.8
+    810700n 0
+    810749n 0
+    810750n 1.8
+    810799n 1.8
+    810800n 0
+    810849n 0
+    810850n 1.8
+    810899n 1.8
+    810900n 0
+    810949n 0
+    810950n 1.8
+    810999n 1.8
+    811000n 0
+    811049n 0
+    811050n 1.8
+    811099n 1.8
+    811100n 0
+    811149n 0
+    811150n 1.8
+    811199n 1.8
+    811200n 0
+    811249n 0
+    811250n 1.8
+    811299n 1.8
+    811300n 0
+    811349n 0
+    811350n 1.8
+    811399n 1.8
+    811400n 0
+    811449n 0
+    811450n 1.8
+    811499n 1.8
+    811500n 0
+    811549n 0
+    811550n 1.8
+    811599n 1.8
+    811600n 0
+    811649n 0
+    811650n 1.8
+    811699n 1.8
+    811700n 0
+    811749n 0
+    811750n 1.8
+    811799n 1.8
+    811800n 0
+    811849n 0
+    811850n 1.8
+    811899n 1.8
+    811900n 0
+    811949n 0
+    811950n 1.8
+    811999n 1.8
+    812000n 0
+    812049n 0
+    812050n 1.8
+    812099n 1.8
+    812100n 0
+    812149n 0
+    812150n 1.8
+    812199n 1.8
+    812200n 0
+    812249n 0
+    812250n 1.8
+    812299n 1.8
+    812300n 0
+    812349n 0
+    812350n 1.8
+    812399n 1.8
+    812400n 0
+    812449n 0
+    812450n 1.8
+    812499n 1.8
+    812500n 0
+    812549n 0
+    812550n 1.8
+    812599n 1.8
+    812600n 0
+    812649n 0
+    812650n 1.8
+    812699n 1.8
+    812700n 0
+    812749n 0
+    812750n 1.8
+    812799n 1.8
+    812800n 0
+    812849n 0
+    812850n 1.8
+    812899n 1.8
+    812900n 0
+    812949n 0
+    812950n 1.8
+    812999n 1.8
+    813000n 0
+    813049n 0
+    813050n 1.8
+    813099n 1.8
+    813100n 0
+    813149n 0
+    813150n 1.8
+    813199n 1.8
+    813200n 0
+    813249n 0
+    813250n 1.8
+    813299n 1.8
+    813300n 0
+    813349n 0
+    813350n 1.8
+    813399n 1.8
+    813400n 0
+    813449n 0
+    813450n 1.8
+    813499n 1.8
+    813500n 0
+    813549n 0
+    813550n 1.8
+    813599n 1.8
+    813600n 0
+    813649n 0
+    813650n 1.8
+    813699n 1.8
+    813700n 0
+    813749n 0
+    813750n 1.8
+    813799n 1.8
+    813800n 0
+    813849n 0
+    813850n 1.8
+    813899n 1.8
+    813900n 0
+    813949n 0
+    813950n 1.8
+    813999n 1.8
+    814000n 0
+    814049n 0
+    814050n 1.8
+    814099n 1.8
+    814100n 0
+    814149n 0
+    814150n 1.8
+    814199n 1.8
+    814200n 0
+    814249n 0
+    814250n 1.8
+    814299n 1.8
+    814300n 0
+    814349n 0
+    814350n 1.8
+    814399n 1.8
+    814400n 0
+    814449n 0
+    814450n 1.8
+    814499n 1.8
+    814500n 0
+    814549n 0
+    814550n 1.8
+    814599n 1.8
+    814600n 0
+    814649n 0
+    814650n 1.8
+    814699n 1.8
+    814700n 0
+    814749n 0
+    814750n 1.8
+    814799n 1.8
+    814800n 0
+    814849n 0
+    814850n 1.8
+    814899n 1.8
+    814900n 0
+    814949n 0
+    814950n 1.8
+    814999n 1.8
+    815000n 0
+    815049n 0
+    815050n 1.8
+    815099n 1.8
+    815100n 0
+    815149n 0
+    815150n 1.8
+    815199n 1.8
+    815200n 0
+    815249n 0
+    815250n 1.8
+    815299n 1.8
+    815300n 0
+    815349n 0
+    815350n 1.8
+    815399n 1.8
+    815400n 0
+    815449n 0
+    815450n 1.8
+    815499n 1.8
+    815500n 0
+    815549n 0
+    815550n 1.8
+    815599n 1.8
+    815600n 0
+    815649n 0
+    815650n 1.8
+    815699n 1.8
+    815700n 0
+    815749n 0
+    815750n 1.8
+    815799n 1.8
+    815800n 0
+    815849n 0
+    815850n 1.8
+    815899n 1.8
+    815900n 0
+    815949n 0
+    815950n 1.8
+    815999n 1.8
+    816000n 0
+    816049n 0
+    816050n 1.8
+    816099n 1.8
+    816100n 0
+    816149n 0
+    816150n 1.8
+    816199n 1.8
+    816200n 0
+    816249n 0
+    816250n 1.8
+    816299n 1.8
+    816300n 0
+    816349n 0
+    816350n 1.8
+    816399n 1.8
+    816400n 0
+    816449n 0
+    816450n 1.8
+    816499n 1.8
+    816500n 0
+    816549n 0
+    816550n 1.8
+    816599n 1.8
+    816600n 0
+    816649n 0
+    816650n 1.8
+    816699n 1.8
+    816700n 0
+    816749n 0
+    816750n 1.8
+    816799n 1.8
+    816800n 0
+    816849n 0
+    816850n 1.8
+    816899n 1.8
+    816900n 0
+    816949n 0
+    816950n 1.8
+    816999n 1.8
+    817000n 0
+    817049n 0
+    817050n 1.8
+    817099n 1.8
+    817100n 0
+    817149n 0
+    817150n 1.8
+    817199n 1.8
+    817200n 0
+    817249n 0
+    817250n 1.8
+    817299n 1.8
+    817300n 0
+    817349n 0
+    817350n 1.8
+    817399n 1.8
+    817400n 0
+    817449n 0
+    817450n 1.8
+    817499n 1.8
+    817500n 0
+    817549n 0
+    817550n 1.8
+    817599n 1.8
+    817600n 0
+    817649n 0
+    817650n 1.8
+    817699n 1.8
+    817700n 0
+    817749n 0
+    817750n 1.8
+    817799n 1.8
+    817800n 0
+    817849n 0
+    817850n 1.8
+    817899n 1.8
+    817900n 0
+    817949n 0
+    817950n 1.8
+    817999n 1.8
+    818000n 0
+    818049n 0
+    818050n 1.8
+    818099n 1.8
+    818100n 0
+    818149n 0
+    818150n 1.8
+    818199n 1.8
+    818200n 0
+    818249n 0
+    818250n 1.8
+    818299n 1.8
+    818300n 0
+    818349n 0
+    818350n 1.8
+    818399n 1.8
+    818400n 0
+    818449n 0
+    818450n 1.8
+    818499n 1.8
+    818500n 0
+    818549n 0
+    818550n 1.8
+    818599n 1.8
+    818600n 0
+    818649n 0
+    818650n 1.8
+    818699n 1.8
+    818700n 0
+    818749n 0
+    818750n 1.8
+    818799n 1.8
+    818800n 0
+    818849n 0
+    818850n 1.8
+    818899n 1.8
+    818900n 0
+    818949n 0
+    818950n 1.8
+    818999n 1.8
+    819000n 0
+    819049n 0
+    819050n 1.8
+    819099n 1.8
+    819100n 0
+    819149n 0
+    819150n 1.8
+    819199n 1.8
+    819200n 0
+    819249n 0
+    819250n 1.8
+    819299n 1.8
+    819300n 0
+    819349n 0
+    819350n 1.8
+    819399n 1.8
+    819400n 0
+    819449n 0
+    819450n 1.8
+    819499n 1.8
+    819500n 0
+    819549n 0
+    819550n 1.8
+    819599n 1.8
+    819600n 0
+    819649n 0
+    819650n 1.8
+    819699n 1.8
+    819700n 0
+    819749n 0
+    819750n 1.8
+    819799n 1.8
+    819800n 0
+    819849n 0
+    819850n 1.8
+    819899n 1.8
+    819900n 0
+    819949n 0
+    819950n 1.8
+    819999n 1.8
+    820000n 0
+    820049n 0
+    820050n 1.8
+    820099n 1.8
+    820100n 0
+    820149n 0
+    820150n 1.8
+    820199n 1.8
+    820200n 0
+    820249n 0
+    820250n 1.8
+    820299n 1.8
+    820300n 0
+    820349n 0
+    820350n 1.8
+    820399n 1.8
+    820400n 0
+    820449n 0
+    820450n 1.8
+    820499n 1.8
+    820500n 0
+    820549n 0
+    820550n 1.8
+    820599n 1.8
+    820600n 0
+    820649n 0
+    820650n 1.8
+    820699n 1.8
+    820700n 0
+    820749n 0
+    820750n 1.8
+    820799n 1.8
+    820800n 0
+    820849n 0
+    820850n 1.8
+    820899n 1.8
+    820900n 0
+    820949n 0
+    820950n 1.8
+    820999n 1.8
+    821000n 0
+    821049n 0
+    821050n 1.8
+    821099n 1.8
+    821100n 0
+    821149n 0
+    821150n 1.8
+    821199n 1.8
+    821200n 0
+    821249n 0
+    821250n 1.8
+    821299n 1.8
+    821300n 0
+    821349n 0
+    821350n 1.8
+    821399n 1.8
+    821400n 0
+    821449n 0
+    821450n 1.8
+    821499n 1.8
+    821500n 0
+    821549n 0
+    821550n 1.8
+    821599n 1.8
+    821600n 0
+    821649n 0
+    821650n 1.8
+    821699n 1.8
+    821700n 0
+    821749n 0
+    821750n 1.8
+    821799n 1.8
+    821800n 0
+    821849n 0
+    821850n 1.8
+    821899n 1.8
+    821900n 0
+    821949n 0
+    821950n 1.8
+    821999n 1.8
+    822000n 0
+    822049n 0
+    822050n 1.8
+    822099n 1.8
+    822100n 0
+    822149n 0
+    822150n 1.8
+    822199n 1.8
+    822200n 0
+    822249n 0
+    822250n 1.8
+    822299n 1.8
+    822300n 0
+    822349n 0
+    822350n 1.8
+    822399n 1.8
+    822400n 0
+    822449n 0
+    822450n 1.8
+    822499n 1.8
+    822500n 0
+    822549n 0
+    822550n 1.8
+    822599n 1.8
+    822600n 0
+    822649n 0
+    822650n 1.8
+    822699n 1.8
+    822700n 0
+    822749n 0
+    822750n 1.8
+    822799n 1.8
+    822800n 0
+    822849n 0
+    822850n 1.8
+    822899n 1.8
+    822900n 0
+    822949n 0
+    822950n 1.8
+    822999n 1.8
+    823000n 0
+    823049n 0
+    823050n 1.8
+    823099n 1.8
+    823100n 0
+    823149n 0
+    823150n 1.8
+    823199n 1.8
+    823200n 0
+    823249n 0
+    823250n 1.8
+    823299n 1.8
+    823300n 0
+    823349n 0
+    823350n 1.8
+    823399n 1.8
+    823400n 0
+    823449n 0
+    823450n 1.8
+    823499n 1.8
+    823500n 0
+    823549n 0
+    823550n 1.8
+    823599n 1.8
+    823600n 0
+    823649n 0
+    823650n 1.8
+    823699n 1.8
+    823700n 0
+    823749n 0
+    823750n 1.8
+    823799n 1.8
+    823800n 0
+    823849n 0
+    823850n 1.8
+    823899n 1.8
+    823900n 0
+    823949n 0
+    823950n 1.8
+    823999n 1.8
+    824000n 0
+    824049n 0
+    824050n 1.8
+    824099n 1.8
+    824100n 0
+    824149n 0
+    824150n 1.8
+    824199n 1.8
+    824200n 0
+    824249n 0
+    824250n 1.8
+    824299n 1.8
+    824300n 0
+    824349n 0
+    824350n 1.8
+    824399n 1.8
+    824400n 0
+    824449n 0
+    824450n 1.8
+    824499n 1.8
+    824500n 0
+    824549n 0
+    824550n 1.8
+    824599n 1.8
+    824600n 0
+    824649n 0
+    824650n 1.8
+    824699n 1.8
+    824700n 0
+    824749n 0
+    824750n 1.8
+    824799n 1.8
+    824800n 0
+    824849n 0
+    824850n 1.8
+    824899n 1.8
+    824900n 0
+    824949n 0
+    824950n 1.8
+    824999n 1.8
+    825000n 0
+    825049n 0
+    825050n 1.8
+    825099n 1.8
+    825100n 0
+    825149n 0
+    825150n 1.8
+    825199n 1.8
+    825200n 0
+    825249n 0
+    825250n 1.8
+    825299n 1.8
+    825300n 0
+    825349n 0
+    825350n 1.8
+    825399n 1.8
+    825400n 0
+    825449n 0
+    825450n 1.8
+    825499n 1.8
+    825500n 0
+    825549n 0
+    825550n 1.8
+    825599n 1.8
+    825600n 0
+    825649n 0
+    825650n 1.8
+    825699n 1.8
+    825700n 0
+    825749n 0
+    825750n 1.8
+    825799n 1.8
+    825800n 0
+    825849n 0
+    825850n 1.8
+    825899n 1.8
+    825900n 0
+    825949n 0
+    825950n 1.8
+    825999n 1.8
+    826000n 0
+    826049n 0
+    826050n 1.8
+    826099n 1.8
+    826100n 0
+    826149n 0
+    826150n 1.8
+    826199n 1.8
+    826200n 0
+    826249n 0
+    826250n 1.8
+    826299n 1.8
+    826300n 0
+    826349n 0
+    826350n 1.8
+    826399n 1.8
+    826400n 0
+    826449n 0
+    826450n 1.8
+    826499n 1.8
+    826500n 0
+    826549n 0
+    826550n 1.8
+    826599n 1.8
+    826600n 0
+    826649n 0
+    826650n 1.8
+    826699n 1.8
+    826700n 0
+    826749n 0
+    826750n 1.8
+    826799n 1.8
+    826800n 0
+    826849n 0
+    826850n 1.8
+    826899n 1.8
+    826900n 0
+    826949n 0
+    826950n 1.8
+    826999n 1.8
+    827000n 0
+    827049n 0
+    827050n 1.8
+    827099n 1.8
+    827100n 0
+    827149n 0
+    827150n 1.8
+    827199n 1.8
+    827200n 0
+    827249n 0
+    827250n 1.8
+    827299n 1.8
+    827300n 0
+    827349n 0
+    827350n 1.8
+    827399n 1.8
+    827400n 0
+    827449n 0
+    827450n 1.8
+    827499n 1.8
+    827500n 0
+    827549n 0
+    827550n 1.8
+    827599n 1.8
+    827600n 0
+    827649n 0
+    827650n 1.8
+    827699n 1.8
+    827700n 0
+    827749n 0
+    827750n 1.8
+    827799n 1.8
+    827800n 0
+    827849n 0
+    827850n 1.8
+    827899n 1.8
+    827900n 0
+    827949n 0
+    827950n 1.8
+    827999n 1.8
+    828000n 0
+    828049n 0
+    828050n 1.8
+    828099n 1.8
+    828100n 0
+    828149n 0
+    828150n 1.8
+    828199n 1.8
+    828200n 0
+    828249n 0
+    828250n 1.8
+    828299n 1.8
+    828300n 0
+    828349n 0
+    828350n 1.8
+    828399n 1.8
+    828400n 0
+    828449n 0
+    828450n 1.8
+    828499n 1.8
+    828500n 0
+    828549n 0
+    828550n 1.8
+    828599n 1.8
+    828600n 0
+    828649n 0
+    828650n 1.8
+    828699n 1.8
+    828700n 0
+    828749n 0
+    828750n 1.8
+    828799n 1.8
+    828800n 0
+    828849n 0
+    828850n 1.8
+    828899n 1.8
+    828900n 0
+    828949n 0
+    828950n 1.8
+    828999n 1.8
+    829000n 0
+    829049n 0
+    829050n 1.8
+    829099n 1.8
+    829100n 0
+    829149n 0
+    829150n 1.8
+    829199n 1.8
+    829200n 0
+    829249n 0
+    829250n 1.8
+    829299n 1.8
+    829300n 0
+    829349n 0
+    829350n 1.8
+    829399n 1.8
+    829400n 0
+    829449n 0
+    829450n 1.8
+    829499n 1.8
+    829500n 0
+    829549n 0
+    829550n 1.8
+    829599n 1.8
+    829600n 0
+    829649n 0
+    829650n 1.8
+    829699n 1.8
+    829700n 0
+    829749n 0
+    829750n 1.8
+    829799n 1.8
+    829800n 0
+    829849n 0
+    829850n 1.8
+    829899n 1.8
+    829900n 0
+    829949n 0
+    829950n 1.8
+    829999n 1.8
+    830000n 0
+    830049n 0
+    830050n 1.8
+    830099n 1.8
+    830100n 0
+    830149n 0
+    830150n 1.8
+    830199n 1.8
+    830200n 0
+    830249n 0
+    830250n 1.8
+    830299n 1.8
+    830300n 0
+    830349n 0
+    830350n 1.8
+    830399n 1.8
+    830400n 0
+    830449n 0
+    830450n 1.8
+    830499n 1.8
+    830500n 0
+    830549n 0
+    830550n 1.8
+    830599n 1.8
+    830600n 0
+    830649n 0
+    830650n 1.8
+    830699n 1.8
+    830700n 0
+    830749n 0
+    830750n 1.8
+    830799n 1.8
+    830800n 0
+    830849n 0
+    830850n 1.8
+    830899n 1.8
+    830900n 0
+    830949n 0
+    830950n 1.8
+    830999n 1.8
+    831000n 0
+    831049n 0
+    831050n 1.8
+    831099n 1.8
+    831100n 0
+    831149n 0
+    831150n 1.8
+    831199n 1.8
+    831200n 0
+    831249n 0
+    831250n 1.8
+    831299n 1.8
+    831300n 0
+    831349n 0
+    831350n 1.8
+    831399n 1.8
+    831400n 0
+    831449n 0
+    831450n 1.8
+    831499n 1.8
+    831500n 0
+    831549n 0
+    831550n 1.8
+    831599n 1.8
+    831600n 0
+    831649n 0
+    831650n 1.8
+    831699n 1.8
+    831700n 0
+    831749n 0
+    831750n 1.8
+    831799n 1.8
+    831800n 0
+    831849n 0
+    831850n 1.8
+    831899n 1.8
+    831900n 0
+    831949n 0
+    831950n 1.8
+    831999n 1.8
+    832000n 0
+    832049n 0
+    832050n 1.8
+    832099n 1.8
+    832100n 0
+    832149n 0
+    832150n 1.8
+    832199n 1.8
+    832200n 0
+    832249n 0
+    832250n 1.8
+    832299n 1.8
+    832300n 0
+    832349n 0
+    832350n 1.8
+    832399n 1.8
+    832400n 0
+    832449n 0
+    832450n 1.8
+    832499n 1.8
+    832500n 0
+    832549n 0
+    832550n 1.8
+    832599n 1.8
+    832600n 0
+    832649n 0
+    832650n 1.8
+    832699n 1.8
+    832700n 0
+    832749n 0
+    832750n 1.8
+    832799n 1.8
+    832800n 0
+    832849n 0
+    832850n 1.8
+    832899n 1.8
+    832900n 0
+    832949n 0
+    832950n 1.8
+    832999n 1.8
+    833000n 0
+    833049n 0
+    833050n 1.8
+    833099n 1.8
+    833100n 0
+    833149n 0
+    833150n 1.8
+    833199n 1.8
+    833200n 0
+    833249n 0
+    833250n 1.8
+    833299n 1.8
+    833300n 0
+    833349n 0
+    833350n 1.8
+    833399n 1.8
+    833400n 0
+    833449n 0
+    833450n 1.8
+    833499n 1.8
+    833500n 0
+    833549n 0
+    833550n 1.8
+    833599n 1.8
+    833600n 0
+    833649n 0
+    833650n 1.8
+    833699n 1.8
+    833700n 0
+    833749n 0
+    833750n 1.8
+    833799n 1.8
+    833800n 0
+    833849n 0
+    833850n 1.8
+    833899n 1.8
+    833900n 0
+    833949n 0
+    833950n 1.8
+    833999n 1.8
+    834000n 0
+    834049n 0
+    834050n 1.8
+    834099n 1.8
+    834100n 0
+    834149n 0
+    834150n 1.8
+    834199n 1.8
+    834200n 0
+    834249n 0
+    834250n 1.8
+    834299n 1.8
+    834300n 0
+    834349n 0
+    834350n 1.8
+    834399n 1.8
+    834400n 0
+    834449n 0
+    834450n 1.8
+    834499n 1.8
+    834500n 0
+    834549n 0
+    834550n 1.8
+    834599n 1.8
+    834600n 0
+    834649n 0
+    834650n 1.8
+    834699n 1.8
+    834700n 0
+    834749n 0
+    834750n 1.8
+    834799n 1.8
+    834800n 0
+    834849n 0
+    834850n 1.8
+    834899n 1.8
+    834900n 0
+    834949n 0
+    834950n 1.8
+    834999n 1.8
+    835000n 0
+    835049n 0
+    835050n 1.8
+    835099n 1.8
+    835100n 0
+    835149n 0
+    835150n 1.8
+    835199n 1.8
+    835200n 0
+    835249n 0
+    835250n 1.8
+    835299n 1.8
+    835300n 0
+    835349n 0
+    835350n 1.8
+    835399n 1.8
+    835400n 0
+    835449n 0
+    835450n 1.8
+    835499n 1.8
+    835500n 0
+    835549n 0
+    835550n 1.8
+    835599n 1.8
+    835600n 0
+    835649n 0
+    835650n 1.8
+    835699n 1.8
+    835700n 0
+    835749n 0
+    835750n 1.8
+    835799n 1.8
+    835800n 0
+    835849n 0
+    835850n 1.8
+    835899n 1.8
+    835900n 0
+    835949n 0
+    835950n 1.8
+    835999n 1.8
+    836000n 0
+    836049n 0
+    836050n 1.8
+    836099n 1.8
+    836100n 0
+    836149n 0
+    836150n 1.8
+    836199n 1.8
+    836200n 0
+    836249n 0
+    836250n 1.8
+    836299n 1.8
+    836300n 0
+    836349n 0
+    836350n 1.8
+    836399n 1.8
+    836400n 0
+    836449n 0
+    836450n 1.8
+    836499n 1.8
+    836500n 0
+    836549n 0
+    836550n 1.8
+    836599n 1.8
+    836600n 0
+    836649n 0
+    836650n 1.8
+    836699n 1.8
+    836700n 0
+    836749n 0
+    836750n 1.8
+    836799n 1.8
+    836800n 0
+    836849n 0
+    836850n 1.8
+    836899n 1.8
+    836900n 0
+    836949n 0
+    836950n 1.8
+    836999n 1.8
+    837000n 0
+    837049n 0
+    837050n 1.8
+    837099n 1.8
+    837100n 0
+    837149n 0
+    837150n 1.8
+    837199n 1.8
+    837200n 0
+    837249n 0
+    837250n 1.8
+    837299n 1.8
+    837300n 0
+    837349n 0
+    837350n 1.8
+    837399n 1.8
+    837400n 0
+    837449n 0
+    837450n 1.8
+    837499n 1.8
+    837500n 0
+    837549n 0
+    837550n 1.8
+    837599n 1.8
+    837600n 0
+    837649n 0
+    837650n 1.8
+    837699n 1.8
+    837700n 0
+    837749n 0
+    837750n 1.8
+    837799n 1.8
+    837800n 0
+    837849n 0
+    837850n 1.8
+    837899n 1.8
+    837900n 0
+    837949n 0
+    837950n 1.8
+    837999n 1.8
+    838000n 0
+    838049n 0
+    838050n 1.8
+    838099n 1.8
+    838100n 0
+    838149n 0
+    838150n 1.8
+    838199n 1.8
+    838200n 0
+    838249n 0
+    838250n 1.8
+    838299n 1.8
+    838300n 0
+    838349n 0
+    838350n 1.8
+    838399n 1.8
+    838400n 0
+    838449n 0
+    838450n 1.8
+    838499n 1.8
+    838500n 0
+    838549n 0
+    838550n 1.8
+    838599n 1.8
+    838600n 0
+    838649n 0
+    838650n 1.8
+    838699n 1.8
+    838700n 0
+    838749n 0
+    838750n 1.8
+    838799n 1.8
+    838800n 0
+    838849n 0
+    838850n 1.8
+    838899n 1.8
+    838900n 0
+    838949n 0
+    838950n 1.8
+    838999n 1.8
+    839000n 0
+    839049n 0
+    839050n 1.8
+    839099n 1.8
+    839100n 0
+    839149n 0
+    839150n 1.8
+    839199n 1.8
+    839200n 0
+    839249n 0
+    839250n 1.8
+    839299n 1.8
+    839300n 0
+    839349n 0
+    839350n 1.8
+    839399n 1.8
+    839400n 0
+    839449n 0
+    839450n 1.8
+    839499n 1.8
+    839500n 0
+    839549n 0
+    839550n 1.8
+    839599n 1.8
+    839600n 0
+    839649n 0
+    839650n 1.8
+    839699n 1.8
+    839700n 0
+    839749n 0
+    839750n 1.8
+    839799n 1.8
+    839800n 0
+    839849n 0
+    839850n 1.8
+    839899n 1.8
+    839900n 0
+    839949n 0
+    839950n 1.8
+    839999n 1.8
+    840000n 0
+    840049n 0
+    840050n 1.8
+    840099n 1.8
+    840100n 0
+    840149n 0
+    840150n 1.8
+    840199n 1.8
+    840200n 0
+    840249n 0
+    840250n 1.8
+    840299n 1.8
+    840300n 0
+    840349n 0
+    840350n 1.8
+    840399n 1.8
+    840400n 0
+    840449n 0
+    840450n 1.8
+    840499n 1.8
+    840500n 0
+    840549n 0
+    840550n 1.8
+    840599n 1.8
+    840600n 0
+    840649n 0
+    840650n 1.8
+    840699n 1.8
+    840700n 0
+    840749n 0
+    840750n 1.8
+    840799n 1.8
+    840800n 0
+    840849n 0
+    840850n 1.8
+    840899n 1.8
+    840900n 0
+    840949n 0
+    840950n 1.8
+    840999n 1.8
+    841000n 0
+    841049n 0
+    841050n 1.8
+    841099n 1.8
+    841100n 0
+    841149n 0
+    841150n 1.8
+    841199n 1.8
+    841200n 0
+    841249n 0
+    841250n 1.8
+    841299n 1.8
+    841300n 0
+    841349n 0
+    841350n 1.8
+    841399n 1.8
+    841400n 0
+    841449n 0
+    841450n 1.8
+    841499n 1.8
+    841500n 0
+    841549n 0
+    841550n 1.8
+    841599n 1.8
+    841600n 0
+    841649n 0
+    841650n 1.8
+    841699n 1.8
+    841700n 0
+    841749n 0
+    841750n 1.8
+    841799n 1.8
+    841800n 0
+    841849n 0
+    841850n 1.8
+    841899n 1.8
+    841900n 0
+    841949n 0
+    841950n 1.8
+    841999n 1.8
+    842000n 0
+    842049n 0
+    842050n 1.8
+    842099n 1.8
+    842100n 0
+    842149n 0
+    842150n 1.8
+    842199n 1.8
+    842200n 0
+    842249n 0
+    842250n 1.8
+    842299n 1.8
+    842300n 0
+    842349n 0
+    842350n 1.8
+    842399n 1.8
+    842400n 0
+    842449n 0
+    842450n 1.8
+    842499n 1.8
+    842500n 0
+    842549n 0
+    842550n 1.8
+    842599n 1.8
+    842600n 0
+    842649n 0
+    842650n 1.8
+    842699n 1.8
+    842700n 0
+    842749n 0
+    842750n 1.8
+    842799n 1.8
+    842800n 0
+    842849n 0
+    842850n 1.8
+    842899n 1.8
+    842900n 0
+    842949n 0
+    842950n 1.8
+    842999n 1.8
+    843000n 0
+    843049n 0
+    843050n 1.8
+    843099n 1.8
+    843100n 0
+    843149n 0
+    843150n 1.8
+    843199n 1.8
+    843200n 0
+    843249n 0
+    843250n 1.8
+    843299n 1.8
+    843300n 0
+    843349n 0
+    843350n 1.8
+    843399n 1.8
+    843400n 0
+    843449n 0
+    843450n 1.8
+    843499n 1.8
+    843500n 0
+    843549n 0
+    843550n 1.8
+    843599n 1.8
+    843600n 0
+    843649n 0
+    843650n 1.8
+    843699n 1.8
+    843700n 0
+    843749n 0
+    843750n 1.8
+    843799n 1.8
+    843800n 0
+    843849n 0
+    843850n 1.8
+    843899n 1.8
+    843900n 0
+    843949n 0
+    843950n 1.8
+    843999n 1.8
+    844000n 0
+    844049n 0
+    844050n 1.8
+    844099n 1.8
+    844100n 0
+    844149n 0
+    844150n 1.8
+    844199n 1.8
+    844200n 0
+    844249n 0
+    844250n 1.8
+    844299n 1.8
+    844300n 0
+    844349n 0
+    844350n 1.8
+    844399n 1.8
+    844400n 0
+    844449n 0
+    844450n 1.8
+    844499n 1.8
+    844500n 0
+    844549n 0
+    844550n 1.8
+    844599n 1.8
+    844600n 0
+    844649n 0
+    844650n 1.8
+    844699n 1.8
+    844700n 0
+    844749n 0
+    844750n 1.8
+    844799n 1.8
+    844800n 0
+    844849n 0
+    844850n 1.8
+    844899n 1.8
+    844900n 0
+    844949n 0
+    844950n 1.8
+    844999n 1.8
+    845000n 0
+    845049n 0
+    845050n 1.8
+    845099n 1.8
+    845100n 0
+    845149n 0
+    845150n 1.8
+    845199n 1.8
+    845200n 0
+    845249n 0
+    845250n 1.8
+    845299n 1.8
+    845300n 0
+    845349n 0
+    845350n 1.8
+    845399n 1.8
+    845400n 0
+    845449n 0
+    845450n 1.8
+    845499n 1.8
+    845500n 0
+    845549n 0
+    845550n 1.8
+    845599n 1.8
+    845600n 0
+    845649n 0
+    845650n 1.8
+    845699n 1.8
+    845700n 0
+    845749n 0
+    845750n 1.8
+    845799n 1.8
+    845800n 0
+    845849n 0
+    845850n 1.8
+    845899n 1.8
+    845900n 0
+    845949n 0
+    845950n 1.8
+    845999n 1.8
+    846000n 0
+    846049n 0
+    846050n 1.8
+    846099n 1.8
+    846100n 0
+    846149n 0
+    846150n 1.8
+    846199n 1.8
+    846200n 0
+    846249n 0
+    846250n 1.8
+    846299n 1.8
+    846300n 0
+    846349n 0
+    846350n 1.8
+    846399n 1.8
+    846400n 0
+    846449n 0
+    846450n 1.8
+    846499n 1.8
+    846500n 0
+    846549n 0
+    846550n 1.8
+    846599n 1.8
+    846600n 0
+    846649n 0
+    846650n 1.8
+    846699n 1.8
+    846700n 0
+    846749n 0
+    846750n 1.8
+    846799n 1.8
+    846800n 0
+    846849n 0
+    846850n 1.8
+    846899n 1.8
+    846900n 0
+    846949n 0
+    846950n 1.8
+    846999n 1.8
+    847000n 0
+    847049n 0
+    847050n 1.8
+    847099n 1.8
+    847100n 0
+    847149n 0
+    847150n 1.8
+    847199n 1.8
+    847200n 0
+    847249n 0
+    847250n 1.8
+    847299n 1.8
+    847300n 0
+    847349n 0
+    847350n 1.8
+    847399n 1.8
+    847400n 0
+    847449n 0
+    847450n 1.8
+    847499n 1.8
+    847500n 0
+    847549n 0
+    847550n 1.8
+    847599n 1.8
+    847600n 0
+    847649n 0
+    847650n 1.8
+    847699n 1.8
+    847700n 0
+    847749n 0
+    847750n 1.8
+    847799n 1.8
+    847800n 0
+    847849n 0
+    847850n 1.8
+    847899n 1.8
+    847900n 0
+    847949n 0
+    847950n 1.8
+    847999n 1.8
+    848000n 0
+    848049n 0
+    848050n 1.8
+    848099n 1.8
+    848100n 0
+    848149n 0
+    848150n 1.8
+    848199n 1.8
+    848200n 0
+    848249n 0
+    848250n 1.8
+    848299n 1.8
+    848300n 0
+    848349n 0
+    848350n 1.8
+    848399n 1.8
+    848400n 0
+    848449n 0
+    848450n 1.8
+    848499n 1.8
+    848500n 0
+    848549n 0
+    848550n 1.8
+    848599n 1.8
+    848600n 0
+    848649n 0
+    848650n 1.8
+    848699n 1.8
+    848700n 0
+    848749n 0
+    848750n 1.8
+    848799n 1.8
+    848800n 0
+    848849n 0
+    848850n 1.8
+    848899n 1.8
+    848900n 0
+    848949n 0
+    848950n 1.8
+    848999n 1.8
+    849000n 0
+    849049n 0
+    849050n 1.8
+    849099n 1.8
+    849100n 0
+    849149n 0
+    849150n 1.8
+    849199n 1.8
+    849200n 0
+    849249n 0
+    849250n 1.8
+    849299n 1.8
+    849300n 0
+    849349n 0
+    849350n 1.8
+    849399n 1.8
+    849400n 0
+    849449n 0
+    849450n 1.8
+    849499n 1.8
+    849500n 0
+    849549n 0
+    849550n 1.8
+    849599n 1.8
+    849600n 0
+    849649n 0
+    849650n 1.8
+    849699n 1.8
+    849700n 0
+    849749n 0
+    849750n 1.8
+    849799n 1.8
+    849800n 0
+    849849n 0
+    849850n 1.8
+    849899n 1.8
+    849900n 0
+    849949n 0
+    849950n 1.8
+    849999n 1.8
+    850000n 0
+    850049n 0
+    850050n 1.8
+    850099n 1.8
+    850100n 0
+    850149n 0
+    850150n 1.8
+    850199n 1.8
+    850200n 0
+    850249n 0
+    850250n 1.8
+    850299n 1.8
+    850300n 0
+    850349n 0
+    850350n 1.8
+    850399n 1.8
+    850400n 0
+    850449n 0
+    850450n 1.8
+    850499n 1.8
+    850500n 0
+    850549n 0
+    850550n 1.8
+    850599n 1.8
+    850600n 0
+    850649n 0
+    850650n 1.8
+    850699n 1.8
+    850700n 0
+    850749n 0
+    850750n 1.8
+    850799n 1.8
+    850800n 0
+    850849n 0
+    850850n 1.8
+    850899n 1.8
+    850900n 0
+    850949n 0
+    850950n 1.8
+    850999n 1.8
+    851000n 0
+    851049n 0
+    851050n 1.8
+    851099n 1.8
+    851100n 0
+    851149n 0
+    851150n 1.8
+    851199n 1.8
+    851200n 0
+    851249n 0
+    851250n 1.8
+    851299n 1.8
+    851300n 0
+    851349n 0
+    851350n 1.8
+    851399n 1.8
+    851400n 0
+    851449n 0
+    851450n 1.8
+    851499n 1.8
+    851500n 0
+    851549n 0
+    851550n 1.8
+    851599n 1.8
+    851600n 0
+    851649n 0
+    851650n 1.8
+    851699n 1.8
+    851700n 0
+    851749n 0
+    851750n 1.8
+    851799n 1.8
+    851800n 0
+    851849n 0
+    851850n 1.8
+    851899n 1.8
+    851900n 0
+    851949n 0
+    851950n 1.8
+    851999n 1.8
+    852000n 0
+    852049n 0
+    852050n 1.8
+    852099n 1.8
+    852100n 0
+    852149n 0
+    852150n 1.8
+    852199n 1.8
+    852200n 0
+    852249n 0
+    852250n 1.8
+    852299n 1.8
+    852300n 0
+    852349n 0
+    852350n 1.8
+    852399n 1.8
+    852400n 0
+    852449n 0
+    852450n 1.8
+    852499n 1.8
+    852500n 0
+    852549n 0
+    852550n 1.8
+    852599n 1.8
+    852600n 0
+    852649n 0
+    852650n 1.8
+    852699n 1.8
+    852700n 0
+    852749n 0
+    852750n 1.8
+    852799n 1.8
+    852800n 0
+    852849n 0
+    852850n 1.8
+    852899n 1.8
+    852900n 0
+    852949n 0
+    852950n 1.8
+    852999n 1.8
+    853000n 0
+    853049n 0
+    853050n 1.8
+    853099n 1.8
+    853100n 0
+    853149n 0
+    853150n 1.8
+    853199n 1.8
+    853200n 0
+    853249n 0
+    853250n 1.8
+    853299n 1.8
+    853300n 0
+    853349n 0
+    853350n 1.8
+    853399n 1.8
+    853400n 0
+    853449n 0
+    853450n 1.8
+    853499n 1.8
+    853500n 0
+    853549n 0
+    853550n 1.8
+    853599n 1.8
+    853600n 0
+    853649n 0
+    853650n 1.8
+    853699n 1.8
+    853700n 0
+    853749n 0
+    853750n 1.8
+    853799n 1.8
+    853800n 0
+    853849n 0
+    853850n 1.8
+    853899n 1.8
+    853900n 0
+    853949n 0
+    853950n 1.8
+    853999n 1.8
+    854000n 0
+    854049n 0
+    854050n 1.8
+    854099n 1.8
+    854100n 0
+    854149n 0
+    854150n 1.8
+    854199n 1.8
+    854200n 0
+    854249n 0
+    854250n 1.8
+    854299n 1.8
+    854300n 0
+    854349n 0
+    854350n 1.8
+    854399n 1.8
+    854400n 0
+    854449n 0
+    854450n 1.8
+    854499n 1.8
+    854500n 0
+    854549n 0
+    854550n 1.8
+    854599n 1.8
+    854600n 0
+    854649n 0
+    854650n 1.8
+    854699n 1.8
+    854700n 0
+    854749n 0
+    854750n 1.8
+    854799n 1.8
+    854800n 0
+    854849n 0
+    854850n 1.8
+    854899n 1.8
+    854900n 0
+    854949n 0
+    854950n 1.8
+    854999n 1.8
+    855000n 0
+    855049n 0
+    855050n 1.8
+    855099n 1.8
+    855100n 0
+    855149n 0
+    855150n 1.8
+    855199n 1.8
+    855200n 0
+    855249n 0
+    855250n 1.8
+    855299n 1.8
+    855300n 0
+    855349n 0
+    855350n 1.8
+    855399n 1.8
+    855400n 0
+    855449n 0
+    855450n 1.8
+    855499n 1.8
+    855500n 0
+    855549n 0
+    855550n 1.8
+    855599n 1.8
+    855600n 0
+    855649n 0
+    855650n 1.8
+    855699n 1.8
+    855700n 0
+    855749n 0
+    855750n 1.8
+    855799n 1.8
+    855800n 0
+    855849n 0
+    855850n 1.8
+    855899n 1.8
+    855900n 0
+    855949n 0
+    855950n 1.8
+    855999n 1.8
+    856000n 0
+    856049n 0
+    856050n 1.8
+    856099n 1.8
+    856100n 0
+    856149n 0
+    856150n 1.8
+    856199n 1.8
+    856200n 0
+    856249n 0
+    856250n 1.8
+    856299n 1.8
+    856300n 0
+    856349n 0
+    856350n 1.8
+    856399n 1.8
+    856400n 0
+    856449n 0
+    856450n 1.8
+    856499n 1.8
+    856500n 0
+    856549n 0
+    856550n 1.8
+    856599n 1.8
+    856600n 0
+    856649n 0
+    856650n 1.8
+    856699n 1.8
+    856700n 0
+    856749n 0
+    856750n 1.8
+    856799n 1.8
+    856800n 0
+    856849n 0
+    856850n 1.8
+    856899n 1.8
+    856900n 0
+    856949n 0
+    856950n 1.8
+    856999n 1.8
+    857000n 0
+    857049n 0
+    857050n 1.8
+    857099n 1.8
+    857100n 0
+    857149n 0
+    857150n 1.8
+    857199n 1.8
+    857200n 0
+    857249n 0
+    857250n 1.8
+    857299n 1.8
+    857300n 0
+    857349n 0
+    857350n 1.8
+    857399n 1.8
+    857400n 0
+    857449n 0
+    857450n 1.8
+    857499n 1.8
+    857500n 0
+    857549n 0
+    857550n 1.8
+    857599n 1.8
+    857600n 0
+    857649n 0
+    857650n 1.8
+    857699n 1.8
+    857700n 0
+    857749n 0
+    857750n 1.8
+    857799n 1.8
+    857800n 0
+    857849n 0
+    857850n 1.8
+    857899n 1.8
+    857900n 0
+    857949n 0
+    857950n 1.8
+    857999n 1.8
+    858000n 0
+    858049n 0
+    858050n 1.8
+    858099n 1.8
+    858100n 0
+    858149n 0
+    858150n 1.8
+    858199n 1.8
+    858200n 0
+    858249n 0
+    858250n 1.8
+    858299n 1.8
+    858300n 0
+    858349n 0
+    858350n 1.8
+    858399n 1.8
+    858400n 0
+    858449n 0
+    858450n 1.8
+    858499n 1.8
+    858500n 0
+    858549n 0
+    858550n 1.8
+    858599n 1.8
+    858600n 0
+    858649n 0
+    858650n 1.8
+    858699n 1.8
+    858700n 0
+    858749n 0
+    858750n 1.8
+    858799n 1.8
+    858800n 0
+    858849n 0
+    858850n 1.8
+    858899n 1.8
+    858900n 0
+    858949n 0
+    858950n 1.8
+    858999n 1.8
+    859000n 0
+    859049n 0
+    859050n 1.8
+    859099n 1.8
+    859100n 0
+    859149n 0
+    859150n 1.8
+    859199n 1.8
+    859200n 0
+    859249n 0
+    859250n 1.8
+    859299n 1.8
+    859300n 0
+    859349n 0
+    859350n 1.8
+    859399n 1.8
+    859400n 0
+    859449n 0
+    859450n 1.8
+    859499n 1.8
+    859500n 0
+    859549n 0
+    859550n 1.8
+    859599n 1.8
+    859600n 0
+    859649n 0
+    859650n 1.8
+    859699n 1.8
+    859700n 0
+    859749n 0
+    859750n 1.8
+    859799n 1.8
+    859800n 0
+    859849n 0
+    859850n 1.8
+    859899n 1.8
+    859900n 0
+    859949n 0
+    859950n 1.8
+    859999n 1.8
+    860000n 0
+    860049n 0
+    860050n 1.8
+    860099n 1.8
+    860100n 0
+    860149n 0
+    860150n 1.8
+    860199n 1.8
+    860200n 0
+    860249n 0
+    860250n 1.8
+    860299n 1.8
+    860300n 0
+    860349n 0
+    860350n 1.8
+    860399n 1.8
+    860400n 0
+    860449n 0
+    860450n 1.8
+    860499n 1.8
+    860500n 0
+    860549n 0
+    860550n 1.8
+    860599n 1.8
+    860600n 0
+    860649n 0
+    860650n 1.8
+    860699n 1.8
+    860700n 0
+    860749n 0
+    860750n 1.8
+    860799n 1.8
+    860800n 0
+    860849n 0
+    860850n 1.8
+    860899n 1.8
+    860900n 0
+    860949n 0
+    860950n 1.8
+    860999n 1.8
+    861000n 0
+    861049n 0
+    861050n 1.8
+    861099n 1.8
+    861100n 0
+    861149n 0
+    861150n 1.8
+    861199n 1.8
+    861200n 0
+    861249n 0
+    861250n 1.8
+    861299n 1.8
+    861300n 0
+    861349n 0
+    861350n 1.8
+    861399n 1.8
+    861400n 0
+    861449n 0
+    861450n 1.8
+    861499n 1.8
+    861500n 0
+    861549n 0
+    861550n 1.8
+    861599n 1.8
+    861600n 0
+    861649n 0
+    861650n 1.8
+    861699n 1.8
+    861700n 0
+    861749n 0
+    861750n 1.8
+    861799n 1.8
+    861800n 0
+    861849n 0
+    861850n 1.8
+    861899n 1.8
+    861900n 0
+    861949n 0
+    861950n 1.8
+    861999n 1.8
+    862000n 0
+    862049n 0
+    862050n 1.8
+    862099n 1.8
+    862100n 0
+    862149n 0
+    862150n 1.8
+    862199n 1.8
+    862200n 0
+    862249n 0
+    862250n 1.8
+    862299n 1.8
+    862300n 0
+    862349n 0
+    862350n 1.8
+    862399n 1.8
+    862400n 0
+    862449n 0
+    862450n 1.8
+    862499n 1.8
+    862500n 0
+    862549n 0
+    862550n 1.8
+    862599n 1.8
+    862600n 0
+    862649n 0
+    862650n 1.8
+    862699n 1.8
+    862700n 0
+    862749n 0
+    862750n 1.8
+    862799n 1.8
+    862800n 0
+    862849n 0
+    862850n 1.8
+    862899n 1.8
+    862900n 0
+    862949n 0
+    862950n 1.8
+    862999n 1.8
+    863000n 0
+    863049n 0
+    863050n 1.8
+    863099n 1.8
+    863100n 0
+    863149n 0
+    863150n 1.8
+    863199n 1.8
+    863200n 0
+    863249n 0
+    863250n 1.8
+    863299n 1.8
+    863300n 0
+    863349n 0
+    863350n 1.8
+    863399n 1.8
+    863400n 0
+    863449n 0
+    863450n 1.8
+    863499n 1.8
+    863500n 0
+    863549n 0
+    863550n 1.8
+    863599n 1.8
+    863600n 0
+    863649n 0
+    863650n 1.8
+    863699n 1.8
+    863700n 0
+    863749n 0
+    863750n 1.8
+    863799n 1.8
+    863800n 0
+    863849n 0
+    863850n 1.8
+    863899n 1.8
+    863900n 0
+    863949n 0
+    863950n 1.8
+    863999n 1.8
+    864000n 0
+    864049n 0
+    864050n 1.8
+    864099n 1.8
+    864100n 0
+    864149n 0
+    864150n 1.8
+    864199n 1.8
+    864200n 0
+    864249n 0
+    864250n 1.8
+    864299n 1.8
+    864300n 0
+    864349n 0
+    864350n 1.8
+    864399n 1.8
+    864400n 0
+    864449n 0
+    864450n 1.8
+    864499n 1.8
+    864500n 0
+    864549n 0
+    864550n 1.8
+    864599n 1.8
+    864600n 0
+    864649n 0
+    864650n 1.8
+    864699n 1.8
+    864700n 0
+    864749n 0
+    864750n 1.8
+    864799n 1.8
+    864800n 0
+    864849n 0
+    864850n 1.8
+    864899n 1.8
+    864900n 0
+    864949n 0
+    864950n 1.8
+    864999n 1.8
+    865000n 0
+    865049n 0
+    865050n 1.8
+    865099n 1.8
+    865100n 0
+    865149n 0
+    865150n 1.8
+    865199n 1.8
+    865200n 0
+    865249n 0
+    865250n 1.8
+    865299n 1.8
+    865300n 0
+    865349n 0
+    865350n 1.8
+    865399n 1.8
+    865400n 0
+    865449n 0
+    865450n 1.8
+    865499n 1.8
+    865500n 0
+    865549n 0
+    865550n 1.8
+    865599n 1.8
+    865600n 0
+    865649n 0
+    865650n 1.8
+    865699n 1.8
+    865700n 0
+    865749n 0
+    865750n 1.8
+    865799n 1.8
+    865800n 0
+    865849n 0
+    865850n 1.8
+    865899n 1.8
+    865900n 0
+    865949n 0
+    865950n 1.8
+    865999n 1.8
+    866000n 0
+    866049n 0
+    866050n 1.8
+    866099n 1.8
+    866100n 0
+    866149n 0
+    866150n 1.8
+    866199n 1.8
+    866200n 0
+    866249n 0
+    866250n 1.8
+    866299n 1.8
+    866300n 0
+    866349n 0
+    866350n 1.8
+    866399n 1.8
+    866400n 0
+    866449n 0
+    866450n 1.8
+    866499n 1.8
+    866500n 0
+    866549n 0
+    866550n 1.8
+    866599n 1.8
+    866600n 0
+    866649n 0
+    866650n 1.8
+    866699n 1.8
+    866700n 0
+    866749n 0
+    866750n 1.8
+    866799n 1.8
+    866800n 0
+    866849n 0
+    866850n 1.8
+    866899n 1.8
+    866900n 0
+    866949n 0
+    866950n 1.8
+    866999n 1.8
+    867000n 0
+    867049n 0
+    867050n 1.8
+    867099n 1.8
+    867100n 0
+    867149n 0
+    867150n 1.8
+    867199n 1.8
+    867200n 0
+    867249n 0
+    867250n 1.8
+    867299n 1.8
+    867300n 0
+    867349n 0
+    867350n 1.8
+    867399n 1.8
+    867400n 0
+    867449n 0
+    867450n 1.8
+    867499n 1.8
+    867500n 0
+    867549n 0
+    867550n 1.8
+    867599n 1.8
+    867600n 0
+    867649n 0
+    867650n 1.8
+    867699n 1.8
+    867700n 0
+    867749n 0
+    867750n 1.8
+    867799n 1.8
+    867800n 0
+    867849n 0
+    867850n 1.8
+    867899n 1.8
+    867900n 0
+    867949n 0
+    867950n 1.8
+    867999n 1.8
+    868000n 0
+    868049n 0
+    868050n 1.8
+    868099n 1.8
+    868100n 0
+    868149n 0
+    868150n 1.8
+    868199n 1.8
+    868200n 0
+    868249n 0
+    868250n 1.8
+    868299n 1.8
+    868300n 0
+    868349n 0
+    868350n 1.8
+    868399n 1.8
+    868400n 0
+    868449n 0
+    868450n 1.8
+    868499n 1.8
+    868500n 0
+    868549n 0
+    868550n 1.8
+    868599n 1.8
+    868600n 0
+    868649n 0
+    868650n 1.8
+    868699n 1.8
+    868700n 0
+    868749n 0
+    868750n 1.8
+    868799n 1.8
+    868800n 0
+    868849n 0
+    868850n 1.8
+    868899n 1.8
+    868900n 0
+    868949n 0
+    868950n 1.8
+    868999n 1.8
+    869000n 0
+    869049n 0
+    869050n 1.8
+    869099n 1.8
+    869100n 0
+    869149n 0
+    869150n 1.8
+    869199n 1.8
+    869200n 0
+    869249n 0
+    869250n 1.8
+    869299n 1.8
+    869300n 0
+    869349n 0
+    869350n 1.8
+    869399n 1.8
+    869400n 0
+    869449n 0
+    869450n 1.8
+    869499n 1.8
+    869500n 0
+    869549n 0
+    869550n 1.8
+    869599n 1.8
+    869600n 0
+    869649n 0
+    869650n 1.8
+    869699n 1.8
+    869700n 0
+    869749n 0
+    869750n 1.8
+    869799n 1.8
+    869800n 0
+    869849n 0
+    869850n 1.8
+    869899n 1.8
+    869900n 0
+    869949n 0
+    869950n 1.8
+    869999n 1.8
+    870000n 0
+    870049n 0
+    870050n 1.8
+    870099n 1.8
+    870100n 0
+    870149n 0
+    870150n 1.8
+    870199n 1.8
+    870200n 0
+    870249n 0
+    870250n 1.8
+    870299n 1.8
+    870300n 0
+    870349n 0
+    870350n 1.8
+    870399n 1.8
+    870400n 0
+    870449n 0
+    870450n 1.8
+    870499n 1.8
+    870500n 0
+    870549n 0
+    870550n 1.8
+    870599n 1.8
+    870600n 0
+    870649n 0
+    870650n 1.8
+    870699n 1.8
+    870700n 0
+    870749n 0
+    870750n 1.8
+    870799n 1.8
+    870800n 0
+    870849n 0
+    870850n 1.8
+    870899n 1.8
+    870900n 0
+    870949n 0
+    870950n 1.8
+    870999n 1.8
+    871000n 0
+    871049n 0
+    871050n 1.8
+    871099n 1.8
+    871100n 0
+    871149n 0
+    871150n 1.8
+    871199n 1.8
+    871200n 0
+    871249n 0
+    871250n 1.8
+    871299n 1.8
+    871300n 0
+    871349n 0
+    871350n 1.8
+    871399n 1.8
+    871400n 0
+    871449n 0
+    871450n 1.8
+    871499n 1.8
+    871500n 0
+    871549n 0
+    871550n 1.8
+    871599n 1.8
+    871600n 0
+    871649n 0
+    871650n 1.8
+    871699n 1.8
+    871700n 0
+    871749n 0
+    871750n 1.8
+    871799n 1.8
+    871800n 0
+    871849n 0
+    871850n 1.8
+    871899n 1.8
+    871900n 0
+    871949n 0
+    871950n 1.8
+    871999n 1.8
+    872000n 0
+    872049n 0
+    872050n 1.8
+    872099n 1.8
+    872100n 0
+    872149n 0
+    872150n 1.8
+    872199n 1.8
+    872200n 0
+    872249n 0
+    872250n 1.8
+    872299n 1.8
+    872300n 0
+    872349n 0
+    872350n 1.8
+    872399n 1.8
+    872400n 0
+    872449n 0
+    872450n 1.8
+    872499n 1.8
+    872500n 0
+    872549n 0
+    872550n 1.8
+    872599n 1.8
+    872600n 0
+    872649n 0
+    872650n 1.8
+    872699n 1.8
+    872700n 0
+    872749n 0
+    872750n 1.8
+    872799n 1.8
+    872800n 0
+    872849n 0
+    872850n 1.8
+    872899n 1.8
+    872900n 0
+    872949n 0
+    872950n 1.8
+    872999n 1.8
+    873000n 0
+    873049n 0
+    873050n 1.8
+    873099n 1.8
+    873100n 0
+    873149n 0
+    873150n 1.8
+    873199n 1.8
+    873200n 0
+    873249n 0
+    873250n 1.8
+    873299n 1.8
+    873300n 0
+    873349n 0
+    873350n 1.8
+    873399n 1.8
+    873400n 0
+    873449n 0
+    873450n 1.8
+    873499n 1.8
+    873500n 0
+    873549n 0
+    873550n 1.8
+    873599n 1.8
+    873600n 0
+    873649n 0
+    873650n 1.8
+    873699n 1.8
+    873700n 0
+    873749n 0
+    873750n 1.8
+    873799n 1.8
+    873800n 0
+    873849n 0
+    873850n 1.8
+    873899n 1.8
+    873900n 0
+    873949n 0
+    873950n 1.8
+    873999n 1.8
+    874000n 0
+    874049n 0
+    874050n 1.8
+    874099n 1.8
+    874100n 0
+    874149n 0
+    874150n 1.8
+    874199n 1.8
+    874200n 0
+    874249n 0
+    874250n 1.8
+    874299n 1.8
+    874300n 0
+    874349n 0
+    874350n 1.8
+    874399n 1.8
+    874400n 0
+    874449n 0
+    874450n 1.8
+    874499n 1.8
+    874500n 0
+    874549n 0
+    874550n 1.8
+    874599n 1.8
+    874600n 0
+    874649n 0
+    874650n 1.8
+    874699n 1.8
+    874700n 0
+    874749n 0
+    874750n 1.8
+    874799n 1.8
+    874800n 0
+    874849n 0
+    874850n 1.8
+    874899n 1.8
+    874900n 0
+    874949n 0
+    874950n 1.8
+    874999n 1.8
+    875000n 0
+    875049n 0
+    875050n 1.8
+    875099n 1.8
+    875100n 0
+    875149n 0
+    875150n 1.8
+    875199n 1.8
+    875200n 0
+    875249n 0
+    875250n 1.8
+    875299n 1.8
+    875300n 0
+    875349n 0
+    875350n 1.8
+    875399n 1.8
+    875400n 0
+    875449n 0
+    875450n 1.8
+    875499n 1.8
+    875500n 0
+    875549n 0
+    875550n 1.8
+    875599n 1.8
+    875600n 0
+    875649n 0
+    875650n 1.8
+    875699n 1.8
+    875700n 0
+    875749n 0
+    875750n 1.8
+    875799n 1.8
+    875800n 0
+    875849n 0
+    875850n 1.8
+    875899n 1.8
+    875900n 0
+    875949n 0
+    875950n 1.8
+    875999n 1.8
+    876000n 0
+    876049n 0
+    876050n 1.8
+    876099n 1.8
+    876100n 0
+    876149n 0
+    876150n 1.8
+    876199n 1.8
+    876200n 0
+    876249n 0
+    876250n 1.8
+    876299n 1.8
+    876300n 0
+    876349n 0
+    876350n 1.8
+    876399n 1.8
+    876400n 0
+    876449n 0
+    876450n 1.8
+    876499n 1.8
+    876500n 0
+    876549n 0
+    876550n 1.8
+    876599n 1.8
+    876600n 0
+    876649n 0
+    876650n 1.8
+    876699n 1.8
+    876700n 0
+    876749n 0
+    876750n 1.8
+    876799n 1.8
+    876800n 0
+    876849n 0
+    876850n 1.8
+    876899n 1.8
+    876900n 0
+    876949n 0
+    876950n 1.8
+    876999n 1.8
+    877000n 0
+    877049n 0
+    877050n 1.8
+    877099n 1.8
+    877100n 0
+    877149n 0
+    877150n 1.8
+    877199n 1.8
+    877200n 0
+    877249n 0
+    877250n 1.8
+    877299n 1.8
+    877300n 0
+    877349n 0
+    877350n 1.8
+    877399n 1.8
+    877400n 0
+    877449n 0
+    877450n 1.8
+    877499n 1.8
+    877500n 0
+    877549n 0
+    877550n 1.8
+    877599n 1.8
+    877600n 0
+    877649n 0
+    877650n 1.8
+    877699n 1.8
+    877700n 0
+    877749n 0
+    877750n 1.8
+    877799n 1.8
+    877800n 0
+    877849n 0
+    877850n 1.8
+    877899n 1.8
+    877900n 0
+    877949n 0
+    877950n 1.8
+    877999n 1.8
+    878000n 0
+    878049n 0
+    878050n 1.8
+    878099n 1.8
+    878100n 0
+    878149n 0
+    878150n 1.8
+    878199n 1.8
+    878200n 0
+    878249n 0
+    878250n 1.8
+    878299n 1.8
+    878300n 0
+    878349n 0
+    878350n 1.8
+    878399n 1.8
+    878400n 0
+    878449n 0
+    878450n 1.8
+    878499n 1.8
+    878500n 0
+    878549n 0
+    878550n 1.8
+    878599n 1.8
+    878600n 0
+    878649n 0
+    878650n 1.8
+    878699n 1.8
+    878700n 0
+    878749n 0
+    878750n 1.8
+    878799n 1.8
+    878800n 0
+    878849n 0
+    878850n 1.8
+    878899n 1.8
+    878900n 0
+    878949n 0
+    878950n 1.8
+    878999n 1.8
+    879000n 0
+    879049n 0
+    879050n 1.8
+    879099n 1.8
+    879100n 0
+    879149n 0
+    879150n 1.8
+    879199n 1.8
+    879200n 0
+    879249n 0
+    879250n 1.8
+    879299n 1.8
+    879300n 0
+    879349n 0
+    879350n 1.8
+    879399n 1.8
+    879400n 0
+    879449n 0
+    879450n 1.8
+    879499n 1.8
+    879500n 0
+    879549n 0
+    879550n 1.8
+    879599n 1.8
+    879600n 0
+    879649n 0
+    879650n 1.8
+    879699n 1.8
+    879700n 0
+    879749n 0
+    879750n 1.8
+    879799n 1.8
+    879800n 0
+    879849n 0
+    879850n 1.8
+    879899n 1.8
+    879900n 0
+    879949n 0
+    879950n 1.8
+    879999n 1.8
+    880000n 0
+    880049n 0
+    880050n 1.8
+    880099n 1.8
+    880100n 0
+    880149n 0
+    880150n 1.8
+    880199n 1.8
+    880200n 0
+    880249n 0
+    880250n 1.8
+    880299n 1.8
+    880300n 0
+    880349n 0
+    880350n 1.8
+    880399n 1.8
+    880400n 0
+    880449n 0
+    880450n 1.8
+    880499n 1.8
+    880500n 0
+    880549n 0
+    880550n 1.8
+    880599n 1.8
+    880600n 0
+    880649n 0
+    880650n 1.8
+    880699n 1.8
+    880700n 0
+    880749n 0
+    880750n 1.8
+    880799n 1.8
+    880800n 0
+    880849n 0
+    880850n 1.8
+    880899n 1.8
+    880900n 0
+    880949n 0
+    880950n 1.8
+    880999n 1.8
+    881000n 0
+    881049n 0
+    881050n 1.8
+    881099n 1.8
+    881100n 0
+    881149n 0
+    881150n 1.8
+    881199n 1.8
+    881200n 0
+    881249n 0
+    881250n 1.8
+    881299n 1.8
+    881300n 0
+    881349n 0
+    881350n 1.8
+    881399n 1.8
+    881400n 0
+    881449n 0
+    881450n 1.8
+    881499n 1.8
+    881500n 0
+    881549n 0
+    881550n 1.8
+    881599n 1.8
+    881600n 0
+    881649n 0
+    881650n 1.8
+    881699n 1.8
+    881700n 0
+    881749n 0
+    881750n 1.8
+    881799n 1.8
+    881800n 0
+    881849n 0
+    881850n 1.8
+    881899n 1.8
+    881900n 0
+    881949n 0
+    881950n 1.8
+    881999n 1.8
+    882000n 0
+    882049n 0
+    882050n 1.8
+    882099n 1.8
+    882100n 0
+    882149n 0
+    882150n 1.8
+    882199n 1.8
+    882200n 0
+    882249n 0
+    882250n 1.8
+    882299n 1.8
+    882300n 0
+    882349n 0
+    882350n 1.8
+    882399n 1.8
+    882400n 0
+    882449n 0
+    882450n 1.8
+    882499n 1.8
+    882500n 0
+    882549n 0
+    882550n 1.8
+    882599n 1.8
+    882600n 0
+    882649n 0
+    882650n 1.8
+    882699n 1.8
+    882700n 0
+    882749n 0
+    882750n 1.8
+    882799n 1.8
+    882800n 0
+    882849n 0
+    882850n 1.8
+    882899n 1.8
+    882900n 0
+    882949n 0
+    882950n 1.8
+    882999n 1.8
+    883000n 0
+    883049n 0
+    883050n 1.8
+    883099n 1.8
+    883100n 0
+    883149n 0
+    883150n 1.8
+    883199n 1.8
+    883200n 0
+    883249n 0
+    883250n 1.8
+    883299n 1.8
+    883300n 0
+    883349n 0
+    883350n 1.8
+    883399n 1.8
+    883400n 0
+    883449n 0
+    883450n 1.8
+    883499n 1.8
+    883500n 0
+    883549n 0
+    883550n 1.8
+    883599n 1.8
+    883600n 0
+    883649n 0
+    883650n 1.8
+    883699n 1.8
+    883700n 0
+    883749n 0
+    883750n 1.8
+    883799n 1.8
+    883800n 0
+    883849n 0
+    883850n 1.8
+    883899n 1.8
+    883900n 0
+    883949n 0
+    883950n 1.8
+    883999n 1.8
+    884000n 0
+    884049n 0
+    884050n 1.8
+    884099n 1.8
+    884100n 0
+    884149n 0
+    884150n 1.8
+    884199n 1.8
+    884200n 0
+    884249n 0
+    884250n 1.8
+    884299n 1.8
+    884300n 0
+    884349n 0
+    884350n 1.8
+    884399n 1.8
+    884400n 0
+    884449n 0
+    884450n 1.8
+    884499n 1.8
+    884500n 0
+    884549n 0
+    884550n 1.8
+    884599n 1.8
+    884600n 0
+    884649n 0
+    884650n 1.8
+    884699n 1.8
+    884700n 0
+    884749n 0
+    884750n 1.8
+    884799n 1.8
+    884800n 0
+    884849n 0
+    884850n 1.8
+    884899n 1.8
+    884900n 0
+    884949n 0
+    884950n 1.8
+    884999n 1.8
+    885000n 0
+    885049n 0
+    885050n 1.8
+    885099n 1.8
+    885100n 0
+    885149n 0
+    885150n 1.8
+    885199n 1.8
+    885200n 0
+    885249n 0
+    885250n 1.8
+    885299n 1.8
+    885300n 0
+    885349n 0
+    885350n 1.8
+    885399n 1.8
+    885400n 0
+    885449n 0
+    885450n 1.8
+    885499n 1.8
+    885500n 0
+    885549n 0
+    885550n 1.8
+    885599n 1.8
+    885600n 0
+    885649n 0
+    885650n 1.8
+    885699n 1.8
+    885700n 0
+    885749n 0
+    885750n 1.8
+    885799n 1.8
+    885800n 0
+    885849n 0
+    885850n 1.8
+    885899n 1.8
+    885900n 0
+    885949n 0
+    885950n 1.8
+    885999n 1.8
+    886000n 0
+    886049n 0
+    886050n 1.8
+    886099n 1.8
+    886100n 0
+    886149n 0
+    886150n 1.8
+    886199n 1.8
+    886200n 0
+    886249n 0
+    886250n 1.8
+    886299n 1.8
+    886300n 0
+    886349n 0
+    886350n 1.8
+    886399n 1.8
+    886400n 0
+    886449n 0
+    886450n 1.8
+    886499n 1.8
+    886500n 0
+    886549n 0
+    886550n 1.8
+    886599n 1.8
+    886600n 0
+    886649n 0
+    886650n 1.8
+    886699n 1.8
+    886700n 0
+    886749n 0
+    886750n 1.8
+    886799n 1.8
+    886800n 0
+    886849n 0
+    886850n 1.8
+    886899n 1.8
+    886900n 0
+    886949n 0
+    886950n 1.8
+    886999n 1.8
+    887000n 0
+    887049n 0
+    887050n 1.8
+    887099n 1.8
+    887100n 0
+    887149n 0
+    887150n 1.8
+    887199n 1.8
+    887200n 0
+    887249n 0
+    887250n 1.8
+    887299n 1.8
+    887300n 0
+    887349n 0
+    887350n 1.8
+    887399n 1.8
+    887400n 0
+    887449n 0
+    887450n 1.8
+    887499n 1.8
+    887500n 0
+    887549n 0
+    887550n 1.8
+    887599n 1.8
+    887600n 0
+    887649n 0
+    887650n 1.8
+    887699n 1.8
+    887700n 0
+    887749n 0
+    887750n 1.8
+    887799n 1.8
+    887800n 0
+    887849n 0
+    887850n 1.8
+    887899n 1.8
+    887900n 0
+    887949n 0
+    887950n 1.8
+    887999n 1.8
+    888000n 0
+    888049n 0
+    888050n 1.8
+    888099n 1.8
+    888100n 0
+    888149n 0
+    888150n 1.8
+    888199n 1.8
+    888200n 0
+    888249n 0
+    888250n 1.8
+    888299n 1.8
+    888300n 0
+    888349n 0
+    888350n 1.8
+    888399n 1.8
+    888400n 0
+    888449n 0
+    888450n 1.8
+    888499n 1.8
+    888500n 0
+    888549n 0
+    888550n 1.8
+    888599n 1.8
+    888600n 0
+    888649n 0
+    888650n 1.8
+    888699n 1.8
+    888700n 0
+    888749n 0
+    888750n 1.8
+    888799n 1.8
+    888800n 0
+    888849n 0
+    888850n 1.8
+    888899n 1.8
+    888900n 0
+    888949n 0
+    888950n 1.8
+    888999n 1.8
+    889000n 0
+    889049n 0
+    889050n 1.8
+    889099n 1.8
+    889100n 0
+    889149n 0
+    889150n 1.8
+    889199n 1.8
+    889200n 0
+    889249n 0
+    889250n 1.8
+    889299n 1.8
+    889300n 0
+    889349n 0
+    889350n 1.8
+    889399n 1.8
+    889400n 0
+    889449n 0
+    889450n 1.8
+    889499n 1.8
+    889500n 0
+    889549n 0
+    889550n 1.8
+    889599n 1.8
+    889600n 0
+    889649n 0
+    889650n 1.8
+    889699n 1.8
+    889700n 0
+    889749n 0
+    889750n 1.8
+    889799n 1.8
+    889800n 0
+    889849n 0
+    889850n 1.8
+    889899n 1.8
+    889900n 0
+    889949n 0
+    889950n 1.8
+    889999n 1.8
+    890000n 0
+    890049n 0
+    890050n 1.8
+    890099n 1.8
+    890100n 0
+    890149n 0
+    890150n 1.8
+    890199n 1.8
+    890200n 0
+    890249n 0
+    890250n 1.8
+    890299n 1.8
+    890300n 0
+    890349n 0
+    890350n 1.8
+    890399n 1.8
+    890400n 0
+    890449n 0
+    890450n 1.8
+    890499n 1.8
+    890500n 0
+    890549n 0
+    890550n 1.8
+    890599n 1.8
+    890600n 0
+    890649n 0
+    890650n 1.8
+    890699n 1.8
+    890700n 0
+    890749n 0
+    890750n 1.8
+    890799n 1.8
+    890800n 0
+    890849n 0
+    890850n 1.8
+    890899n 1.8
+    890900n 0
+    890949n 0
+    890950n 1.8
+    890999n 1.8
+    891000n 0
+    891049n 0
+    891050n 1.8
+    891099n 1.8
+    891100n 0
+    891149n 0
+    891150n 1.8
+    891199n 1.8
+    891200n 0
+    891249n 0
+    891250n 1.8
+    891299n 1.8
+    891300n 0
+    891349n 0
+    891350n 1.8
+    891399n 1.8
+    891400n 0
+    891449n 0
+    891450n 1.8
+    891499n 1.8
+    891500n 0
+    891549n 0
+    891550n 1.8
+    891599n 1.8
+    891600n 0
+    891649n 0
+    891650n 1.8
+    891699n 1.8
+    891700n 0
+    891749n 0
+    891750n 1.8
+    891799n 1.8
+    891800n 0
+    891849n 0
+    891850n 1.8
+    891899n 1.8
+    891900n 0
+    891949n 0
+    891950n 1.8
+    891999n 1.8
+    892000n 0
+    892049n 0
+    892050n 1.8
+    892099n 1.8
+    892100n 0
+    892149n 0
+    892150n 1.8
+    892199n 1.8
+    892200n 0
+    892249n 0
+    892250n 1.8
+    892299n 1.8
+    892300n 0
+    892349n 0
+    892350n 1.8
+    892399n 1.8
+    892400n 0
+    892449n 0
+    892450n 1.8
+    892499n 1.8
+    892500n 0
+    892549n 0
+    892550n 1.8
+    892599n 1.8
+    892600n 0
+    892649n 0
+    892650n 1.8
+    892699n 1.8
+    892700n 0
+    892749n 0
+    892750n 1.8
+    892799n 1.8
+    892800n 0
+    892849n 0
+    892850n 1.8
+    892899n 1.8
+    892900n 0
+    892949n 0
+    892950n 1.8
+    892999n 1.8
+    893000n 0
+    893049n 0
+    893050n 1.8
+    893099n 1.8
+    893100n 0
+    893149n 0
+    893150n 1.8
+    893199n 1.8
+    893200n 0
+    893249n 0
+    893250n 1.8
+    893299n 1.8
+    893300n 0
+    893349n 0
+    893350n 1.8
+    893399n 1.8
+    893400n 0
+    893449n 0
+    893450n 1.8
+    893499n 1.8
+    893500n 0
+    893549n 0
+    893550n 1.8
+    893599n 1.8
+    893600n 0
+    893649n 0
+    893650n 1.8
+    893699n 1.8
+    893700n 0
+    893749n 0
+    893750n 1.8
+    893799n 1.8
+    893800n 0
+    893849n 0
+    893850n 1.8
+    893899n 1.8
+    893900n 0
+    893949n 0
+    893950n 1.8
+    893999n 1.8
+    894000n 0
+    894049n 0
+    894050n 1.8
+    894099n 1.8
+    894100n 0
+    894149n 0
+    894150n 1.8
+    894199n 1.8
+    894200n 0
+    894249n 0
+    894250n 1.8
+    894299n 1.8
+    894300n 0
+    894349n 0
+    894350n 1.8
+    894399n 1.8
+    894400n 0
+    894449n 0
+    894450n 1.8
+    894499n 1.8
+    894500n 0
+    894549n 0
+    894550n 1.8
+    894599n 1.8
+    894600n 0
+    894649n 0
+    894650n 1.8
+    894699n 1.8
+    894700n 0
+    894749n 0
+    894750n 1.8
+    894799n 1.8
+    894800n 0
+    894849n 0
+    894850n 1.8
+    894899n 1.8
+    894900n 0
+    894949n 0
+    894950n 1.8
+    894999n 1.8
+    895000n 0
+    895049n 0
+    895050n 1.8
+    895099n 1.8
+    895100n 0
+    895149n 0
+    895150n 1.8
+    895199n 1.8
+    895200n 0
+    895249n 0
+    895250n 1.8
+    895299n 1.8
+    895300n 0
+    895349n 0
+    895350n 1.8
+    895399n 1.8
+    895400n 0
+    895449n 0
+    895450n 1.8
+    895499n 1.8
+    895500n 0
+    895549n 0
+    895550n 1.8
+    895599n 1.8
+    895600n 0
+    895649n 0
+    895650n 1.8
+    895699n 1.8
+    895700n 0
+    895749n 0
+    895750n 1.8
+    895799n 1.8
+    895800n 0
+    895849n 0
+    895850n 1.8
+    895899n 1.8
+    895900n 0
+    895949n 0
+    895950n 1.8
+    895999n 1.8
+    896000n 0
+    896049n 0
+    896050n 1.8
+    896099n 1.8
+    896100n 0
+    896149n 0
+    896150n 1.8
+    896199n 1.8
+    896200n 0
+    896249n 0
+    896250n 1.8
+    896299n 1.8
+    896300n 0
+    896349n 0
+    896350n 1.8
+    896399n 1.8
+    896400n 0
+    896449n 0
+    896450n 1.8
+    896499n 1.8
+    896500n 0
+    896549n 0
+    896550n 1.8
+    896599n 1.8
+    896600n 0
+    896649n 0
+    896650n 1.8
+    896699n 1.8
+    896700n 0
+    896749n 0
+    896750n 1.8
+    896799n 1.8
+    896800n 0
+    896849n 0
+    896850n 1.8
+    896899n 1.8
+    896900n 0
+    896949n 0
+    896950n 1.8
+    896999n 1.8
+    897000n 0
+    897049n 0
+    897050n 1.8
+    897099n 1.8
+    897100n 0
+    897149n 0
+    897150n 1.8
+    897199n 1.8
+    897200n 0
+    897249n 0
+    897250n 1.8
+    897299n 1.8
+    897300n 0
+    897349n 0
+    897350n 1.8
+    897399n 1.8
+    897400n 0
+    897449n 0
+    897450n 1.8
+    897499n 1.8
+    897500n 0
+    897549n 0
+    897550n 1.8
+    897599n 1.8
+    897600n 0
+    897649n 0
+    897650n 1.8
+    897699n 1.8
+    897700n 0
+    897749n 0
+    897750n 1.8
+    897799n 1.8
+    897800n 0
+    897849n 0
+    897850n 1.8
+    897899n 1.8
+    897900n 0
+    897949n 0
+    897950n 1.8
+    897999n 1.8
+    898000n 0
+    898049n 0
+    898050n 1.8
+    898099n 1.8
+    898100n 0
+    898149n 0
+    898150n 1.8
+    898199n 1.8
+    898200n 0
+    898249n 0
+    898250n 1.8
+    898299n 1.8
+    898300n 0
+    898349n 0
+    898350n 1.8
+    898399n 1.8
+    898400n 0
+    898449n 0
+    898450n 1.8
+    898499n 1.8
+    898500n 0
+    898549n 0
+    898550n 1.8
+    898599n 1.8
+    898600n 0
+    898649n 0
+    898650n 1.8
+    898699n 1.8
+    898700n 0
+    898749n 0
+    898750n 1.8
+    898799n 1.8
+    898800n 0
+    898849n 0
+    898850n 1.8
+    898899n 1.8
+    898900n 0
+    898949n 0
+    898950n 1.8
+    898999n 1.8
+    899000n 0
+    899049n 0
+    899050n 1.8
+    899099n 1.8
+    899100n 0
+    899149n 0
+    899150n 1.8
+    899199n 1.8
+    899200n 0
+    899249n 0
+    899250n 1.8
+    899299n 1.8
+    899300n 0
+    899349n 0
+    899350n 1.8
+    899399n 1.8
+    899400n 0
+    899449n 0
+    899450n 1.8
+    899499n 1.8
+    899500n 0
+    899549n 0
+    899550n 1.8
+    899599n 1.8
+    899600n 0
+    899649n 0
+    899650n 1.8
+    899699n 1.8
+    899700n 0
+    899749n 0
+    899750n 1.8
+    899799n 1.8
+    899800n 0
+    899849n 0
+    899850n 1.8
+    899899n 1.8
+    899900n 0
+    899949n 0
+    899950n 1.8
+    899999n 1.8
+    900000n 0
+    900049n 0
+    900050n 1.8
+    900099n 1.8
+    900100n 0
+    900149n 0
+    900150n 1.8
+    900199n 1.8
+    900200n 0
+    900249n 0
+    900250n 1.8
+    900299n 1.8
+    900300n 0
+    900349n 0
+    900350n 1.8
+    900399n 1.8
+    900400n 0
+    900449n 0
+    900450n 1.8
+    900499n 1.8
+    900500n 0
+    900549n 0
+    900550n 1.8
+    900599n 1.8
+    900600n 0
+    900649n 0
+    900650n 1.8
+    900699n 1.8
+    900700n 0
+    900749n 0
+    900750n 1.8
+    900799n 1.8
+    900800n 0
+    900849n 0
+    900850n 1.8
+    900899n 1.8
+    900900n 0
+    900949n 0
+    900950n 1.8
+    900999n 1.8
+    901000n 0
+    901049n 0
+    901050n 1.8
+    901099n 1.8
+    901100n 0
+    901149n 0
+    901150n 1.8
+    901199n 1.8
+    901200n 0
+    901249n 0
+    901250n 1.8
+    901299n 1.8
+    901300n 0
+    901349n 0
+    901350n 1.8
+    901399n 1.8
+    901400n 0
+    901449n 0
+    901450n 1.8
+    901499n 1.8
+    901500n 0
+    901549n 0
+    901550n 1.8
+    901599n 1.8
+    901600n 0
+    901649n 0
+    901650n 1.8
+    901699n 1.8
+    901700n 0
+    901749n 0
+    901750n 1.8
+    901799n 1.8
+    901800n 0
+    901849n 0
+    901850n 1.8
+    901899n 1.8
+    901900n 0
+    901949n 0
+    901950n 1.8
+    901999n 1.8
+    902000n 0
+    902049n 0
+    902050n 1.8
+    902099n 1.8
+    902100n 0
+    902149n 0
+    902150n 1.8
+    902199n 1.8
+    902200n 0
+    902249n 0
+    902250n 1.8
+    902299n 1.8
+    902300n 0
+    902349n 0
+    902350n 1.8
+    902399n 1.8
+    902400n 0
+    902449n 0
+    902450n 1.8
+    902499n 1.8
+    902500n 0
+    902549n 0
+    902550n 1.8
+    902599n 1.8
+    902600n 0
+    902649n 0
+    902650n 1.8
+    902699n 1.8
+    902700n 0
+    902749n 0
+    902750n 1.8
+    902799n 1.8
+    902800n 0
+    902849n 0
+    902850n 1.8
+    902899n 1.8
+    902900n 0
+    902949n 0
+    902950n 1.8
+    902999n 1.8
+    903000n 0
+    903049n 0
+    903050n 1.8
+    903099n 1.8
+    903100n 0
+    903149n 0
+    903150n 1.8
+    903199n 1.8
+    903200n 0
+    903249n 0
+    903250n 1.8
+    903299n 1.8
+    903300n 0
+    903349n 0
+    903350n 1.8
+    903399n 1.8
+    903400n 0
+    903449n 0
+    903450n 1.8
+    903499n 1.8
+    903500n 0
+    903549n 0
+    903550n 1.8
+    903599n 1.8
+    903600n 0
+    903649n 0
+    903650n 1.8
+    903699n 1.8
+    903700n 0
+    903749n 0
+    903750n 1.8
+    903799n 1.8
+    903800n 0
+    903849n 0
+    903850n 1.8
+    903899n 1.8
+    903900n 0
+    903949n 0
+    903950n 1.8
+    903999n 1.8
+    904000n 0
+    904049n 0
+    904050n 1.8
+    904099n 1.8
+    904100n 0
+    904149n 0
+    904150n 1.8
+    904199n 1.8
+    904200n 0
+    904249n 0
+    904250n 1.8
+    904299n 1.8
+    904300n 0
+    904349n 0
+    904350n 1.8
+    904399n 1.8
+    904400n 0
+    904449n 0
+    904450n 1.8
+    904499n 1.8
+    904500n 0
+    904549n 0
+    904550n 1.8
+    904599n 1.8
+    904600n 0
+    904649n 0
+    904650n 1.8
+    904699n 1.8
+    904700n 0
+    904749n 0
+    904750n 1.8
+    904799n 1.8
+    904800n 0
+    904849n 0
+    904850n 1.8
+    904899n 1.8
+    904900n 0
+    904949n 0
+    904950n 1.8
+    904999n 1.8
+    905000n 0
+    905049n 0
+    905050n 1.8
+    905099n 1.8
+    905100n 0
+    905149n 0
+    905150n 1.8
+    905199n 1.8
+    905200n 0
+    905249n 0
+    905250n 1.8
+    905299n 1.8
+    905300n 0
+    905349n 0
+    905350n 1.8
+    905399n 1.8
+    905400n 0
+    905449n 0
+    905450n 1.8
+    905499n 1.8
+    905500n 0
+    905549n 0
+    905550n 1.8
+    905599n 1.8
+    905600n 0
+    905649n 0
+    905650n 1.8
+    905699n 1.8
+    905700n 0
+    905749n 0
+    905750n 1.8
+    905799n 1.8
+    905800n 0
+    905849n 0
+    905850n 1.8
+    905899n 1.8
+    905900n 0
+    905949n 0
+    905950n 1.8
+    905999n 1.8
+    906000n 0
+    906049n 0
+    906050n 1.8
+    906099n 1.8
+    906100n 0
+    906149n 0
+    906150n 1.8
+    906199n 1.8
+    906200n 0
+    906249n 0
+    906250n 1.8
+    906299n 1.8
+    906300n 0
+    906349n 0
+    906350n 1.8
+    906399n 1.8
+    906400n 0
+    906449n 0
+    906450n 1.8
+    906499n 1.8
+    906500n 0
+    906549n 0
+    906550n 1.8
+    906599n 1.8
+    906600n 0
+    906649n 0
+    906650n 1.8
+    906699n 1.8
+    906700n 0
+    906749n 0
+    906750n 1.8
+    906799n 1.8
+    906800n 0
+    906849n 0
+    906850n 1.8
+    906899n 1.8
+    906900n 0
+    906949n 0
+    906950n 1.8
+    906999n 1.8
+    907000n 0
+    907049n 0
+    907050n 1.8
+    907099n 1.8
+    907100n 0
+    907149n 0
+    907150n 1.8
+    907199n 1.8
+    907200n 0
+    907249n 0
+    907250n 1.8
+    907299n 1.8
+    907300n 0
+    907349n 0
+    907350n 1.8
+    907399n 1.8
+    907400n 0
+    907449n 0
+    907450n 1.8
+    907499n 1.8
+    907500n 0
+    907549n 0
+    907550n 1.8
+    907599n 1.8
+    907600n 0
+    907649n 0
+    907650n 1.8
+    907699n 1.8
+    907700n 0
+    907749n 0
+    907750n 1.8
+    907799n 1.8
+    907800n 0
+    907849n 0
+    907850n 1.8
+    907899n 1.8
+    907900n 0
+    907949n 0
+    907950n 1.8
+    907999n 1.8
+    908000n 0
+    908049n 0
+    908050n 1.8
+    908099n 1.8
+    908100n 0
+    908149n 0
+    908150n 1.8
+    908199n 1.8
+    908200n 0
+    908249n 0
+    908250n 1.8
+    908299n 1.8
+    908300n 0
+    908349n 0
+    908350n 1.8
+    908399n 1.8
+    908400n 0
+    908449n 0
+    908450n 1.8
+    908499n 1.8
+    908500n 0
+    908549n 0
+    908550n 1.8
+    908599n 1.8
+    908600n 0
+    908649n 0
+    908650n 1.8
+    908699n 1.8
+    908700n 0
+    908749n 0
+    908750n 1.8
+    908799n 1.8
+    908800n 0
+    908849n 0
+    908850n 1.8
+    908899n 1.8
+    908900n 0
+    908949n 0
+    908950n 1.8
+    908999n 1.8
+    909000n 0
+    909049n 0
+    909050n 1.8
+    909099n 1.8
+    909100n 0
+    909149n 0
+    909150n 1.8
+    909199n 1.8
+    909200n 0
+    909249n 0
+    909250n 1.8
+    909299n 1.8
+    909300n 0
+    909349n 0
+    909350n 1.8
+    909399n 1.8
+    909400n 0
+    909449n 0
+    909450n 1.8
+    909499n 1.8
+    909500n 0
+    909549n 0
+    909550n 1.8
+    909599n 1.8
+    909600n 0
+    909649n 0
+    909650n 1.8
+    909699n 1.8
+    909700n 0
+    909749n 0
+    909750n 1.8
+    909799n 1.8
+    909800n 0
+    909849n 0
+    909850n 1.8
+    909899n 1.8
+    909900n 0
+    909949n 0
+    909950n 1.8
+    909999n 1.8
+    910000n 0
+    910049n 0
+    910050n 1.8
+    910099n 1.8
+    910100n 0
+    910149n 0
+    910150n 1.8
+    910199n 1.8
+    910200n 0
+    910249n 0
+    910250n 1.8
+    910299n 1.8
+    910300n 0
+    910349n 0
+    910350n 1.8
+    910399n 1.8
+    910400n 0
+    910449n 0
+    910450n 1.8
+    910499n 1.8
+    910500n 0
+    910549n 0
+    910550n 1.8
+    910599n 1.8
+    910600n 0
+    910649n 0
+    910650n 1.8
+    910699n 1.8
+    910700n 0
+    910749n 0
+    910750n 1.8
+    910799n 1.8
+    910800n 0
+    910849n 0
+    910850n 1.8
+    910899n 1.8
+    910900n 0
+    910949n 0
+    910950n 1.8
+    910999n 1.8
+    911000n 0
+    911049n 0
+    911050n 1.8
+    911099n 1.8
+    911100n 0
+    911149n 0
+    911150n 1.8
+    911199n 1.8
+    911200n 0
+    911249n 0
+    911250n 1.8
+    911299n 1.8
+    911300n 0
+    911349n 0
+    911350n 1.8
+    911399n 1.8
+    911400n 0
+    911449n 0
+    911450n 1.8
+    911499n 1.8
+    911500n 0
+    911549n 0
+    911550n 1.8
+    911599n 1.8
+    911600n 0
+    911649n 0
+    911650n 1.8
+    911699n 1.8
+    911700n 0
+    911749n 0
+    911750n 1.8
+    911799n 1.8
+    911800n 0
+    911849n 0
+    911850n 1.8
+    911899n 1.8
+    911900n 0
+    911949n 0
+    911950n 1.8
+    911999n 1.8
+    912000n 0
+    912049n 0
+    912050n 1.8
+    912099n 1.8
+    912100n 0
+    912149n 0
+    912150n 1.8
+    912199n 1.8
+    912200n 0
+    912249n 0
+    912250n 1.8
+    912299n 1.8
+    912300n 0
+    912349n 0
+    912350n 1.8
+    912399n 1.8
+    912400n 0
+    912449n 0
+    912450n 1.8
+    912499n 1.8
+    912500n 0
+    912549n 0
+    912550n 1.8
+    912599n 1.8
+    912600n 0
+    912649n 0
+    912650n 1.8
+    912699n 1.8
+    912700n 0
+    912749n 0
+    912750n 1.8
+    912799n 1.8
+    912800n 0
+    912849n 0
+    912850n 1.8
+    912899n 1.8
+    912900n 0
+    912949n 0
+    912950n 1.8
+    912999n 1.8
+    913000n 0
+    913049n 0
+    913050n 1.8
+    913099n 1.8
+    913100n 0
+    913149n 0
+    913150n 1.8
+    913199n 1.8
+    913200n 0
+    913249n 0
+    913250n 1.8
+    913299n 1.8
+    913300n 0
+    913349n 0
+    913350n 1.8
+    913399n 1.8
+    913400n 0
+    913449n 0
+    913450n 1.8
+    913499n 1.8
+    913500n 0
+    913549n 0
+    913550n 1.8
+    913599n 1.8
+    913600n 0
+    913649n 0
+    913650n 1.8
+    913699n 1.8
+    913700n 0
+    913749n 0
+    913750n 1.8
+    913799n 1.8
+    913800n 0
+    913849n 0
+    913850n 1.8
+    913899n 1.8
+    913900n 0
+    913949n 0
+    913950n 1.8
+    913999n 1.8
+    914000n 0
+    914049n 0
+    914050n 1.8
+    914099n 1.8
+    914100n 0
+    914149n 0
+    914150n 1.8
+    914199n 1.8
+    914200n 0
+    914249n 0
+    914250n 1.8
+    914299n 1.8
+    914300n 0
+    914349n 0
+    914350n 1.8
+    914399n 1.8
+    914400n 0
+    914449n 0
+    914450n 1.8
+    914499n 1.8
+    914500n 0
+    914549n 0
+    914550n 1.8
+    914599n 1.8
+    914600n 0
+    914649n 0
+    914650n 1.8
+    914699n 1.8
+    914700n 0
+    914749n 0
+    914750n 1.8
+    914799n 1.8
+    914800n 0
+    914849n 0
+    914850n 1.8
+    914899n 1.8
+    914900n 0
+    914949n 0
+    914950n 1.8
+    914999n 1.8
+    915000n 0
+    915049n 0
+    915050n 1.8
+    915099n 1.8
+    915100n 0
+    915149n 0
+    915150n 1.8
+    915199n 1.8
+    915200n 0
+    915249n 0
+    915250n 1.8
+    915299n 1.8
+    915300n 0
+    915349n 0
+    915350n 1.8
+    915399n 1.8
+    915400n 0
+    915449n 0
+    915450n 1.8
+    915499n 1.8
+    915500n 0
+    915549n 0
+    915550n 1.8
+    915599n 1.8
+    915600n 0
+    915649n 0
+    915650n 1.8
+    915699n 1.8
+    915700n 0
+    915749n 0
+    915750n 1.8
+    915799n 1.8
+    915800n 0
+    915849n 0
+    915850n 1.8
+    915899n 1.8
+    915900n 0
+    915949n 0
+    915950n 1.8
+    915999n 1.8
+    916000n 0
+    916049n 0
+    916050n 1.8
+    916099n 1.8
+    916100n 0
+    916149n 0
+    916150n 1.8
+    916199n 1.8
+    916200n 0
+    916249n 0
+    916250n 1.8
+    916299n 1.8
+    916300n 0
+    916349n 0
+    916350n 1.8
+    916399n 1.8
+    916400n 0
+    916449n 0
+    916450n 1.8
+    916499n 1.8
+    916500n 0
+    916549n 0
+    916550n 1.8
+    916599n 1.8
+    916600n 0
+    916649n 0
+    916650n 1.8
+    916699n 1.8
+    916700n 0
+    916749n 0
+    916750n 1.8
+    916799n 1.8
+    916800n 0
+    916849n 0
+    916850n 1.8
+    916899n 1.8
+    916900n 0
+    916949n 0
+    916950n 1.8
+    916999n 1.8
+    917000n 0
+    917049n 0
+    917050n 1.8
+    917099n 1.8
+    917100n 0
+    917149n 0
+    917150n 1.8
+    917199n 1.8
+    917200n 0
+    917249n 0
+    917250n 1.8
+    917299n 1.8
+    917300n 0
+    917349n 0
+    917350n 1.8
+    917399n 1.8
+    917400n 0
+    917449n 0
+    917450n 1.8
+    917499n 1.8
+    917500n 0
+    917549n 0
+    917550n 1.8
+    917599n 1.8
+    917600n 0
+    917649n 0
+    917650n 1.8
+    917699n 1.8
+    917700n 0
+    917749n 0
+    917750n 1.8
+    917799n 1.8
+    917800n 0
+    917849n 0
+    917850n 1.8
+    917899n 1.8
+    917900n 0
+    917949n 0
+    917950n 1.8
+    917999n 1.8
+    918000n 0
+    918049n 0
+    918050n 1.8
+    918099n 1.8
+    918100n 0
+    918149n 0
+    918150n 1.8
+    918199n 1.8
+    918200n 0
+    918249n 0
+    918250n 1.8
+    918299n 1.8
+    918300n 0
+    918349n 0
+    918350n 1.8
+    918399n 1.8
+    918400n 0
+    918449n 0
+    918450n 1.8
+    918499n 1.8
+    918500n 0
+    918549n 0
+    918550n 1.8
+    918599n 1.8
+    918600n 0
+    918649n 0
+    918650n 1.8
+    918699n 1.8
+    918700n 0
+    918749n 0
+    918750n 1.8
+    918799n 1.8
+    918800n 0
+    918849n 0
+    918850n 1.8
+    918899n 1.8
+    918900n 0
+    918949n 0
+    918950n 1.8
+    918999n 1.8
+    919000n 0
+    919049n 0
+    919050n 1.8
+    919099n 1.8
+    919100n 0
+    919149n 0
+    919150n 1.8
+    919199n 1.8
+    919200n 0
+    919249n 0
+    919250n 1.8
+    919299n 1.8
+    919300n 0
+    919349n 0
+    919350n 1.8
+    919399n 1.8
+    919400n 0
+    919449n 0
+    919450n 1.8
+    919499n 1.8
+    919500n 0
+    919549n 0
+    919550n 1.8
+    919599n 1.8
+    919600n 0
+    919649n 0
+    919650n 1.8
+    919699n 1.8
+    919700n 0
+    919749n 0
+    919750n 1.8
+    919799n 1.8
+    919800n 0
+    919849n 0
+    919850n 1.8
+    919899n 1.8
+    919900n 0
+    919949n 0
+    919950n 1.8
+    919999n 1.8
+    920000n 0
+    920049n 0
+    920050n 1.8
+    920099n 1.8
+    920100n 0
+    920149n 0
+    920150n 1.8
+    920199n 1.8
+    920200n 0
+    920249n 0
+    920250n 1.8
+    920299n 1.8
+    920300n 0
+    920349n 0
+    920350n 1.8
+    920399n 1.8
+    920400n 0
+    920449n 0
+    920450n 1.8
+    920499n 1.8
+    920500n 0
+    920549n 0
+    920550n 1.8
+    920599n 1.8
+    920600n 0
+    920649n 0
+    920650n 1.8
+    920699n 1.8
+    920700n 0
+    920749n 0
+    920750n 1.8
+    920799n 1.8
+    920800n 0
+    920849n 0
+    920850n 1.8
+    920899n 1.8
+    920900n 0
+    920949n 0
+    920950n 1.8
+    920999n 1.8
+    921000n 0
+    921049n 0
+    921050n 1.8
+    921099n 1.8
+    921100n 0
+    921149n 0
+    921150n 1.8
+    921199n 1.8
+    921200n 0
+    921249n 0
+    921250n 1.8
+    921299n 1.8
+    921300n 0
+    921349n 0
+    921350n 1.8
+    921399n 1.8
+    921400n 0
+    921449n 0
+    921450n 1.8
+    921499n 1.8
+    921500n 0
+    921549n 0
+    921550n 1.8
+    921599n 1.8
+    921600n 0
+    921649n 0
+    921650n 1.8
+    921699n 1.8
+    921700n 0
+    921749n 0
+    921750n 1.8
+    921799n 1.8
+    921800n 0
+    921849n 0
+    921850n 1.8
+    921899n 1.8
+    921900n 0
+    921949n 0
+    921950n 1.8
+    921999n 1.8
+    922000n 0
+    922049n 0
+    922050n 1.8
+    922099n 1.8
+    922100n 0
+    922149n 0
+    922150n 1.8
+    922199n 1.8
+    922200n 0
+    922249n 0
+    922250n 1.8
+    922299n 1.8
+    922300n 0
+    922349n 0
+    922350n 1.8
+    922399n 1.8
+    922400n 0
+    922449n 0
+    922450n 1.8
+    922499n 1.8
+    922500n 0
+    922549n 0
+    922550n 1.8
+    922599n 1.8
+    922600n 0
+    922649n 0
+    922650n 1.8
+    922699n 1.8
+    922700n 0
+    922749n 0
+    922750n 1.8
+    922799n 1.8
+    922800n 0
+    922849n 0
+    922850n 1.8
+    922899n 1.8
+    922900n 0
+    922949n 0
+    922950n 1.8
+    922999n 1.8
+    923000n 0
+    923049n 0
+    923050n 1.8
+    923099n 1.8
+    923100n 0
+    923149n 0
+    923150n 1.8
+    923199n 1.8
+    923200n 0
+    923249n 0
+    923250n 1.8
+    923299n 1.8
+    923300n 0
+    923349n 0
+    923350n 1.8
+    923399n 1.8
+    923400n 0
+    923449n 0
+    923450n 1.8
+    923499n 1.8
+    923500n 0
+    923549n 0
+    923550n 1.8
+    923599n 1.8
+    923600n 0
+    923649n 0
+    923650n 1.8
+    923699n 1.8
+    923700n 0
+    923749n 0
+    923750n 1.8
+    923799n 1.8
+    923800n 0
+    923849n 0
+    923850n 1.8
+    923899n 1.8
+    923900n 0
+    923949n 0
+    923950n 1.8
+    923999n 1.8
+    924000n 0
+    924049n 0
+    924050n 1.8
+    924099n 1.8
+    924100n 0
+    924149n 0
+    924150n 1.8
+    924199n 1.8
+    924200n 0
+    924249n 0
+    924250n 1.8
+    924299n 1.8
+    924300n 0
+    924349n 0
+    924350n 1.8
+    924399n 1.8
+    924400n 0
+    924449n 0
+    924450n 1.8
+    924499n 1.8
+    924500n 0
+    924549n 0
+    924550n 1.8
+    924599n 1.8
+    924600n 0
+    924649n 0
+    924650n 1.8
+    924699n 1.8
+    924700n 0
+    924749n 0
+    924750n 1.8
+    924799n 1.8
+    924800n 0
+    924849n 0
+    924850n 1.8
+    924899n 1.8
+    924900n 0
+    924949n 0
+    924950n 1.8
+    924999n 1.8
+    925000n 0
+    925049n 0
+    925050n 1.8
+    925099n 1.8
+    925100n 0
+    925149n 0
+    925150n 1.8
+    925199n 1.8
+    925200n 0
+    925249n 0
+    925250n 1.8
+    925299n 1.8
+    925300n 0
+    925349n 0
+    925350n 1.8
+    925399n 1.8
+    925400n 0
+    925449n 0
+    925450n 1.8
+    925499n 1.8
+    925500n 0
+    925549n 0
+    925550n 1.8
+    925599n 1.8
+    925600n 0
+    925649n 0
+    925650n 1.8
+    925699n 1.8
+    925700n 0
+    925749n 0
+    925750n 1.8
+    925799n 1.8
+    925800n 0
+    925849n 0
+    925850n 1.8
+    925899n 1.8
+    925900n 0
+    925949n 0
+    925950n 1.8
+    925999n 1.8
+    926000n 0
+    926049n 0
+    926050n 1.8
+    926099n 1.8
+    926100n 0
+    926149n 0
+    926150n 1.8
+    926199n 1.8
+    926200n 0
+    926249n 0
+    926250n 1.8
+    926299n 1.8
+    926300n 0
+    926349n 0
+    926350n 1.8
+    926399n 1.8
+    926400n 0
+    926449n 0
+    926450n 1.8
+    926499n 1.8
+    926500n 0
+    926549n 0
+    926550n 1.8
+    926599n 1.8
+    926600n 0
+    926649n 0
+    926650n 1.8
+    926699n 1.8
+    926700n 0
+    926749n 0
+    926750n 1.8
+    926799n 1.8
+    926800n 0
+    926849n 0
+    926850n 1.8
+    926899n 1.8
+    926900n 0
+    926949n 0
+    926950n 1.8
+    926999n 1.8
+    927000n 0
+    927049n 0
+    927050n 1.8
+    927099n 1.8
+    927100n 0
+    927149n 0
+    927150n 1.8
+    927199n 1.8
+    927200n 0
+    927249n 0
+    927250n 1.8
+    927299n 1.8
+    927300n 0
+    927349n 0
+    927350n 1.8
+    927399n 1.8
+    927400n 0
+    927449n 0
+    927450n 1.8
+    927499n 1.8
+    927500n 0
+    927549n 0
+    927550n 1.8
+    927599n 1.8
+    927600n 0
+    927649n 0
+    927650n 1.8
+    927699n 1.8
+    927700n 0
+    927749n 0
+    927750n 1.8
+    927799n 1.8
+    927800n 0
+    927849n 0
+    927850n 1.8
+    927899n 1.8
+    927900n 0
+    927949n 0
+    927950n 1.8
+    927999n 1.8
+    928000n 0
+    928049n 0
+    928050n 1.8
+    928099n 1.8
+    928100n 0
+    928149n 0
+    928150n 1.8
+    928199n 1.8
+    928200n 0
+    928249n 0
+    928250n 1.8
+    928299n 1.8
+    928300n 0
+    928349n 0
+    928350n 1.8
+    928399n 1.8
+    928400n 0
+    928449n 0
+    928450n 1.8
+    928499n 1.8
+    928500n 0
+    928549n 0
+    928550n 1.8
+    928599n 1.8
+    928600n 0
+    928649n 0
+    928650n 1.8
+    928699n 1.8
+    928700n 0
+    928749n 0
+    928750n 1.8
+    928799n 1.8
+    928800n 0
+    928849n 0
+    928850n 1.8
+    928899n 1.8
+    928900n 0
+    928949n 0
+    928950n 1.8
+    928999n 1.8
+    929000n 0
+    929049n 0
+    929050n 1.8
+    929099n 1.8
+    929100n 0
+    929149n 0
+    929150n 1.8
+    929199n 1.8
+    929200n 0
+    929249n 0
+    929250n 1.8
+    929299n 1.8
+    929300n 0
+    929349n 0
+    929350n 1.8
+    929399n 1.8
+    929400n 0
+    929449n 0
+    929450n 1.8
+    929499n 1.8
+    929500n 0
+    929549n 0
+    929550n 1.8
+    929599n 1.8
+    929600n 0
+    929649n 0
+    929650n 1.8
+    929699n 1.8
+    929700n 0
+    929749n 0
+    929750n 1.8
+    929799n 1.8
+    929800n 0
+    929849n 0
+    929850n 1.8
+    929899n 1.8
+    929900n 0
+    929949n 0
+    929950n 1.8
+    929999n 1.8
+    930000n 0
+    930049n 0
+    930050n 1.8
+    930099n 1.8
+    930100n 0
+    930149n 0
+    930150n 1.8
+    930199n 1.8
+    930200n 0
+    930249n 0
+    930250n 1.8
+    930299n 1.8
+    930300n 0
+    930349n 0
+    930350n 1.8
+    930399n 1.8
+    930400n 0
+    930449n 0
+    930450n 1.8
+    930499n 1.8
+    930500n 0
+    930549n 0
+    930550n 1.8
+    930599n 1.8
+    930600n 0
+    930649n 0
+    930650n 1.8
+    930699n 1.8
+    930700n 0
+    930749n 0
+    930750n 1.8
+    930799n 1.8
+    930800n 0
+    930849n 0
+    930850n 1.8
+    930899n 1.8
+    930900n 0
+    930949n 0
+    930950n 1.8
+    930999n 1.8
+    931000n 0
+    931049n 0
+    931050n 1.8
+    931099n 1.8
+    931100n 0
+    931149n 0
+    931150n 1.8
+    931199n 1.8
+    931200n 0
+    931249n 0
+    931250n 1.8
+    931299n 1.8
+    931300n 0
+    931349n 0
+    931350n 1.8
+    931399n 1.8
+    931400n 0
+    931449n 0
+    931450n 1.8
+    931499n 1.8
+    931500n 0
+    931549n 0
+    931550n 1.8
+    931599n 1.8
+    931600n 0
+    931649n 0
+    931650n 1.8
+    931699n 1.8
+    931700n 0
+    931749n 0
+    931750n 1.8
+    931799n 1.8
+    931800n 0
+    931849n 0
+    931850n 1.8
+    931899n 1.8
+    931900n 0
+    931949n 0
+    931950n 1.8
+    931999n 1.8
+    932000n 0
+    932049n 0
+    932050n 1.8
+    932099n 1.8
+    932100n 0
+    932149n 0
+    932150n 1.8
+    932199n 1.8
+    932200n 0
+    932249n 0
+    932250n 1.8
+    932299n 1.8
+    932300n 0
+    932349n 0
+    932350n 1.8
+    932399n 1.8
+    932400n 0
+    932449n 0
+    932450n 1.8
+    932499n 1.8
+    932500n 0
+    932549n 0
+    932550n 1.8
+    932599n 1.8
+    932600n 0
+    932649n 0
+    932650n 1.8
+    932699n 1.8
+    932700n 0
+    932749n 0
+    932750n 1.8
+    932799n 1.8
+    932800n 0
+    932849n 0
+    932850n 1.8
+    932899n 1.8
+    932900n 0
+    932949n 0
+    932950n 1.8
+    932999n 1.8
+    933000n 0
+    933049n 0
+    933050n 1.8
+    933099n 1.8
+    933100n 0
+    933149n 0
+    933150n 1.8
+    933199n 1.8
+    933200n 0
+    933249n 0
+    933250n 1.8
+    933299n 1.8
+    933300n 0
+    933349n 0
+    933350n 1.8
+    933399n 1.8
+    933400n 0
+    933449n 0
+    933450n 1.8
+    933499n 1.8
+    933500n 0
+    933549n 0
+    933550n 1.8
+    933599n 1.8
+    933600n 0
+    933649n 0
+    933650n 1.8
+    933699n 1.8
+    933700n 0
+    933749n 0
+    933750n 1.8
+    933799n 1.8
+    933800n 0
+    933849n 0
+    933850n 1.8
+    933899n 1.8
+    933900n 0
+    933949n 0
+    933950n 1.8
+    933999n 1.8
+    934000n 0
+    934049n 0
+    934050n 1.8
+    934099n 1.8
+    934100n 0
+    934149n 0
+    934150n 1.8
+    934199n 1.8
+    934200n 0
+    934249n 0
+    934250n 1.8
+    934299n 1.8
+    934300n 0
+    934349n 0
+    934350n 1.8
+    934399n 1.8
+    934400n 0
+    934449n 0
+    934450n 1.8
+    934499n 1.8
+    934500n 0
+    934549n 0
+    934550n 1.8
+    934599n 1.8
+    934600n 0
+    934649n 0
+    934650n 1.8
+    934699n 1.8
+    934700n 0
+    934749n 0
+    934750n 1.8
+    934799n 1.8
+    934800n 0
+    934849n 0
+    934850n 1.8
+    934899n 1.8
+    934900n 0
+    934949n 0
+    934950n 1.8
+    934999n 1.8
+    935000n 0
+    935049n 0
+    935050n 1.8
+    935099n 1.8
+    935100n 0
+    935149n 0
+    935150n 1.8
+    935199n 1.8
+    935200n 0
+    935249n 0
+    935250n 1.8
+    935299n 1.8
+    935300n 0
+    935349n 0
+    935350n 1.8
+    935399n 1.8
+    935400n 0
+    935449n 0
+    935450n 1.8
+    935499n 1.8
+    935500n 0
+    935549n 0
+    935550n 1.8
+    935599n 1.8
+    935600n 0
+    935649n 0
+    935650n 1.8
+    935699n 1.8
+    935700n 0
+    935749n 0
+    935750n 1.8
+    935799n 1.8
+    935800n 0
+    935849n 0
+    935850n 1.8
+    935899n 1.8
+    935900n 0
+    935949n 0
+    935950n 1.8
+    935999n 1.8
+    936000n 0
+    936049n 0
+    936050n 1.8
+    936099n 1.8
+    936100n 0
+    936149n 0
+    936150n 1.8
+    936199n 1.8
+    936200n 0
+    936249n 0
+    936250n 1.8
+    936299n 1.8
+    936300n 0
+    936349n 0
+    936350n 1.8
+    936399n 1.8
+    936400n 0
+    936449n 0
+    936450n 1.8
+    936499n 1.8
+    936500n 0
+    936549n 0
+    936550n 1.8
+    936599n 1.8
+    936600n 0
+    936649n 0
+    936650n 1.8
+    936699n 1.8
+    936700n 0
+    936749n 0
+    936750n 1.8
+    936799n 1.8
+    936800n 0
+    936849n 0
+    936850n 1.8
+    936899n 1.8
+    936900n 0
+    936949n 0
+    936950n 1.8
+    936999n 1.8
+    937000n 0
+    937049n 0
+    937050n 1.8
+    937099n 1.8
+    937100n 0
+    937149n 0
+    937150n 1.8
+    937199n 1.8
+    937200n 0
+    937249n 0
+    937250n 1.8
+    937299n 1.8
+    937300n 0
+    937349n 0
+    937350n 1.8
+    937399n 1.8
+    937400n 0
+    937449n 0
+    937450n 1.8
+    937499n 1.8
+    937500n 0
+    937549n 0
+    937550n 1.8
+    937599n 1.8
+    937600n 0
+    937649n 0
+    937650n 1.8
+    937699n 1.8
+    937700n 0
+    937749n 0
+    937750n 1.8
+    937799n 1.8
+    937800n 0
+    937849n 0
+    937850n 1.8
+    937899n 1.8
+    937900n 0
+    937949n 0
+    937950n 1.8
+    937999n 1.8
+    938000n 0
+    938049n 0
+    938050n 1.8
+    938099n 1.8
+    938100n 0
+    938149n 0
+    938150n 1.8
+    938199n 1.8
+    938200n 0
+    938249n 0
+    938250n 1.8
+    938299n 1.8
+    938300n 0
+    938349n 0
+    938350n 1.8
+    938399n 1.8
+    938400n 0
+    938449n 0
+    938450n 1.8
+    938499n 1.8
+    938500n 0
+    938549n 0
+    938550n 1.8
+    938599n 1.8
+    938600n 0
+    938649n 0
+    938650n 1.8
+    938699n 1.8
+    938700n 0
+    938749n 0
+    938750n 1.8
+    938799n 1.8
+    938800n 0
+    938849n 0
+    938850n 1.8
+    938899n 1.8
+    938900n 0
+    938949n 0
+    938950n 1.8
+    938999n 1.8
+    939000n 0
+    939049n 0
+    939050n 1.8
+    939099n 1.8
+    939100n 0
+    939149n 0
+    939150n 1.8
+    939199n 1.8
+    939200n 0
+    939249n 0
+    939250n 1.8
+    939299n 1.8
+    939300n 0
+    939349n 0
+    939350n 1.8
+    939399n 1.8
+    939400n 0
+    939449n 0
+    939450n 1.8
+    939499n 1.8
+    939500n 0
+    939549n 0
+    939550n 1.8
+    939599n 1.8
+    939600n 0
+    939649n 0
+    939650n 1.8
+    939699n 1.8
+    939700n 0
+    939749n 0
+    939750n 1.8
+    939799n 1.8
+    939800n 0
+    939849n 0
+    939850n 1.8
+    939899n 1.8
+    939900n 0
+    939949n 0
+    939950n 1.8
+    939999n 1.8
+    940000n 0
+    940049n 0
+    940050n 1.8
+    940099n 1.8
+    940100n 0
+    940149n 0
+    940150n 1.8
+    940199n 1.8
+    940200n 0
+    940249n 0
+    940250n 1.8
+    940299n 1.8
+    940300n 0
+    940349n 0
+    940350n 1.8
+    940399n 1.8
+    940400n 0
+    940449n 0
+    940450n 1.8
+    940499n 1.8
+    940500n 0
+    940549n 0
+    940550n 1.8
+    940599n 1.8
+    940600n 0
+    940649n 0
+    940650n 1.8
+    940699n 1.8
+    940700n 0
+    940749n 0
+    940750n 1.8
+    940799n 1.8
+    940800n 0
+    940849n 0
+    940850n 1.8
+    940899n 1.8
+    940900n 0
+    940949n 0
+    940950n 1.8
+    940999n 1.8
+    941000n 0
+    941049n 0
+    941050n 1.8
+    941099n 1.8
+    941100n 0
+    941149n 0
+    941150n 1.8
+    941199n 1.8
+    941200n 0
+    941249n 0
+    941250n 1.8
+    941299n 1.8
+    941300n 0
+    941349n 0
+    941350n 1.8
+    941399n 1.8
+    941400n 0
+    941449n 0
+    941450n 1.8
+    941499n 1.8
+    941500n 0
+    941549n 0
+    941550n 1.8
+    941599n 1.8
+    941600n 0
+    941649n 0
+    941650n 1.8
+    941699n 1.8
+    941700n 0
+    941749n 0
+    941750n 1.8
+    941799n 1.8
+    941800n 0
+    941849n 0
+    941850n 1.8
+    941899n 1.8
+    941900n 0
+    941949n 0
+    941950n 1.8
+    941999n 1.8
+    942000n 0
+    942049n 0
+    942050n 1.8
+    942099n 1.8
+    942100n 0
+    942149n 0
+    942150n 1.8
+    942199n 1.8
+    942200n 0
+    942249n 0
+    942250n 1.8
+    942299n 1.8
+    942300n 0
+    942349n 0
+    942350n 1.8
+    942399n 1.8
+    942400n 0
+    942449n 0
+    942450n 1.8
+    942499n 1.8
+    942500n 0
+    942549n 0
+    942550n 1.8
+    942599n 1.8
+    942600n 0
+    942649n 0
+    942650n 1.8
+    942699n 1.8
+    942700n 0
+    942749n 0
+    942750n 1.8
+    942799n 1.8
+    942800n 0
+    942849n 0
+    942850n 1.8
+    942899n 1.8
+    942900n 0
+    942949n 0
+    942950n 1.8
+    942999n 1.8
+    943000n 0
+    943049n 0
+    943050n 1.8
+    943099n 1.8
+    943100n 0
+    943149n 0
+    943150n 1.8
+    943199n 1.8
+    943200n 0
+    943249n 0
+    943250n 1.8
+    943299n 1.8
+    943300n 0
+    943349n 0
+    943350n 1.8
+    943399n 1.8
+    943400n 0
+    943449n 0
+    943450n 1.8
+    943499n 1.8
+    943500n 0
+    943549n 0
+    943550n 1.8
+    943599n 1.8
+    943600n 0
+    943649n 0
+    943650n 1.8
+    943699n 1.8
+    943700n 0
+    943749n 0
+    943750n 1.8
+    943799n 1.8
+    943800n 0
+    943849n 0
+    943850n 1.8
+    943899n 1.8
+    943900n 0
+    943949n 0
+    943950n 1.8
+    943999n 1.8
+    944000n 0
+    944049n 0
+    944050n 1.8
+    944099n 1.8
+    944100n 0
+    944149n 0
+    944150n 1.8
+    944199n 1.8
+    944200n 0
+    944249n 0
+    944250n 1.8
+    944299n 1.8
+    944300n 0
+    944349n 0
+    944350n 1.8
+    944399n 1.8
+    944400n 0
+    944449n 0
+    944450n 1.8
+    944499n 1.8
+    944500n 0
+    944549n 0
+    944550n 1.8
+    944599n 1.8
+    944600n 0
+    944649n 0
+    944650n 1.8
+    944699n 1.8
+    944700n 0
+    944749n 0
+    944750n 1.8
+    944799n 1.8
+    944800n 0
+    944849n 0
+    944850n 1.8
+    944899n 1.8
+    944900n 0
+    944949n 0
+    944950n 1.8
+    944999n 1.8
+    945000n 0
+    945049n 0
+    945050n 1.8
+    945099n 1.8
+    945100n 0
+    945149n 0
+    945150n 1.8
+    945199n 1.8
+    945200n 0
+    945249n 0
+    945250n 1.8
+    945299n 1.8
+    945300n 0
+    945349n 0
+    945350n 1.8
+    945399n 1.8
+    945400n 0
+    945449n 0
+    945450n 1.8
+    945499n 1.8
+    945500n 0
+    945549n 0
+    945550n 1.8
+    945599n 1.8
+    945600n 0
+    945649n 0
+    945650n 1.8
+    945699n 1.8
+    945700n 0
+    945749n 0
+    945750n 1.8
+    945799n 1.8
+    945800n 0
+    945849n 0
+    945850n 1.8
+    945899n 1.8
+    945900n 0
+    945949n 0
+    945950n 1.8
+    945999n 1.8
+    946000n 0
+    946049n 0
+    946050n 1.8
+    946099n 1.8
+    946100n 0
+    946149n 0
+    946150n 1.8
+    946199n 1.8
+    946200n 0
+    946249n 0
+    946250n 1.8
+    946299n 1.8
+    946300n 0
+    946349n 0
+    946350n 1.8
+    946399n 1.8
+    946400n 0
+    946449n 0
+    946450n 1.8
+    946499n 1.8
+    946500n 0
+    946549n 0
+    946550n 1.8
+    946599n 1.8
+    946600n 0
+    946649n 0
+    946650n 1.8
+    946699n 1.8
+    946700n 0
+    946749n 0
+    946750n 1.8
+    946799n 1.8
+    946800n 0
+    946849n 0
+    946850n 1.8
+    946899n 1.8
+    946900n 0
+    946949n 0
+    946950n 1.8
+    946999n 1.8
+    947000n 0
+    947049n 0
+    947050n 1.8
+    947099n 1.8
+    947100n 0
+    947149n 0
+    947150n 1.8
+    947199n 1.8
+    947200n 0
+    947249n 0
+    947250n 1.8
+    947299n 1.8
+    947300n 0
+    947349n 0
+    947350n 1.8
+    947399n 1.8
+    947400n 0
+    947449n 0
+    947450n 1.8
+    947499n 1.8
+    947500n 0
+    947549n 0
+    947550n 1.8
+    947599n 1.8
+    947600n 0
+    947649n 0
+    947650n 1.8
+    947699n 1.8
+    947700n 0
+    947749n 0
+    947750n 1.8
+    947799n 1.8
+    947800n 0
+    947849n 0
+    947850n 1.8
+    947899n 1.8
+    947900n 0
+    947949n 0
+    947950n 1.8
+    947999n 1.8
+    948000n 0
+    948049n 0
+    948050n 1.8
+    948099n 1.8
+    948100n 0
+    948149n 0
+    948150n 1.8
+    948199n 1.8
+    948200n 0
+    948249n 0
+    948250n 1.8
+    948299n 1.8
+    948300n 0
+    948349n 0
+    948350n 1.8
+    948399n 1.8
+    948400n 0
+    948449n 0
+    948450n 1.8
+    948499n 1.8
+    948500n 0
+    948549n 0
+    948550n 1.8
+    948599n 1.8
+    948600n 0
+    948649n 0
+    948650n 1.8
+    948699n 1.8
+    948700n 0
+    948749n 0
+    948750n 1.8
+    948799n 1.8
+    948800n 0
+    948849n 0
+    948850n 1.8
+    948899n 1.8
+    948900n 0
+    948949n 0
+    948950n 1.8
+    948999n 1.8
+    949000n 0
+    949049n 0
+    949050n 1.8
+    949099n 1.8
+    949100n 0
+    949149n 0
+    949150n 1.8
+    949199n 1.8
+    949200n 0
+    949249n 0
+    949250n 1.8
+    949299n 1.8
+    949300n 0
+    949349n 0
+    949350n 1.8
+    949399n 1.8
+    949400n 0
+    949449n 0
+    949450n 1.8
+    949499n 1.8
+    949500n 0
+    949549n 0
+    949550n 1.8
+    949599n 1.8
+    949600n 0
+    949649n 0
+    949650n 1.8
+    949699n 1.8
+    949700n 0
+    949749n 0
+    949750n 1.8
+    949799n 1.8
+    949800n 0
+    949849n 0
+    949850n 1.8
+    949899n 1.8
+    949900n 0
+    949949n 0
+    949950n 1.8
+    949999n 1.8
+    950000n 0
+    950049n 0
+    950050n 1.8
+    950099n 1.8
+    950100n 0
+    950149n 0
+    950150n 1.8
+    950199n 1.8
+    950200n 0
+    950249n 0
+    950250n 1.8
+    950299n 1.8
+    950300n 0
+    950349n 0
+    950350n 1.8
+    950399n 1.8
+    950400n 0
+    950449n 0
+    950450n 1.8
+    950499n 1.8
+    950500n 0
+    950549n 0
+    950550n 1.8
+    950599n 1.8
+    950600n 0
+    950649n 0
+    950650n 1.8
+    950699n 1.8
+    950700n 0
+    950749n 0
+    950750n 1.8
+    950799n 1.8
+    950800n 0
+    950849n 0
+    950850n 1.8
+    950899n 1.8
+    950900n 0
+    950949n 0
+    950950n 1.8
+    950999n 1.8
+    951000n 0
+    951049n 0
+    951050n 1.8
+    951099n 1.8
+    951100n 0
+    951149n 0
+    951150n 1.8
+    951199n 1.8
+    951200n 0
+    951249n 0
+    951250n 1.8
+    951299n 1.8
+    951300n 0
+    951349n 0
+    951350n 1.8
+    951399n 1.8
+    951400n 0
+    951449n 0
+    951450n 1.8
+    951499n 1.8
+    951500n 0
+    951549n 0
+    951550n 1.8
+    951599n 1.8
+    951600n 0
+    951649n 0
+    951650n 1.8
+    951699n 1.8
+    951700n 0
+    951749n 0
+    951750n 1.8
+    951799n 1.8
+    951800n 0
+    951849n 0
+    951850n 1.8
+    951899n 1.8
+    951900n 0
+    951949n 0
+    951950n 1.8
+    951999n 1.8
+    952000n 0
+    952049n 0
+    952050n 1.8
+    952099n 1.8
+    952100n 0
+    952149n 0
+    952150n 1.8
+    952199n 1.8
+    952200n 0
+    952249n 0
+    952250n 1.8
+    952299n 1.8
+    952300n 0
+    952349n 0
+    952350n 1.8
+    952399n 1.8
+    952400n 0
+    952449n 0
+    952450n 1.8
+    952499n 1.8
+    952500n 0
+    952549n 0
+    952550n 1.8
+    952599n 1.8
+    952600n 0
+    952649n 0
+    952650n 1.8
+    952699n 1.8
+    952700n 0
+    952749n 0
+    952750n 1.8
+    952799n 1.8
+    952800n 0
+    952849n 0
+    952850n 1.8
+    952899n 1.8
+    952900n 0
+    952949n 0
+    952950n 1.8
+    952999n 1.8
+    953000n 0
+    953049n 0
+    953050n 1.8
+    953099n 1.8
+    953100n 0
+    953149n 0
+    953150n 1.8
+    953199n 1.8
+    953200n 0
+    953249n 0
+    953250n 1.8
+    953299n 1.8
+    953300n 0
+    953349n 0
+    953350n 1.8
+    953399n 1.8
+    953400n 0
+    953449n 0
+    953450n 1.8
+    953499n 1.8
+    953500n 0
+    953549n 0
+    953550n 1.8
+    953599n 1.8
+    953600n 0
+    953649n 0
+    953650n 1.8
+    953699n 1.8
+    953700n 0
+    953749n 0
+    953750n 1.8
+    953799n 1.8
+    953800n 0
+    953849n 0
+    953850n 1.8
+    953899n 1.8
+    953900n 0
+    953949n 0
+    953950n 1.8
+    953999n 1.8
+    954000n 0
+    954049n 0
+    954050n 1.8
+    954099n 1.8
+    954100n 0
+    954149n 0
+    954150n 1.8
+    954199n 1.8
+    954200n 0
+    954249n 0
+    954250n 1.8
+    954299n 1.8
+    954300n 0
+    954349n 0
+    954350n 1.8
+    954399n 1.8
+    954400n 0
+    954449n 0
+    954450n 1.8
+    954499n 1.8
+    954500n 0
+    954549n 0
+    954550n 1.8
+    954599n 1.8
+    954600n 0
+    954649n 0
+    954650n 1.8
+    954699n 1.8
+    954700n 0
+    954749n 0
+    954750n 1.8
+    954799n 1.8
+    954800n 0
+    954849n 0
+    954850n 1.8
+    954899n 1.8
+    954900n 0
+    954949n 0
+    954950n 1.8
+    954999n 1.8
+    955000n 0
+    955049n 0
+    955050n 1.8
+    955099n 1.8
+    955100n 0
+    955149n 0
+    955150n 1.8
+    955199n 1.8
+    955200n 0
+    955249n 0
+    955250n 1.8
+    955299n 1.8
+    955300n 0
+    955349n 0
+    955350n 1.8
+    955399n 1.8
+    955400n 0
+    955449n 0
+    955450n 1.8
+    955499n 1.8
+    955500n 0
+    955549n 0
+    955550n 1.8
+    955599n 1.8
+    955600n 0
+    955649n 0
+    955650n 1.8
+    955699n 1.8
+    955700n 0
+    955749n 0
+    955750n 1.8
+    955799n 1.8
+    955800n 0
+    955849n 0
+    955850n 1.8
+    955899n 1.8
+    955900n 0
+    955949n 0
+    955950n 1.8
+    955999n 1.8
+    956000n 0
+    956049n 0
+    956050n 1.8
+    956099n 1.8
+    956100n 0
+    956149n 0
+    956150n 1.8
+    956199n 1.8
+    956200n 0
+    956249n 0
+    956250n 1.8
+    956299n 1.8
+    956300n 0
+    956349n 0
+    956350n 1.8
+    956399n 1.8
+    956400n 0
+    956449n 0
+    956450n 1.8
+    956499n 1.8
+    956500n 0
+    956549n 0
+    956550n 1.8
+    956599n 1.8
+    956600n 0
+    956649n 0
+    956650n 1.8
+    956699n 1.8
+    956700n 0
+    956749n 0
+    956750n 1.8
+    956799n 1.8
+    956800n 0
+    956849n 0
+    956850n 1.8
+    956899n 1.8
+    956900n 0
+    956949n 0
+    956950n 1.8
+    956999n 1.8
+    957000n 0
+    957049n 0
+    957050n 1.8
+    957099n 1.8
+    957100n 0
+    957149n 0
+    957150n 1.8
+    957199n 1.8
+    957200n 0
+    957249n 0
+    957250n 1.8
+    957299n 1.8
+    957300n 0
+    957349n 0
+    957350n 1.8
+    957399n 1.8
+    957400n 0
+    957449n 0
+    957450n 1.8
+    957499n 1.8
+    957500n 0
+    957549n 0
+    957550n 1.8
+    957599n 1.8
+    957600n 0
+    957649n 0
+    957650n 1.8
+    957699n 1.8
+    957700n 0
+    957749n 0
+    957750n 1.8
+    957799n 1.8
+    957800n 0
+    957849n 0
+    957850n 1.8
+    957899n 1.8
+    957900n 0
+    957949n 0
+    957950n 1.8
+    957999n 1.8
+    958000n 0
+    958049n 0
+    958050n 1.8
+    958099n 1.8
+    958100n 0
+    958149n 0
+    958150n 1.8
+    958199n 1.8
+    958200n 0
+    958249n 0
+    958250n 1.8
+    958299n 1.8
+    958300n 0
+    958349n 0
+    958350n 1.8
+    958399n 1.8
+    958400n 0
+    958449n 0
+    958450n 1.8
+    958499n 1.8
+    958500n 0
+    958549n 0
+    958550n 1.8
+    958599n 1.8
+    958600n 0
+    958649n 0
+    958650n 1.8
+    958699n 1.8
+    958700n 0
+    958749n 0
+    958750n 1.8
+    958799n 1.8
+    958800n 0
+    958849n 0
+    958850n 1.8
+    958899n 1.8
+    958900n 0
+    958949n 0
+    958950n 1.8
+    958999n 1.8
+    959000n 0
+    959049n 0
+    959050n 1.8
+    959099n 1.8
+    959100n 0
+    959149n 0
+    959150n 1.8
+    959199n 1.8
+    959200n 0
+    959249n 0
+    959250n 1.8
+    959299n 1.8
+    959300n 0
+    959349n 0
+    959350n 1.8
+    959399n 1.8
+    959400n 0
+    959449n 0
+    959450n 1.8
+    959499n 1.8
+    959500n 0
+    959549n 0
+    959550n 1.8
+    959599n 1.8
+    959600n 0
+    959649n 0
+    959650n 1.8
+    959699n 1.8
+    959700n 0
+    959749n 0
+    959750n 1.8
+    959799n 1.8
+    959800n 0
+    959849n 0
+    959850n 1.8
+    959899n 1.8
+    959900n 0
+    959949n 0
+    959950n 1.8
+    959999n 1.8
+    960000n 0
+    960049n 0
+    960050n 1.8
+    960099n 1.8
+    960100n 0
+    960149n 0
+    960150n 1.8
+    960199n 1.8
+    960200n 0
+    960249n 0
+    960250n 1.8
+    960299n 1.8
+    960300n 0
+    960349n 0
+    960350n 1.8
+    960399n 1.8
+    960400n 0
+    960449n 0
+    960450n 1.8
+    960499n 1.8
+    960500n 0
+    960549n 0
+    960550n 1.8
+    960599n 1.8
+    960600n 0
+    960649n 0
+    960650n 1.8
+    960699n 1.8
+    960700n 0
+    960749n 0
+    960750n 1.8
+    960799n 1.8
+    960800n 0
+    960849n 0
+    960850n 1.8
+    960899n 1.8
+    960900n 0
+    960949n 0
+    960950n 1.8
+    960999n 1.8
+    961000n 0
+    961049n 0
+    961050n 1.8
+    961099n 1.8
+    961100n 0
+    961149n 0
+    961150n 1.8
+    961199n 1.8
+    961200n 0
+    961249n 0
+    961250n 1.8
+    961299n 1.8
+    961300n 0
+    961349n 0
+    961350n 1.8
+    961399n 1.8
+    961400n 0
+    961449n 0
+    961450n 1.8
+    961499n 1.8
+    961500n 0
+    961549n 0
+    961550n 1.8
+    961599n 1.8
+    961600n 0
+    961649n 0
+    961650n 1.8
+    961699n 1.8
+    961700n 0
+    961749n 0
+    961750n 1.8
+    961799n 1.8
+    961800n 0
+    961849n 0
+    961850n 1.8
+    961899n 1.8
+    961900n 0
+    961949n 0
+    961950n 1.8
+    961999n 1.8
+    962000n 0
+    962049n 0
+    962050n 1.8
+    962099n 1.8
+    962100n 0
+    962149n 0
+    962150n 1.8
+    962199n 1.8
+    962200n 0
+    962249n 0
+    962250n 1.8
+    962299n 1.8
+    962300n 0
+    962349n 0
+    962350n 1.8
+    962399n 1.8
+    962400n 0
+    962449n 0
+    962450n 1.8
+    962499n 1.8
+    962500n 0
+    962549n 0
+    962550n 1.8
+    962599n 1.8
+    962600n 0
+    962649n 0
+    962650n 1.8
+    962699n 1.8
+    962700n 0
+    962749n 0
+    962750n 1.8
+    962799n 1.8
+    962800n 0
+    962849n 0
+    962850n 1.8
+    962899n 1.8
+    962900n 0
+    962949n 0
+    962950n 1.8
+    962999n 1.8
+    963000n 0
+    963049n 0
+    963050n 1.8
+    963099n 1.8
+    963100n 0
+    963149n 0
+    963150n 1.8
+    963199n 1.8
+    963200n 0
+    963249n 0
+    963250n 1.8
+    963299n 1.8
+    963300n 0
+    963349n 0
+    963350n 1.8
+    963399n 1.8
+    963400n 0
+    963449n 0
+    963450n 1.8
+    963499n 1.8
+    963500n 0
+    963549n 0
+    963550n 1.8
+    963599n 1.8
+    963600n 0
+    963649n 0
+    963650n 1.8
+    963699n 1.8
+    963700n 0
+    963749n 0
+    963750n 1.8
+    963799n 1.8
+    963800n 0
+    963849n 0
+    963850n 1.8
+    963899n 1.8
+    963900n 0
+    963949n 0
+    963950n 1.8
+    963999n 1.8
+    964000n 0
+    964049n 0
+    964050n 1.8
+    964099n 1.8
+    964100n 0
+    964149n 0
+    964150n 1.8
+    964199n 1.8
+    964200n 0
+    964249n 0
+    964250n 1.8
+    964299n 1.8
+    964300n 0
+    964349n 0
+    964350n 1.8
+    964399n 1.8
+    964400n 0
+    964449n 0
+    964450n 1.8
+    964499n 1.8
+    964500n 0
+    964549n 0
+    964550n 1.8
+    964599n 1.8
+    964600n 0
+    964649n 0
+    964650n 1.8
+    964699n 1.8
+    964700n 0
+    964749n 0
+    964750n 1.8
+    964799n 1.8
+    964800n 0
+    964849n 0
+    964850n 1.8
+    964899n 1.8
+    964900n 0
+    964949n 0
+    964950n 1.8
+    964999n 1.8
+    965000n 0
+    965049n 0
+    965050n 1.8
+    965099n 1.8
+    965100n 0
+    965149n 0
+    965150n 1.8
+    965199n 1.8
+    965200n 0
+    965249n 0
+    965250n 1.8
+    965299n 1.8
+    965300n 0
+    965349n 0
+    965350n 1.8
+    965399n 1.8
+    965400n 0
+    965449n 0
+    965450n 1.8
+    965499n 1.8
+    965500n 0
+    965549n 0
+    965550n 1.8
+    965599n 1.8
+    965600n 0
+    965649n 0
+    965650n 1.8
+    965699n 1.8
+    965700n 0
+    965749n 0
+    965750n 1.8
+    965799n 1.8
+    965800n 0
+    965849n 0
+    965850n 1.8
+    965899n 1.8
+    965900n 0
+    965949n 0
+    965950n 1.8
+    965999n 1.8
+    966000n 0
+    966049n 0
+    966050n 1.8
+    966099n 1.8
+    966100n 0
+    966149n 0
+    966150n 1.8
+    966199n 1.8
+    966200n 0
+    966249n 0
+    966250n 1.8
+    966299n 1.8
+    966300n 0
+    966349n 0
+    966350n 1.8
+    966399n 1.8
+    966400n 0
+    966449n 0
+    966450n 1.8
+    966499n 1.8
+    966500n 0
+    966549n 0
+    966550n 1.8
+    966599n 1.8
+    966600n 0
+    966649n 0
+    966650n 1.8
+    966699n 1.8
+    966700n 0
+    966749n 0
+    966750n 1.8
+    966799n 1.8
+    966800n 0
+    966849n 0
+    966850n 1.8
+    966899n 1.8
+    966900n 0
+    966949n 0
+    966950n 1.8
+    966999n 1.8
+    967000n 0
+    967049n 0
+    967050n 1.8
+    967099n 1.8
+    967100n 0
+    967149n 0
+    967150n 1.8
+    967199n 1.8
+    967200n 0
+    967249n 0
+    967250n 1.8
+    967299n 1.8
+    967300n 0
+    967349n 0
+    967350n 1.8
+    967399n 1.8
+    967400n 0
+    967449n 0
+    967450n 1.8
+    967499n 1.8
+    967500n 0
+    967549n 0
+    967550n 1.8
+    967599n 1.8
+    967600n 0
+    967649n 0
+    967650n 1.8
+    967699n 1.8
+    967700n 0
+    967749n 0
+    967750n 1.8
+    967799n 1.8
+    967800n 0
+    967849n 0
+    967850n 1.8
+    967899n 1.8
+    967900n 0
+    967949n 0
+    967950n 1.8
+    967999n 1.8
+    968000n 0
+    968049n 0
+    968050n 1.8
+    968099n 1.8
+    968100n 0
+    968149n 0
+    968150n 1.8
+    968199n 1.8
+    968200n 0
+    968249n 0
+    968250n 1.8
+    968299n 1.8
+    968300n 0
+    968349n 0
+    968350n 1.8
+    968399n 1.8
+    968400n 0
+    968449n 0
+    968450n 1.8
+    968499n 1.8
+    968500n 0
+    968549n 0
+    968550n 1.8
+    968599n 1.8
+    968600n 0
+    968649n 0
+    968650n 1.8
+    968699n 1.8
+    968700n 0
+    968749n 0
+    968750n 1.8
+    968799n 1.8
+    968800n 0
+    968849n 0
+    968850n 1.8
+    968899n 1.8
+    968900n 0
+    968949n 0
+    968950n 1.8
+    968999n 1.8
+    969000n 0
+    969049n 0
+    969050n 1.8
+    969099n 1.8
+    969100n 0
+    969149n 0
+    969150n 1.8
+    969199n 1.8
+    969200n 0
+    969249n 0
+    969250n 1.8
+    969299n 1.8
+    969300n 0
+    969349n 0
+    969350n 1.8
+    969399n 1.8
+    969400n 0
+    969449n 0
+    969450n 1.8
+    969499n 1.8
+    969500n 0
+    969549n 0
+    969550n 1.8
+    969599n 1.8
+    969600n 0
+    969649n 0
+    969650n 1.8
+    969699n 1.8
+    969700n 0
+    969749n 0
+    969750n 1.8
+    969799n 1.8
+    969800n 0
+    969849n 0
+    969850n 1.8
+    969899n 1.8
+    969900n 0
+    969949n 0
+    969950n 1.8
+    969999n 1.8
+    970000n 0
+    970049n 0
+    970050n 1.8
+    970099n 1.8
+    970100n 0
+    970149n 0
+    970150n 1.8
+    970199n 1.8
+    970200n 0
+    970249n 0
+    970250n 1.8
+    970299n 1.8
+    970300n 0
+    970349n 0
+    970350n 1.8
+    970399n 1.8
+    970400n 0
+    970449n 0
+    970450n 1.8
+    970499n 1.8
+    970500n 0
+    970549n 0
+    970550n 1.8
+    970599n 1.8
+    970600n 0
+    970649n 0
+    970650n 1.8
+    970699n 1.8
+    970700n 0
+    970749n 0
+    970750n 1.8
+    970799n 1.8
+    970800n 0
+    970849n 0
+    970850n 1.8
+    970899n 1.8
+    970900n 0
+    970949n 0
+    970950n 1.8
+    970999n 1.8
+    971000n 0
+    971049n 0
+    971050n 1.8
+    971099n 1.8
+    971100n 0
+    971149n 0
+    971150n 1.8
+    971199n 1.8
+    971200n 0
+    971249n 0
+    971250n 1.8
+    971299n 1.8
+    971300n 0
+    971349n 0
+    971350n 1.8
+    971399n 1.8
+    971400n 0
+    971449n 0
+    971450n 1.8
+    971499n 1.8
+    971500n 0
+    971549n 0
+    971550n 1.8
+    971599n 1.8
+    971600n 0
+    971649n 0
+    971650n 1.8
+    971699n 1.8
+    971700n 0
+    971749n 0
+    971750n 1.8
+    971799n 1.8
+    971800n 0
+    971849n 0
+    971850n 1.8
+    971899n 1.8
+    971900n 0
+    971949n 0
+    971950n 1.8
+    971999n 1.8
+    972000n 0
+    972049n 0
+    972050n 1.8
+    972099n 1.8
+    972100n 0
+    972149n 0
+    972150n 1.8
+    972199n 1.8
+    972200n 0
+    972249n 0
+    972250n 1.8
+    972299n 1.8
+    972300n 0
+    972349n 0
+    972350n 1.8
+    972399n 1.8
+    972400n 0
+    972449n 0
+    972450n 1.8
+    972499n 1.8
+    972500n 0
+    972549n 0
+    972550n 1.8
+    972599n 1.8
+    972600n 0
+    972649n 0
+    972650n 1.8
+    972699n 1.8
+    972700n 0
+    972749n 0
+    972750n 1.8
+    972799n 1.8
+    972800n 0
+    972849n 0
+    972850n 1.8
+    972899n 1.8
+    972900n 0
+    972949n 0
+    972950n 1.8
+    972999n 1.8
+    973000n 0
+    973049n 0
+    973050n 1.8
+    973099n 1.8
+    973100n 0
+    973149n 0
+    973150n 1.8
+    973199n 1.8
+    973200n 0
+    973249n 0
+    973250n 1.8
+    973299n 1.8
+    973300n 0
+    973349n 0
+    973350n 1.8
+    973399n 1.8
+    973400n 0
+    973449n 0
+    973450n 1.8
+    973499n 1.8
+    973500n 0
+    973549n 0
+    973550n 1.8
+    973599n 1.8
+    973600n 0
+    973649n 0
+    973650n 1.8
+    973699n 1.8
+    973700n 0
+    973749n 0
+    973750n 1.8
+    973799n 1.8
+    973800n 0
+    973849n 0
+    973850n 1.8
+    973899n 1.8
+    973900n 0
+    973949n 0
+    973950n 1.8
+    973999n 1.8
+    974000n 0
+    974049n 0
+    974050n 1.8
+    974099n 1.8
+    974100n 0
+    974149n 0
+    974150n 1.8
+    974199n 1.8
+    974200n 0
+    974249n 0
+    974250n 1.8
+    974299n 1.8
+    974300n 0
+    974349n 0
+    974350n 1.8
+    974399n 1.8
+    974400n 0
+    974449n 0
+    974450n 1.8
+    974499n 1.8
+    974500n 0
+    974549n 0
+    974550n 1.8
+    974599n 1.8
+    974600n 0
+    974649n 0
+    974650n 1.8
+    974699n 1.8
+    974700n 0
+    974749n 0
+    974750n 1.8
+    974799n 1.8
+    974800n 0
+    974849n 0
+    974850n 1.8
+    974899n 1.8
+    974900n 0
+    974949n 0
+    974950n 1.8
+    974999n 1.8
+    975000n 0
+    975049n 0
+    975050n 1.8
+    975099n 1.8
+    975100n 0
+    975149n 0
+    975150n 1.8
+    975199n 1.8
+    975200n 0
+    975249n 0
+    975250n 1.8
+    975299n 1.8
+    975300n 0
+    975349n 0
+    975350n 1.8
+    975399n 1.8
+    975400n 0
+    975449n 0
+    975450n 1.8
+    975499n 1.8
+    975500n 0
+    975549n 0
+    975550n 1.8
+    975599n 1.8
+    975600n 0
+    975649n 0
+    975650n 1.8
+    975699n 1.8
+    975700n 0
+    975749n 0
+    975750n 1.8
+    975799n 1.8
+    975800n 0
+    975849n 0
+    975850n 1.8
+    975899n 1.8
+    975900n 0
+    975949n 0
+    975950n 1.8
+    975999n 1.8
+    976000n 0
+    976049n 0
+    976050n 1.8
+    976099n 1.8
+    976100n 0
+    976149n 0
+    976150n 1.8
+    976199n 1.8
+    976200n 0
+    976249n 0
+    976250n 1.8
+    976299n 1.8
+    976300n 0
+    976349n 0
+    976350n 1.8
+    976399n 1.8
+    976400n 0
+    976449n 0
+    976450n 1.8
+    976499n 1.8
+    976500n 0
+    976549n 0
+    976550n 1.8
+    976599n 1.8
+    976600n 0
+    976649n 0
+    976650n 1.8
+    976699n 1.8
+    976700n 0
+    976749n 0
+    976750n 1.8
+    976799n 1.8
+    976800n 0
+    976849n 0
+    976850n 1.8
+    976899n 1.8
+    976900n 0
+    976949n 0
+    976950n 1.8
+    976999n 1.8
+    977000n 0
+    977049n 0
+    977050n 1.8
+    977099n 1.8
+    977100n 0
+    977149n 0
+    977150n 1.8
+    977199n 1.8
+    977200n 0
+    977249n 0
+    977250n 1.8
+    977299n 1.8
+    977300n 0
+    977349n 0
+    977350n 1.8
+    977399n 1.8
+    977400n 0
+    977449n 0
+    977450n 1.8
+    977499n 1.8
+    977500n 0
+    977549n 0
+    977550n 1.8
+    977599n 1.8
+    977600n 0
+    977649n 0
+    977650n 1.8
+    977699n 1.8
+    977700n 0
+    977749n 0
+    977750n 1.8
+    977799n 1.8
+    977800n 0
+    977849n 0
+    977850n 1.8
+    977899n 1.8
+    977900n 0
+    977949n 0
+    977950n 1.8
+    977999n 1.8
+    978000n 0
+    978049n 0
+    978050n 1.8
+    978099n 1.8
+    978100n 0
+    978149n 0
+    978150n 1.8
+    978199n 1.8
+    978200n 0
+    978249n 0
+    978250n 1.8
+    978299n 1.8
+    978300n 0
+    978349n 0
+    978350n 1.8
+    978399n 1.8
+    978400n 0
+    978449n 0
+    978450n 1.8
+    978499n 1.8
+    978500n 0
+    978549n 0
+    978550n 1.8
+    978599n 1.8
+    978600n 0
+    978649n 0
+    978650n 1.8
+    978699n 1.8
+    978700n 0
+    978749n 0
+    978750n 1.8
+    978799n 1.8
+    978800n 0
+    978849n 0
+    978850n 1.8
+    978899n 1.8
+    978900n 0
+    978949n 0
+    978950n 1.8
+    978999n 1.8
+    979000n 0
+    979049n 0
+    979050n 1.8
+    979099n 1.8
+    979100n 0
+    979149n 0
+    979150n 1.8
+    979199n 1.8
+    979200n 0
+    979249n 0
+    979250n 1.8
+    979299n 1.8
+    979300n 0
+    979349n 0
+    979350n 1.8
+    979399n 1.8
+    979400n 0
+    979449n 0
+    979450n 1.8
+    979499n 1.8
+    979500n 0
+    979549n 0
+    979550n 1.8
+    979599n 1.8
+    979600n 0
+    979649n 0
+    979650n 1.8
+    979699n 1.8
+    979700n 0
+    979749n 0
+    979750n 1.8
+    979799n 1.8
+    979800n 0
+    979849n 0
+    979850n 1.8
+    979899n 1.8
+    979900n 0
+    979949n 0
+    979950n 1.8
+    979999n 1.8
+    980000n 0
+    980049n 0
+    980050n 1.8
+    980099n 1.8
+    980100n 0
+    980149n 0
+    980150n 1.8
+    980199n 1.8
+    980200n 0
+    980249n 0
+    980250n 1.8
+    980299n 1.8
+    980300n 0
+    980349n 0
+    980350n 1.8
+    980399n 1.8
+    980400n 0
+    980449n 0
+    980450n 1.8
+    980499n 1.8
+    980500n 0
+    980549n 0
+    980550n 1.8
+    980599n 1.8
+    980600n 0
+    980649n 0
+    980650n 1.8
+    980699n 1.8
+    980700n 0
+    980749n 0
+    980750n 1.8
+    980799n 1.8
+    980800n 0
+    980849n 0
+    980850n 1.8
+    980899n 1.8
+    980900n 0
+    980949n 0
+    980950n 1.8
+    980999n 1.8
+    981000n 0
+    981049n 0
+    981050n 1.8
+    981099n 1.8
+    981100n 0
+    981149n 0
+    981150n 1.8
+    981199n 1.8
+    981200n 0
+    981249n 0
+    981250n 1.8
+    981299n 1.8
+    981300n 0
+    981349n 0
+    981350n 1.8
+    981399n 1.8
+    981400n 0
+    981449n 0
+    981450n 1.8
+    981499n 1.8
+    981500n 0
+    981549n 0
+    981550n 1.8
+    981599n 1.8
+    981600n 0
+    981649n 0
+    981650n 1.8
+    981699n 1.8
+    981700n 0
+    981749n 0
+    981750n 1.8
+    981799n 1.8
+    981800n 0
+    981849n 0
+    981850n 1.8
+    981899n 1.8
+    981900n 0
+    981949n 0
+    981950n 1.8
+    981999n 1.8
+    982000n 0
+    982049n 0
+    982050n 1.8
+    982099n 1.8
+    982100n 0
+    982149n 0
+    982150n 1.8
+    982199n 1.8
+    982200n 0
+    982249n 0
+    982250n 1.8
+    982299n 1.8
+    982300n 0
+    982349n 0
+    982350n 1.8
+    982399n 1.8
+    982400n 0
+    982449n 0
+    982450n 1.8
+    982499n 1.8
+    982500n 0
+    982549n 0
+    982550n 1.8
+    982599n 1.8
+    982600n 0
+    982649n 0
+    982650n 1.8
+    982699n 1.8
+    982700n 0
+    982749n 0
+    982750n 1.8
+    982799n 1.8
+    982800n 0
+    982849n 0
+    982850n 1.8
+    982899n 1.8
+    982900n 0
+    982949n 0
+    982950n 1.8
+    982999n 1.8
+    983000n 0
+    983049n 0
+    983050n 1.8
+    983099n 1.8
+    983100n 0
+    983149n 0
+    983150n 1.8
+    983199n 1.8
+    983200n 0
+    983249n 0
+    983250n 1.8
+    983299n 1.8
+    983300n 0
+    983349n 0
+    983350n 1.8
+    983399n 1.8
+    983400n 0
+    983449n 0
+    983450n 1.8
+    983499n 1.8
+    983500n 0
+    983549n 0
+    983550n 1.8
+    983599n 1.8
+    983600n 0
+    983649n 0
+    983650n 1.8
+    983699n 1.8
+    983700n 0
+    983749n 0
+    983750n 1.8
+    983799n 1.8
+    983800n 0
+    983849n 0
+    983850n 1.8
+    983899n 1.8
+    983900n 0
+    983949n 0
+    983950n 1.8
+    983999n 1.8
+    984000n 0
+    984049n 0
+    984050n 1.8
+    984099n 1.8
+    984100n 0
+    984149n 0
+    984150n 1.8
+    984199n 1.8
+    984200n 0
+    984249n 0
+    984250n 1.8
+    984299n 1.8
+    984300n 0
+    984349n 0
+    984350n 1.8
+    984399n 1.8
+    984400n 0
+    984449n 0
+    984450n 1.8
+    984499n 1.8
+    984500n 0
+    984549n 0
+    984550n 1.8
+    984599n 1.8
+    984600n 0
+    984649n 0
+    984650n 1.8
+    984699n 1.8
+    984700n 0
+    984749n 0
+    984750n 1.8
+    984799n 1.8
+    984800n 0
+    984849n 0
+    984850n 1.8
+    984899n 1.8
+    984900n 0
+    984949n 0
+    984950n 1.8
+    984999n 1.8
+    985000n 0
+    985049n 0
+    985050n 1.8
+    985099n 1.8
+    985100n 0
+    985149n 0
+    985150n 1.8
+    985199n 1.8
+    985200n 0
+    985249n 0
+    985250n 1.8
+    985299n 1.8
+    985300n 0
+    985349n 0
+    985350n 1.8
+    985399n 1.8
+    985400n 0
+    985449n 0
+    985450n 1.8
+    985499n 1.8
+    985500n 0
+    985549n 0
+    985550n 1.8
+    985599n 1.8
+    985600n 0
+    985649n 0
+    985650n 1.8
+    985699n 1.8
+    985700n 0
+    985749n 0
+    985750n 1.8
+    985799n 1.8
+    985800n 0
+    985849n 0
+    985850n 1.8
+    985899n 1.8
+    985900n 0
+    985949n 0
+    985950n 1.8
+    985999n 1.8
+    986000n 0
+    986049n 0
+    986050n 1.8
+    986099n 1.8
+    986100n 0
+    986149n 0
+    986150n 1.8
+    986199n 1.8
+    986200n 0
+    986249n 0
+    986250n 1.8
+    986299n 1.8
+    986300n 0
+    986349n 0
+    986350n 1.8
+    986399n 1.8
+    986400n 0
+    986449n 0
+    986450n 1.8
+    986499n 1.8
+    986500n 0
+    986549n 0
+    986550n 1.8
+    986599n 1.8
+    986600n 0
+    986649n 0
+    986650n 1.8
+    986699n 1.8
+    986700n 0
+    986749n 0
+    986750n 1.8
+    986799n 1.8
+    986800n 0
+    986849n 0
+    986850n 1.8
+    986899n 1.8
+    986900n 0
+    986949n 0
+    986950n 1.8
+    986999n 1.8
+    987000n 0
+    987049n 0
+    987050n 1.8
+    987099n 1.8
+    987100n 0
+    987149n 0
+    987150n 1.8
+    987199n 1.8
+    987200n 0
+    987249n 0
+    987250n 1.8
+    987299n 1.8
+    987300n 0
+    987349n 0
+    987350n 1.8
+    987399n 1.8
+    987400n 0
+    987449n 0
+    987450n 1.8
+    987499n 1.8
+    987500n 0
+    987549n 0
+    987550n 1.8
+    987599n 1.8
+    987600n 0
+    987649n 0
+    987650n 1.8
+    987699n 1.8
+    987700n 0
+    987749n 0
+    987750n 1.8
+    987799n 1.8
+    987800n 0
+    987849n 0
+    987850n 1.8
+    987899n 1.8
+    987900n 0
+    987949n 0
+    987950n 1.8
+    987999n 1.8
+    988000n 0
+    988049n 0
+    988050n 1.8
+    988099n 1.8
+    988100n 0
+    988149n 0
+    988150n 1.8
+    988199n 1.8
+    988200n 0
+    988249n 0
+    988250n 1.8
+    988299n 1.8
+    988300n 0
+    988349n 0
+    988350n 1.8
+    988399n 1.8
+    988400n 0
+    988449n 0
+    988450n 1.8
+    988499n 1.8
+    988500n 0
+    988549n 0
+    988550n 1.8
+    988599n 1.8
+    988600n 0
+    988649n 0
+    988650n 1.8
+    988699n 1.8
+    988700n 0
+    988749n 0
+    988750n 1.8
+    988799n 1.8
+    988800n 0
+    988849n 0
+    988850n 1.8
+    988899n 1.8
+    988900n 0
+    988949n 0
+    988950n 1.8
+    988999n 1.8
+    989000n 0
+    989049n 0
+    989050n 1.8
+    989099n 1.8
+    989100n 0
+    989149n 0
+    989150n 1.8
+    989199n 1.8
+    989200n 0
+    989249n 0
+    989250n 1.8
+    989299n 1.8
+    989300n 0
+    989349n 0
+    989350n 1.8
+    989399n 1.8
+    989400n 0
+    989449n 0
+    989450n 1.8
+    989499n 1.8
+    989500n 0
+    989549n 0
+    989550n 1.8
+    989599n 1.8
+    989600n 0
+    989649n 0
+    989650n 1.8
+    989699n 1.8
+    989700n 0
+    989749n 0
+    989750n 1.8
+    989799n 1.8
+    989800n 0
+    989849n 0
+    989850n 1.8
+    989899n 1.8
+    989900n 0
+    989949n 0
+    989950n 1.8
+    989999n 1.8
+    990000n 0
+    990049n 0
+    990050n 1.8
+    990099n 1.8
+    990100n 0
+    990149n 0
+    990150n 1.8
+    990199n 1.8
+    990200n 0
+    990249n 0
+    990250n 1.8
+    990299n 1.8
+    990300n 0
+    990349n 0
+    990350n 1.8
+    990399n 1.8
+    990400n 0
+    990449n 0
+    990450n 1.8
+    990499n 1.8
+    990500n 0
+    990549n 0
+    990550n 1.8
+    990599n 1.8
+    990600n 0
+    990649n 0
+    990650n 1.8
+    990699n 1.8
+    990700n 0
+    990749n 0
+    990750n 1.8
+    990799n 1.8
+    990800n 0
+    990849n 0
+    990850n 1.8
+    990899n 1.8
+    990900n 0
+    990949n 0
+    990950n 1.8
+    990999n 1.8
+    991000n 0
+    991049n 0
+    991050n 1.8
+    991099n 1.8
+    991100n 0
+    991149n 0
+    991150n 1.8
+    991199n 1.8
+    991200n 0
+    991249n 0
+    991250n 1.8
+    991299n 1.8
+    991300n 0
+    991349n 0
+    991350n 1.8
+    991399n 1.8
+    991400n 0
+    991449n 0
+    991450n 1.8
+    991499n 1.8
+    991500n 0
+    991549n 0
+    991550n 1.8
+    991599n 1.8
+    991600n 0
+    991649n 0
+    991650n 1.8
+    991699n 1.8
+    991700n 0
+    991749n 0
+    991750n 1.8
+    991799n 1.8
+    991800n 0
+    991849n 0
+    991850n 1.8
+    991899n 1.8
+    991900n 0
+    991949n 0
+    991950n 1.8
+    991999n 1.8
+    992000n 0
+    992049n 0
+    992050n 1.8
+    992099n 1.8
+    992100n 0
+    992149n 0
+    992150n 1.8
+    992199n 1.8
+    992200n 0
+    992249n 0
+    992250n 1.8
+    992299n 1.8
+    992300n 0
+    992349n 0
+    992350n 1.8
+    992399n 1.8
+    992400n 0
+    992449n 0
+    992450n 1.8
+    992499n 1.8
+    992500n 0
+    992549n 0
+    992550n 1.8
+    992599n 1.8
+    992600n 0
+    992649n 0
+    992650n 1.8
+    992699n 1.8
+    992700n 0
+    992749n 0
+    992750n 1.8
+    992799n 1.8
+    992800n 0
+    992849n 0
+    992850n 1.8
+    992899n 1.8
+    992900n 0
+    992949n 0
+    992950n 1.8
+    992999n 1.8
+    993000n 0
+    993049n 0
+    993050n 1.8
+    993099n 1.8
+    993100n 0
+    993149n 0
+    993150n 1.8
+    993199n 1.8
+    993200n 0
+    993249n 0
+    993250n 1.8
+    993299n 1.8
+    993300n 0
+    993349n 0
+    993350n 1.8
+    993399n 1.8
+    993400n 0
+    993449n 0
+    993450n 1.8
+    993499n 1.8
+    993500n 0
+    993549n 0
+    993550n 1.8
+    993599n 1.8
+    993600n 0
+    993649n 0
+    993650n 1.8
+    993699n 1.8
+    993700n 0
+    993749n 0
+    993750n 1.8
+    993799n 1.8
+    993800n 0
+    993849n 0
+    993850n 1.8
+    993899n 1.8
+    993900n 0
+    993949n 0
+    993950n 1.8
+    993999n 1.8
+    994000n 0
+    994049n 0
+    994050n 1.8
+    994099n 1.8
+    994100n 0
+    994149n 0
+    994150n 1.8
+    994199n 1.8
+    994200n 0
+    994249n 0
+    994250n 1.8
+    994299n 1.8
+    994300n 0
+    994349n 0
+    994350n 1.8
+    994399n 1.8
+    994400n 0
+    994449n 0
+    994450n 1.8
+    994499n 1.8
+    994500n 0
+    994549n 0
+    994550n 1.8
+    994599n 1.8
+    994600n 0
+    994649n 0
+    994650n 1.8
+    994699n 1.8
+    994700n 0
+    994749n 0
+    994750n 1.8
+    994799n 1.8
+    994800n 0
+    994849n 0
+    994850n 1.8
+    994899n 1.8
+    994900n 0
+    994949n 0
+    994950n 1.8
+    994999n 1.8
+    995000n 0
+    995049n 0
+    995050n 1.8
+    995099n 1.8
+    995100n 0
+    995149n 0
+    995150n 1.8
+    995199n 1.8
+    995200n 0
+    995249n 0
+    995250n 1.8
+    995299n 1.8
+    995300n 0
+    995349n 0
+    995350n 1.8
+    995399n 1.8
+    995400n 0
+    995449n 0
+    995450n 1.8
+    995499n 1.8
+    995500n 0
+    995549n 0
+    995550n 1.8
+    995599n 1.8
+    995600n 0
+    995649n 0
+    995650n 1.8
+    995699n 1.8
+    995700n 0
+    995749n 0
+    995750n 1.8
+    995799n 1.8
+    995800n 0
+    995849n 0
+    995850n 1.8
+    995899n 1.8
+    995900n 0
+    995949n 0
+    995950n 1.8
+    995999n 1.8
+    996000n 0
+    996049n 0
+    996050n 1.8
+    996099n 1.8
+    996100n 0
+    996149n 0
+    996150n 1.8
+    996199n 1.8
+    996200n 0
+    996249n 0
+    996250n 1.8
+    996299n 1.8
+    996300n 0
+    996349n 0
+    996350n 1.8
+    996399n 1.8
+    996400n 0
+    996449n 0
+    996450n 1.8
+    996499n 1.8
+    996500n 0
+    996549n 0
+    996550n 1.8
+    996599n 1.8
+    996600n 0
+    996649n 0
+    996650n 1.8
+    996699n 1.8
+    996700n 0
+    996749n 0
+    996750n 1.8
+    996799n 1.8
+    996800n 0
+    996849n 0
+    996850n 1.8
+    996899n 1.8
+    996900n 0
+    996949n 0
+    996950n 1.8
+    996999n 1.8
+    997000n 0
+    997049n 0
+    997050n 1.8
+    997099n 1.8
+    997100n 0
+    997149n 0
+    997150n 1.8
+    997199n 1.8
+    997200n 0
+    997249n 0
+    997250n 1.8
+    997299n 1.8
+    997300n 0
+    997349n 0
+    997350n 1.8
+    997399n 1.8
+    997400n 0
+    997449n 0
+    997450n 1.8
+    997499n 1.8
+    997500n 0
+    997549n 0
+    997550n 1.8
+    997599n 1.8
+    997600n 0
+    997649n 0
+    997650n 1.8
+    997699n 1.8
+    997700n 0
+    997749n 0
+    997750n 1.8
+    997799n 1.8
+    997800n 0
+    997849n 0
+    997850n 1.8
+    997899n 1.8
+    997900n 0
+    997949n 0
+    997950n 1.8
+    997999n 1.8
+    998000n 0
+    998049n 0
+    998050n 1.8
+    998099n 1.8
+    998100n 0
+    998149n 0
+    998150n 1.8
+    998199n 1.8
+    998200n 0
+    998249n 0
+    998250n 1.8
+    998299n 1.8
+    998300n 0
+    998349n 0
+    998350n 1.8
+    998399n 1.8
+    998400n 0
+    998449n 0
+    998450n 1.8
+    998499n 1.8
+    998500n 0
+    998549n 0
+    998550n 1.8
+    998599n 1.8
+    998600n 0
+    998649n 0
+    998650n 1.8
+    998699n 1.8
+    998700n 0
+    998749n 0
+    998750n 1.8
+    998799n 1.8
+    998800n 0
+    998849n 0
+    998850n 1.8
+    998899n 1.8
+    998900n 0
+    998949n 0
+    998950n 1.8
+    998999n 1.8
+    999000n 0
+    999049n 0
+    999050n 1.8
+    999099n 1.8
+    999100n 0
+    999149n 0
+    999150n 1.8
+    999199n 1.8
+    999200n 0
+    999249n 0
+    999250n 1.8
+    999299n 1.8
+    999300n 0
+    999349n 0
+    999350n 1.8
+    999399n 1.8
+    999400n 0
+    999449n 0
+    999450n 1.8
+    999499n 1.8
+    999500n 0
+    999549n 0
+    999550n 1.8
+    999599n 1.8
+    999600n 0
+    999649n 0
+    999650n 1.8
+    999699n 1.8
+    999700n 0
+    999749n 0
+    999750n 1.8
+    999799n 1.8
+    999800n 0
+    999849n 0
+    999850n 1.8
+    999899n 1.8
+    999900n 0
+    999949n 0
+    999950n 1.8
+    999999n 1.8
+    1000000n 0
+    1000049n 0
+    1000050n 1.8
+    1000099n 1.8
+    1000100n 0
+    1000149n 0
+    1000150n 1.8
+    1000199n 1.8
+    1000200n 0
+    1000249n 0
+    1000250n 1.8
+    1000299n 1.8
+    1000300n 0
+    1000349n 0
+    1000350n 1.8
+    1000399n 1.8
+    1000400n 0
+    1000449n 0
+    1000450n 1.8
+    1000499n 1.8
+    1000500n 0
+    1000549n 0
+    1000550n 1.8
+    1000599n 1.8
+    1000600n 0
+    1000649n 0
+    1000650n 1.8
+    1000699n 1.8
+    1000700n 0
+    1000749n 0
+    1000750n 1.8
+    1000799n 1.8
+    1000800n 0
+    1000849n 0
+    1000850n 1.8
+    1000899n 1.8
+    1000900n 0
+    1000949n 0
+    1000950n 1.8
+    1000999n 1.8
+    1001000n 0
+    1001049n 0
+    1001050n 1.8
+    1001099n 1.8
+    1001100n 0
+    1001149n 0
+    1001150n 1.8
+    1001199n 1.8
+    1001200n 0
+    1001249n 0
+    1001250n 1.8
+    1001299n 1.8
+    1001300n 0
+    1001349n 0
+    1001350n 1.8
+    1001399n 1.8
+    1001400n 0
+    1001449n 0
+    1001450n 1.8
+    1001499n 1.8
+    1001500n 0
+    1001549n 0
+    1001550n 1.8
+    1001599n 1.8
+    1001600n 0
+    1001649n 0
+    1001650n 1.8
+    1001699n 1.8
+    1001700n 0
+    1001749n 0
+    1001750n 1.8
+    1001799n 1.8
+    1001800n 0
+    1001849n 0
+    1001850n 1.8
+    1001899n 1.8
+    1001900n 0
+    1001949n 0
+    1001950n 1.8
+    1001999n 1.8
+    1002000n 0
+    1002049n 0
+    1002050n 1.8
+    1002099n 1.8
+    1002100n 0
+    1002149n 0
+    1002150n 1.8
+    1002199n 1.8
+    1002200n 0
+    1002249n 0
+    1002250n 1.8
+    1002299n 1.8
+    1002300n 0
+    1002349n 0
+    1002350n 1.8
+    1002399n 1.8
+    1002400n 0
+    1002449n 0
+    1002450n 1.8
+    1002499n 1.8
+    1002500n 0
+    1002549n 0
+    1002550n 1.8
+    1002599n 1.8
+    1002600n 0
+    1002649n 0
+    1002650n 1.8
+    1002699n 1.8
+    1002700n 0
+    1002749n 0
+    1002750n 1.8
+    1002799n 1.8
+    1002800n 0
+    1002849n 0
+    1002850n 1.8
+    1002899n 1.8
+    1002900n 0
+    1002949n 0
+    1002950n 1.8
+    1002999n 1.8
+    1003000n 0
+    1003049n 0
+    1003050n 1.8
+    1003099n 1.8
+    1003100n 0
+    1003149n 0
+    1003150n 1.8
+    1003199n 1.8
+    1003200n 0
+    1003249n 0
+    1003250n 1.8
+    1003299n 1.8
+    1003300n 0
+    1003349n 0
+    1003350n 1.8
+    1003399n 1.8
+    1003400n 0
+    1003449n 0
+    1003450n 1.8
+    1003499n 1.8
+    1003500n 0
+    1003549n 0
+    1003550n 1.8
+    1003599n 1.8
+    1003600n 0
+    1003649n 0
+    1003650n 1.8
+    1003699n 1.8
+    1003700n 0
+    1003749n 0
+    1003750n 1.8
+    1003799n 1.8
+    1003800n 0
+    1003849n 0
+    1003850n 1.8
+    1003899n 1.8
+    1003900n 0
+    1003949n 0
+    1003950n 1.8
+    1003999n 1.8
+    1004000n 0
+    1004049n 0
+    1004050n 1.8
+    1004099n 1.8
+    1004100n 0
+    1004149n 0
+    1004150n 1.8
+    1004199n 1.8
+    1004200n 0
+    1004249n 0
+    1004250n 1.8
+    1004299n 1.8
+    1004300n 0
+    1004349n 0
+    1004350n 1.8
+    1004399n 1.8
+    1004400n 0
+    1004449n 0
+    1004450n 1.8
+    1004499n 1.8
+    1004500n 0
+    1004549n 0
+    1004550n 1.8
+    1004599n 1.8
+    1004600n 0
+    1004649n 0
+    1004650n 1.8
+    1004699n 1.8
+    1004700n 0
+    1004749n 0
+    1004750n 1.8
+    1004799n 1.8
+    1004800n 0
+    1004849n 0
+    1004850n 1.8
+    1004899n 1.8
+    1004900n 0
+    1004949n 0
+    1004950n 1.8
+    1004999n 1.8
+    1005000n 0
+    1005049n 0
+    1005050n 1.8
+    1005099n 1.8
+    1005100n 0
+    1005149n 0
+    1005150n 1.8
+    1005199n 1.8
+    1005200n 0
+    1005249n 0
+    1005250n 1.8
+    1005299n 1.8
+    1005300n 0
+    1005349n 0
+    1005350n 1.8
+    1005399n 1.8
+    1005400n 0
+    1005449n 0
+    1005450n 1.8
+    1005499n 1.8
+    1005500n 0
+    1005549n 0
+    1005550n 1.8
+    1005599n 1.8
+    1005600n 0
+    1005649n 0
+    1005650n 1.8
+    1005699n 1.8
+    1005700n 0
+    1005749n 0
+    1005750n 1.8
+    1005799n 1.8
+    1005800n 0
+    1005849n 0
+    1005850n 1.8
+    1005899n 1.8
+    1005900n 0
+    1005949n 0
+    1005950n 1.8
+    1005999n 1.8
+    1006000n 0
+    1006049n 0
+    1006050n 1.8
+    1006099n 1.8
+    1006100n 0
+    1006149n 0
+    1006150n 1.8
+    1006199n 1.8
+    1006200n 0
+    1006249n 0
+    1006250n 1.8
+    1006299n 1.8
+    1006300n 0
+    1006349n 0
+    1006350n 1.8
+    1006399n 1.8
+    1006400n 0
+    1006449n 0
+    1006450n 1.8
+    1006499n 1.8
+    1006500n 0
+    1006549n 0
+    1006550n 1.8
+    1006599n 1.8
+    1006600n 0
+    1006649n 0
+    1006650n 1.8
+    1006699n 1.8
+    1006700n 0
+    1006749n 0
+    1006750n 1.8
+    1006799n 1.8
+    1006800n 0
+    1006849n 0
+    1006850n 1.8
+    1006899n 1.8
+    1006900n 0
+    1006949n 0
+    1006950n 1.8
+    1006999n 1.8
+    1007000n 0
+    1007049n 0
+    1007050n 1.8
+    1007099n 1.8
+    1007100n 0
+    1007149n 0
+    1007150n 1.8
+    1007199n 1.8
+    1007200n 0
+    1007249n 0
+    1007250n 1.8
+    1007299n 1.8
+    1007300n 0
+    1007349n 0
+    1007350n 1.8
+    1007399n 1.8
+    1007400n 0
+    1007449n 0
+    1007450n 1.8
+    1007499n 1.8
+    1007500n 0
+    1007549n 0
+    1007550n 1.8
+    1007599n 1.8
+    1007600n 0
+    1007649n 0
+    1007650n 1.8
+    1007699n 1.8
+    1007700n 0
+    1007749n 0
+    1007750n 1.8
+    1007799n 1.8
+    1007800n 0
+    1007849n 0
+    1007850n 1.8
+    1007899n 1.8
+    1007900n 0
+    1007949n 0
+    1007950n 1.8
+    1007999n 1.8
+    1008000n 0
+    1008049n 0
+    1008050n 1.8
+    1008099n 1.8
+    1008100n 0
+    1008149n 0
+    1008150n 1.8
+    1008199n 1.8
+    1008200n 0
+    1008249n 0
+    1008250n 1.8
+    1008299n 1.8
+    1008300n 0
+    1008349n 0
+    1008350n 1.8
+    1008399n 1.8
+    1008400n 0
+    1008449n 0
+    1008450n 1.8
+    1008499n 1.8
+    1008500n 0
+    1008549n 0
+    1008550n 1.8
+    1008599n 1.8
+    1008600n 0
+    1008649n 0
+    1008650n 1.8
+    1008699n 1.8
+    1008700n 0
+    1008749n 0
+    1008750n 1.8
+    1008799n 1.8
+    1008800n 0
+    1008849n 0
+    1008850n 1.8
+    1008899n 1.8
+    1008900n 0
+    1008949n 0
+    1008950n 1.8
+    1008999n 1.8
+    1009000n 0
+    1009049n 0
+    1009050n 1.8
+    1009099n 1.8
+    1009100n 0
+    1009149n 0
+    1009150n 1.8
+    1009199n 1.8
+    1009200n 0
+    1009249n 0
+    1009250n 1.8
+    1009299n 1.8
+    1009300n 0
+    1009349n 0
+    1009350n 1.8
+    1009399n 1.8
+    1009400n 0
+    1009449n 0
+    1009450n 1.8
+    1009499n 1.8
+    1009500n 0
+    1009549n 0
+    1009550n 1.8
+    1009599n 1.8
+    1009600n 0
+    1009649n 0
+    1009650n 1.8
+    1009699n 1.8
+    1009700n 0
+    1009749n 0
+    1009750n 1.8
+    1009799n 1.8
+    1009800n 0
+    1009849n 0
+    1009850n 1.8
+    1009899n 1.8
+    1009900n 0
+    1009949n 0
+    1009950n 1.8
+    1009999n 1.8
+    1010000n 0
+    1010049n 0
+    1010050n 1.8
+    1010099n 1.8
+    1010100n 0
+    1010149n 0
+    1010150n 1.8
+    1010199n 1.8
+    1010200n 0
+    1010249n 0
+    1010250n 1.8
+    1010299n 1.8
+    1010300n 0
+    1010349n 0
+    1010350n 1.8
+    1010399n 1.8
+    1010400n 0
+    1010449n 0
+    1010450n 1.8
+    1010499n 1.8
+    1010500n 0
+    1010549n 0
+    1010550n 1.8
+    1010599n 1.8
+    1010600n 0
+    1010649n 0
+    1010650n 1.8
+    1010699n 1.8
+    1010700n 0
+    1010749n 0
+    1010750n 1.8
+    1010799n 1.8
+    1010800n 0
+    1010849n 0
+    1010850n 1.8
+    1010899n 1.8
+    1010900n 0
+    1010949n 0
+    1010950n 1.8
+    1010999n 1.8
+    1011000n 0
+    1011049n 0
+    1011050n 1.8
+    1011099n 1.8
+    1011100n 0
+    1011149n 0
+    1011150n 1.8
+    1011199n 1.8
+    1011200n 0
+    1011249n 0
+    1011250n 1.8
+    1011299n 1.8
+    1011300n 0
+    1011349n 0
+    1011350n 1.8
+    1011399n 1.8
+    1011400n 0
+    1011449n 0
+    1011450n 1.8
+    1011499n 1.8
+    1011500n 0
+    1011549n 0
+    1011550n 1.8
+    1011599n 1.8
+    1011600n 0
+    1011649n 0
+    1011650n 1.8
+    1011699n 1.8
+    1011700n 0
+    1011749n 0
+    1011750n 1.8
+    1011799n 1.8
+    1011800n 0
+    1011849n 0
+    1011850n 1.8
+    1011899n 1.8
+    1011900n 0
+    1011949n 0
+    1011950n 1.8
+    1011999n 1.8
+    1012000n 0
+    1012049n 0
+    1012050n 1.8
+    1012099n 1.8
+    1012100n 0
+    1012149n 0
+    1012150n 1.8
+    1012199n 1.8
+    1012200n 0
+    1012249n 0
+    1012250n 1.8
+    1012299n 1.8
+    1012300n 0
+    1012349n 0
+    1012350n 1.8
+    1012399n 1.8
+    1012400n 0
+    1012449n 0
+    1012450n 1.8
+    1012499n 1.8
+    1012500n 0
+    1012549n 0
+    1012550n 1.8
+    1012599n 1.8
+    1012600n 0
+    1012649n 0
+    1012650n 1.8
+    1012699n 1.8
+    1012700n 0
+    1012749n 0
+    1012750n 1.8
+    1012799n 1.8
+    1012800n 0
+    1012849n 0
+    1012850n 1.8
+    1012899n 1.8
+    1012900n 0
+    1012949n 0
+    1012950n 1.8
+    1012999n 1.8
+    1013000n 0
+    1013049n 0
+    1013050n 1.8
+    1013099n 1.8
+    1013100n 0
+    1013149n 0
+    1013150n 1.8
+    1013199n 1.8
+    1013200n 0
+    1013249n 0
+    1013250n 1.8
+    1013299n 1.8
+    1013300n 0
+    1013349n 0
+    1013350n 1.8
+    1013399n 1.8
+    1013400n 0
+    1013449n 0
+    1013450n 1.8
+    1013499n 1.8
+    1013500n 0
+    1013549n 0
+    1013550n 1.8
+    1013599n 1.8
+    1013600n 0
+    1013649n 0
+    1013650n 1.8
+    1013699n 1.8
+    1013700n 0
+    1013749n 0
+    1013750n 1.8
+    1013799n 1.8
+    1013800n 0
+    1013849n 0
+    1013850n 1.8
+    1013899n 1.8
+    1013900n 0
+    1013949n 0
+    1013950n 1.8
+    1013999n 1.8
+    1014000n 0
+    1014049n 0
+    1014050n 1.8
+    1014099n 1.8
+    1014100n 0
+    1014149n 0
+    1014150n 1.8
+    1014199n 1.8
+    1014200n 0
+    1014249n 0
+    1014250n 1.8
+    1014299n 1.8
+    1014300n 0
+    1014349n 0
+    1014350n 1.8
+    1014399n 1.8
+    1014400n 0
+    1014449n 0
+    1014450n 1.8
+    1014499n 1.8
+    1014500n 0
+    1014549n 0
+    1014550n 1.8
+    1014599n 1.8
+    1014600n 0
+    1014649n 0
+    1014650n 1.8
+    1014699n 1.8
+    1014700n 0
+    1014749n 0
+    1014750n 1.8
+    1014799n 1.8
+    1014800n 0
+    1014849n 0
+    1014850n 1.8
+    1014899n 1.8
+    1014900n 0
+    1014949n 0
+    1014950n 1.8
+    1014999n 1.8
+    1015000n 0
+    1015049n 0
+    1015050n 1.8
+    1015099n 1.8
+    1015100n 0
+    1015149n 0
+    1015150n 1.8
+    1015199n 1.8
+    1015200n 0
+    1015249n 0
+    1015250n 1.8
+    1015299n 1.8
+    1015300n 0
+    1015349n 0
+    1015350n 1.8
+    1015399n 1.8
+    1015400n 0
+    1015449n 0
+    1015450n 1.8
+    1015499n 1.8
+    1015500n 0
+    1015549n 0
+    1015550n 1.8
+    1015599n 1.8
+    1015600n 0
+    1015649n 0
+    1015650n 1.8
+    1015699n 1.8
+    1015700n 0
+    1015749n 0
+    1015750n 1.8
+    1015799n 1.8
+    1015800n 0
+    1015849n 0
+    1015850n 1.8
+    1015899n 1.8
+    1015900n 0
+    1015949n 0
+    1015950n 1.8
+    1015999n 1.8
+    1016000n 0
+    1016049n 0
+    1016050n 1.8
+    1016099n 1.8
+    1016100n 0
+    1016149n 0
+    1016150n 1.8
+    1016199n 1.8
+    1016200n 0
+    1016249n 0
+    1016250n 1.8
+    1016299n 1.8
+    1016300n 0
+    1016349n 0
+    1016350n 1.8
+    1016399n 1.8
+    1016400n 0
+    1016449n 0
+    1016450n 1.8
+    1016499n 1.8
+    1016500n 0
+    1016549n 0
+    1016550n 1.8
+    1016599n 1.8
+    1016600n 0
+    1016649n 0
+    1016650n 1.8
+    1016699n 1.8
+    1016700n 0
+    1016749n 0
+    1016750n 1.8
+    1016799n 1.8
+    1016800n 0
+    1016849n 0
+    1016850n 1.8
+    1016899n 1.8
+    1016900n 0
+    1016949n 0
+    1016950n 1.8
+    1016999n 1.8
+    1017000n 0
+    1017049n 0
+    1017050n 1.8
+    1017099n 1.8
+    1017100n 0
+    1017149n 0
+    1017150n 1.8
+    1017199n 1.8
+    1017200n 0
+    1017249n 0
+    1017250n 1.8
+    1017299n 1.8
+    1017300n 0
+    1017349n 0
+    1017350n 1.8
+    1017399n 1.8
+    1017400n 0
+    1017449n 0
+    1017450n 1.8
+    1017499n 1.8
+    1017500n 0
+    1017549n 0
+    1017550n 1.8
+    1017599n 1.8
+    1017600n 0
+    1017649n 0
+    1017650n 1.8
+    1017699n 1.8
+    1017700n 0
+    1017749n 0
+    1017750n 1.8
+    1017799n 1.8
+    1017800n 0
+    1017849n 0
+    1017850n 1.8
+    1017899n 1.8
+    1017900n 0
+    1017949n 0
+    1017950n 1.8
+    1017999n 1.8
+    1018000n 0
+    1018049n 0
+    1018050n 1.8
+    1018099n 1.8
+    1018100n 0
+    1018149n 0
+    1018150n 1.8
+    1018199n 1.8
+    1018200n 0
+    1018249n 0
+    1018250n 1.8
+    1018299n 1.8
+    1018300n 0
+    1018349n 0
+    1018350n 1.8
+    1018399n 1.8
+    1018400n 0
+    1018449n 0
+    1018450n 1.8
+    1018499n 1.8
+    1018500n 0
+    1018549n 0
+    1018550n 1.8
+    1018599n 1.8
+    1018600n 0
+    1018649n 0
+    1018650n 1.8
+    1018699n 1.8
+    1018700n 0
+    1018749n 0
+    1018750n 1.8
+    1018799n 1.8
+    1018800n 0
+    1018849n 0
+    1018850n 1.8
+    1018899n 1.8
+    1018900n 0
+    1018949n 0
+    1018950n 1.8
+    1018999n 1.8
+    1019000n 0
+    1019049n 0
+    1019050n 1.8
+    1019099n 1.8
+    1019100n 0
+    1019149n 0
+    1019150n 1.8
+    1019199n 1.8
+    1019200n 0
+    1019249n 0
+    1019250n 1.8
+    1019299n 1.8
+    1019300n 0
+    1019349n 0
+    1019350n 1.8
+    1019399n 1.8
+    1019400n 0
+    1019449n 0
+    1019450n 1.8
+    1019499n 1.8
+    1019500n 0
+    1019549n 0
+    1019550n 1.8
+    1019599n 1.8
+    1019600n 0
+    1019649n 0
+    1019650n 1.8
+    1019699n 1.8
+    1019700n 0
+    1019749n 0
+    1019750n 1.8
+    1019799n 1.8
+    1019800n 0
+    1019849n 0
+    1019850n 1.8
+    1019899n 1.8
+    1019900n 0
+    1019949n 0
+    1019950n 1.8
+    1019999n 1.8
+    1020000n 0
+    1020049n 0
+    1020050n 1.8
+    1020099n 1.8
+    1020100n 0
+    1020149n 0
+    1020150n 1.8
+    1020199n 1.8
+    1020200n 0
+    1020249n 0
+    1020250n 1.8
+    1020299n 1.8
+    1020300n 0
+    1020349n 0
+    1020350n 1.8
+    1020399n 1.8
+    1020400n 0
+    1020449n 0
+    1020450n 1.8
+    1020499n 1.8
+    1020500n 0
+    1020549n 0
+    1020550n 1.8
+    1020599n 1.8
+    1020600n 0
+    1020649n 0
+    1020650n 1.8
+    1020699n 1.8
+    1020700n 0
+    1020749n 0
+    1020750n 1.8
+    1020799n 1.8
+    1020800n 0
+    1020849n 0
+    1020850n 1.8
+    1020899n 1.8
+    1020900n 0
+    1020949n 0
+    1020950n 1.8
+    1020999n 1.8
+    1021000n 0
+    1021049n 0
+    1021050n 1.8
+    1021099n 1.8
+    1021100n 0
+    1021149n 0
+    1021150n 1.8
+    1021199n 1.8
+    1021200n 0
+    1021249n 0
+    1021250n 1.8
+    1021299n 1.8
+    1021300n 0
+    1021349n 0
+    1021350n 1.8
+    1021399n 1.8
+    1021400n 0
+    1021449n 0
+    1021450n 1.8
+    1021499n 1.8
+    1021500n 0
+    1021549n 0
+    1021550n 1.8
+    1021599n 1.8
+    1021600n 0
+    1021649n 0
+    1021650n 1.8
+    1021699n 1.8
+    1021700n 0
+    1021749n 0
+    1021750n 1.8
+    1021799n 1.8
+    1021800n 0
+    1021849n 0
+    1021850n 1.8
+    1021899n 1.8
+    1021900n 0
+    1021949n 0
+    1021950n 1.8
+    1021999n 1.8
+    1022000n 0
+    1022049n 0
+    1022050n 1.8
+    1022099n 1.8
+    1022100n 0
+    1022149n 0
+    1022150n 1.8
+    1022199n 1.8
+    1022200n 0
+    1022249n 0
+    1022250n 1.8
+    1022299n 1.8
+    1022300n 0
+    1022349n 0
+    1022350n 1.8
+    1022399n 1.8
+    1022400n 0
+    1022449n 0
+    1022450n 1.8
+    1022499n 1.8
+    1022500n 0
+    1022549n 0
+    1022550n 1.8
+    1022599n 1.8
+    1022600n 0
+    1022649n 0
+    1022650n 1.8
+    1022699n 1.8
+    1022700n 0
+    1022749n 0
+    1022750n 1.8
+    1022799n 1.8
+    1022800n 0
+    1022849n 0
+    1022850n 1.8
+    1022899n 1.8
+    1022900n 0
+    1022949n 0
+    1022950n 1.8
+    1022999n 1.8
+    1023000n 0
+    1023049n 0
+    1023050n 1.8
+    1023099n 1.8
+    1023100n 0
+    1023149n 0
+    1023150n 1.8
+    1023199n 1.8
+    1023200n 0
+    1023249n 0
+    1023250n 1.8
+    1023299n 1.8
+    1023300n 0
+    1023349n 0
+    1023350n 1.8
+    1023399n 1.8
+    1023400n 0
+    1023449n 0
+    1023450n 1.8
+    1023499n 1.8
+    1023500n 0
+    1023549n 0
+    1023550n 1.8
+    1023599n 1.8
+    1023600n 0
+    1023649n 0
+    1023650n 1.8
+    1023699n 1.8
+    1023700n 0
+    1023749n 0
+    1023750n 1.8
+    1023799n 1.8
+    1023800n 0
+    1023849n 0
+    1023850n 1.8
+    1023899n 1.8
+    1023900n 0
+    1023949n 0
+    1023950n 1.8
+    1023999n 1.8
+    1024000n 0
+    1024049n 0
+    1024050n 1.8
+    1024099n 1.8
+    1024100n 0
+    1024149n 0
+    1024150n 1.8
+    1024199n 1.8
+    1024200n 0
+    1024249n 0
+    1024250n 1.8
+    1024299n 1.8
+    1024300n 0
+    1024349n 0
+    1024350n 1.8
+    1024399n 1.8
+    1024400n 0
+    1024449n 0
+    1024450n 1.8
+    1024499n 1.8
+    1024500n 0
+    1024549n 0
+    1024550n 1.8
+    1024599n 1.8
+    1024600n 0
+    1024649n 0
+    1024650n 1.8
+    1024699n 1.8
+    1024700n 0
+    1024749n 0
+    1024750n 1.8
+    1024799n 1.8
+    1024800n 0
+    1024849n 0
+    1024850n 1.8
+    1024899n 1.8
+    1024900n 0
+    1024949n 0
+    1024950n 1.8
+    1024999n 1.8
+    1025000n 0
+    1025049n 0
+    1025050n 1.8
+    1025099n 1.8
+    1025100n 0
+    1025149n 0
+    1025150n 1.8
+    1025199n 1.8
+    1025200n 0
+    1025249n 0
+    1025250n 1.8
+    1025299n 1.8
+    1025300n 0
+    1025349n 0
+    1025350n 1.8
+    1025399n 1.8
+    1025400n 0
+    1025449n 0
+    1025450n 1.8
+    1025499n 1.8
+    1025500n 0
+    1025549n 0
+    1025550n 1.8
+    1025599n 1.8
+    1025600n 0
+    1025649n 0
+    1025650n 1.8
+    1025699n 1.8
+    1025700n 0
+    1025749n 0
+    1025750n 1.8
+    1025799n 1.8
+    1025800n 0
+    1025849n 0
+    1025850n 1.8
+    1025899n 1.8
+    1025900n 0
+    1025949n 0
+    1025950n 1.8
+    1025999n 1.8
+    1026000n 0
+    1026049n 0
+    1026050n 1.8
+    1026099n 1.8
+    1026100n 0
+    1026149n 0
+    1026150n 1.8
+    1026199n 1.8
+    1026200n 0
+    1026249n 0
+    1026250n 1.8
+    1026299n 1.8
+    1026300n 0
+    1026349n 0
+    1026350n 1.8
+    1026399n 1.8
+    1026400n 0
+    1026449n 0
+    1026450n 1.8
+    1026499n 1.8
+    1026500n 0
+    1026549n 0
+    1026550n 1.8
+    1026599n 1.8
+    1026600n 0
+    1026649n 0
+    1026650n 1.8
+    1026699n 1.8
+    1026700n 0
+    1026749n 0
+    1026750n 1.8
+    1026799n 1.8
+    1026800n 0
+    1026849n 0
+    1026850n 1.8
+    1026899n 1.8
+    1026900n 0
+    1026949n 0
+    1026950n 1.8
+    1026999n 1.8
+    1027000n 0
+    1027049n 0
+    1027050n 1.8
+    1027099n 1.8
+    1027100n 0
+    1027149n 0
+    1027150n 1.8
+    1027199n 1.8
+    1027200n 0
+    1027249n 0
+    1027250n 1.8
+    1027299n 1.8
+    1027300n 0
+    1027349n 0
+    1027350n 1.8
+    1027399n 1.8
+    1027400n 0
+    1027449n 0
+    1027450n 1.8
+    1027499n 1.8
+    1027500n 0
+    1027549n 0
+    1027550n 1.8
+    1027599n 1.8
+    1027600n 0
+    1027649n 0
+    1027650n 1.8
+    1027699n 1.8
+    1027700n 0
+    1027749n 0
+    1027750n 1.8
+    1027799n 1.8
+    1027800n 0
+    1027849n 0
+    1027850n 1.8
+    1027899n 1.8
+    1027900n 0
+    1027949n 0
+    1027950n 1.8
+    1027999n 1.8
+    1028000n 0
+    1028049n 0
+    1028050n 1.8
+    1028099n 1.8
+    1028100n 0
+    1028149n 0
+    1028150n 1.8
+    1028199n 1.8
+    1028200n 0
+    1028249n 0
+    1028250n 1.8
+    1028299n 1.8
+    1028300n 0
+    1028349n 0
+    1028350n 1.8
+    1028399n 1.8
+    1028400n 0
+    1028449n 0
+    1028450n 1.8
+    1028499n 1.8
+    1028500n 0
+    1028549n 0
+    1028550n 1.8
+    1028599n 1.8
+    1028600n 0
+    1028649n 0
+    1028650n 1.8
+    1028699n 1.8
+    1028700n 0
+    1028749n 0
+    1028750n 1.8
+    1028799n 1.8
+    1028800n 0
+    1028849n 0
+    1028850n 1.8
+    1028899n 1.8
+    1028900n 0
+    1028949n 0
+    1028950n 1.8
+    1028999n 1.8
+    1029000n 0
+    1029049n 0
+    1029050n 1.8
+    1029099n 1.8
+    1029100n 0
+    1029149n 0
+    1029150n 1.8
+    1029199n 1.8
+    1029200n 0
+    1029249n 0
+    1029250n 1.8
+    1029299n 1.8
+    1029300n 0
+    1029349n 0
+    1029350n 1.8
+    1029399n 1.8
+    1029400n 0
+    1029449n 0
+    1029450n 1.8
+    1029499n 1.8
+    1029500n 0
+    1029549n 0
+    1029550n 1.8
+    1029599n 1.8
+    1029600n 0
+    1029649n 0
+    1029650n 1.8
+    1029699n 1.8
+    1029700n 0
+    1029749n 0
+    1029750n 1.8
+    1029799n 1.8
+    1029800n 0
+    1029849n 0
+    1029850n 1.8
+    1029899n 1.8
+    1029900n 0
+    1029949n 0
+    1029950n 1.8
+    1029999n 1.8
+    1030000n 0
+    1030049n 0
+    1030050n 1.8
+    1030099n 1.8
+    1030100n 0
+    1030149n 0
+    1030150n 1.8
+    1030199n 1.8
+    1030200n 0
+    1030249n 0
+    1030250n 1.8
+    1030299n 1.8
+    1030300n 0
+    1030349n 0
+    1030350n 1.8
+    1030399n 1.8
+    1030400n 0
+    1030449n 0
+    1030450n 1.8
+    1030499n 1.8
+    1030500n 0
+    1030549n 0
+    1030550n 1.8
+    1030599n 1.8
+    1030600n 0
+    1030649n 0
+    1030650n 1.8
+    1030699n 1.8
+    1030700n 0
+    1030749n 0
+    1030750n 1.8
+    1030799n 1.8
+    1030800n 0
+    1030849n 0
+    1030850n 1.8
+    1030899n 1.8
+    1030900n 0
+    1030949n 0
+    1030950n 1.8
+    1030999n 1.8
+    1031000n 0
+    1031049n 0
+    1031050n 1.8
+    1031099n 1.8
+    1031100n 0
+    1031149n 0
+    1031150n 1.8
+    1031199n 1.8
+    1031200n 0
+    1031249n 0
+    1031250n 1.8
+    1031299n 1.8
+    1031300n 0
+    1031349n 0
+    1031350n 1.8
+    1031399n 1.8
+    1031400n 0
+    1031449n 0
+    1031450n 1.8
+    1031499n 1.8
+    1031500n 0
+    1031549n 0
+    1031550n 1.8
+    1031599n 1.8
+    1031600n 0
+    1031649n 0
+    1031650n 1.8
+    1031699n 1.8
+    1031700n 0
+    1031749n 0
+    1031750n 1.8
+    1031799n 1.8
+    1031800n 0
+    1031849n 0
+    1031850n 1.8
+    1031899n 1.8
+    1031900n 0
+    1031949n 0
+    1031950n 1.8
+    1031999n 1.8
+    1032000n 0
+    1032049n 0
+    1032050n 1.8
+    1032099n 1.8
+    1032100n 0
+    1032149n 0
+    1032150n 1.8
+    1032199n 1.8
+    1032200n 0
+    1032249n 0
+    1032250n 1.8
+    1032299n 1.8
+    1032300n 0
+    1032349n 0
+    1032350n 1.8
+    1032399n 1.8
+    1032400n 0
+    1032449n 0
+    1032450n 1.8
+    1032499n 1.8
+    1032500n 0
+    1032549n 0
+    1032550n 1.8
+    1032599n 1.8
+    1032600n 0
+    1032649n 0
+    1032650n 1.8
+    1032699n 1.8
+    1032700n 0
+    1032749n 0
+    1032750n 1.8
+    1032799n 1.8
+    1032800n 0
+    1032849n 0
+    1032850n 1.8
+    1032899n 1.8
+    1032900n 0
+    1032949n 0
+    1032950n 1.8
+    1032999n 1.8
+    1033000n 0
+    1033049n 0
+    1033050n 1.8
+    1033099n 1.8
+    1033100n 0
+    1033149n 0
+    1033150n 1.8
+    1033199n 1.8
+    1033200n 0
+    1033249n 0
+    1033250n 1.8
+    1033299n 1.8
+    1033300n 0
+    1033349n 0
+    1033350n 1.8
+    1033399n 1.8
+    1033400n 0
+    1033449n 0
+    1033450n 1.8
+    1033499n 1.8
+    1033500n 0
+    1033549n 0
+    1033550n 1.8
+    1033599n 1.8
+    1033600n 0
+    1033649n 0
+    1033650n 1.8
+    1033699n 1.8
+    1033700n 0
+    1033749n 0
+    1033750n 1.8
+    1033799n 1.8
+    1033800n 0
+    1033849n 0
+    1033850n 1.8
+    1033899n 1.8
+    1033900n 0
+    1033949n 0
+    1033950n 1.8
+    1033999n 1.8
+    1034000n 0
+    1034049n 0
+    1034050n 1.8
+    1034099n 1.8
+    1034100n 0
+    1034149n 0
+    1034150n 1.8
+    1034199n 1.8
+    1034200n 0
+    1034249n 0
+    1034250n 1.8
+    1034299n 1.8
+    1034300n 0
+    1034349n 0
+    1034350n 1.8
+    1034399n 1.8
+    1034400n 0
+    1034449n 0
+    1034450n 1.8
+    1034499n 1.8
+    1034500n 0
+    1034549n 0
+    1034550n 1.8
+    1034599n 1.8
+    1034600n 0
+    1034649n 0
+    1034650n 1.8
+    1034699n 1.8
+    1034700n 0
+    1034749n 0
+    1034750n 1.8
+    1034799n 1.8
+    1034800n 0
+    1034849n 0
+    1034850n 1.8
+    1034899n 1.8
+    1034900n 0
+    1034949n 0
+    1034950n 1.8
+    1034999n 1.8
+    1035000n 0
+    1035049n 0
+    1035050n 1.8
+    1035099n 1.8
+    1035100n 0
+    1035149n 0
+    1035150n 1.8
+    1035199n 1.8
+    1035200n 0
+    1035249n 0
+    1035250n 1.8
+    1035299n 1.8
+    1035300n 0
+    1035349n 0
+    1035350n 1.8
+    1035399n 1.8
+    1035400n 0
+    1035449n 0
+    1035450n 1.8
+    1035499n 1.8
+    1035500n 0
+    1035549n 0
+    1035550n 1.8
+    1035599n 1.8
+    1035600n 0
+    1035649n 0
+    1035650n 1.8
+    1035699n 1.8
+    1035700n 0
+    1035749n 0
+    1035750n 1.8
+    1035799n 1.8
+    1035800n 0
+    1035849n 0
+    1035850n 1.8
+    1035899n 1.8
+    1035900n 0
+    1035949n 0
+    1035950n 1.8
+    1035999n 1.8
+    1036000n 0
+    1036049n 0
+    1036050n 1.8
+    1036099n 1.8
+    1036100n 0
+    1036149n 0
+    1036150n 1.8
+    1036199n 1.8
+    1036200n 0
+    1036249n 0
+    1036250n 1.8
+    1036299n 1.8
+    1036300n 0
+    1036349n 0
+    1036350n 1.8
+    1036399n 1.8
+    1036400n 0
+    1036449n 0
+    1036450n 1.8
+    1036499n 1.8
+    1036500n 0
+    1036549n 0
+    1036550n 1.8
+    1036599n 1.8
+    1036600n 0
+    1036649n 0
+    1036650n 1.8
+    1036699n 1.8
+    1036700n 0
+    1036749n 0
+    1036750n 1.8
+    1036799n 1.8
+    1036800n 0
+    1036849n 0
+    1036850n 1.8
+    1036899n 1.8
+    1036900n 0
+    1036949n 0
+    1036950n 1.8
+    1036999n 1.8
+    1037000n 0
+    1037049n 0
+    1037050n 1.8
+    1037099n 1.8
+    1037100n 0
+    1037149n 0
+    1037150n 1.8
+    1037199n 1.8
+    1037200n 0
+    1037249n 0
+    1037250n 1.8
+    1037299n 1.8
+    1037300n 0
+    1037349n 0
+    1037350n 1.8
+    1037399n 1.8
+    1037400n 0
+    1037449n 0
+    1037450n 1.8
+    1037499n 1.8
+    1037500n 0
+    1037549n 0
+    1037550n 1.8
+    1037599n 1.8
+    1037600n 0
+    1037649n 0
+    1037650n 1.8
+    1037699n 1.8
+    1037700n 0
+    1037749n 0
+    1037750n 1.8
+    1037799n 1.8
+    1037800n 0
+    1037849n 0
+    1037850n 1.8
+    1037899n 1.8
+    1037900n 0
+    1037949n 0
+    1037950n 1.8
+    1037999n 1.8
+    1038000n 0
+    1038049n 0
+    1038050n 1.8
+    1038099n 1.8
+    1038100n 0
+    1038149n 0
+    1038150n 1.8
+    1038199n 1.8
+    1038200n 0
+    1038249n 0
+    1038250n 1.8
+    1038299n 1.8
+    1038300n 0
+    1038349n 0
+    1038350n 1.8
+    1038399n 1.8
+    1038400n 0
+    1038449n 0
+    1038450n 1.8
+    1038499n 1.8
+    1038500n 0
+    1038549n 0
+    1038550n 1.8
+    1038599n 1.8
+    1038600n 0
+    1038649n 0
+    1038650n 1.8
+    1038699n 1.8
+    1038700n 0
+    1038749n 0
+    1038750n 1.8
+    1038799n 1.8
+    1038800n 0
+    1038849n 0
+    1038850n 1.8
+    1038899n 1.8
+    1038900n 0
+    1038949n 0
+    1038950n 1.8
+    1038999n 1.8
+    1039000n 0
+    1039049n 0
+    1039050n 1.8
+    1039099n 1.8
+    1039100n 0
+    1039149n 0
+    1039150n 1.8
+    1039199n 1.8
+    1039200n 0
+    1039249n 0
+    1039250n 1.8
+    1039299n 1.8
+    1039300n 0
+    1039349n 0
+    1039350n 1.8
+    1039399n 1.8
+    1039400n 0
+    1039449n 0
+    1039450n 1.8
+    1039499n 1.8
+    1039500n 0
+    1039549n 0
+    1039550n 1.8
+    1039599n 1.8
+    1039600n 0
+    1039649n 0
+    1039650n 1.8
+    1039699n 1.8
+    1039700n 0
+    1039749n 0
+    1039750n 1.8
+    1039799n 1.8
+    1039800n 0
+    1039849n 0
+    1039850n 1.8
+    1039899n 1.8
+    1039900n 0
+    1039949n 0
+    1039950n 1.8
+    1039999n 1.8
+    1040000n 0
+    1040049n 0
+    1040050n 1.8
+    1040099n 1.8
+    1040100n 0
+    1040149n 0
+    1040150n 1.8
+    1040199n 1.8
+    1040200n 0
+    1040249n 0
+    1040250n 1.8
+    1040299n 1.8
+    1040300n 0
+    1040349n 0
+    1040350n 1.8
+    1040399n 1.8
+    1040400n 0
+    1040449n 0
+    1040450n 1.8
+    1040499n 1.8
+    1040500n 0
+    1040549n 0
+    1040550n 1.8
+    1040599n 1.8
+    1040600n 0
+    1040649n 0
+    1040650n 1.8
+    1040699n 1.8
+    1040700n 0
+    1040749n 0
+    1040750n 1.8
+    1040799n 1.8
+    1040800n 0
+    1040849n 0
+    1040850n 1.8
+    1040899n 1.8
+    1040900n 0
+    1040949n 0
+    1040950n 1.8
+    1040999n 1.8
+    1041000n 0
+    1041049n 0
+    1041050n 1.8
+    1041099n 1.8
+    1041100n 0
+    1041149n 0
+    1041150n 1.8
+    1041199n 1.8
+    1041200n 0
+    1041249n 0
+    1041250n 1.8
+    1041299n 1.8
+    1041300n 0
+    1041349n 0
+    1041350n 1.8
+    1041399n 1.8
+    1041400n 0
+    1041449n 0
+    1041450n 1.8
+    1041499n 1.8
+    1041500n 0
+    1041549n 0
+    1041550n 1.8
+    1041599n 1.8
+    1041600n 0
+    1041649n 0
+    1041650n 1.8
+    1041699n 1.8
+    1041700n 0
+    1041749n 0
+    1041750n 1.8
+    1041799n 1.8
+    1041800n 0
+    1041849n 0
+    1041850n 1.8
+    1041899n 1.8
+    1041900n 0
+    1041949n 0
+    1041950n 1.8
+    1041999n 1.8
+    1042000n 0
+    1042049n 0
+    1042050n 1.8
+    1042099n 1.8
+    1042100n 0
+    1042149n 0
+    1042150n 1.8
+    1042199n 1.8
+    1042200n 0
+    1042249n 0
+    1042250n 1.8
+    1042299n 1.8
+    1042300n 0
+    1042349n 0
+    1042350n 1.8
+    1042399n 1.8
+    1042400n 0
+    1042449n 0
+    1042450n 1.8
+    1042499n 1.8
+    1042500n 0
+    1042549n 0
+    1042550n 1.8
+    1042599n 1.8
+    1042600n 0
+    1042649n 0
+    1042650n 1.8
+    1042699n 1.8
+    1042700n 0
+    1042749n 0
+    1042750n 1.8
+    1042799n 1.8
+    1042800n 0
+    1042849n 0
+    1042850n 1.8
+    1042899n 1.8
+    1042900n 0
+    1042949n 0
+    1042950n 1.8
+    1042999n 1.8
+    1043000n 0
+    1043049n 0
+    1043050n 1.8
+    1043099n 1.8
+    1043100n 0
+    1043149n 0
+    1043150n 1.8
+    1043199n 1.8
+    1043200n 0
+    1043249n 0
+    1043250n 1.8
+    1043299n 1.8
+    1043300n 0
+    1043349n 0
+    1043350n 1.8
+    1043399n 1.8
+    1043400n 0
+    1043449n 0
+    1043450n 1.8
+    1043499n 1.8
+    1043500n 0
+    1043549n 0
+    1043550n 1.8
+    1043599n 1.8
+    1043600n 0
+    1043649n 0
+    1043650n 1.8
+    1043699n 1.8
+    1043700n 0
+    1043749n 0
+    1043750n 1.8
+    1043799n 1.8
+    1043800n 0
+    1043849n 0
+    1043850n 1.8
+    1043899n 1.8
+    1043900n 0
+    1043949n 0
+    1043950n 1.8
+    1043999n 1.8
+    1044000n 0
+    1044049n 0
+    1044050n 1.8
+    1044099n 1.8
+    1044100n 0
+    1044149n 0
+    1044150n 1.8
+    1044199n 1.8
+    1044200n 0
+    1044249n 0
+    1044250n 1.8
+    1044299n 1.8
+    1044300n 0
+    1044349n 0
+    1044350n 1.8
+    1044399n 1.8
+    1044400n 0
+    1044449n 0
+    1044450n 1.8
+    1044499n 1.8
+    1044500n 0
+    1044549n 0
+    1044550n 1.8
+    1044599n 1.8
+    1044600n 0
+    1044649n 0
+    1044650n 1.8
+    1044699n 1.8
+    1044700n 0
+    1044749n 0
+    1044750n 1.8
+    1044799n 1.8
+    1044800n 0
+    1044849n 0
+    1044850n 1.8
+    1044899n 1.8
+    1044900n 0
+    1044949n 0
+    1044950n 1.8
+    1044999n 1.8
+    1045000n 0
+    1045049n 0
+    1045050n 1.8
+    1045099n 1.8
+    1045100n 0
+    1045149n 0
+    1045150n 1.8
+    1045199n 1.8
+    1045200n 0
+    1045249n 0
+    1045250n 1.8
+    1045299n 1.8
+    1045300n 0
+    1045349n 0
+    1045350n 1.8
+    1045399n 1.8
+    1045400n 0
+    1045449n 0
+    1045450n 1.8
+    1045499n 1.8
+    1045500n 0
+    1045549n 0
+    1045550n 1.8
+    1045599n 1.8
+    1045600n 0
+    1045649n 0
+    1045650n 1.8
+    1045699n 1.8
+    1045700n 0
+    1045749n 0
+    1045750n 1.8
+    1045799n 1.8
+    1045800n 0
+    1045849n 0
+    1045850n 1.8
+    1045899n 1.8
+    1045900n 0
+    1045949n 0
+    1045950n 1.8
+    1045999n 1.8
+    1046000n 0
+    1046049n 0
+    1046050n 1.8
+    1046099n 1.8
+    1046100n 0
+    1046149n 0
+    1046150n 1.8
+    1046199n 1.8
+    1046200n 0
+    1046249n 0
+    1046250n 1.8
+    1046299n 1.8
+    1046300n 0
+    1046349n 0
+    1046350n 1.8
+    1046399n 1.8
+    1046400n 0
+    1046449n 0
+    1046450n 1.8
+    1046499n 1.8
+    1046500n 0
+    1046549n 0
+    1046550n 1.8
+    1046599n 1.8
+    1046600n 0
+    1046649n 0
+    1046650n 1.8
+    1046699n 1.8
+    1046700n 0
+    1046749n 0
+    1046750n 1.8
+    1046799n 1.8
+    1046800n 0
+    1046849n 0
+    1046850n 1.8
+    1046899n 1.8
+    1046900n 0
+    1046949n 0
+    1046950n 1.8
+    1046999n 1.8
+    1047000n 0
+    1047049n 0
+    1047050n 1.8
+    1047099n 1.8
+    1047100n 0
+    1047149n 0
+    1047150n 1.8
+    1047199n 1.8
+    1047200n 0
+    1047249n 0
+    1047250n 1.8
+    1047299n 1.8
+    1047300n 0
+    1047349n 0
+    1047350n 1.8
+    1047399n 1.8
+    1047400n 0
+    1047449n 0
+    1047450n 1.8
+    1047499n 1.8
+    1047500n 0
+    1047549n 0
+    1047550n 1.8
+    1047599n 1.8
+    1047600n 0
+    1047649n 0
+    1047650n 1.8
+    1047699n 1.8
+    1047700n 0
+    1047749n 0
+    1047750n 1.8
+    1047799n 1.8
+    1047800n 0
+    1047849n 0
+    1047850n 1.8
+    1047899n 1.8
+    1047900n 0
+    1047949n 0
+    1047950n 1.8
+    1047999n 1.8
+    1048000n 0
+    1048049n 0
+    1048050n 1.8
+    1048099n 1.8
+    1048100n 0
+    1048149n 0
+    1048150n 1.8
+    1048199n 1.8
+    1048200n 0
+    1048249n 0
+    1048250n 1.8
+    1048299n 1.8
+    1048300n 0
+    1048349n 0
+    1048350n 1.8
+    1048399n 1.8
+    1048400n 0
+    1048449n 0
+    1048450n 1.8
+    1048499n 1.8
+    1048500n 0
+    1048549n 0
+    1048550n 1.8
+    1048599n 1.8
+    1048600n 0
+    1048649n 0
+    1048650n 1.8
+    1048699n 1.8
+    1048700n 0
+    1048749n 0
+    1048750n 1.8
+    1048799n 1.8
+    1048800n 0
+    1048849n 0
+    1048850n 1.8
+    1048899n 1.8
+    1048900n 0
+    1048949n 0
+    1048950n 1.8
+    1048999n 1.8
+    1049000n 0
+    1049049n 0
+    1049050n 1.8
+    1049099n 1.8
+    1049100n 0
+    1049149n 0
+    1049150n 1.8
+    1049199n 1.8
+    1049200n 0
+    1049249n 0
+    1049250n 1.8
+    1049299n 1.8
+    1049300n 0
+    1049349n 0
+    1049350n 1.8
+    1049399n 1.8
+    1049400n 0
+    1049449n 0
+    1049450n 1.8
+    1049499n 1.8
+    1049500n 0
+    1049549n 0
+    1049550n 1.8
+    1049599n 1.8
+    1049600n 0
+    1049649n 0
+    1049650n 1.8
+    1049699n 1.8
+    1049700n 0
+    1049749n 0
+    1049750n 1.8
+    1049799n 1.8
+    1049800n 0
+    1049849n 0
+    1049850n 1.8
+    1049899n 1.8
+    1049900n 0
+    1049949n 0
+    1049950n 1.8
+    1049999n 1.8
+    1050000n 0
+    1050049n 0
+    1050050n 1.8
+    1050099n 1.8
+    1050100n 0
+    1050149n 0
+    1050150n 1.8
+    1050199n 1.8
+    1050200n 0
+    1050249n 0
+    1050250n 1.8
+    1050299n 1.8
+    1050300n 0
+    1050349n 0
+    1050350n 1.8
+    1050399n 1.8
+    1050400n 0
+    1050449n 0
+    1050450n 1.8
+    1050499n 1.8
+    1050500n 0
+    1050549n 0
+    1050550n 1.8
+    1050599n 1.8
+    1050600n 0
+    1050649n 0
+    1050650n 1.8
+    1050699n 1.8
+    1050700n 0
+    1050749n 0
+    1050750n 1.8
+    1050799n 1.8
+    1050800n 0
+    1050849n 0
+    1050850n 1.8
+    1050899n 1.8
+    1050900n 0
+    1050949n 0
+    1050950n 1.8
+    1050999n 1.8
+    1051000n 0
+    1051049n 0
+    1051050n 1.8
+    1051099n 1.8
+    1051100n 0
+    1051149n 0
+    1051150n 1.8
+    1051199n 1.8
+    1051200n 0
+    1051249n 0
+    1051250n 1.8
+    1051299n 1.8
+    1051300n 0
+    1051349n 0
+    1051350n 1.8
+    1051399n 1.8
+    1051400n 0
+    1051449n 0
+    1051450n 1.8
+    1051499n 1.8
+    1051500n 0
+    1051549n 0
+    1051550n 1.8
+    1051599n 1.8
+    1051600n 0
+    1051649n 0
+    1051650n 1.8
+    1051699n 1.8
+    1051700n 0
+    1051749n 0
+    1051750n 1.8
+    1051799n 1.8
+    1051800n 0
+    1051849n 0
+    1051850n 1.8
+    1051899n 1.8
+    1051900n 0
+    1051949n 0
+    1051950n 1.8
+    1051999n 1.8
+    1052000n 0
+    1052049n 0
+    1052050n 1.8
+    1052099n 1.8
+    1052100n 0
+    1052149n 0
+    1052150n 1.8
+    1052199n 1.8
+    1052200n 0
+    1052249n 0
+    1052250n 1.8
+    1052299n 1.8
+    1052300n 0
+    1052349n 0
+    1052350n 1.8
+    1052399n 1.8
+    1052400n 0
+    1052449n 0
+    1052450n 1.8
+    1052499n 1.8
+    1052500n 0
+    1052549n 0
+    1052550n 1.8
+    1052599n 1.8
+    1052600n 0
+    1052649n 0
+    1052650n 1.8
+    1052699n 1.8
+    1052700n 0
+    1052749n 0
+    1052750n 1.8
+    1052799n 1.8
+    1052800n 0
+    1052849n 0
+    1052850n 1.8
+    1052899n 1.8
+    1052900n 0
+    1052949n 0
+    1052950n 1.8
+    1052999n 1.8
+    1053000n 0
+    1053049n 0
+    1053050n 1.8
+    1053099n 1.8
+    1053100n 0
+    1053149n 0
+    1053150n 1.8
+    1053199n 1.8
+    1053200n 0
+    1053249n 0
+    1053250n 1.8
+    1053299n 1.8
+    1053300n 0
+    1053349n 0
+    1053350n 1.8
+    1053399n 1.8
+    1053400n 0
+    1053449n 0
+    1053450n 1.8
+    1053499n 1.8
+    1053500n 0
+    1053549n 0
+    1053550n 1.8
+    1053599n 1.8
+    1053600n 0
+    1053649n 0
+    1053650n 1.8
+    1053699n 1.8
+    1053700n 0
+    1053749n 0
+    1053750n 1.8
+    1053799n 1.8
+    1053800n 0
+    1053849n 0
+    1053850n 1.8
+    1053899n 1.8
+    1053900n 0
+    1053949n 0
+    1053950n 1.8
+    1053999n 1.8
+    1054000n 0
+    1054049n 0
+    1054050n 1.8
+    1054099n 1.8
+    1054100n 0
+    1054149n 0
+    1054150n 1.8
+    1054199n 1.8
+    1054200n 0
+    1054249n 0
+    1054250n 1.8
+    1054299n 1.8
+    1054300n 0
+    1054349n 0
+    1054350n 1.8
+    1054399n 1.8
+    1054400n 0
+    1054449n 0
+    1054450n 1.8
+    1054499n 1.8
+    1054500n 0
+    1054549n 0
+    1054550n 1.8
+    1054599n 1.8
+    1054600n 0
+    1054649n 0
+    1054650n 1.8
+    1054699n 1.8
+    1054700n 0
+    1054749n 0
+    1054750n 1.8
+    1054799n 1.8
+    1054800n 0
+    1054849n 0
+    1054850n 1.8
+    1054899n 1.8
+    1054900n 0
+    1054949n 0
+    1054950n 1.8
+    1054999n 1.8
+    1055000n 0
+    1055049n 0
+    1055050n 1.8
+    1055099n 1.8
+    1055100n 0
+    1055149n 0
+    1055150n 1.8
+    1055199n 1.8
+    1055200n 0
+    1055249n 0
+    1055250n 1.8
+    1055299n 1.8
+    1055300n 0
+    1055349n 0
+    1055350n 1.8
+    1055399n 1.8
+    1055400n 0
+    1055449n 0
+    1055450n 1.8
+    1055499n 1.8
+    1055500n 0
+    1055549n 0
+    1055550n 1.8
+    1055599n 1.8
+    1055600n 0
+    1055649n 0
+    1055650n 1.8
+    1055699n 1.8
+    1055700n 0
+    1055749n 0
+    1055750n 1.8
+    1055799n 1.8
+    1055800n 0
+    1055849n 0
+    1055850n 1.8
+    1055899n 1.8
+    1055900n 0
+    1055949n 0
+    1055950n 1.8
+    1055999n 1.8
+    1056000n 0
+    1056049n 0
+    1056050n 1.8
+    1056099n 1.8
+    1056100n 0
+    1056149n 0
+    1056150n 1.8
+    1056199n 1.8
+    1056200n 0
+    1056249n 0
+    1056250n 1.8
+    1056299n 1.8
+    1056300n 0
+    1056349n 0
+    1056350n 1.8
+    1056399n 1.8
+    1056400n 0
+    1056449n 0
+    1056450n 1.8
+    1056499n 1.8
+    1056500n 0
+    1056549n 0
+    1056550n 1.8
+    1056599n 1.8
+    1056600n 0
+    1056649n 0
+    1056650n 1.8
+    1056699n 1.8
+    1056700n 0
+    1056749n 0
+    1056750n 1.8
+    1056799n 1.8
+    1056800n 0
+    1056849n 0
+    1056850n 1.8
+    1056899n 1.8
+    1056900n 0
+    1056949n 0
+    1056950n 1.8
+    1056999n 1.8
+    1057000n 0
+    1057049n 0
+    1057050n 1.8
+    1057099n 1.8
+    1057100n 0
+    1057149n 0
+    1057150n 1.8
+    1057199n 1.8
+    1057200n 0
+    1057249n 0
+    1057250n 1.8
+    1057299n 1.8
+    1057300n 0
+    1057349n 0
+    1057350n 1.8
+    1057399n 1.8
+    1057400n 0
+    1057449n 0
+    1057450n 1.8
+    1057499n 1.8
+    1057500n 0
+    1057549n 0
+    1057550n 1.8
+    1057599n 1.8
+    1057600n 0
+    1057649n 0
+    1057650n 1.8
+    1057699n 1.8
+    1057700n 0
+    1057749n 0
+    1057750n 1.8
+    1057799n 1.8
+    1057800n 0
+    1057849n 0
+    1057850n 1.8
+    1057899n 1.8
+    1057900n 0
+    1057949n 0
+    1057950n 1.8
+    1057999n 1.8
+    1058000n 0
+    1058049n 0
+    1058050n 1.8
+    1058099n 1.8
+    1058100n 0
+    1058149n 0
+    1058150n 1.8
+    1058199n 1.8
+    1058200n 0
+    1058249n 0
+    1058250n 1.8
+    1058299n 1.8
+    1058300n 0
+    1058349n 0
+    1058350n 1.8
+    1058399n 1.8
+    1058400n 0
+    1058449n 0
+    1058450n 1.8
+    1058499n 1.8
+    1058500n 0
+    1058549n 0
+    1058550n 1.8
+    1058599n 1.8
+    1058600n 0
+    1058649n 0
+    1058650n 1.8
+    1058699n 1.8
+    1058700n 0
+    1058749n 0
+    1058750n 1.8
+    1058799n 1.8
+    1058800n 0
+    1058849n 0
+    1058850n 1.8
+    1058899n 1.8
+    1058900n 0
+    1058949n 0
+    1058950n 1.8
+    1058999n 1.8
+    1059000n 0
+    1059049n 0
+    1059050n 1.8
+    1059099n 1.8
+    1059100n 0
+    1059149n 0
+    1059150n 1.8
+    1059199n 1.8
+    1059200n 0
+    1059249n 0
+    1059250n 1.8
+    1059299n 1.8
+    1059300n 0
+    1059349n 0
+    1059350n 1.8
+    1059399n 1.8
+    1059400n 0
+    1059449n 0
+    1059450n 1.8
+    1059499n 1.8
+    1059500n 0
+    1059549n 0
+    1059550n 1.8
+    1059599n 1.8
+    1059600n 0
+    1059649n 0
+    1059650n 1.8
+    1059699n 1.8
+    1059700n 0
+    1059749n 0
+    1059750n 1.8
+    1059799n 1.8
+    1059800n 0
+    1059849n 0
+    1059850n 1.8
+    1059899n 1.8
+    1059900n 0
+    1059949n 0
+    1059950n 1.8
+    1059999n 1.8
+    1060000n 0
+    1060049n 0
+    1060050n 1.8
+    1060099n 1.8
+    1060100n 0
+    1060149n 0
+    1060150n 1.8
+    1060199n 1.8
+    1060200n 0
+    1060249n 0
+    1060250n 1.8
+    1060299n 1.8
+    1060300n 0
+    1060349n 0
+    1060350n 1.8
+    1060399n 1.8
+    1060400n 0
+    1060449n 0
+    1060450n 1.8
+    1060499n 1.8
+    1060500n 0
+    1060549n 0
+    1060550n 1.8
+    1060599n 1.8
+    1060600n 0
+    1060649n 0
+    1060650n 1.8
+    1060699n 1.8
+    1060700n 0
+    1060749n 0
+    1060750n 1.8
+    1060799n 1.8
+    1060800n 0
+    1060849n 0
+    1060850n 1.8
+    1060899n 1.8
+    1060900n 0
+    1060949n 0
+    1060950n 1.8
+    1060999n 1.8
+    1061000n 0
+    1061049n 0
+    1061050n 1.8
+    1061099n 1.8
+    1061100n 0
+    1061149n 0
+    1061150n 1.8
+    1061199n 1.8
+    1061200n 0
+    1061249n 0
+    1061250n 1.8
+    1061299n 1.8
+    1061300n 0
+    1061349n 0
+    1061350n 1.8
+    1061399n 1.8
+    1061400n 0
+    1061449n 0
+    1061450n 1.8
+    1061499n 1.8
+    1061500n 0
+    1061549n 0
+    1061550n 1.8
+    1061599n 1.8
+    1061600n 0
+    1061649n 0
+    1061650n 1.8
+    1061699n 1.8
+    1061700n 0
+    1061749n 0
+    1061750n 1.8
+    1061799n 1.8
+    1061800n 0
+    1061849n 0
+    1061850n 1.8
+    1061899n 1.8
+    1061900n 0
+    1061949n 0
+    1061950n 1.8
+    1061999n 1.8
+    1062000n 0
+    1062049n 0
+    1062050n 1.8
+    1062099n 1.8
+    1062100n 0
+    1062149n 0
+    1062150n 1.8
+    1062199n 1.8
+    1062200n 0
+    1062249n 0
+    1062250n 1.8
+    1062299n 1.8
+    1062300n 0
+    1062349n 0
+    1062350n 1.8
+    1062399n 1.8
+    1062400n 0
+    1062449n 0
+    1062450n 1.8
+    1062499n 1.8
+    1062500n 0
+    1062549n 0
+    1062550n 1.8
+    1062599n 1.8
+    1062600n 0
+    1062649n 0
+    1062650n 1.8
+    1062699n 1.8
+    1062700n 0
+    1062749n 0
+    1062750n 1.8
+    1062799n 1.8
+    1062800n 0
+    1062849n 0
+    1062850n 1.8
+    1062899n 1.8
+    1062900n 0
+    1062949n 0
+    1062950n 1.8
+    1062999n 1.8
+    1063000n 0
+    1063049n 0
+    1063050n 1.8
+    1063099n 1.8
+    1063100n 0
+    1063149n 0
+    1063150n 1.8
+    1063199n 1.8
+    1063200n 0
+    1063249n 0
+    1063250n 1.8
+    1063299n 1.8
+    1063300n 0
+    1063349n 0
+    1063350n 1.8
+    1063399n 1.8
+    1063400n 0
+    1063449n 0
+    1063450n 1.8
+    1063499n 1.8
+    1063500n 0
+    1063549n 0
+    1063550n 1.8
+    1063599n 1.8
+    1063600n 0
+    1063649n 0
+    1063650n 1.8
+    1063699n 1.8
+    1063700n 0
+    1063749n 0
+    1063750n 1.8
+    1063799n 1.8
+    1063800n 0
+    1063849n 0
+    1063850n 1.8
+    1063899n 1.8
+    1063900n 0
+    1063949n 0
+    1063950n 1.8
+    1063999n 1.8
+    1064000n 0
+    1064049n 0
+    1064050n 1.8
+    1064099n 1.8
+    1064100n 0
+    1064149n 0
+    1064150n 1.8
+    1064199n 1.8
+    1064200n 0
+    1064249n 0
+    1064250n 1.8
+    1064299n 1.8
+    1064300n 0
+    1064349n 0
+    1064350n 1.8
+    1064399n 1.8
+    1064400n 0
+    1064449n 0
+    1064450n 1.8
+    1064499n 1.8
+    1064500n 0
+    1064549n 0
+    1064550n 1.8
+    1064599n 1.8
+    1064600n 0
+    1064649n 0
+    1064650n 1.8
+    1064699n 1.8
+    1064700n 0
+    1064749n 0
+    1064750n 1.8
+    1064799n 1.8
+    1064800n 0
+    1064849n 0
+    1064850n 1.8
+    1064899n 1.8
+    1064900n 0
+    1064949n 0
+    1064950n 1.8
+    1064999n 1.8
+    1065000n 0
+    1065049n 0
+    1065050n 1.8
+    1065099n 1.8
+    1065100n 0
+    1065149n 0
+    1065150n 1.8
+    1065199n 1.8
+    1065200n 0
+    1065249n 0
+    1065250n 1.8
+    1065299n 1.8
+    1065300n 0
+    1065349n 0
+    1065350n 1.8
+    1065399n 1.8
+    1065400n 0
+    1065449n 0
+    1065450n 1.8
+    1065499n 1.8
+    1065500n 0
+    1065549n 0
+    1065550n 1.8
+    1065599n 1.8
+    1065600n 0
+    1065649n 0
+    1065650n 1.8
+    1065699n 1.8
+    1065700n 0
+    1065749n 0
+    1065750n 1.8
+    1065799n 1.8
+    1065800n 0
+    1065849n 0
+    1065850n 1.8
+    1065899n 1.8
+    1065900n 0
+    1065949n 0
+    1065950n 1.8
+    1065999n 1.8
+    1066000n 0
+    1066049n 0
+    1066050n 1.8
+    1066099n 1.8
+    1066100n 0
+    1066149n 0
+    1066150n 1.8
+    1066199n 1.8
+    1066200n 0
+    1066249n 0
+    1066250n 1.8
+    1066299n 1.8
+    1066300n 0
+    1066349n 0
+    1066350n 1.8
+    1066399n 1.8
+    1066400n 0
+    1066449n 0
+    1066450n 1.8
+    1066499n 1.8
+    1066500n 0
+    1066549n 0
+    1066550n 1.8
+    1066599n 1.8
+    1066600n 0
+    1066649n 0
+    1066650n 1.8
+    1066699n 1.8
+    1066700n 0
+    1066749n 0
+    1066750n 1.8
+    1066799n 1.8
+    1066800n 0
+    1066849n 0
+    1066850n 1.8
+    1066899n 1.8
+    1066900n 0
+    1066949n 0
+    1066950n 1.8
+    1066999n 1.8
+    1067000n 0
+    1067049n 0
+    1067050n 1.8
+    1067099n 1.8
+    1067100n 0
+    1067149n 0
+    1067150n 1.8
+    1067199n 1.8
+    1067200n 0
+    1067249n 0
+    1067250n 1.8
+    1067299n 1.8
+    1067300n 0
+    1067349n 0
+    1067350n 1.8
+    1067399n 1.8
+    1067400n 0
+    1067449n 0
+    1067450n 1.8
+    1067499n 1.8
+    1067500n 0
+    1067549n 0
+    1067550n 1.8
+    1067599n 1.8
+    1067600n 0
+    1067649n 0
+    1067650n 1.8
+    1067699n 1.8
+    1067700n 0
+    1067749n 0
+    1067750n 1.8
+    1067799n 1.8
+    1067800n 0
+    1067849n 0
+    1067850n 1.8
+    1067899n 1.8
+    1067900n 0
+    1067949n 0
+    1067950n 1.8
+    1067999n 1.8
+    1068000n 0
+    1068049n 0
+    1068050n 1.8
+    1068099n 1.8
+    1068100n 0
+    1068149n 0
+    1068150n 1.8
+    1068199n 1.8
+    1068200n 0
+    1068249n 0
+    1068250n 1.8
+    1068299n 1.8
+    1068300n 0
+    1068349n 0
+    1068350n 1.8
+    1068399n 1.8
+    1068400n 0
+    1068449n 0
+    1068450n 1.8
+    1068499n 1.8
+    1068500n 0
+    1068549n 0
+    1068550n 1.8
+    1068599n 1.8
+    1068600n 0
+    1068649n 0
+    1068650n 1.8
+    1068699n 1.8
+    1068700n 0
+    1068749n 0
+    1068750n 1.8
+    1068799n 1.8
+    1068800n 0
+    1068849n 0
+    1068850n 1.8
+    1068899n 1.8
+    1068900n 0
+    1068949n 0
+    1068950n 1.8
+    1068999n 1.8
+    1069000n 0
+    1069049n 0
+    1069050n 1.8
+    1069099n 1.8
+    1069100n 0
+    1069149n 0
+    1069150n 1.8
+    1069199n 1.8
+    1069200n 0
+    1069249n 0
+    1069250n 1.8
+    1069299n 1.8
+    1069300n 0
+    1069349n 0
+    1069350n 1.8
+    1069399n 1.8
+    1069400n 0
+    1069449n 0
+    1069450n 1.8
+    1069499n 1.8
+    1069500n 0
+    1069549n 0
+    1069550n 1.8
+    1069599n 1.8
+    1069600n 0
+    1069649n 0
+    1069650n 1.8
+    1069699n 1.8
+    1069700n 0
+    1069749n 0
+    1069750n 1.8
+    1069799n 1.8
+    1069800n 0
+    1069849n 0
+    1069850n 1.8
+    1069899n 1.8
+    1069900n 0
+    1069949n 0
+    1069950n 1.8
+    1069999n 1.8
+    1070000n 0
+    1070049n 0
+    1070050n 1.8
+    1070099n 1.8
+    1070100n 0
+    1070149n 0
+    1070150n 1.8
+    1070199n 1.8
+    1070200n 0
+    1070249n 0
+    1070250n 1.8
+    1070299n 1.8
+    1070300n 0
+    1070349n 0
+    1070350n 1.8
+    1070399n 1.8
+    1070400n 0
+    1070449n 0
+    1070450n 1.8
+    1070499n 1.8
+    1070500n 0
+    1070549n 0
+    1070550n 1.8
+    1070599n 1.8
+    1070600n 0
+    1070649n 0
+    1070650n 1.8
+    1070699n 1.8
+    1070700n 0
+    1070749n 0
+    1070750n 1.8
+    1070799n 1.8
+    1070800n 0
+    1070849n 0
+    1070850n 1.8
+    1070899n 1.8
+    1070900n 0
+    1070949n 0
+    1070950n 1.8
+    1070999n 1.8
+    1071000n 0
+    1071049n 0
+    1071050n 1.8
+    1071099n 1.8
+    1071100n 0
+    1071149n 0
+    1071150n 1.8
+    1071199n 1.8
+    1071200n 0
+    1071249n 0
+    1071250n 1.8
+    1071299n 1.8
+    1071300n 0
+    1071349n 0
+    1071350n 1.8
+    1071399n 1.8
+    1071400n 0
+    1071449n 0
+    1071450n 1.8
+    1071499n 1.8
+    1071500n 0
+    1071549n 0
+    1071550n 1.8
+    1071599n 1.8
+    1071600n 0
+    1071649n 0
+    1071650n 1.8
+    1071699n 1.8
+    1071700n 0
+    1071749n 0
+    1071750n 1.8
+    1071799n 1.8
+    1071800n 0
+    1071849n 0
+    1071850n 1.8
+    1071899n 1.8
+    1071900n 0
+    1071949n 0
+    1071950n 1.8
+    1071999n 1.8
+    1072000n 0
+    1072049n 0
+    1072050n 1.8
+    1072099n 1.8
+    1072100n 0
+    1072149n 0
+    1072150n 1.8
+    1072199n 1.8
+    1072200n 0
+    1072249n 0
+    1072250n 1.8
+    1072299n 1.8
+    1072300n 0
+    1072349n 0
+    1072350n 1.8
+    1072399n 1.8
+    1072400n 0
+    1072449n 0
+    1072450n 1.8
+    1072499n 1.8
+    1072500n 0
+    1072549n 0
+    1072550n 1.8
+    1072599n 1.8
+    1072600n 0
+    1072649n 0
+    1072650n 1.8
+    1072699n 1.8
+    1072700n 0
+    1072749n 0
+    1072750n 1.8
+    1072799n 1.8
+    1072800n 0
+    1072849n 0
+    1072850n 1.8
+    1072899n 1.8
+    1072900n 0
+    1072949n 0
+    1072950n 1.8
+    1072999n 1.8
+    1073000n 0
+    1073049n 0
+    1073050n 1.8
+    1073099n 1.8
+    1073100n 0
+    1073149n 0
+    1073150n 1.8
+    1073199n 1.8
+    1073200n 0
+    1073249n 0
+    1073250n 1.8
+    1073299n 1.8
+    1073300n 0
+    1073349n 0
+    1073350n 1.8
+    1073399n 1.8
+    1073400n 0
+    1073449n 0
+    1073450n 1.8
+    1073499n 1.8
+    1073500n 0
+    1073549n 0
+    1073550n 1.8
+    1073599n 1.8
+    1073600n 0
+    1073649n 0
+    1073650n 1.8
+    1073699n 1.8
+    1073700n 0
+    1073749n 0
+    1073750n 1.8
+    1073799n 1.8
+    1073800n 0
+    1073849n 0
+    1073850n 1.8
+    1073899n 1.8
+    1073900n 0
+    1073949n 0
+    1073950n 1.8
+    1073999n 1.8
+    1074000n 0
+    1074049n 0
+    1074050n 1.8
+    1074099n 1.8
+    1074100n 0
+    1074149n 0
+    1074150n 1.8
+    1074199n 1.8
+    1074200n 0
+    1074249n 0
+    1074250n 1.8
+    1074299n 1.8
+    1074300n 0
+    1074349n 0
+    1074350n 1.8
+    1074399n 1.8
+    1074400n 0
+    1074449n 0
+    1074450n 1.8
+    1074499n 1.8
+    1074500n 0
+    1074549n 0
+    1074550n 1.8
+    1074599n 1.8
+    1074600n 0
+    1074649n 0
+    1074650n 1.8
+    1074699n 1.8
+    1074700n 0
+    1074749n 0
+    1074750n 1.8
+    1074799n 1.8
+    1074800n 0
+    1074849n 0
+    1074850n 1.8
+    1074899n 1.8
+    1074900n 0
+    1074949n 0
+    1074950n 1.8
+    1074999n 1.8
+    1075000n 0
+    1075049n 0
+    1075050n 1.8
+    1075099n 1.8
+    1075100n 0
+    1075149n 0
+    1075150n 1.8
+    1075199n 1.8
+    1075200n 0
+    1075249n 0
+    1075250n 1.8
+    1075299n 1.8
+    1075300n 0
+    1075349n 0
+    1075350n 1.8
+    1075399n 1.8
+    1075400n 0
+    1075449n 0
+    1075450n 1.8
+    1075499n 1.8
+    1075500n 0
+    1075549n 0
+    1075550n 1.8
+    1075599n 1.8
+    1075600n 0
+    1075649n 0
+    1075650n 1.8
+    1075699n 1.8
+    1075700n 0
+    1075749n 0
+    1075750n 1.8
+    1075799n 1.8
+    1075800n 0
+    1075849n 0
+    1075850n 1.8
+    1075899n 1.8
+    1075900n 0
+    1075949n 0
+    1075950n 1.8
+    1075999n 1.8
+    1076000n 0
+    1076049n 0
+    1076050n 1.8
+    1076099n 1.8
+    1076100n 0
+    1076149n 0
+    1076150n 1.8
+    1076199n 1.8
+    1076200n 0
+    1076249n 0
+    1076250n 1.8
+    1076299n 1.8
+    1076300n 0
+    1076349n 0
+    1076350n 1.8
+    1076399n 1.8
+    1076400n 0
+    1076449n 0
+    1076450n 1.8
+    1076499n 1.8
+    1076500n 0
+    1076549n 0
+    1076550n 1.8
+    1076599n 1.8
+    1076600n 0
+    1076649n 0
+    1076650n 1.8
+    1076699n 1.8
+    1076700n 0
+    1076749n 0
+    1076750n 1.8
+    1076799n 1.8
+    1076800n 0
+    1076849n 0
+    1076850n 1.8
+    1076899n 1.8
+    1076900n 0
+    1076949n 0
+    1076950n 1.8
+    1076999n 1.8
+    1077000n 0
+    1077049n 0
+    1077050n 1.8
+    1077099n 1.8
+    1077100n 0
+    1077149n 0
+    1077150n 1.8
+    1077199n 1.8
+    1077200n 0
+    1077249n 0
+    1077250n 1.8
+    1077299n 1.8
+    1077300n 0
+    1077349n 0
+    1077350n 1.8
+    1077399n 1.8
+    1077400n 0
+    1077449n 0
+    1077450n 1.8
+    1077499n 1.8
+    1077500n 0
+    1077549n 0
+    1077550n 1.8
+    1077599n 1.8
+    1077600n 0
+    1077649n 0
+    1077650n 1.8
+    1077699n 1.8
+    1077700n 0
+    1077749n 0
+    1077750n 1.8
+    1077799n 1.8
+    1077800n 0
+    1077849n 0
+    1077850n 1.8
+    1077899n 1.8
+    1077900n 0
+    1077949n 0
+    1077950n 1.8
+    1077999n 1.8
+    1078000n 0
+    1078049n 0
+    1078050n 1.8
+    1078099n 1.8
+    1078100n 0
+    1078149n 0
+    1078150n 1.8
+    1078199n 1.8
+    1078200n 0
+    1078249n 0
+    1078250n 1.8
+    1078299n 1.8
+    1078300n 0
+    1078349n 0
+    1078350n 1.8
+    1078399n 1.8
+    1078400n 0
+    1078449n 0
+    1078450n 1.8
+    1078499n 1.8
+    1078500n 0
+    1078549n 0
+    1078550n 1.8
+    1078599n 1.8
+    1078600n 0
+    1078649n 0
+    1078650n 1.8
+    1078699n 1.8
+    1078700n 0
+    1078749n 0
+    1078750n 1.8
+    1078799n 1.8
+    1078800n 0
+    1078849n 0
+    1078850n 1.8
+    1078899n 1.8
+    1078900n 0
+    1078949n 0
+    1078950n 1.8
+    1078999n 1.8
+    1079000n 0
+    1079049n 0
+    1079050n 1.8
+    1079099n 1.8
+    1079100n 0
+    1079149n 0
+    1079150n 1.8
+    1079199n 1.8
+    1079200n 0
+    1079249n 0
+    1079250n 1.8
+    1079299n 1.8
+    1079300n 0
+    1079349n 0
+    1079350n 1.8
+    1079399n 1.8
+    1079400n 0
+    1079449n 0
+    1079450n 1.8
+    1079499n 1.8
+    1079500n 0
+    1079549n 0
+    1079550n 1.8
+    1079599n 1.8
+    1079600n 0
+    1079649n 0
+    1079650n 1.8
+    1079699n 1.8
+    1079700n 0
+    1079749n 0
+    1079750n 1.8
+    1079799n 1.8
+    1079800n 0
+    1079849n 0
+    1079850n 1.8
+    1079899n 1.8
+    1079900n 0
+    1079949n 0
+    1079950n 1.8
+    1079999n 1.8
+    1080000n 0
+    1080049n 0
+    1080050n 1.8
+    1080099n 1.8
+    1080100n 0
+    1080149n 0
+    1080150n 1.8
+    1080199n 1.8
+    1080200n 0
+    1080249n 0
+    1080250n 1.8
+    1080299n 1.8
+    1080300n 0
+    1080349n 0
+    1080350n 1.8
+    1080399n 1.8
+    1080400n 0
+    1080449n 0
+    1080450n 1.8
+    1080499n 1.8
+    1080500n 0
+    1080549n 0
+    1080550n 1.8
+    1080599n 1.8
+    1080600n 0
+    1080649n 0
+    1080650n 1.8
+    1080699n 1.8
+    1080700n 0
+    1080749n 0
+    1080750n 1.8
+    1080799n 1.8
+    1080800n 0
+    1080849n 0
+    1080850n 1.8
+    1080899n 1.8
+    1080900n 0
+    1080949n 0
+    1080950n 1.8
+    1080999n 1.8
+    1081000n 0
+    1081049n 0
+    1081050n 1.8
+    1081099n 1.8
+    1081100n 0
+    1081149n 0
+    1081150n 1.8
+    1081199n 1.8
+    1081200n 0
+    1081249n 0
+    1081250n 1.8
+    1081299n 1.8
+    1081300n 0
+    1081349n 0
+    1081350n 1.8
+    1081399n 1.8
+    1081400n 0
+    1081449n 0
+    1081450n 1.8
+    1081499n 1.8
+    1081500n 0
+    1081549n 0
+    1081550n 1.8
+    1081599n 1.8
+    1081600n 0
+    1081649n 0
+    1081650n 1.8
+    1081699n 1.8
+    1081700n 0
+    1081749n 0
+    1081750n 1.8
+    1081799n 1.8
+    1081800n 0
+    1081849n 0
+    1081850n 1.8
+    1081899n 1.8
+    1081900n 0
+    1081949n 0
+    1081950n 1.8
+    1081999n 1.8
+    1082000n 0
+    1082049n 0
+    1082050n 1.8
+    1082099n 1.8
+    1082100n 0
+    1082149n 0
+    1082150n 1.8
+    1082199n 1.8
+    1082200n 0
+    1082249n 0
+    1082250n 1.8
+    1082299n 1.8
+    1082300n 0
+    1082349n 0
+    1082350n 1.8
+    1082399n 1.8
+    1082400n 0
+    1082449n 0
+    1082450n 1.8
+    1082499n 1.8
+    1082500n 0
+    1082549n 0
+    1082550n 1.8
+    1082599n 1.8
+    1082600n 0
+    1082649n 0
+    1082650n 1.8
+    1082699n 1.8
+    1082700n 0
+    1082749n 0
+    1082750n 1.8
+    1082799n 1.8
+    1082800n 0
+    1082849n 0
+    1082850n 1.8
+    1082899n 1.8
+    1082900n 0
+    1082949n 0
+    1082950n 1.8
+    1082999n 1.8
+    1083000n 0
+    1083049n 0
+    1083050n 1.8
+    1083099n 1.8
+    1083100n 0
+    1083149n 0
+    1083150n 1.8
+    1083199n 1.8
+    1083200n 0
+    1083249n 0
+    1083250n 1.8
+    1083299n 1.8
+    1083300n 0
+    1083349n 0
+    1083350n 1.8
+    1083399n 1.8
+    1083400n 0
+    1083449n 0
+    1083450n 1.8
+    1083499n 1.8
+    1083500n 0
+    1083549n 0
+    1083550n 1.8
+    1083599n 1.8
+    1083600n 0
+    1083649n 0
+    1083650n 1.8
+    1083699n 1.8
+    1083700n 0
+    1083749n 0
+    1083750n 1.8
+    1083799n 1.8
+    1083800n 0
+    1083849n 0
+    1083850n 1.8
+    1083899n 1.8
+    1083900n 0
+    1083949n 0
+    1083950n 1.8
+    1083999n 1.8
+    1084000n 0
+    1084049n 0
+    1084050n 1.8
+    1084099n 1.8
+    1084100n 0
+    1084149n 0
+    1084150n 1.8
+    1084199n 1.8
+    1084200n 0
+    1084249n 0
+    1084250n 1.8
+    1084299n 1.8
+    1084300n 0
+    1084349n 0
+    1084350n 1.8
+    1084399n 1.8
+    1084400n 0
+    1084449n 0
+    1084450n 1.8
+    1084499n 1.8
+    1084500n 0
+    1084549n 0
+    1084550n 1.8
+    1084599n 1.8
+    1084600n 0
+    1084649n 0
+    1084650n 1.8
+    1084699n 1.8
+    1084700n 0
+    1084749n 0
+    1084750n 1.8
+    1084799n 1.8
+    1084800n 0
+    1084849n 0
+    1084850n 1.8
+    1084899n 1.8
+    1084900n 0
+    1084949n 0
+    1084950n 1.8
+    1084999n 1.8
+    1085000n 0
+    1085049n 0
+    1085050n 1.8
+    1085099n 1.8
+    1085100n 0
+    1085149n 0
+    1085150n 1.8
+    1085199n 1.8
+    1085200n 0
+    1085249n 0
+    1085250n 1.8
+    1085299n 1.8
+    1085300n 0
+    1085349n 0
+    1085350n 1.8
+    1085399n 1.8
+    1085400n 0
+    1085449n 0
+    1085450n 1.8
+    1085499n 1.8
+    1085500n 0
+    1085549n 0
+    1085550n 1.8
+    1085599n 1.8
+    1085600n 0
+    1085649n 0
+    1085650n 1.8
+    1085699n 1.8
+    1085700n 0
+    1085749n 0
+    1085750n 1.8
+    1085799n 1.8
+    1085800n 0
+    1085849n 0
+    1085850n 1.8
+    1085899n 1.8
+    1085900n 0
+    1085949n 0
+    1085950n 1.8
+    1085999n 1.8
+    1086000n 0
+    1086049n 0
+    1086050n 1.8
+    1086099n 1.8
+    1086100n 0
+    1086149n 0
+    1086150n 1.8
+    1086199n 1.8
+    1086200n 0
+    1086249n 0
+    1086250n 1.8
+    1086299n 1.8
+    1086300n 0
+    1086349n 0
+    1086350n 1.8
+    1086399n 1.8
+    1086400n 0
+    1086449n 0
+    1086450n 1.8
+    1086499n 1.8
+    1086500n 0
+    1086549n 0
+    1086550n 1.8
+    1086599n 1.8
+    1086600n 0
+    1086649n 0
+    1086650n 1.8
+    1086699n 1.8
+    1086700n 0
+    1086749n 0
+    1086750n 1.8
+    1086799n 1.8
+    1086800n 0
+    1086849n 0
+    1086850n 1.8
+    1086899n 1.8
+    1086900n 0
+    1086949n 0
+    1086950n 1.8
+    1086999n 1.8
+    1087000n 0
+    1087049n 0
+    1087050n 1.8
+    1087099n 1.8
+    1087100n 0
+    1087149n 0
+    1087150n 1.8
+    1087199n 1.8
+    1087200n 0
+    1087249n 0
+    1087250n 1.8
+    1087299n 1.8
+    1087300n 0
+    1087349n 0
+    1087350n 1.8
+    1087399n 1.8
+    1087400n 0
+    1087449n 0
+    1087450n 1.8
+    1087499n 1.8
+    1087500n 0
+    1087549n 0
+    1087550n 1.8
+    1087599n 1.8
+    1087600n 0
+    1087649n 0
+    1087650n 1.8
+    1087699n 1.8
+    1087700n 0
+    1087749n 0
+    1087750n 1.8
+    1087799n 1.8
+    1087800n 0
+    1087849n 0
+    1087850n 1.8
+    1087899n 1.8
+    1087900n 0
+    1087949n 0
+    1087950n 1.8
+    1087999n 1.8
+    1088000n 0
+    1088049n 0
+    1088050n 1.8
+    1088099n 1.8
+    1088100n 0
+    1088149n 0
+    1088150n 1.8
+    1088199n 1.8
+    1088200n 0
+    1088249n 0
+    1088250n 1.8
+    1088299n 1.8
+    1088300n 0
+    1088349n 0
+    1088350n 1.8
+    1088399n 1.8
+    1088400n 0
+    1088449n 0
+    1088450n 1.8
+    1088499n 1.8
+    1088500n 0
+    1088549n 0
+    1088550n 1.8
+    1088599n 1.8
+    1088600n 0
+    1088649n 0
+    1088650n 1.8
+    1088699n 1.8
+    1088700n 0
+    1088749n 0
+    1088750n 1.8
+    1088799n 1.8
+    1088800n 0
+    1088849n 0
+    1088850n 1.8
+    1088899n 1.8
+    1088900n 0
+    1088949n 0
+    1088950n 1.8
+    1088999n 1.8
+    1089000n 0
+    1089049n 0
+    1089050n 1.8
+    1089099n 1.8
+    1089100n 0
+    1089149n 0
+    1089150n 1.8
+    1089199n 1.8
+    1089200n 0
+    1089249n 0
+    1089250n 1.8
+    1089299n 1.8
+    1089300n 0
+    1089349n 0
+    1089350n 1.8
+    1089399n 1.8
+    1089400n 0
+    1089449n 0
+    1089450n 1.8
+    1089499n 1.8
+    1089500n 0
+    1089549n 0
+    1089550n 1.8
+    1089599n 1.8
+    1089600n 0
+    1089649n 0
+    1089650n 1.8
+    1089699n 1.8
+    1089700n 0
+    1089749n 0
+    1089750n 1.8
+    1089799n 1.8
+    1089800n 0
+    1089849n 0
+    1089850n 1.8
+    1089899n 1.8
+    1089900n 0
+    1089949n 0
+    1089950n 1.8
+    1089999n 1.8
+    1090000n 0
+    1090049n 0
+    1090050n 1.8
+    1090099n 1.8
+    1090100n 0
+    1090149n 0
+    1090150n 1.8
+    1090199n 1.8
+    1090200n 0
+    1090249n 0
+    1090250n 1.8
+    1090299n 1.8
+    1090300n 0
+    1090349n 0
+    1090350n 1.8
+    1090399n 1.8
+    1090400n 0
+    1090449n 0
+    1090450n 1.8
+    1090499n 1.8
+    1090500n 0
+    1090549n 0
+    1090550n 1.8
+    1090599n 1.8
+    1090600n 0
+    1090649n 0
+    1090650n 1.8
+    1090699n 1.8
+    1090700n 0
+    1090749n 0
+    1090750n 1.8
+    1090799n 1.8
+    1090800n 0
+    1090849n 0
+    1090850n 1.8
+    1090899n 1.8
+    1090900n 0
+    1090949n 0
+    1090950n 1.8
+    1090999n 1.8
+    1091000n 0
+    1091049n 0
+    1091050n 1.8
+    1091099n 1.8
+    1091100n 0
+    1091149n 0
+    1091150n 1.8
+    1091199n 1.8
+    1091200n 0
+    1091249n 0
+    1091250n 1.8
+    1091299n 1.8
+    1091300n 0
+    1091349n 0
+    1091350n 1.8
+    1091399n 1.8
+    1091400n 0
+    1091449n 0
+    1091450n 1.8
+    1091499n 1.8
+    1091500n 0
+    1091549n 0
+    1091550n 1.8
+    1091599n 1.8
+    1091600n 0
+    1091649n 0
+    1091650n 1.8
+    1091699n 1.8
+    1091700n 0
+    1091749n 0
+    1091750n 1.8
+    1091799n 1.8
+    1091800n 0
+    1091849n 0
+    1091850n 1.8
+    1091899n 1.8
+    1091900n 0
+    1091949n 0
+    1091950n 1.8
+    1091999n 1.8
+    1092000n 0
+    1092049n 0
+    1092050n 1.8
+    1092099n 1.8
+    1092100n 0
+    1092149n 0
+    1092150n 1.8
+    1092199n 1.8
+    1092200n 0
+    1092249n 0
+    1092250n 1.8
+    1092299n 1.8
+    1092300n 0
+    1092349n 0
+    1092350n 1.8
+    1092399n 1.8
+    1092400n 0
+    1092449n 0
+    1092450n 1.8
+    1092499n 1.8
+    1092500n 0
+    1092549n 0
+    1092550n 1.8
+    1092599n 1.8
+    1092600n 0
+    1092649n 0
+    1092650n 1.8
+    1092699n 1.8
+    1092700n 0
+    1092749n 0
+    1092750n 1.8
+    1092799n 1.8
+    1092800n 0
+    1092849n 0
+    1092850n 1.8
+    1092899n 1.8
+    1092900n 0
+    1092949n 0
+    1092950n 1.8
+    1092999n 1.8
+    1093000n 0
+    1093049n 0
+    1093050n 1.8
+    1093099n 1.8
+    1093100n 0
+    1093149n 0
+    1093150n 1.8
+    1093199n 1.8
+    1093200n 0
+    1093249n 0
+    1093250n 1.8
+    1093299n 1.8
+    1093300n 0
+    1093349n 0
+    1093350n 1.8
+    1093399n 1.8
+    1093400n 0
+    1093449n 0
+    1093450n 1.8
+    1093499n 1.8
+    1093500n 0
+    1093549n 0
+    1093550n 1.8
+    1093599n 1.8
+    1093600n 0
+    1093649n 0
+    1093650n 1.8
+    1093699n 1.8
+    1093700n 0
+    1093749n 0
+    1093750n 1.8
+    1093799n 1.8
+    1093800n 0
+    1093849n 0
+    1093850n 1.8
+    1093899n 1.8
+    1093900n 0
+    1093949n 0
+    1093950n 1.8
+    1093999n 1.8
+    1094000n 0
+    1094049n 0
+    1094050n 1.8
+    1094099n 1.8
+    1094100n 0
+    1094149n 0
+    1094150n 1.8
+    1094199n 1.8
+    1094200n 0
+    1094249n 0
+    1094250n 1.8
+    1094299n 1.8
+    1094300n 0
+    1094349n 0
+    1094350n 1.8
+    1094399n 1.8
+    1094400n 0
+    1094449n 0
+    1094450n 1.8
+    1094499n 1.8
+    1094500n 0
+    1094549n 0
+    1094550n 1.8
+    1094599n 1.8
+    1094600n 0
+    1094649n 0
+    1094650n 1.8
+    1094699n 1.8
+    1094700n 0
+    1094749n 0
+    1094750n 1.8
+    1094799n 1.8
+    1094800n 0
+    1094849n 0
+    1094850n 1.8
+    1094899n 1.8
+    1094900n 0
+    1094949n 0
+    1094950n 1.8
+    1094999n 1.8
+    1095000n 0
+    1095049n 0
+    1095050n 1.8
+    1095099n 1.8
+    1095100n 0
+    1095149n 0
+    1095150n 1.8
+    1095199n 1.8
+    1095200n 0
+    1095249n 0
+    1095250n 1.8
+    1095299n 1.8
+    1095300n 0
+    1095349n 0
+    1095350n 1.8
+    1095399n 1.8
+    1095400n 0
+    1095449n 0
+    1095450n 1.8
+    1095499n 1.8
+    1095500n 0
+    1095549n 0
+    1095550n 1.8
+    1095599n 1.8
+    1095600n 0
+    1095649n 0
+    1095650n 1.8
+    1095699n 1.8
+    1095700n 0
+    1095749n 0
+    1095750n 1.8
+    1095799n 1.8
+    1095800n 0
+    1095849n 0
+    1095850n 1.8
+    1095899n 1.8
+    1095900n 0
+    1095949n 0
+    1095950n 1.8
+    1095999n 1.8
+    1096000n 0
+    1096049n 0
+    1096050n 1.8
+    1096099n 1.8
+    1096100n 0
+    1096149n 0
+    1096150n 1.8
+    1096199n 1.8
+    1096200n 0
+    1096249n 0
+    1096250n 1.8
+    1096299n 1.8
+    1096300n 0
+    1096349n 0
+    1096350n 1.8
+    1096399n 1.8
+    1096400n 0
+    1096449n 0
+    1096450n 1.8
+    1096499n 1.8
+    1096500n 0
+    1096549n 0
+    1096550n 1.8
+    1096599n 1.8
+    1096600n 0
+    1096649n 0
+    1096650n 1.8
+    1096699n 1.8
+    1096700n 0
+    1096749n 0
+    1096750n 1.8
+    1096799n 1.8
+    1096800n 0
+    1096849n 0
+    1096850n 1.8
+    1096899n 1.8
+    1096900n 0
+    1096949n 0
+    1096950n 1.8
+    1096999n 1.8
+    1097000n 0
+    1097049n 0
+    1097050n 1.8
+    1097099n 1.8
+    1097100n 0
+    1097149n 0
+    1097150n 1.8
+    1097199n 1.8
+    1097200n 0
+    1097249n 0
+    1097250n 1.8
+    1097299n 1.8
+    1097300n 0
+    1097349n 0
+    1097350n 1.8
+    1097399n 1.8
+    1097400n 0
+    1097449n 0
+    1097450n 1.8
+    1097499n 1.8
+    1097500n 0
+    1097549n 0
+    1097550n 1.8
+    1097599n 1.8
+    1097600n 0
+    1097649n 0
+    1097650n 1.8
+    1097699n 1.8
+    1097700n 0
+    1097749n 0
+    1097750n 1.8
+    1097799n 1.8
+    1097800n 0
+    1097849n 0
+    1097850n 1.8
+    1097899n 1.8
+    1097900n 0
+    1097949n 0
+    1097950n 1.8
+    1097999n 1.8
+    1098000n 0
+    1098049n 0
+    1098050n 1.8
+    1098099n 1.8
+    1098100n 0
+    1098149n 0
+    1098150n 1.8
+    1098199n 1.8
+    1098200n 0
+    1098249n 0
+    1098250n 1.8
+    1098299n 1.8
+    1098300n 0
+    1098349n 0
+    1098350n 1.8
+    1098399n 1.8
+    1098400n 0
+    1098449n 0
+    1098450n 1.8
+    1098499n 1.8
+    1098500n 0
+    1098549n 0
+    1098550n 1.8
+    1098599n 1.8
+    1098600n 0
+    1098649n 0
+    1098650n 1.8
+    1098699n 1.8
+    1098700n 0
+    1098749n 0
+    1098750n 1.8
+    1098799n 1.8
+    1098800n 0
+    1098849n 0
+    1098850n 1.8
+    1098899n 1.8
+    1098900n 0
+    1098949n 0
+    1098950n 1.8
+    1098999n 1.8
+    1099000n 0
+    1099049n 0
+    1099050n 1.8
+    1099099n 1.8
+    1099100n 0
+    1099149n 0
+    1099150n 1.8
+    1099199n 1.8
+    1099200n 0
+    1099249n 0
+    1099250n 1.8
+    1099299n 1.8
+    1099300n 0
+    1099349n 0
+    1099350n 1.8
+    1099399n 1.8
+    1099400n 0
+    1099449n 0
+    1099450n 1.8
+    1099499n 1.8
+    1099500n 0
+    1099549n 0
+    1099550n 1.8
+    1099599n 1.8
+    1099600n 0
+    1099649n 0
+    1099650n 1.8
+    1099699n 1.8
+    1099700n 0
+    1099749n 0
+    1099750n 1.8
+    1099799n 1.8
+    1099800n 0
+    1099849n 0
+    1099850n 1.8
+    1099899n 1.8
+    1099900n 0
+    1099949n 0
+    1099950n 1.8
+    1099999n 1.8
+    1100000n 0
+    1100049n 0
+    1100050n 1.8
+    1100099n 1.8
+    1100100n 0
+    1100149n 0
+    1100150n 1.8
+    1100199n 1.8
+    1100200n 0
+    1100249n 0
+    1100250n 1.8
+    1100299n 1.8
+    1100300n 0
+    1100349n 0
+    1100350n 1.8
+    1100399n 1.8
+    1100400n 0
+    1100449n 0
+    1100450n 1.8
+    1100499n 1.8
+    1100500n 0
+    1100549n 0
+    1100550n 1.8
+    1100599n 1.8
+    1100600n 0
+    1100649n 0
+    1100650n 1.8
+    1100699n 1.8
+    1100700n 0
+    1100749n 0
+    1100750n 1.8
+    1100799n 1.8
+    1100800n 0
+    1100849n 0
+    1100850n 1.8
+    1100899n 1.8
+    1100900n 0
+    1100949n 0
+    1100950n 1.8
+    1100999n 1.8
+    1101000n 0
+    1101049n 0
+    1101050n 1.8
+    1101099n 1.8
+    1101100n 0
+    1101149n 0
+    1101150n 1.8
+    1101199n 1.8
+    1101200n 0
+    1101249n 0
+    1101250n 1.8
+    1101299n 1.8
+    1101300n 0
+    1101349n 0
+    1101350n 1.8
+    1101399n 1.8
+    1101400n 0
+    1101449n 0
+    1101450n 1.8
+    1101499n 1.8
+    1101500n 0
+    1101549n 0
+    1101550n 1.8
+    1101599n 1.8
+    1101600n 0
+    1101649n 0
+    1101650n 1.8
+    1101699n 1.8
+    1101700n 0
+    1101749n 0
+    1101750n 1.8
+    1101799n 1.8
+    1101800n 0
+    1101849n 0
+    1101850n 1.8
+    1101899n 1.8
+    1101900n 0
+    1101949n 0
+    1101950n 1.8
+    1101999n 1.8
+    1102000n 0
+    1102049n 0
+    1102050n 1.8
+    1102099n 1.8
+    1102100n 0
+    1102149n 0
+    1102150n 1.8
+    1102199n 1.8
+    1102200n 0
+    1102249n 0
+    1102250n 1.8
+    1102299n 1.8
+    1102300n 0
+    1102349n 0
+    1102350n 1.8
+    1102399n 1.8
+    1102400n 0
+    1102449n 0
+    1102450n 1.8
+    1102499n 1.8
+    1102500n 0
+    1102549n 0
+    1102550n 1.8
+    1102599n 1.8
+    1102600n 0
+    1102649n 0
+    1102650n 1.8
+    1102699n 1.8
+    1102700n 0
+    1102749n 0
+    1102750n 1.8
+    1102799n 1.8
+    1102800n 0
+    1102849n 0
+    1102850n 1.8
+    1102899n 1.8
+    1102900n 0
+    1102949n 0
+    1102950n 1.8
+    1102999n 1.8
+    1103000n 0
+    1103049n 0
+    1103050n 1.8
+    1103099n 1.8
+    1103100n 0
+    1103149n 0
+    1103150n 1.8
+    1103199n 1.8
+    1103200n 0
+    1103249n 0
+    1103250n 1.8
+    1103299n 1.8
+    1103300n 0
+    1103349n 0
+    1103350n 1.8
+    1103399n 1.8
+    1103400n 0
+    1103449n 0
+    1103450n 1.8
+    1103499n 1.8
+    1103500n 0
+    1103549n 0
+    1103550n 1.8
+    1103599n 1.8
+    1103600n 0
+    1103649n 0
+    1103650n 1.8
+    1103699n 1.8
+    1103700n 0
+    1103749n 0
+    1103750n 1.8
+    1103799n 1.8
+    1103800n 0
+    1103849n 0
+    1103850n 1.8
+    1103899n 1.8
+    1103900n 0
+    1103949n 0
+    1103950n 1.8
+    1103999n 1.8
+    1104000n 0
+    1104049n 0
+    1104050n 1.8
+    1104099n 1.8
+    1104100n 0
+    1104149n 0
+    1104150n 1.8
+    1104199n 1.8
+    1104200n 0
+    1104249n 0
+    1104250n 1.8
+    1104299n 1.8
+    1104300n 0
+    1104349n 0
+    1104350n 1.8
+    1104399n 1.8
+    1104400n 0
+    1104449n 0
+    1104450n 1.8
+    1104499n 1.8
+    1104500n 0
+    1104549n 0
+    1104550n 1.8
+    1104599n 1.8
+    1104600n 0
+    1104649n 0
+    1104650n 1.8
+    1104699n 1.8
+    1104700n 0
+    1104749n 0
+    1104750n 1.8
+    1104799n 1.8
+    1104800n 0
+    1104849n 0
+    1104850n 1.8
+    1104899n 1.8
+    1104900n 0
+    1104949n 0
+    1104950n 1.8
+    1104999n 1.8
+    1105000n 0
+    1105049n 0
+    1105050n 1.8
+    1105099n 1.8
+    1105100n 0
+    1105149n 0
+    1105150n 1.8
+    1105199n 1.8
+    1105200n 0
+    1105249n 0
+    1105250n 1.8
+    1105299n 1.8
+    1105300n 0
+    1105349n 0
+    1105350n 1.8
+    1105399n 1.8
+    1105400n 0
+    1105449n 0
+    1105450n 1.8
+    1105499n 1.8
+    1105500n 0
+    1105549n 0
+    1105550n 1.8
+    1105599n 1.8
+    1105600n 0
+    1105649n 0
+    1105650n 1.8
+    1105699n 1.8
+    1105700n 0
+    1105749n 0
+    1105750n 1.8
+    1105799n 1.8
+    1105800n 0
+    1105849n 0
+    1105850n 1.8
+    1105899n 1.8
+    1105900n 0
+    1105949n 0
+    1105950n 1.8
+    1105999n 1.8
+    1106000n 0
+    1106049n 0
+    1106050n 1.8
+    1106099n 1.8
+    1106100n 0
+    1106149n 0
+    1106150n 1.8
+    1106199n 1.8
+    1106200n 0
+    1106249n 0
+    1106250n 1.8
+    1106299n 1.8
+    1106300n 0
+    1106349n 0
+    1106350n 1.8
+    1106399n 1.8
+    1106400n 0
+    1106449n 0
+    1106450n 1.8
+    1106499n 1.8
+    1106500n 0
+    1106549n 0
+    1106550n 1.8
+    1106599n 1.8
+    1106600n 0
+    1106649n 0
+    1106650n 1.8
+    1106699n 1.8
+    1106700n 0
+    1106749n 0
+    1106750n 1.8
+    1106799n 1.8
+    1106800n 0
+    1106849n 0
+    1106850n 1.8
+    1106899n 1.8
+    1106900n 0
+    1106949n 0
+    1106950n 1.8
+    1106999n 1.8
+    1107000n 0
+    1107049n 0
+    1107050n 1.8
+    1107099n 1.8
+    1107100n 0
+    1107149n 0
+    1107150n 1.8
+    1107199n 1.8
+    1107200n 0
+    1107249n 0
+    1107250n 1.8
+    1107299n 1.8
+    1107300n 0
+    1107349n 0
+    1107350n 1.8
+    1107399n 1.8
+    1107400n 0
+    1107449n 0
+    1107450n 1.8
+    1107499n 1.8
+    1107500n 0
+    1107549n 0
+    1107550n 1.8
+    1107599n 1.8
+    1107600n 0
+    1107649n 0
+    1107650n 1.8
+    1107699n 1.8
+    1107700n 0
+    1107749n 0
+    1107750n 1.8
+    1107799n 1.8
+    1107800n 0
+    1107849n 0
+    1107850n 1.8
+    1107899n 1.8
+    1107900n 0
+    1107949n 0
+    1107950n 1.8
+    1107999n 1.8
+    1108000n 0
+    1108049n 0
+    1108050n 1.8
+    1108099n 1.8
+    1108100n 0
+    1108149n 0
+    1108150n 1.8
+    1108199n 1.8
+    1108200n 0
+    1108249n 0
+    1108250n 1.8
+    1108299n 1.8
+    1108300n 0
+    1108349n 0
+    1108350n 1.8
+    1108399n 1.8
+    1108400n 0
+    1108449n 0
+    1108450n 1.8
+    1108499n 1.8
+    1108500n 0
+    1108549n 0
+    1108550n 1.8
+    1108599n 1.8
+    1108600n 0
+    1108649n 0
+    1108650n 1.8
+    1108699n 1.8
+    1108700n 0
+    1108749n 0
+    1108750n 1.8
+    1108799n 1.8
+    1108800n 0
+    1108849n 0
+    1108850n 1.8
+    1108899n 1.8
+    1108900n 0
+    1108949n 0
+    1108950n 1.8
+    1108999n 1.8
+    1109000n 0
+    1109049n 0
+    1109050n 1.8
+    1109099n 1.8
+    1109100n 0
+    1109149n 0
+    1109150n 1.8
+    1109199n 1.8
+    1109200n 0
+    1109249n 0
+    1109250n 1.8
+    1109299n 1.8
+    1109300n 0
+    1109349n 0
+    1109350n 1.8
+    1109399n 1.8
+    1109400n 0
+    1109449n 0
+    1109450n 1.8
+    1109499n 1.8
+    1109500n 0
+    1109549n 0
+    1109550n 1.8
+    1109599n 1.8
+    1109600n 0
+    1109649n 0
+    1109650n 1.8
+    1109699n 1.8
+    1109700n 0
+    1109749n 0
+    1109750n 1.8
+    1109799n 1.8
+    1109800n 0
+    1109849n 0
+    1109850n 1.8
+    1109899n 1.8
+    1109900n 0
+    1109949n 0
+    1109950n 1.8
+    1109999n 1.8
+    1110000n 0
+    1110049n 0
+    1110050n 1.8
+    1110099n 1.8
+    1110100n 0
+    1110149n 0
+    1110150n 1.8
+    1110199n 1.8
+    1110200n 0
+    1110249n 0
+    1110250n 1.8
+    1110299n 1.8
+    1110300n 0
+    1110349n 0
+    1110350n 1.8
+    1110399n 1.8
+    1110400n 0
+    1110449n 0
+    1110450n 1.8
+    1110499n 1.8
+    1110500n 0
+    1110549n 0
+    1110550n 1.8
+    1110599n 1.8
+    1110600n 0
+    1110649n 0
+    1110650n 1.8
+    1110699n 1.8
+    1110700n 0
+    1110749n 0
+    1110750n 1.8
+    1110799n 1.8
+    1110800n 0
+    1110849n 0
+    1110850n 1.8
+    1110899n 1.8
+    1110900n 0
+    1110949n 0
+    1110950n 1.8
+    1110999n 1.8
+    1111000n 0
+    1111049n 0
+    1111050n 1.8
+    1111099n 1.8
+    1111100n 0
+    1111149n 0
+    1111150n 1.8
+    1111199n 1.8
+    1111200n 0
+    1111249n 0
+    1111250n 1.8
+    1111299n 1.8
+    1111300n 0
+    1111349n 0
+    1111350n 1.8
+    1111399n 1.8
+    1111400n 0
+    1111449n 0
+    1111450n 1.8
+    1111499n 1.8
+    1111500n 0
+    1111549n 0
+    1111550n 1.8
+    1111599n 1.8
+    1111600n 0
+    1111649n 0
+    1111650n 1.8
+    1111699n 1.8
+    1111700n 0
+    1111749n 0
+    1111750n 1.8
+    1111799n 1.8
+    1111800n 0
+    1111849n 0
+    1111850n 1.8
+    1111899n 1.8
+    1111900n 0
+    1111949n 0
+    1111950n 1.8
+    1111999n 1.8
+    1112000n 0
+    1112049n 0
+    1112050n 1.8
+    1112099n 1.8
+    1112100n 0
+    1112149n 0
+    1112150n 1.8
+    1112199n 1.8
+    1112200n 0
+    1112249n 0
+    1112250n 1.8
+    1112299n 1.8
+    1112300n 0
+    1112349n 0
+    1112350n 1.8
+    1112399n 1.8
+    1112400n 0
+    1112449n 0
+    1112450n 1.8
+    1112499n 1.8
+    1112500n 0
+    1112549n 0
+    1112550n 1.8
+    1112599n 1.8
+    1112600n 0
+    1112649n 0
+    1112650n 1.8
+    1112699n 1.8
+    1112700n 0
+    1112749n 0
+    1112750n 1.8
+    1112799n 1.8
+    1112800n 0
+    1112849n 0
+    1112850n 1.8
+    1112899n 1.8
+    1112900n 0
+    1112949n 0
+    1112950n 1.8
+    1112999n 1.8
+    1113000n 0
+    1113049n 0
+    1113050n 1.8
+    1113099n 1.8
+    1113100n 0
+    1113149n 0
+    1113150n 1.8
+    1113199n 1.8
+    1113200n 0
+    1113249n 0
+    1113250n 1.8
+    1113299n 1.8
+    1113300n 0
+    1113349n 0
+    1113350n 1.8
+    1113399n 1.8
+    1113400n 0
+    1113449n 0
+    1113450n 1.8
+    1113499n 1.8
+    1113500n 0
+    1113549n 0
+    1113550n 1.8
+    1113599n 1.8
+    1113600n 0
+    1113649n 0
+    1113650n 1.8
+    1113699n 1.8
+    1113700n 0
+    1113749n 0
+    1113750n 1.8
+    1113799n 1.8
+    1113800n 0
+    1113849n 0
+    1113850n 1.8
+    1113899n 1.8
+    1113900n 0
+    1113949n 0
+    1113950n 1.8
+    1113999n 1.8
+    1114000n 0
+    1114049n 0
+    1114050n 1.8
+    1114099n 1.8
+    1114100n 0
+    1114149n 0
+    1114150n 1.8
+    1114199n 1.8
+    1114200n 0
+    1114249n 0
+    1114250n 1.8
+    1114299n 1.8
+    1114300n 0
+    1114349n 0
+    1114350n 1.8
+    1114399n 1.8
+    1114400n 0
+    1114449n 0
+    1114450n 1.8
+    1114499n 1.8
+    1114500n 0
+    1114549n 0
+    1114550n 1.8
+    1114599n 1.8
+    1114600n 0
+    1114649n 0
+    1114650n 1.8
+    1114699n 1.8
+    1114700n 0
+    1114749n 0
+    1114750n 1.8
+    1114799n 1.8
+    1114800n 0
+    1114849n 0
+    1114850n 1.8
+    1114899n 1.8
+    1114900n 0
+    1114949n 0
+    1114950n 1.8
+    1114999n 1.8
+    1115000n 0
+    1115049n 0
+    1115050n 1.8
+    1115099n 1.8
+    1115100n 0
+    1115149n 0
+    1115150n 1.8
+    1115199n 1.8
+    1115200n 0
+    1115249n 0
+    1115250n 1.8
+    1115299n 1.8
+    1115300n 0
+    1115349n 0
+    1115350n 1.8
+    1115399n 1.8
+    1115400n 0
+    1115449n 0
+    1115450n 1.8
+    1115499n 1.8
+    1115500n 0
+    1115549n 0
+    1115550n 1.8
+    1115599n 1.8
+    1115600n 0
+    1115649n 0
+    1115650n 1.8
+    1115699n 1.8
+    1115700n 0
+    1115749n 0
+    1115750n 1.8
+    1115799n 1.8
+    1115800n 0
+    1115849n 0
+    1115850n 1.8
+    1115899n 1.8
+    1115900n 0
+    1115949n 0
+    1115950n 1.8
+    1115999n 1.8
+    1116000n 0
+    1116049n 0
+    1116050n 1.8
+    1116099n 1.8
+    1116100n 0
+    1116149n 0
+    1116150n 1.8
+    1116199n 1.8
+    1116200n 0
+    1116249n 0
+    1116250n 1.8
+    1116299n 1.8
+    1116300n 0
+    1116349n 0
+    1116350n 1.8
+    1116399n 1.8
+    1116400n 0
+    1116449n 0
+    1116450n 1.8
+    1116499n 1.8
+    1116500n 0
+    1116549n 0
+    1116550n 1.8
+    1116599n 1.8
+    1116600n 0
+    1116649n 0
+    1116650n 1.8
+    1116699n 1.8
+    1116700n 0
+    1116749n 0
+    1116750n 1.8
+    1116799n 1.8
+    1116800n 0
+    1116849n 0
+    1116850n 1.8
+    1116899n 1.8
+    1116900n 0
+    1116949n 0
+    1116950n 1.8
+    1116999n 1.8
+    1117000n 0
+    1117049n 0
+    1117050n 1.8
+    1117099n 1.8
+    1117100n 0
+    1117149n 0
+    1117150n 1.8
+    1117199n 1.8
+    1117200n 0
+    1117249n 0
+    1117250n 1.8
+    1117299n 1.8
+    1117300n 0
+    1117349n 0
+    1117350n 1.8
+    1117399n 1.8
+    1117400n 0
+    1117449n 0
+    1117450n 1.8
+    1117499n 1.8
+    1117500n 0
+    1117549n 0
+    1117550n 1.8
+    1117599n 1.8
+    1117600n 0
+    1117649n 0
+    1117650n 1.8
+    1117699n 1.8
+    1117700n 0
+    1117749n 0
+    1117750n 1.8
+    1117799n 1.8
+    1117800n 0
+    1117849n 0
+    1117850n 1.8
+    1117899n 1.8
+    1117900n 0
+    1117949n 0
+    1117950n 1.8
+    1117999n 1.8
+    1118000n 0
+    1118049n 0
+    1118050n 1.8
+    1118099n 1.8
+    1118100n 0
+    1118149n 0
+    1118150n 1.8
+    1118199n 1.8
+    1118200n 0
+    1118249n 0
+    1118250n 1.8
+    1118299n 1.8
+    1118300n 0
+    1118349n 0
+    1118350n 1.8
+    1118399n 1.8
+    1118400n 0
+    1118449n 0
+    1118450n 1.8
+    1118499n 1.8
+    1118500n 0
+    1118549n 0
+    1118550n 1.8
+    1118599n 1.8
+    1118600n 0
+    1118649n 0
+    1118650n 1.8
+    1118699n 1.8
+    1118700n 0
+    1118749n 0
+    1118750n 1.8
+    1118799n 1.8
+    1118800n 0
+    1118849n 0
+    1118850n 1.8
+    1118899n 1.8
+    1118900n 0
+    1118949n 0
+    1118950n 1.8
+    1118999n 1.8
+    1119000n 0
+    1119049n 0
+    1119050n 1.8
+    1119099n 1.8
+    1119100n 0
+    1119149n 0
+    1119150n 1.8
+    1119199n 1.8
+    1119200n 0
+    1119249n 0
+    1119250n 1.8
+    1119299n 1.8
+    1119300n 0
+    1119349n 0
+    1119350n 1.8
+    1119399n 1.8
+    1119400n 0
+    1119449n 0
+    1119450n 1.8
+    1119499n 1.8
+    1119500n 0
+    1119549n 0
+    1119550n 1.8
+    1119599n 1.8
+    1119600n 0
+    1119649n 0
+    1119650n 1.8
+    1119699n 1.8
+    1119700n 0
+    1119749n 0
+    1119750n 1.8
+    1119799n 1.8
+    1119800n 0
+    1119849n 0
+    1119850n 1.8
+    1119899n 1.8
+    1119900n 0
+    1119949n 0
+    1119950n 1.8
+    1119999n 1.8
+    1120000n 0
+    1120049n 0
+    1120050n 1.8
+    1120099n 1.8
+    1120100n 0
+    1120149n 0
+    1120150n 1.8
+    1120199n 1.8
+    1120200n 0
+    1120249n 0
+    1120250n 1.8
+    1120299n 1.8
+    1120300n 0
+    1120349n 0
+    1120350n 1.8
+    1120399n 1.8
+    1120400n 0
+    1120449n 0
+    1120450n 1.8
+    1120499n 1.8
+    1120500n 0
+    1120549n 0
+    1120550n 1.8
+    1120599n 1.8
+    1120600n 0
+    1120649n 0
+    1120650n 1.8
+    1120699n 1.8
+    1120700n 0
+    1120749n 0
+    1120750n 1.8
+    1120799n 1.8
+    1120800n 0
+    1120849n 0
+    1120850n 1.8
+    1120899n 1.8
+    1120900n 0
+    1120949n 0
+    1120950n 1.8
+    1120999n 1.8
+    1121000n 0
+    1121049n 0
+    1121050n 1.8
+    1121099n 1.8
+    1121100n 0
+    1121149n 0
+    1121150n 1.8
+    1121199n 1.8
+    1121200n 0
+    1121249n 0
+    1121250n 1.8
+    1121299n 1.8
+    1121300n 0
+    1121349n 0
+    1121350n 1.8
+    1121399n 1.8
+    1121400n 0
+    1121449n 0
+    1121450n 1.8
+    1121499n 1.8
+    1121500n 0
+    1121549n 0
+    1121550n 1.8
+    1121599n 1.8
+    1121600n 0
+    1121649n 0
+    1121650n 1.8
+    1121699n 1.8
+    1121700n 0
+    1121749n 0
+    1121750n 1.8
+    1121799n 1.8
+    1121800n 0
+    1121849n 0
+    1121850n 1.8
+    1121899n 1.8
+    1121900n 0
+    1121949n 0
+    1121950n 1.8
+    1121999n 1.8
+    1122000n 0
+    1122049n 0
+    1122050n 1.8
+    1122099n 1.8
+    1122100n 0
+    1122149n 0
+    1122150n 1.8
+    1122199n 1.8
+    1122200n 0
+    1122249n 0
+    1122250n 1.8
+    1122299n 1.8
+    1122300n 0
+    1122349n 0
+    1122350n 1.8
+    1122399n 1.8
+    1122400n 0
+    1122449n 0
+    1122450n 1.8
+    1122499n 1.8
+    1122500n 0
+    1122549n 0
+    1122550n 1.8
+    1122599n 1.8
+    1122600n 0
+    1122649n 0
+    1122650n 1.8
+    1122699n 1.8
+    1122700n 0
+    1122749n 0
+    1122750n 1.8
+    1122799n 1.8
+    1122800n 0
+    1122849n 0
+    1122850n 1.8
+    1122899n 1.8
+    1122900n 0
+    1122949n 0
+    1122950n 1.8
+    1122999n 1.8
+    1123000n 0
+    1123049n 0
+    1123050n 1.8
+    1123099n 1.8
+    1123100n 0
+    1123149n 0
+    1123150n 1.8
+    1123199n 1.8
+    1123200n 0
+    1123249n 0
+    1123250n 1.8
+    1123299n 1.8
+    1123300n 0
+    1123349n 0
+    1123350n 1.8
+    1123399n 1.8
+    1123400n 0
+    1123449n 0
+    1123450n 1.8
+    1123499n 1.8
+    1123500n 0
+    1123549n 0
+    1123550n 1.8
+    1123599n 1.8
+    1123600n 0
+    1123649n 0
+    1123650n 1.8
+    1123699n 1.8
+    1123700n 0
+    1123749n 0
+    1123750n 1.8
+    1123799n 1.8
+    1123800n 0
+    1123849n 0
+    1123850n 1.8
+    1123899n 1.8
+    1123900n 0
+    1123949n 0
+    1123950n 1.8
+    1123999n 1.8
+    1124000n 0
+    1124049n 0
+    1124050n 1.8
+    1124099n 1.8
+    1124100n 0
+    1124149n 0
+    1124150n 1.8
+    1124199n 1.8
+    1124200n 0
+    1124249n 0
+    1124250n 1.8
+    1124299n 1.8
+    1124300n 0
+    1124349n 0
+    1124350n 1.8
+    1124399n 1.8
+    1124400n 0
+    1124449n 0
+    1124450n 1.8
+    1124499n 1.8
+    1124500n 0
+    1124549n 0
+    1124550n 1.8
+    1124599n 1.8
+    1124600n 0
+    1124649n 0
+    1124650n 1.8
+    1124699n 1.8
+    1124700n 0
+    1124749n 0
+    1124750n 1.8
+    1124799n 1.8
+    1124800n 0
+    1124849n 0
+    1124850n 1.8
+    1124899n 1.8
+    1124900n 0
+    1124949n 0
+    1124950n 1.8
+    1124999n 1.8
+    1125000n 0
+    1125049n 0
+    1125050n 1.8
+    1125099n 1.8
+    1125100n 0
+    1125149n 0
+    1125150n 1.8
+    1125199n 1.8
+    1125200n 0
+    1125249n 0
+    1125250n 1.8
+    1125299n 1.8
+    1125300n 0
+    1125349n 0
+    1125350n 1.8
+    1125399n 1.8
+    1125400n 0
+    1125449n 0
+    1125450n 1.8
+    1125499n 1.8
+    1125500n 0
+    1125549n 0
+    1125550n 1.8
+    1125599n 1.8
+    1125600n 0
+    1125649n 0
+    1125650n 1.8
+    1125699n 1.8
+    1125700n 0
+    1125749n 0
+    1125750n 1.8
+    1125799n 1.8
+    1125800n 0
+    1125849n 0
+    1125850n 1.8
+    1125899n 1.8
+    1125900n 0
+    1125949n 0
+    1125950n 1.8
+    1125999n 1.8
+    1126000n 0
+    1126049n 0
+    1126050n 1.8
+    1126099n 1.8
+    1126100n 0
+    1126149n 0
+    1126150n 1.8
+    1126199n 1.8
+    1126200n 0
+    1126249n 0
+    1126250n 1.8
+    1126299n 1.8
+    1126300n 0
+    1126349n 0
+    1126350n 1.8
+    1126399n 1.8
+    1126400n 0
+    1126449n 0
+    1126450n 1.8
+    1126499n 1.8
+    1126500n 0
+    1126549n 0
+    1126550n 1.8
+    1126599n 1.8
+    1126600n 0
+    1126649n 0
+    1126650n 1.8
+    1126699n 1.8
+    1126700n 0
+    1126749n 0
+    1126750n 1.8
+    1126799n 1.8
+    1126800n 0
+    1126849n 0
+    1126850n 1.8
+    1126899n 1.8
+    1126900n 0
+    1126949n 0
+    1126950n 1.8
+    1126999n 1.8
+    1127000n 0
+    1127049n 0
+    1127050n 1.8
+    1127099n 1.8
+    1127100n 0
+    1127149n 0
+    1127150n 1.8
+    1127199n 1.8
+    1127200n 0
+    1127249n 0
+    1127250n 1.8
+    1127299n 1.8
+    1127300n 0
+    1127349n 0
+    1127350n 1.8
+    1127399n 1.8
+    1127400n 0
+    1127449n 0
+    1127450n 1.8
+    1127499n 1.8
+    1127500n 0
+    1127549n 0
+    1127550n 1.8
+    1127599n 1.8
+    1127600n 0
+    1127649n 0
+    1127650n 1.8
+    1127699n 1.8
+    1127700n 0
+    1127749n 0
+    1127750n 1.8
+    1127799n 1.8
+    1127800n 0
+    1127849n 0
+    1127850n 1.8
+    1127899n 1.8
+    1127900n 0
+    1127949n 0
+    1127950n 1.8
+    1127999n 1.8
+    1128000n 0
+    1128049n 0
+    1128050n 1.8
+    1128099n 1.8
+    1128100n 0
+    1128149n 0
+    1128150n 1.8
+    1128199n 1.8
+    1128200n 0
+    1128249n 0
+    1128250n 1.8
+    1128299n 1.8
+    1128300n 0
+    1128349n 0
+    1128350n 1.8
+    1128399n 1.8
+    1128400n 0
+    1128449n 0
+    1128450n 1.8
+    1128499n 1.8
+    1128500n 0
+    1128549n 0
+    1128550n 1.8
+    1128599n 1.8
+    1128600n 0
+    1128649n 0
+    1128650n 1.8
+    1128699n 1.8
+    1128700n 0
+    1128749n 0
+    1128750n 1.8
+    1128799n 1.8
+    1128800n 0
+    1128849n 0
+    1128850n 1.8
+    1128899n 1.8
+    1128900n 0
+    1128949n 0
+    1128950n 1.8
+    1128999n 1.8
+    1129000n 0
+    1129049n 0
+    1129050n 1.8
+    1129099n 1.8
+    1129100n 0
+    1129149n 0
+    1129150n 1.8
+    1129199n 1.8
+    1129200n 0
+    1129249n 0
+    1129250n 1.8
+    1129299n 1.8
+    1129300n 0
+    1129349n 0
+    1129350n 1.8
+    1129399n 1.8
+    1129400n 0
+    1129449n 0
+    1129450n 1.8
+    1129499n 1.8
+    1129500n 0
+    1129549n 0
+    1129550n 1.8
+    1129599n 1.8
+    1129600n 0
+    1129649n 0
+    1129650n 1.8
+    1129699n 1.8
+    1129700n 0
+    1129749n 0
+    1129750n 1.8
+    1129799n 1.8
+    1129800n 0
+    1129849n 0
+    1129850n 1.8
+    1129899n 1.8
+    1129900n 0
+    1129949n 0
+    1129950n 1.8
+    1129999n 1.8
+    1130000n 0
+    1130049n 0
+    1130050n 1.8
+    1130099n 1.8
+    1130100n 0
+    1130149n 0
+    1130150n 1.8
+    1130199n 1.8
+    1130200n 0
+    1130249n 0
+    1130250n 1.8
+    1130299n 1.8
+    1130300n 0
+    1130349n 0
+    1130350n 1.8
+    1130399n 1.8
+    1130400n 0
+    1130449n 0
+    1130450n 1.8
+    1130499n 1.8
+    1130500n 0
+    1130549n 0
+    1130550n 1.8
+    1130599n 1.8
+    1130600n 0
+    1130649n 0
+    1130650n 1.8
+    1130699n 1.8
+    1130700n 0
+    1130749n 0
+    1130750n 1.8
+    1130799n 1.8
+    1130800n 0
+    1130849n 0
+    1130850n 1.8
+    1130899n 1.8
+    1130900n 0
+    1130949n 0
+    1130950n 1.8
+    1130999n 1.8
+    1131000n 0
+    1131049n 0
+    1131050n 1.8
+    1131099n 1.8
+    1131100n 0
+    1131149n 0
+    1131150n 1.8
+    1131199n 1.8
+    1131200n 0
+    1131249n 0
+    1131250n 1.8
+    1131299n 1.8
+    1131300n 0
+    1131349n 0
+    1131350n 1.8
+    1131399n 1.8
+    1131400n 0
+    1131449n 0
+    1131450n 1.8
+    1131499n 1.8
+    1131500n 0
+    1131549n 0
+    1131550n 1.8
+    1131599n 1.8
+    1131600n 0
+    1131649n 0
+    1131650n 1.8
+    1131699n 1.8
+    1131700n 0
+    1131749n 0
+    1131750n 1.8
+    1131799n 1.8
+    1131800n 0
+    1131849n 0
+    1131850n 1.8
+    1131899n 1.8
+    1131900n 0
+    1131949n 0
+    1131950n 1.8
+    1131999n 1.8
+    1132000n 0
+    1132049n 0
+    1132050n 1.8
+    1132099n 1.8
+    1132100n 0
+    1132149n 0
+    1132150n 1.8
+    1132199n 1.8
+    1132200n 0
+    1132249n 0
+    1132250n 1.8
+    1132299n 1.8
+    1132300n 0
+    1132349n 0
+    1132350n 1.8
+    1132399n 1.8
+    1132400n 0
+    1132449n 0
+    1132450n 1.8
+    1132499n 1.8
+    1132500n 0
+    1132549n 0
+    1132550n 1.8
+    1132599n 1.8
+    1132600n 0
+    1132649n 0
+    1132650n 1.8
+    1132699n 1.8
+    1132700n 0
+    1132749n 0
+    1132750n 1.8
+    1132799n 1.8
+    1132800n 0
+    1132849n 0
+    1132850n 1.8
+    1132899n 1.8
+    1132900n 0
+    1132949n 0
+    1132950n 1.8
+    1132999n 1.8
+    1133000n 0
+    1133049n 0
+    1133050n 1.8
+    1133099n 1.8
+    1133100n 0
+    1133149n 0
+    1133150n 1.8
+    1133199n 1.8
+    1133200n 0
+    1133249n 0
+    1133250n 1.8
+    1133299n 1.8
+    1133300n 0
+    1133349n 0
+    1133350n 1.8
+    1133399n 1.8
+    1133400n 0
+    1133449n 0
+    1133450n 1.8
+    1133499n 1.8
+    1133500n 0
+    1133549n 0
+    1133550n 1.8
+    1133599n 1.8
+    1133600n 0
+    1133649n 0
+    1133650n 1.8
+    1133699n 1.8
+    1133700n 0
+    1133749n 0
+    1133750n 1.8
+    1133799n 1.8
+    1133800n 0
+    1133849n 0
+    1133850n 1.8
+    1133899n 1.8
+    1133900n 0
+    1133949n 0
+    1133950n 1.8
+    1133999n 1.8
+    1134000n 0
+    1134049n 0
+    1134050n 1.8
+    1134099n 1.8
+    1134100n 0
+    1134149n 0
+    1134150n 1.8
+    1134199n 1.8
+    1134200n 0
+    1134249n 0
+    1134250n 1.8
+    1134299n 1.8
+    1134300n 0
+    1134349n 0
+    1134350n 1.8
+    1134399n 1.8
+    1134400n 0
+    1134449n 0
+    1134450n 1.8
+    1134499n 1.8
+    1134500n 0
+    1134549n 0
+    1134550n 1.8
+    1134599n 1.8
+    1134600n 0
+    1134649n 0
+    1134650n 1.8
+    1134699n 1.8
+    1134700n 0
+    1134749n 0
+    1134750n 1.8
+    1134799n 1.8
+    1134800n 0
+    1134849n 0
+    1134850n 1.8
+    1134899n 1.8
+    1134900n 0
+    1134949n 0
+    1134950n 1.8
+    1134999n 1.8
+    1135000n 0
+    1135049n 0
+    1135050n 1.8
+    1135099n 1.8
+    1135100n 0
+    1135149n 0
+    1135150n 1.8
+    1135199n 1.8
+    1135200n 0
+    1135249n 0
+    1135250n 1.8
+    1135299n 1.8
+    1135300n 0
+    1135349n 0
+    1135350n 1.8
+    1135399n 1.8
+    1135400n 0
+    1135449n 0
+    1135450n 1.8
+    1135499n 1.8
+    1135500n 0
+    1135549n 0
+    1135550n 1.8
+    1135599n 1.8
+    1135600n 0
+    1135649n 0
+    1135650n 1.8
+    1135699n 1.8
+    1135700n 0
+    1135749n 0
+    1135750n 1.8
+    1135799n 1.8
+    1135800n 0
+    1135849n 0
+    1135850n 1.8
+    1135899n 1.8
+    1135900n 0
+    1135949n 0
+    1135950n 1.8
+    1135999n 1.8
+    1136000n 0
+    1136049n 0
+    1136050n 1.8
+    1136099n 1.8
+    1136100n 0
+    1136149n 0
+    1136150n 1.8
+    1136199n 1.8
+    1136200n 0
+    1136249n 0
+    1136250n 1.8
+    1136299n 1.8
+    1136300n 0
+    1136349n 0
+    1136350n 1.8
+    1136399n 1.8
+    1136400n 0
+    1136449n 0
+    1136450n 1.8
+    1136499n 1.8
+    1136500n 0
+    1136549n 0
+    1136550n 1.8
+    1136599n 1.8
+    1136600n 0
+    1136649n 0
+    1136650n 1.8
+    1136699n 1.8
+    1136700n 0
+    1136749n 0
+    1136750n 1.8
+    1136799n 1.8
+    1136800n 0
+    1136849n 0
+    1136850n 1.8
+    1136899n 1.8
+    1136900n 0
+    1136949n 0
+    1136950n 1.8
+    1136999n 1.8
+    1137000n 0
+    1137049n 0
+    1137050n 1.8
+    1137099n 1.8
+    1137100n 0
+    1137149n 0
+    1137150n 1.8
+    1137199n 1.8
+    1137200n 0
+    1137249n 0
+    1137250n 1.8
+    1137299n 1.8
+    1137300n 0
+    1137349n 0
+    1137350n 1.8
+    1137399n 1.8
+    1137400n 0
+    1137449n 0
+    1137450n 1.8
+    1137499n 1.8
+    1137500n 0
+    1137549n 0
+    1137550n 1.8
+    1137599n 1.8
+    1137600n 0
+    1137649n 0
+    1137650n 1.8
+    1137699n 1.8
+    1137700n 0
+    1137749n 0
+    1137750n 1.8
+    1137799n 1.8
+    1137800n 0
+    1137849n 0
+    1137850n 1.8
+    1137899n 1.8
+    1137900n 0
+    1137949n 0
+    1137950n 1.8
+    1137999n 1.8
+    1138000n 0
+    1138049n 0
+    1138050n 1.8
+    1138099n 1.8
+    1138100n 0
+    1138149n 0
+    1138150n 1.8
+    1138199n 1.8
+    1138200n 0
+    1138249n 0
+    1138250n 1.8
+    1138299n 1.8
+    1138300n 0
+    1138349n 0
+    1138350n 1.8
+    1138399n 1.8
+    1138400n 0
+    1138449n 0
+    1138450n 1.8
+    1138499n 1.8
+    1138500n 0
+    1138549n 0
+    1138550n 1.8
+    1138599n 1.8
+    1138600n 0
+    1138649n 0
+    1138650n 1.8
+    1138699n 1.8
+    1138700n 0
+    1138749n 0
+    1138750n 1.8
+    1138799n 1.8
+    1138800n 0
+    1138849n 0
+    1138850n 1.8
+    1138899n 1.8
+    1138900n 0
+    1138949n 0
+    1138950n 1.8
+    1138999n 1.8
+    1139000n 0
+    1139049n 0
+    1139050n 1.8
+    1139099n 1.8
+    1139100n 0
+    1139149n 0
+    1139150n 1.8
+    1139199n 1.8
+    1139200n 0
+    1139249n 0
+    1139250n 1.8
+    1139299n 1.8
+    1139300n 0
+    1139349n 0
+    1139350n 1.8
+    1139399n 1.8
+    1139400n 0
+    1139449n 0
+    1139450n 1.8
+    1139499n 1.8
+    1139500n 0
+    1139549n 0
+    1139550n 1.8
+    1139599n 1.8
+    1139600n 0
+    1139649n 0
+    1139650n 1.8
+    1139699n 1.8
+    1139700n 0
+    1139749n 0
+    1139750n 1.8
+    1139799n 1.8
+    1139800n 0
+    1139849n 0
+    1139850n 1.8
+    1139899n 1.8
+    1139900n 0
+    1139949n 0
+    1139950n 1.8
+    1139999n 1.8
+    1140000n 0
+    1140049n 0
+    1140050n 1.8
+    1140099n 1.8
+    1140100n 0
+    1140149n 0
+    1140150n 1.8
+    1140199n 1.8
+    1140200n 0
+    1140249n 0
+    1140250n 1.8
+    1140299n 1.8
+    1140300n 0
+    1140349n 0
+    1140350n 1.8
+    1140399n 1.8
+    1140400n 0
+    1140449n 0
+    1140450n 1.8
+    1140499n 1.8
+    1140500n 0
+    1140549n 0
+    1140550n 1.8
+    1140599n 1.8
+    1140600n 0
+    1140649n 0
+    1140650n 1.8
+    1140699n 1.8
+    1140700n 0
+    1140749n 0
+    1140750n 1.8
+    1140799n 1.8
+    1140800n 0
+    1140849n 0
+    1140850n 1.8
+    1140899n 1.8
+    1140900n 0
+    1140949n 0
+    1140950n 1.8
+    1140999n 1.8
+    1141000n 0
+    1141049n 0
+    1141050n 1.8
+    1141099n 1.8
+    1141100n 0
+    1141149n 0
+    1141150n 1.8
+    1141199n 1.8
+    1141200n 0
+    1141249n 0
+    1141250n 1.8
+    1141299n 1.8
+    1141300n 0
+    1141349n 0
+    1141350n 1.8
+    1141399n 1.8
+    1141400n 0
+    1141449n 0
+    1141450n 1.8
+    1141499n 1.8
+    1141500n 0
+    1141549n 0
+    1141550n 1.8
+    1141599n 1.8
+    1141600n 0
+    1141649n 0
+    1141650n 1.8
+    1141699n 1.8
+    1141700n 0
+    1141749n 0
+    1141750n 1.8
+    1141799n 1.8
+    1141800n 0
+    1141849n 0
+    1141850n 1.8
+    1141899n 1.8
+    1141900n 0
+    1141949n 0
+    1141950n 1.8
+    1141999n 1.8
+    1142000n 0
+    1142049n 0
+    1142050n 1.8
+    1142099n 1.8
+    1142100n 0
+    1142149n 0
+    1142150n 1.8
+    1142199n 1.8
+    1142200n 0
+    1142249n 0
+    1142250n 1.8
+    1142299n 1.8
+    1142300n 0
+    1142349n 0
+    1142350n 1.8
+    1142399n 1.8
+    1142400n 0
+    1142449n 0
+    1142450n 1.8
+    1142499n 1.8
+    1142500n 0
+    1142549n 0
+    1142550n 1.8
+    1142599n 1.8
+    1142600n 0
+    1142649n 0
+    1142650n 1.8
+    1142699n 1.8
+    1142700n 0
+    1142749n 0
+    1142750n 1.8
+    1142799n 1.8
+    1142800n 0
+    1142849n 0
+    1142850n 1.8
+    1142899n 1.8
+    1142900n 0
+    1142949n 0
+    1142950n 1.8
+    1142999n 1.8
+    1143000n 0
+    1143049n 0
+    1143050n 1.8
+    1143099n 1.8
+    1143100n 0
+    1143149n 0
+    1143150n 1.8
+    1143199n 1.8
+    1143200n 0
+    1143249n 0
+    1143250n 1.8
+    1143299n 1.8
+    1143300n 0
+    1143349n 0
+    1143350n 1.8
+    1143399n 1.8
+    1143400n 0
+    1143449n 0
+    1143450n 1.8
+    1143499n 1.8
+    1143500n 0
+    1143549n 0
+    1143550n 1.8
+    1143599n 1.8
+    1143600n 0
+    1143649n 0
+    1143650n 1.8
+    1143699n 1.8
+    1143700n 0
+    1143749n 0
+    1143750n 1.8
+    1143799n 1.8
+    1143800n 0
+    1143849n 0
+    1143850n 1.8
+    1143899n 1.8
+    1143900n 0
+    1143949n 0
+    1143950n 1.8
+    1143999n 1.8
+    1144000n 0
+    1144049n 0
+    1144050n 1.8
+    1144099n 1.8
+    1144100n 0
+    1144149n 0
+    1144150n 1.8
+    1144199n 1.8
+    1144200n 0
+    1144249n 0
+    1144250n 1.8
+    1144299n 1.8
+    1144300n 0
+    1144349n 0
+    1144350n 1.8
+    1144399n 1.8
+    1144400n 0
+    1144449n 0
+    1144450n 1.8
+    1144499n 1.8
+    1144500n 0
+    1144549n 0
+    1144550n 1.8
+    1144599n 1.8
+    1144600n 0
+    1144649n 0
+    1144650n 1.8
+    1144699n 1.8
+    1144700n 0
+    1144749n 0
+    1144750n 1.8
+    1144799n 1.8
+    1144800n 0
+    1144849n 0
+    1144850n 1.8
+    1144899n 1.8
+    1144900n 0
+    1144949n 0
+    1144950n 1.8
+    1144999n 1.8
+    1145000n 0
+    1145049n 0
+    1145050n 1.8
+    1145099n 1.8
+    1145100n 0
+    1145149n 0
+    1145150n 1.8
+    1145199n 1.8
+    1145200n 0
+    1145249n 0
+    1145250n 1.8
+    1145299n 1.8
+    1145300n 0
+    1145349n 0
+    1145350n 1.8
+    1145399n 1.8
+    1145400n 0
+    1145449n 0
+    1145450n 1.8
+    1145499n 1.8
+    1145500n 0
+    1145549n 0
+    1145550n 1.8
+    1145599n 1.8
+    1145600n 0
+    1145649n 0
+    1145650n 1.8
+    1145699n 1.8
+    1145700n 0
+    1145749n 0
+    1145750n 1.8
+    1145799n 1.8
+    1145800n 0
+    1145849n 0
+    1145850n 1.8
+    1145899n 1.8
+    1145900n 0
+    1145949n 0
+    1145950n 1.8
+    1145999n 1.8
+    1146000n 0
+    1146049n 0
+    1146050n 1.8
+    1146099n 1.8
+    1146100n 0
+    1146149n 0
+    1146150n 1.8
+    1146199n 1.8
+    1146200n 0
+    1146249n 0
+    1146250n 1.8
+    1146299n 1.8
+    1146300n 0
+    1146349n 0
+    1146350n 1.8
+    1146399n 1.8
+    1146400n 0
+    1146449n 0
+    1146450n 1.8
+    1146499n 1.8
+    1146500n 0
+    1146549n 0
+    1146550n 1.8
+    1146599n 1.8
+    1146600n 0
+    1146649n 0
+    1146650n 1.8
+    1146699n 1.8
+    1146700n 0
+    1146749n 0
+    1146750n 1.8
+    1146799n 1.8
+    1146800n 0
+    1146849n 0
+    1146850n 1.8
+    1146899n 1.8
+    1146900n 0
+    1146949n 0
+    1146950n 1.8
+    1146999n 1.8
+    1147000n 0
+    1147049n 0
+    1147050n 1.8
+    1147099n 1.8
+    1147100n 0
+    1147149n 0
+    1147150n 1.8
+    1147199n 1.8
+    1147200n 0
+    1147249n 0
+    1147250n 1.8
+    1147299n 1.8
+    1147300n 0
+    1147349n 0
+    1147350n 1.8
+    1147399n 1.8
+    1147400n 0
+    1147449n 0
+    1147450n 1.8
+    1147499n 1.8
+    1147500n 0
+    1147549n 0
+    1147550n 1.8
+    1147599n 1.8
+    1147600n 0
+    1147649n 0
+    1147650n 1.8
+    1147699n 1.8
+    1147700n 0
+    1147749n 0
+    1147750n 1.8
+    1147799n 1.8
+    1147800n 0
+    1147849n 0
+    1147850n 1.8
+    1147899n 1.8
+    1147900n 0
+    1147949n 0
+    1147950n 1.8
+    1147999n 1.8
+    1148000n 0
+    1148049n 0
+    1148050n 1.8
+    1148099n 1.8
+    1148100n 0
+    1148149n 0
+    1148150n 1.8
+    1148199n 1.8
+    1148200n 0
+    1148249n 0
+    1148250n 1.8
+    1148299n 1.8
+    1148300n 0
+    1148349n 0
+    1148350n 1.8
+    1148399n 1.8
+    1148400n 0
+    1148449n 0
+    1148450n 1.8
+    1148499n 1.8
+    1148500n 0
+    1148549n 0
+    1148550n 1.8
+    1148599n 1.8
+    1148600n 0
+    1148649n 0
+    1148650n 1.8
+    1148699n 1.8
+    1148700n 0
+    1148749n 0
+    1148750n 1.8
+    1148799n 1.8
+    1148800n 0
+    1148849n 0
+    1148850n 1.8
+    1148899n 1.8
+    1148900n 0
+    1148949n 0
+    1148950n 1.8
+    1148999n 1.8
+    1149000n 0
+    1149049n 0
+    1149050n 1.8
+    1149099n 1.8
+    1149100n 0
+    1149149n 0
+    1149150n 1.8
+    1149199n 1.8
+    1149200n 0
+    1149249n 0
+    1149250n 1.8
+    1149299n 1.8
+    1149300n 0
+    1149349n 0
+    1149350n 1.8
+    1149399n 1.8
+    1149400n 0
+    1149449n 0
+    1149450n 1.8
+    1149499n 1.8
+    1149500n 0
+    1149549n 0
+    1149550n 1.8
+    1149599n 1.8
+    1149600n 0
+    1149649n 0
+    1149650n 1.8
+    1149699n 1.8
+    1149700n 0
+    1149749n 0
+    1149750n 1.8
+    1149799n 1.8
+    1149800n 0
+    1149849n 0
+    1149850n 1.8
+    1149899n 1.8
+    1149900n 0
+    1149949n 0
+    1149950n 1.8
+    1149999n 1.8
+    1150000n 0
+    1150049n 0
+    1150050n 1.8
+    1150099n 1.8
+    1150100n 0
+    1150149n 0
+    1150150n 1.8
+    1150199n 1.8
+    1150200n 0
+    1150249n 0
+    1150250n 1.8
+    1150299n 1.8
+    1150300n 0
+    1150349n 0
+    1150350n 1.8
+    1150399n 1.8
+    1150400n 0
+    1150449n 0
+    1150450n 1.8
+    1150499n 1.8
+    1150500n 0
+    1150549n 0
+    1150550n 1.8
+    1150599n 1.8
+    1150600n 0
+    1150649n 0
+    1150650n 1.8
+    1150699n 1.8
+    1150700n 0
+    1150749n 0
+    1150750n 1.8
+    1150799n 1.8
+    1150800n 0
+    1150849n 0
+    1150850n 1.8
+    1150899n 1.8
+    1150900n 0
+    1150949n 0
+    1150950n 1.8
+    1150999n 1.8
+    1151000n 0
+    1151049n 0
+    1151050n 1.8
+    1151099n 1.8
+    1151100n 0
+    1151149n 0
+    1151150n 1.8
+    1151199n 1.8
+    1151200n 0
+    1151249n 0
+    1151250n 1.8
+    1151299n 1.8
+    1151300n 0
+    1151349n 0
+    1151350n 1.8
+    1151399n 1.8
+    1151400n 0
+    1151449n 0
+    1151450n 1.8
+    1151499n 1.8
+    1151500n 0
+    1151549n 0
+    1151550n 1.8
+    1151599n 1.8
+    1151600n 0
+    1151649n 0
+    1151650n 1.8
+    1151699n 1.8
+    1151700n 0
+    1151749n 0
+    1151750n 1.8
+    1151799n 1.8
+    1151800n 0
+    1151849n 0
+    1151850n 1.8
+    1151899n 1.8
+    1151900n 0
+    1151949n 0
+    1151950n 1.8
+    1151999n 1.8
+    1152000n 0
+    1152049n 0
+    1152050n 1.8
+    1152099n 1.8
+    1152100n 0
+    1152149n 0
+    1152150n 1.8
+    1152199n 1.8
+    1152200n 0
+    1152249n 0
+    1152250n 1.8
+    1152299n 1.8
+    1152300n 0
+    1152349n 0
+    1152350n 1.8
+    1152399n 1.8
+    1152400n 0
+    1152449n 0
+    1152450n 1.8
+    1152499n 1.8
+    1152500n 0
+    1152549n 0
+    1152550n 1.8
+    1152599n 1.8
+    1152600n 0
+    1152649n 0
+    1152650n 1.8
+    1152699n 1.8
+    1152700n 0
+    1152749n 0
+    1152750n 1.8
+    1152799n 1.8
+    1152800n 0
+    1152849n 0
+    1152850n 1.8
+    1152899n 1.8
+    1152900n 0
+    1152949n 0
+    1152950n 1.8
+    1152999n 1.8
+    1153000n 0
+    1153049n 0
+    1153050n 1.8
+    1153099n 1.8
+    1153100n 0
+    1153149n 0
+    1153150n 1.8
+    1153199n 1.8
+    1153200n 0
+    1153249n 0
+    1153250n 1.8
+    1153299n 1.8
+    1153300n 0
+    1153349n 0
+    1153350n 1.8
+    1153399n 1.8
+    1153400n 0
+    1153449n 0
+    1153450n 1.8
+    1153499n 1.8
+    1153500n 0
+    1153549n 0
+    1153550n 1.8
+    1153599n 1.8
+    1153600n 0
+    1153649n 0
+    1153650n 1.8
+    1153699n 1.8
+    1153700n 0
+    1153749n 0
+    1153750n 1.8
+    1153799n 1.8
+    1153800n 0
+    1153849n 0
+    1153850n 1.8
+    1153899n 1.8
+    1153900n 0
+    1153949n 0
+    1153950n 1.8
+    1153999n 1.8
+    1154000n 0
+    1154049n 0
+    1154050n 1.8
+    1154099n 1.8
+    1154100n 0
+    1154149n 0
+    1154150n 1.8
+    1154199n 1.8
+    1154200n 0
+    1154249n 0
+    1154250n 1.8
+    1154299n 1.8
+    1154300n 0
+    1154349n 0
+    1154350n 1.8
+    1154399n 1.8
+    1154400n 0
+    1154449n 0
+    1154450n 1.8
+    1154499n 1.8
+    1154500n 0
+    1154549n 0
+    1154550n 1.8
+    1154599n 1.8
+    1154600n 0
+    1154649n 0
+    1154650n 1.8
+    1154699n 1.8
+    1154700n 0
+    1154749n 0
+    1154750n 1.8
+    1154799n 1.8
+    1154800n 0
+    1154849n 0
+    1154850n 1.8
+    1154899n 1.8
+    1154900n 0
+    1154949n 0
+    1154950n 1.8
+    1154999n 1.8
+    1155000n 0
+    1155049n 0
+    1155050n 1.8
+    1155099n 1.8
+    1155100n 0
+    1155149n 0
+    1155150n 1.8
+    1155199n 1.8
+    1155200n 0
+    1155249n 0
+    1155250n 1.8
+    1155299n 1.8
+    1155300n 0
+    1155349n 0
+    1155350n 1.8
+    1155399n 1.8
+    1155400n 0
+    1155449n 0
+    1155450n 1.8
+    1155499n 1.8
+    1155500n 0
+    1155549n 0
+    1155550n 1.8
+    1155599n 1.8
+    1155600n 0
+    1155649n 0
+    1155650n 1.8
+    1155699n 1.8
+    1155700n 0
+    1155749n 0
+    1155750n 1.8
+    1155799n 1.8
+    1155800n 0
+    1155849n 0
+    1155850n 1.8
+    1155899n 1.8
+    1155900n 0
+    1155949n 0
+    1155950n 1.8
+    1155999n 1.8
+    1156000n 0
+    1156049n 0
+    1156050n 1.8
+    1156099n 1.8
+    1156100n 0
+    1156149n 0
+    1156150n 1.8
+    1156199n 1.8
+    1156200n 0
+    1156249n 0
+    1156250n 1.8
+    1156299n 1.8
+    1156300n 0
+    1156349n 0
+    1156350n 1.8
+    1156399n 1.8
+    1156400n 0
+    1156449n 0
+    1156450n 1.8
+    1156499n 1.8
+    1156500n 0
+    1156549n 0
+    1156550n 1.8
+    1156599n 1.8
+    1156600n 0
+    1156649n 0
+    1156650n 1.8
+    1156699n 1.8
+    1156700n 0
+    1156749n 0
+    1156750n 1.8
+    1156799n 1.8
+    1156800n 0
+    1156849n 0
+    1156850n 1.8
+    1156899n 1.8
+    1156900n 0
+    1156949n 0
+    1156950n 1.8
+    1156999n 1.8
+    1157000n 0
+    1157049n 0
+    1157050n 1.8
+    1157099n 1.8
+    1157100n 0
+    1157149n 0
+    1157150n 1.8
+    1157199n 1.8
+    1157200n 0
+    1157249n 0
+    1157250n 1.8
+    1157299n 1.8
+    1157300n 0
+    1157349n 0
+    1157350n 1.8
+    1157399n 1.8
+    1157400n 0
+    1157449n 0
+    1157450n 1.8
+    1157499n 1.8
+    1157500n 0
+    1157549n 0
+    1157550n 1.8
+    1157599n 1.8
+    1157600n 0
+    1157649n 0
+    1157650n 1.8
+    1157699n 1.8
+    1157700n 0
+    1157749n 0
+    1157750n 1.8
+    1157799n 1.8
+    1157800n 0
+    1157849n 0
+    1157850n 1.8
+    1157899n 1.8
+    1157900n 0
+    1157949n 0
+    1157950n 1.8
+    1157999n 1.8
+    1158000n 0
+    1158049n 0
+    1158050n 1.8
+    1158099n 1.8
+    1158100n 0
+    1158149n 0
+    1158150n 1.8
+    1158199n 1.8
+    1158200n 0
+    1158249n 0
+    1158250n 1.8
+    1158299n 1.8
+    1158300n 0
+    1158349n 0
+    1158350n 1.8
+    1158399n 1.8
+    1158400n 0
+    1158449n 0
+    1158450n 1.8
+    1158499n 1.8
+    1158500n 0
+    1158549n 0
+    1158550n 1.8
+    1158599n 1.8
+    1158600n 0
+    1158649n 0
+    1158650n 1.8
+    1158699n 1.8
+    1158700n 0
+    1158749n 0
+    1158750n 1.8
+    1158799n 1.8
+    1158800n 0
+    1158849n 0
+    1158850n 1.8
+    1158899n 1.8
+    1158900n 0
+    1158949n 0
+    1158950n 1.8
+    1158999n 1.8
+    1159000n 0
+    1159049n 0
+    1159050n 1.8
+    1159099n 1.8
+    1159100n 0
+    1159149n 0
+    1159150n 1.8
+    1159199n 1.8
+    1159200n 0
+    1159249n 0
+    1159250n 1.8
+    1159299n 1.8
+    1159300n 0
+    1159349n 0
+    1159350n 1.8
+    1159399n 1.8
+    1159400n 0
+    1159449n 0
+    1159450n 1.8
+    1159499n 1.8
+    1159500n 0
+    1159549n 0
+    1159550n 1.8
+    1159599n 1.8
+    1159600n 0
+    1159649n 0
+    1159650n 1.8
+    1159699n 1.8
+    1159700n 0
+    1159749n 0
+    1159750n 1.8
+    1159799n 1.8
+    1159800n 0
+    1159849n 0
+    1159850n 1.8
+    1159899n 1.8
+    1159900n 0
+    1159949n 0
+    1159950n 1.8
+    1159999n 1.8
+    1160000n 0
+    1160049n 0
+    1160050n 1.8
+    1160099n 1.8
+    1160100n 0
+    1160149n 0
+    1160150n 1.8
+    1160199n 1.8
+    1160200n 0
+    1160249n 0
+    1160250n 1.8
+    1160299n 1.8
+    1160300n 0
+    1160349n 0
+    1160350n 1.8
+    1160399n 1.8
+    1160400n 0
+    1160449n 0
+    1160450n 1.8
+    1160499n 1.8
+    1160500n 0
+    1160549n 0
+    1160550n 1.8
+    1160599n 1.8
+    1160600n 0
+    1160649n 0
+    1160650n 1.8
+    1160699n 1.8
+    1160700n 0
+    1160749n 0
+    1160750n 1.8
+    1160799n 1.8
+    1160800n 0
+    1160849n 0
+    1160850n 1.8
+    1160899n 1.8
+    1160900n 0
+    1160949n 0
+    1160950n 1.8
+    1160999n 1.8
+    1161000n 0
+    1161049n 0
+    1161050n 1.8
+    1161099n 1.8
+    1161100n 0
+    1161149n 0
+    1161150n 1.8
+    1161199n 1.8
+    1161200n 0
+    1161249n 0
+    1161250n 1.8
+    1161299n 1.8
+    1161300n 0
+    1161349n 0
+    1161350n 1.8
+    1161399n 1.8
+    1161400n 0
+    1161449n 0
+    1161450n 1.8
+    1161499n 1.8
+    1161500n 0
+    1161549n 0
+    1161550n 1.8
+    1161599n 1.8
+    1161600n 0
+    1161649n 0
+    1161650n 1.8
+    1161699n 1.8
+    1161700n 0
+    1161749n 0
+    1161750n 1.8
+    1161799n 1.8
+    1161800n 0
+    1161849n 0
+    1161850n 1.8
+    1161899n 1.8
+    1161900n 0
+    1161949n 0
+    1161950n 1.8
+    1161999n 1.8
+    1162000n 0
+    1162049n 0
+    1162050n 1.8
+    1162099n 1.8
+    1162100n 0
+    1162149n 0
+    1162150n 1.8
+    1162199n 1.8
+    1162200n 0
+    1162249n 0
+    1162250n 1.8
+    1162299n 1.8
+    1162300n 0
+    1162349n 0
+    1162350n 1.8
+    1162399n 1.8
+    1162400n 0
+    1162449n 0
+    1162450n 1.8
+    1162499n 1.8
+    1162500n 0
+    1162549n 0
+    1162550n 1.8
+    1162599n 1.8
+    1162600n 0
+    1162649n 0
+    1162650n 1.8
+    1162699n 1.8
+    1162700n 0
+    1162749n 0
+    1162750n 1.8
+    1162799n 1.8
+    1162800n 0
+    1162849n 0
+    1162850n 1.8
+    1162899n 1.8
+    1162900n 0
+    1162949n 0
+    1162950n 1.8
+    1162999n 1.8
+    1163000n 0
+    1163049n 0
+    1163050n 1.8
+    1163099n 1.8
+    1163100n 0
+    1163149n 0
+    1163150n 1.8
+    1163199n 1.8
+    1163200n 0
+    1163249n 0
+    1163250n 1.8
+    1163299n 1.8
+    1163300n 0
+    1163349n 0
+    1163350n 1.8
+    1163399n 1.8
+    1163400n 0
+    1163449n 0
+    1163450n 1.8
+    1163499n 1.8
+    1163500n 0
+    1163549n 0
+    1163550n 1.8
+    1163599n 1.8
+    1163600n 0
+    1163649n 0
+    1163650n 1.8
+    1163699n 1.8
+    1163700n 0
+    1163749n 0
+    1163750n 1.8
+    1163799n 1.8
+    1163800n 0
+    1163849n 0
+    1163850n 1.8
+    1163899n 1.8
+    1163900n 0
+    1163949n 0
+    1163950n 1.8
+    1163999n 1.8
+    1164000n 0
+    1164049n 0
+    1164050n 1.8
+    1164099n 1.8
+    1164100n 0
+    1164149n 0
+    1164150n 1.8
+    1164199n 1.8
+    1164200n 0
+    1164249n 0
+    1164250n 1.8
+    1164299n 1.8
+    1164300n 0
+    1164349n 0
+    1164350n 1.8
+    1164399n 1.8
+    1164400n 0
+    1164449n 0
+    1164450n 1.8
+    1164499n 1.8
+    1164500n 0
+    1164549n 0
+    1164550n 1.8
+    1164599n 1.8
+    1164600n 0
+    1164649n 0
+    1164650n 1.8
+    1164699n 1.8
+    1164700n 0
+    1164749n 0
+    1164750n 1.8
+    1164799n 1.8
+    1164800n 0
+    1164849n 0
+    1164850n 1.8
+    1164899n 1.8
+    1164900n 0
+    1164949n 0
+    1164950n 1.8
+    1164999n 1.8
+    1165000n 0
+    1165049n 0
+    1165050n 1.8
+    1165099n 1.8
+    1165100n 0
+    1165149n 0
+    1165150n 1.8
+    1165199n 1.8
+    1165200n 0
+    1165249n 0
+    1165250n 1.8
+    1165299n 1.8
+    1165300n 0
+    1165349n 0
+    1165350n 1.8
+    1165399n 1.8
+    1165400n 0
+    1165449n 0
+    1165450n 1.8
+    1165499n 1.8
+    1165500n 0
+    1165549n 0
+    1165550n 1.8
+    1165599n 1.8
+    1165600n 0
+    1165649n 0
+    1165650n 1.8
+    1165699n 1.8
+    1165700n 0
+    1165749n 0
+    1165750n 1.8
+    1165799n 1.8
+    1165800n 0
+    1165849n 0
+    1165850n 1.8
+    1165899n 1.8
+    1165900n 0
+    1165949n 0
+    1165950n 1.8
+    1165999n 1.8
+    1166000n 0
+    1166049n 0
+    1166050n 1.8
+    1166099n 1.8
+    1166100n 0
+    1166149n 0
+    1166150n 1.8
+    1166199n 1.8
+    1166200n 0
+    1166249n 0
+    1166250n 1.8
+    1166299n 1.8
+    1166300n 0
+    1166349n 0
+    1166350n 1.8
+    1166399n 1.8
+    1166400n 0
+    1166449n 0
+    1166450n 1.8
+    1166499n 1.8
+    1166500n 0
+    1166549n 0
+    1166550n 1.8
+    1166599n 1.8
+    1166600n 0
+    1166649n 0
+    1166650n 1.8
+    1166699n 1.8
+    1166700n 0
+    1166749n 0
+    1166750n 1.8
+    1166799n 1.8
+    1166800n 0
+    1166849n 0
+    1166850n 1.8
+    1166899n 1.8
+    1166900n 0
+    1166949n 0
+    1166950n 1.8
+    1166999n 1.8
+    1167000n 0
+    1167049n 0
+    1167050n 1.8
+    1167099n 1.8
+    1167100n 0
+    1167149n 0
+    1167150n 1.8
+    1167199n 1.8
+    1167200n 0
+    1167249n 0
+    1167250n 1.8
+    1167299n 1.8
+    1167300n 0
+    1167349n 0
+    1167350n 1.8
+    1167399n 1.8
+    1167400n 0
+    1167449n 0
+    1167450n 1.8
+    1167499n 1.8
+    1167500n 0
+    1167549n 0
+    1167550n 1.8
+    1167599n 1.8
+    1167600n 0
+    1167649n 0
+    1167650n 1.8
+    1167699n 1.8
+    1167700n 0
+    1167749n 0
+    1167750n 1.8
+    1167799n 1.8
+    1167800n 0
+    1167849n 0
+    1167850n 1.8
+    1167899n 1.8
+    1167900n 0
+    1167949n 0
+    1167950n 1.8
+    1167999n 1.8
+    1168000n 0
+    1168049n 0
+    1168050n 1.8
+    1168099n 1.8
+    1168100n 0
+    1168149n 0
+    1168150n 1.8
+    1168199n 1.8
+    1168200n 0
+    1168249n 0
+    1168250n 1.8
+    1168299n 1.8
+    1168300n 0
+    1168349n 0
+    1168350n 1.8
+    1168399n 1.8
+    1168400n 0
+    1168449n 0
+    1168450n 1.8
+    1168499n 1.8
+    1168500n 0
+    1168549n 0
+    1168550n 1.8
+    1168599n 1.8
+    1168600n 0
+    1168649n 0
+    1168650n 1.8
+    1168699n 1.8
+    1168700n 0
+    1168749n 0
+    1168750n 1.8
+    1168799n 1.8
+    1168800n 0
+    1168849n 0
+    1168850n 1.8
+    1168899n 1.8
+    1168900n 0
+    1168949n 0
+    1168950n 1.8
+    1168999n 1.8
+    1169000n 0
+    1169049n 0
+    1169050n 1.8
+    1169099n 1.8
+    1169100n 0
+    1169149n 0
+    1169150n 1.8
+    1169199n 1.8
+    1169200n 0
+    1169249n 0
+    1169250n 1.8
+    1169299n 1.8
+    1169300n 0
+    1169349n 0
+    1169350n 1.8
+    1169399n 1.8
+    1169400n 0
+    1169449n 0
+    1169450n 1.8
+    1169499n 1.8
+    1169500n 0
+    1169549n 0
+    1169550n 1.8
+    1169599n 1.8
+    1169600n 0
+    1169649n 0
+    1169650n 1.8
+    1169699n 1.8
+    1169700n 0
+    1169749n 0
+    1169750n 1.8
+    1169799n 1.8
+    1169800n 0
+    1169849n 0
+    1169850n 1.8
+    1169899n 1.8
+    1169900n 0
+    1169949n 0
+    1169950n 1.8
+    1169999n 1.8
+    1170000n 0
+    1170049n 0
+    1170050n 1.8
+    1170099n 1.8
+    1170100n 0
+    1170149n 0
+    1170150n 1.8
+    1170199n 1.8
+    1170200n 0
+    1170249n 0
+    1170250n 1.8
+    1170299n 1.8
+    1170300n 0
+    1170349n 0
+    1170350n 1.8
+    1170399n 1.8
+    1170400n 0
+    1170449n 0
+    1170450n 1.8
+    1170499n 1.8
+    1170500n 0
+    1170549n 0
+    1170550n 1.8
+    1170599n 1.8
+    1170600n 0
+    1170649n 0
+    1170650n 1.8
+    1170699n 1.8
+    1170700n 0
+    1170749n 0
+    1170750n 1.8
+    1170799n 1.8
+    1170800n 0
+    1170849n 0
+    1170850n 1.8
+    1170899n 1.8
+    1170900n 0
+    1170949n 0
+    1170950n 1.8
+    1170999n 1.8
+    1171000n 0
+    1171049n 0
+    1171050n 1.8
+    1171099n 1.8
+    1171100n 0
+    1171149n 0
+    1171150n 1.8
+    1171199n 1.8
+    1171200n 0
+    1171249n 0
+    1171250n 1.8
+    1171299n 1.8
+    1171300n 0
+    1171349n 0
+    1171350n 1.8
+    1171399n 1.8
+    1171400n 0
+    1171449n 0
+    1171450n 1.8
+    1171499n 1.8
+    1171500n 0
+    1171549n 0
+    1171550n 1.8
+    1171599n 1.8
+    1171600n 0
+    1171649n 0
+    1171650n 1.8
+    1171699n 1.8
+    1171700n 0
+    1171749n 0
+    1171750n 1.8
+    1171799n 1.8
+    1171800n 0
+    1171849n 0
+    1171850n 1.8
+    1171899n 1.8
+    1171900n 0
+    1171949n 0
+    1171950n 1.8
+    1171999n 1.8
+    1172000n 0
+    1172049n 0
+    1172050n 1.8
+    1172099n 1.8
+    1172100n 0
+    1172149n 0
+    1172150n 1.8
+    1172199n 1.8
+    1172200n 0
+    1172249n 0
+    1172250n 1.8
+    1172299n 1.8
+    1172300n 0
+    1172349n 0
+    1172350n 1.8
+    1172399n 1.8
+    1172400n 0
+    1172449n 0
+    1172450n 1.8
+    1172499n 1.8
+    1172500n 0
+    1172549n 0
+    1172550n 1.8
+    1172599n 1.8
+    1172600n 0
+    1172649n 0
+    1172650n 1.8
+    1172699n 1.8
+    1172700n 0
+    1172749n 0
+    1172750n 1.8
+    1172799n 1.8
+    1172800n 0
+    1172849n 0
+    1172850n 1.8
+    1172899n 1.8
+    1172900n 0
+    1172949n 0
+    1172950n 1.8
+    1172999n 1.8
+    1173000n 0
+    1173049n 0
+    1173050n 1.8
+    1173099n 1.8
+    1173100n 0
+    1173149n 0
+    1173150n 1.8
+    1173199n 1.8
+    1173200n 0
+    1173249n 0
+    1173250n 1.8
+    1173299n 1.8
+    1173300n 0
+    1173349n 0
+    1173350n 1.8
+    1173399n 1.8
+    1173400n 0
+    1173449n 0
+    1173450n 1.8
+    1173499n 1.8
+    1173500n 0
+    1173549n 0
+    1173550n 1.8
+    1173599n 1.8
+    1173600n 0
+    1173649n 0
+    1173650n 1.8
+    1173699n 1.8
+    1173700n 0
+    1173749n 0
+    1173750n 1.8
+    1173799n 1.8
+    1173800n 0
+    1173849n 0
+    1173850n 1.8
+    1173899n 1.8
+    1173900n 0
+    1173949n 0
+    1173950n 1.8
+    1173999n 1.8
+    1174000n 0
+    1174049n 0
+    1174050n 1.8
+    1174099n 1.8
+    1174100n 0
+    1174149n 0
+    1174150n 1.8
+    1174199n 1.8
+    1174200n 0
+    1174249n 0
+    1174250n 1.8
+    1174299n 1.8
+    1174300n 0
+    1174349n 0
+    1174350n 1.8
+    1174399n 1.8
+    1174400n 0
+    1174449n 0
+    1174450n 1.8
+    1174499n 1.8
+    1174500n 0
+    1174549n 0
+    1174550n 1.8
+    1174599n 1.8
+    1174600n 0
+    1174649n 0
+    1174650n 1.8
+    1174699n 1.8
+    1174700n 0
+    1174749n 0
+    1174750n 1.8
+    1174799n 1.8
+    1174800n 0
+    1174849n 0
+    1174850n 1.8
+    1174899n 1.8
+    1174900n 0
+    1174949n 0
+    1174950n 1.8
+    1174999n 1.8
+    1175000n 0
+    1175049n 0
+    1175050n 1.8
+    1175099n 1.8
+    1175100n 0
+    1175149n 0
+    1175150n 1.8
+    1175199n 1.8
+    1175200n 0
+    1175249n 0
+    1175250n 1.8
+    1175299n 1.8
+    1175300n 0
+    1175349n 0
+    1175350n 1.8
+    1175399n 1.8
+    1175400n 0
+    1175449n 0
+    1175450n 1.8
+    1175499n 1.8
+    1175500n 0
+    1175549n 0
+    1175550n 1.8
+    1175599n 1.8
+    1175600n 0
+    1175649n 0
+    1175650n 1.8
+    1175699n 1.8
+    1175700n 0
+    1175749n 0
+    1175750n 1.8
+    1175799n 1.8
+    1175800n 0
+    1175849n 0
+    1175850n 1.8
+    1175899n 1.8
+    1175900n 0
+    1175949n 0
+    1175950n 1.8
+    1175999n 1.8
+    1176000n 0
+    1176049n 0
+    1176050n 1.8
+    1176099n 1.8
+    1176100n 0
+    1176149n 0
+    1176150n 1.8
+    1176199n 1.8
+    1176200n 0
+    1176249n 0
+    1176250n 1.8
+    1176299n 1.8
+    1176300n 0
+    1176349n 0
+    1176350n 1.8
+    1176399n 1.8
+    1176400n 0
+    1176449n 0
+    1176450n 1.8
+    1176499n 1.8
+    1176500n 0
+    1176549n 0
+    1176550n 1.8
+    1176599n 1.8
+    1176600n 0
+    1176649n 0
+    1176650n 1.8
+    1176699n 1.8
+    1176700n 0
+    1176749n 0
+    1176750n 1.8
+    1176799n 1.8
+    1176800n 0
+    1176849n 0
+    1176850n 1.8
+    1176899n 1.8
+    1176900n 0
+    1176949n 0
+    1176950n 1.8
+    1176999n 1.8
+    1177000n 0
+    1177049n 0
+    1177050n 1.8
+    1177099n 1.8
+    1177100n 0
+    1177149n 0
+    1177150n 1.8
+    1177199n 1.8
+    1177200n 0
+    1177249n 0
+    1177250n 1.8
+    1177299n 1.8
+    1177300n 0
+    1177349n 0
+    1177350n 1.8
+    1177399n 1.8
+    1177400n 0
+    1177449n 0
+    1177450n 1.8
+    1177499n 1.8
+    1177500n 0
+    1177549n 0
+    1177550n 1.8
+    1177599n 1.8
+    1177600n 0
+    1177649n 0
+    1177650n 1.8
+    1177699n 1.8
+    1177700n 0
+    1177749n 0
+    1177750n 1.8
+    1177799n 1.8
+    1177800n 0
+    1177849n 0
+    1177850n 1.8
+    1177899n 1.8
+    1177900n 0
+    1177949n 0
+    1177950n 1.8
+    1177999n 1.8
+    1178000n 0
+    1178049n 0
+    1178050n 1.8
+    1178099n 1.8
+    1178100n 0
+    1178149n 0
+    1178150n 1.8
+    1178199n 1.8
+    1178200n 0
+    1178249n 0
+    1178250n 1.8
+    1178299n 1.8
+    1178300n 0
+    1178349n 0
+    1178350n 1.8
+    1178399n 1.8
+    1178400n 0
+    1178449n 0
+    1178450n 1.8
+    1178499n 1.8
+    1178500n 0
+    1178549n 0
+    1178550n 1.8
+    1178599n 1.8
+    1178600n 0
+    1178649n 0
+    1178650n 1.8
+    1178699n 1.8
+    1178700n 0
+    1178749n 0
+    1178750n 1.8
+    1178799n 1.8
+    1178800n 0
+    1178849n 0
+    1178850n 1.8
+    1178899n 1.8
+    1178900n 0
+    1178949n 0
+    1178950n 1.8
+    1178999n 1.8
+    1179000n 0
+    1179049n 0
+    1179050n 1.8
+    1179099n 1.8
+    1179100n 0
+    1179149n 0
+    1179150n 1.8
+    1179199n 1.8
+    1179200n 0
+    1179249n 0
+    1179250n 1.8
+    1179299n 1.8
+    1179300n 0
+    1179349n 0
+    1179350n 1.8
+    1179399n 1.8
+    1179400n 0
+    1179449n 0
+    1179450n 1.8
+    1179499n 1.8
+    1179500n 0
+    1179549n 0
+    1179550n 1.8
+    1179599n 1.8
+    1179600n 0
+    1179649n 0
+    1179650n 1.8
+    1179699n 1.8
+    1179700n 0
+    1179749n 0
+    1179750n 1.8
+    1179799n 1.8
+    1179800n 0
+    1179849n 0
+    1179850n 1.8
+    1179899n 1.8
+    1179900n 0
+    1179949n 0
+    1179950n 1.8
+    1179999n 1.8
+    1180000n 0
+    1180049n 0
+    1180050n 1.8
+    1180099n 1.8
+    1180100n 0
+    1180149n 0
+    1180150n 1.8
+    1180199n 1.8
+    1180200n 0
+    1180249n 0
+    1180250n 1.8
+    1180299n 1.8
+    1180300n 0
+    1180349n 0
+    1180350n 1.8
+    1180399n 1.8
+    1180400n 0
+    1180449n 0
+    1180450n 1.8
+    1180499n 1.8
+    1180500n 0
+    1180549n 0
+    1180550n 1.8
+    1180599n 1.8
+    1180600n 0
+    1180649n 0
+    1180650n 1.8
+    1180699n 1.8
+    1180700n 0
+    1180749n 0
+    1180750n 1.8
+    1180799n 1.8
+    1180800n 0
+    1180849n 0
+    1180850n 1.8
+    1180899n 1.8
+    1180900n 0
+    1180949n 0
+    1180950n 1.8
+    1180999n 1.8
+    1181000n 0
+    1181049n 0
+    1181050n 1.8
+    1181099n 1.8
+    1181100n 0
+    1181149n 0
+    1181150n 1.8
+    1181199n 1.8
+    1181200n 0
+    1181249n 0
+    1181250n 1.8
+    1181299n 1.8
+    1181300n 0
+    1181349n 0
+    1181350n 1.8
+    1181399n 1.8
+    1181400n 0
+    1181449n 0
+    1181450n 1.8
+    1181499n 1.8
+    1181500n 0
+    1181549n 0
+    1181550n 1.8
+    1181599n 1.8
+    1181600n 0
+    1181649n 0
+    1181650n 1.8
+    1181699n 1.8
+    1181700n 0
+    1181749n 0
+    1181750n 1.8
+    1181799n 1.8
+    1181800n 0
+    1181849n 0
+    1181850n 1.8
+    1181899n 1.8
+    1181900n 0
+    1181949n 0
+    1181950n 1.8
+    1181999n 1.8
+    1182000n 0
+    1182049n 0
+    1182050n 1.8
+    1182099n 1.8
+    1182100n 0
+    1182149n 0
+    1182150n 1.8
+    1182199n 1.8
+    1182200n 0
+    1182249n 0
+    1182250n 1.8
+    1182299n 1.8
+    1182300n 0
+    1182349n 0
+    1182350n 1.8
+    1182399n 1.8
+    1182400n 0
+    1182449n 0
+    1182450n 1.8
+    1182499n 1.8
+    1182500n 0
+    1182549n 0
+    1182550n 1.8
+    1182599n 1.8
+    1182600n 0
+    1182649n 0
+    1182650n 1.8
+    1182699n 1.8
+    1182700n 0
+    1182749n 0
+    1182750n 1.8
+    1182799n 1.8
+    1182800n 0
+    1182849n 0
+    1182850n 1.8
+    1182899n 1.8
+    1182900n 0
+    1182949n 0
+    1182950n 1.8
+    1182999n 1.8
+    1183000n 0
+    1183049n 0
+    1183050n 1.8
+    1183099n 1.8
+    1183100n 0
+    1183149n 0
+    1183150n 1.8
+    1183199n 1.8
+    1183200n 0
+    1183249n 0
+    1183250n 1.8
+    1183299n 1.8
+    1183300n 0
+    1183349n 0
+    1183350n 1.8
+    1183399n 1.8
+    1183400n 0
+    1183449n 0
+    1183450n 1.8
+    1183499n 1.8
+    1183500n 0
+    1183549n 0
+    1183550n 1.8
+    1183599n 1.8
+    1183600n 0
+    1183649n 0
+    1183650n 1.8
+    1183699n 1.8
+    1183700n 0
+    1183749n 0
+    1183750n 1.8
+    1183799n 1.8
+    1183800n 0
+    1183849n 0
+    1183850n 1.8
+    1183899n 1.8
+    1183900n 0
+    1183949n 0
+    1183950n 1.8
+    1183999n 1.8
+    1184000n 0
+    1184049n 0
+    1184050n 1.8
+    1184099n 1.8
+    1184100n 0
+    1184149n 0
+    1184150n 1.8
+    1184199n 1.8
+    1184200n 0
+    1184249n 0
+    1184250n 1.8
+    1184299n 1.8
+    1184300n 0
+    1184349n 0
+    1184350n 1.8
+    1184399n 1.8
+    1184400n 0
+    1184449n 0
+    1184450n 1.8
+    1184499n 1.8
+    1184500n 0
+    1184549n 0
+    1184550n 1.8
+    1184599n 1.8
+    1184600n 0
+    1184649n 0
+    1184650n 1.8
+    1184699n 1.8
+    1184700n 0
+    1184749n 0
+    1184750n 1.8
+    1184799n 1.8
+    1184800n 0
+    1184849n 0
+    1184850n 1.8
+    1184899n 1.8
+    1184900n 0
+    1184949n 0
+    1184950n 1.8
+    1184999n 1.8
+    1185000n 0
+    1185049n 0
+    1185050n 1.8
+    1185099n 1.8
+    1185100n 0
+    1185149n 0
+    1185150n 1.8
+    1185199n 1.8
+    1185200n 0
+    1185249n 0
+    1185250n 1.8
+    1185299n 1.8
+    1185300n 0
+    1185349n 0
+    1185350n 1.8
+    1185399n 1.8
+    1185400n 0
+    1185449n 0
+    1185450n 1.8
+    1185499n 1.8
+    1185500n 0
+    1185549n 0
+    1185550n 1.8
+    1185599n 1.8
+    1185600n 0
+    1185649n 0
+    1185650n 1.8
+    1185699n 1.8
+    1185700n 0
+    1185749n 0
+    1185750n 1.8
+    1185799n 1.8
+    1185800n 0
+    1185849n 0
+    1185850n 1.8
+    1185899n 1.8
+    1185900n 0
+    1185949n 0
+    1185950n 1.8
+    1185999n 1.8
+    1186000n 0
+    1186049n 0
+    1186050n 1.8
+    1186099n 1.8
+    1186100n 0
+    1186149n 0
+    1186150n 1.8
+    1186199n 1.8
+    1186200n 0
+    1186249n 0
+    1186250n 1.8
+    1186299n 1.8
+    1186300n 0
+    1186349n 0
+    1186350n 1.8
+    1186399n 1.8
+    1186400n 0
+    1186449n 0
+    1186450n 1.8
+    1186499n 1.8
+    1186500n 0
+    1186549n 0
+    1186550n 1.8
+    1186599n 1.8
+    1186600n 0
+    1186649n 0
+    1186650n 1.8
+    1186699n 1.8
+    1186700n 0
+    1186749n 0
+    1186750n 1.8
+    1186799n 1.8
+    1186800n 0
+    1186849n 0
+    1186850n 1.8
+    1186899n 1.8
+    1186900n 0
+    1186949n 0
+    1186950n 1.8
+    1186999n 1.8
+    1187000n 0
+    1187049n 0
+    1187050n 1.8
+    1187099n 1.8
+    1187100n 0
+    1187149n 0
+    1187150n 1.8
+    1187199n 1.8
+    1187200n 0
+    1187249n 0
+    1187250n 1.8
+    1187299n 1.8
+    1187300n 0
+    1187349n 0
+    1187350n 1.8
+    1187399n 1.8
+    1187400n 0
+    1187449n 0
+    1187450n 1.8
+    1187499n 1.8
+    1187500n 0
+    1187549n 0
+    1187550n 1.8
+    1187599n 1.8
+    1187600n 0
+    1187649n 0
+    1187650n 1.8
+    1187699n 1.8
+    1187700n 0
+    1187749n 0
+    1187750n 1.8
+    1187799n 1.8
+    1187800n 0
+    1187849n 0
+    1187850n 1.8
+    1187899n 1.8
+    1187900n 0
+    1187949n 0
+    1187950n 1.8
+    1187999n 1.8
+    1188000n 0
+    1188049n 0
+    1188050n 1.8
+    1188099n 1.8
+    1188100n 0
+    1188149n 0
+    1188150n 1.8
+    1188199n 1.8
+    1188200n 0
+    1188249n 0
+    1188250n 1.8
+    1188299n 1.8
+    1188300n 0
+    1188349n 0
+    1188350n 1.8
+    1188399n 1.8
+    1188400n 0
+    1188449n 0
+    1188450n 1.8
+    1188499n 1.8
+    1188500n 0
+    1188549n 0
+    1188550n 1.8
+    1188599n 1.8
+    1188600n 0
+    1188649n 0
+    1188650n 1.8
+    1188699n 1.8
+    1188700n 0
+    1188749n 0
+    1188750n 1.8
+    1188799n 1.8
+    1188800n 0
+    1188849n 0
+    1188850n 1.8
+    1188899n 1.8
+    1188900n 0
+    1188949n 0
+    1188950n 1.8
+    1188999n 1.8
+    1189000n 0
+    1189049n 0
+    1189050n 1.8
+    1189099n 1.8
+    1189100n 0
+    1189149n 0
+    1189150n 1.8
+    1189199n 1.8
+    1189200n 0
+    1189249n 0
+    1189250n 1.8
+    1189299n 1.8
+    1189300n 0
+    1189349n 0
+    1189350n 1.8
+    1189399n 1.8
+    1189400n 0
+    1189449n 0
+    1189450n 1.8
+    1189499n 1.8
+    1189500n 0
+    1189549n 0
+    1189550n 1.8
+    1189599n 1.8
+    1189600n 0
+    1189649n 0
+    1189650n 1.8
+    1189699n 1.8
+    1189700n 0
+    1189749n 0
+    1189750n 1.8
+    1189799n 1.8
+    1189800n 0
+    1189849n 0
+    1189850n 1.8
+    1189899n 1.8
+    1189900n 0
+    1189949n 0
+    1189950n 1.8
+    1189999n 1.8
+    1190000n 0
+    1190049n 0
+    1190050n 1.8
+    1190099n 1.8
+    1190100n 0
+    1190149n 0
+    1190150n 1.8
+    1190199n 1.8
+    1190200n 0
+    1190249n 0
+    1190250n 1.8
+    1190299n 1.8
+    1190300n 0
+    1190349n 0
+    1190350n 1.8
+    1190399n 1.8
+    1190400n 0
+    1190449n 0
+    1190450n 1.8
+    1190499n 1.8
+    1190500n 0
+    1190549n 0
+    1190550n 1.8
+    1190599n 1.8
+    1190600n 0
+    1190649n 0
+    1190650n 1.8
+    1190699n 1.8
+    1190700n 0
+    1190749n 0
+    1190750n 1.8
+    1190799n 1.8
+    1190800n 0
+    1190849n 0
+    1190850n 1.8
+    1190899n 1.8
+    1190900n 0
+    1190949n 0
+    1190950n 1.8
+    1190999n 1.8
+    1191000n 0
+    1191049n 0
+    1191050n 1.8
+    1191099n 1.8
+    1191100n 0
+    1191149n 0
+    1191150n 1.8
+    1191199n 1.8
+    1191200n 0
+    1191249n 0
+    1191250n 1.8
+    1191299n 1.8
+    1191300n 0
+    1191349n 0
+    1191350n 1.8
+    1191399n 1.8
+    1191400n 0
+    1191449n 0
+    1191450n 1.8
+    1191499n 1.8
+    1191500n 0
+    1191549n 0
+    1191550n 1.8
+    1191599n 1.8
+    1191600n 0
+    1191649n 0
+    1191650n 1.8
+    1191699n 1.8
+    1191700n 0
+    1191749n 0
+    1191750n 1.8
+    1191799n 1.8
+    1191800n 0
+    1191849n 0
+    1191850n 1.8
+    1191899n 1.8
+    1191900n 0
+    1191949n 0
+    1191950n 1.8
+    1191999n 1.8
+    1192000n 0
+    1192049n 0
+    1192050n 1.8
+    1192099n 1.8
+    1192100n 0
+    1192149n 0
+    1192150n 1.8
+    1192199n 1.8
+    1192200n 0
+    1192249n 0
+    1192250n 1.8
+    1192299n 1.8
+    1192300n 0
+    1192349n 0
+    1192350n 1.8
+    1192399n 1.8
+    1192400n 0
+    1192449n 0
+    1192450n 1.8
+    1192499n 1.8
+    1192500n 0
+    1192549n 0
+    1192550n 1.8
+    1192599n 1.8
+    1192600n 0
+    1192649n 0
+    1192650n 1.8
+    1192699n 1.8
+    1192700n 0
+    1192749n 0
+    1192750n 1.8
+    1192799n 1.8
+    1192800n 0
+    1192849n 0
+    1192850n 1.8
+    1192899n 1.8
+    1192900n 0
+    1192949n 0
+    1192950n 1.8
+    1192999n 1.8
+    1193000n 0
+    1193049n 0
+    1193050n 1.8
+    1193099n 1.8
+    1193100n 0
+    1193149n 0
+    1193150n 1.8
+    1193199n 1.8
+    1193200n 0
+    1193249n 0
+    1193250n 1.8
+    1193299n 1.8
+    1193300n 0
+    1193349n 0
+    1193350n 1.8
+    1193399n 1.8
+    1193400n 0
+    1193449n 0
+    1193450n 1.8
+    1193499n 1.8
+    1193500n 0
+    1193549n 0
+    1193550n 1.8
+    1193599n 1.8
+    1193600n 0
+    1193649n 0
+    1193650n 1.8
+    1193699n 1.8
+    1193700n 0
+    1193749n 0
+    1193750n 1.8
+    1193799n 1.8
+    1193800n 0
+    1193849n 0
+    1193850n 1.8
+    1193899n 1.8
+    1193900n 0
+    1193949n 0
+    1193950n 1.8
+    1193999n 1.8
+    1194000n 0
+    1194049n 0
+    1194050n 1.8
+    1194099n 1.8
+    1194100n 0
+    1194149n 0
+    1194150n 1.8
+    1194199n 1.8
+    1194200n 0
+    1194249n 0
+    1194250n 1.8
+    1194299n 1.8
+    1194300n 0
+    1194349n 0
+    1194350n 1.8
+    1194399n 1.8
+    1194400n 0
+    1194449n 0
+    1194450n 1.8
+    1194499n 1.8
+    1194500n 0
+    1194549n 0
+    1194550n 1.8
+    1194599n 1.8
+    1194600n 0
+    1194649n 0
+    1194650n 1.8
+    1194699n 1.8
+    1194700n 0
+    1194749n 0
+    1194750n 1.8
+    1194799n 1.8
+    1194800n 0
+    1194849n 0
+    1194850n 1.8
+    1194899n 1.8
+    1194900n 0
+    1194949n 0
+    1194950n 1.8
+    1194999n 1.8
+    1195000n 0
+    1195049n 0
+    1195050n 1.8
+    1195099n 1.8
+    1195100n 0
+    1195149n 0
+    1195150n 1.8
+    1195199n 1.8
+    1195200n 0
+    1195249n 0
+    1195250n 1.8
+    1195299n 1.8
+    1195300n 0
+    1195349n 0
+    1195350n 1.8
+    1195399n 1.8
+    1195400n 0
+    1195449n 0
+    1195450n 1.8
+    1195499n 1.8
+    1195500n 0
+    1195549n 0
+    1195550n 1.8
+    1195599n 1.8
+    1195600n 0
+    1195649n 0
+    1195650n 1.8
+    1195699n 1.8
+    1195700n 0
+    1195749n 0
+    1195750n 1.8
+    1195799n 1.8
+    1195800n 0
+    1195849n 0
+    1195850n 1.8
+    1195899n 1.8
+    1195900n 0
+    1195949n 0
+    1195950n 1.8
+    1195999n 1.8
+    1196000n 0
+    1196049n 0
+    1196050n 1.8
+    1196099n 1.8
+    1196100n 0
+    1196149n 0
+    1196150n 1.8
+    1196199n 1.8
+    1196200n 0
+    1196249n 0
+    1196250n 1.8
+    1196299n 1.8
+    1196300n 0
+    1196349n 0
+    1196350n 1.8
+    1196399n 1.8
+    1196400n 0
+    1196449n 0
+    1196450n 1.8
+    1196499n 1.8
+    1196500n 0
+    1196549n 0
+    1196550n 1.8
+    1196599n 1.8
+    1196600n 0
+    1196649n 0
+    1196650n 1.8
+    1196699n 1.8
+    1196700n 0
+    1196749n 0
+    1196750n 1.8
+    1196799n 1.8
+    1196800n 0
+    1196849n 0
+    1196850n 1.8
+    1196899n 1.8
+    1196900n 0
+    1196949n 0
+    1196950n 1.8
+    1196999n 1.8
+    1197000n 0
+    1197049n 0
+    1197050n 1.8
+    1197099n 1.8
+    1197100n 0
+    1197149n 0
+    1197150n 1.8
+    1197199n 1.8
+    1197200n 0
+    1197249n 0
+    1197250n 1.8
+    1197299n 1.8
+    1197300n 0
+    1197349n 0
+    1197350n 1.8
+    1197399n 1.8
+    1197400n 0
+    1197449n 0
+    1197450n 1.8
+    1197499n 1.8
+    1197500n 0
+    1197549n 0
+    1197550n 1.8
+    1197599n 1.8
+    1197600n 0
+    1197649n 0
+    1197650n 1.8
+    1197699n 1.8
+    1197700n 0
+    1197749n 0
+    1197750n 1.8
+    1197799n 1.8
+    1197800n 0
+    1197849n 0
+    1197850n 1.8
+    1197899n 1.8
+    1197900n 0
+    1197949n 0
+    1197950n 1.8
+    1197999n 1.8
+    1198000n 0
+    1198049n 0
+    1198050n 1.8
+    1198099n 1.8
+    1198100n 0
+    1198149n 0
+    1198150n 1.8
+    1198199n 1.8
+    1198200n 0
+    1198249n 0
+    1198250n 1.8
+    1198299n 1.8
+    1198300n 0
+    1198349n 0
+    1198350n 1.8
+    1198399n 1.8
+    1198400n 0
+    1198449n 0
+    1198450n 1.8
+    1198499n 1.8
+    1198500n 0
+    1198549n 0
+    1198550n 1.8
+    1198599n 1.8
+    1198600n 0
+    1198649n 0
+    1198650n 1.8
+    1198699n 1.8
+    1198700n 0
+    1198749n 0
+    1198750n 1.8
+    1198799n 1.8
+    1198800n 0
+    1198849n 0
+    1198850n 1.8
+    1198899n 1.8
+    1198900n 0
+    1198949n 0
+    1198950n 1.8
+    1198999n 1.8
+    1199000n 0
+    1199049n 0
+    1199050n 1.8
+    1199099n 1.8
+    1199100n 0
+    1199149n 0
+    1199150n 1.8
+    1199199n 1.8
+    1199200n 0
+    1199249n 0
+    1199250n 1.8
+    1199299n 1.8
+    1199300n 0
+    1199349n 0
+    1199350n 1.8
+    1199399n 1.8
+    1199400n 0
+    1199449n 0
+    1199450n 1.8
+    1199499n 1.8
+    1199500n 0
+    1199549n 0
+    1199550n 1.8
+    1199599n 1.8
+    1199600n 0
+    1199649n 0
+    1199650n 1.8
+    1199699n 1.8
+    1199700n 0
+    1199749n 0
+    1199750n 1.8
+    1199799n 1.8
+    1199800n 0
+    1199849n 0
+    1199850n 1.8
+    1199899n 1.8
+    1199900n 0
+    1199949n 0
+    1199950n 1.8
+    1199999n 1.8
+    1200000n 0
+    1200049n 0
+    1200050n 1.8
+    1200099n 1.8
+    1200100n 0
+    1200149n 0
+    1200150n 1.8
+    1200199n 1.8
+    1200200n 0
+    1200249n 0
+    1200250n 1.8
+    1200299n 1.8
+    1200300n 0
+    1200349n 0
+    1200350n 1.8
+    1200399n 1.8
+    1200400n 0
+    1200449n 0
+    1200450n 1.8
+    1200499n 1.8
+    1200500n 0
+    1200549n 0
+    1200550n 1.8
+    1200599n 1.8
+    1200600n 0
+    1200649n 0
+    1200650n 1.8
+    1200699n 1.8
+    1200700n 0
+    1200749n 0
+    1200750n 1.8
+    1200799n 1.8
+    1200800n 0
+    1200849n 0
+    1200850n 1.8
+    1200899n 1.8
+    1200900n 0
+    1200949n 0
+    1200950n 1.8
+    1200999n 1.8
+    1201000n 0
+    1201049n 0
+    1201050n 1.8
+    1201099n 1.8
+    1201100n 0
+    1201149n 0
+    1201150n 1.8
+    1201199n 1.8
+    1201200n 0
+    1201249n 0
+    1201250n 1.8
+    1201299n 1.8
+    1201300n 0
+    1201349n 0
+    1201350n 1.8
+    1201399n 1.8
+    1201400n 0
+    1201449n 0
+    1201450n 1.8
+    1201499n 1.8
+    1201500n 0
+    1201549n 0
+    1201550n 1.8
+    1201599n 1.8
+    1201600n 0
+    1201649n 0
+    1201650n 1.8
+    1201699n 1.8
+    1201700n 0
+    1201749n 0
+    1201750n 1.8
+    1201799n 1.8
+    1201800n 0
+    1201849n 0
+    1201850n 1.8
+    1201899n 1.8
+    1201900n 0
+    1201949n 0
+    1201950n 1.8
+    1201999n 1.8
+    1202000n 0
+    1202049n 0
+    1202050n 1.8
+    1202099n 1.8
+    1202100n 0
+    1202149n 0
+    1202150n 1.8
+    1202199n 1.8
+    1202200n 0
+    1202249n 0
+    1202250n 1.8
+    1202299n 1.8
+    1202300n 0
+    1202349n 0
+    1202350n 1.8
+    1202399n 1.8
+    1202400n 0
+    1202449n 0
+    1202450n 1.8
+    1202499n 1.8
+    1202500n 0
+    1202549n 0
+    1202550n 1.8
+    1202599n 1.8
+    1202600n 0
+    1202649n 0
+    1202650n 1.8
+    1202699n 1.8
+    1202700n 0
+    1202749n 0
+    1202750n 1.8
+    1202799n 1.8
+    1202800n 0
+    1202849n 0
+    1202850n 1.8
+    1202899n 1.8
+    1202900n 0
+    1202949n 0
+    1202950n 1.8
+    1202999n 1.8
+    1203000n 0
+    1203049n 0
+    1203050n 1.8
+    1203099n 1.8
+    1203100n 0
+    1203149n 0
+    1203150n 1.8
+    1203199n 1.8
+    1203200n 0
+    1203249n 0
+    1203250n 1.8
+    1203299n 1.8
+    1203300n 0
+    1203349n 0
+    1203350n 1.8
+    1203399n 1.8
+    1203400n 0
+    1203449n 0
+    1203450n 1.8
+    1203499n 1.8
+    1203500n 0
+    1203549n 0
+    1203550n 1.8
+    1203599n 1.8
+    1203600n 0
+    1203649n 0
+    1203650n 1.8
+    1203699n 1.8
+    1203700n 0
+    1203749n 0
+    1203750n 1.8
+    1203799n 1.8
+    1203800n 0
+    1203849n 0
+    1203850n 1.8
+    1203899n 1.8
+    1203900n 0
+    1203949n 0
+    1203950n 1.8
+    1203999n 1.8
+    1204000n 0
+    1204049n 0
+    1204050n 1.8
+    1204099n 1.8
+    1204100n 0
+    1204149n 0
+    1204150n 1.8
+    1204199n 1.8
+    1204200n 0
+    1204249n 0
+    1204250n 1.8
+    1204299n 1.8
+    1204300n 0
+    1204349n 0
+    1204350n 1.8
+    1204399n 1.8
+    1204400n 0
+    1204449n 0
+    1204450n 1.8
+    1204499n 1.8
+    1204500n 0
+    1204549n 0
+    1204550n 1.8
+    1204599n 1.8
+    1204600n 0
+    1204649n 0
+    1204650n 1.8
+    1204699n 1.8
+    1204700n 0
+    1204749n 0
+    1204750n 1.8
+    1204799n 1.8
+    1204800n 0
+    1204849n 0
+    1204850n 1.8
+    1204899n 1.8
+    1204900n 0
+    1204949n 0
+    1204950n 1.8
+    1204999n 1.8
+    1205000n 0
+    1205049n 0
+    1205050n 1.8
+    1205099n 1.8
+    1205100n 0
+    1205149n 0
+    1205150n 1.8
+    1205199n 1.8
+    1205200n 0
+    1205249n 0
+    1205250n 1.8
+    1205299n 1.8
+    1205300n 0
+    1205349n 0
+    1205350n 1.8
+    1205399n 1.8
+    1205400n 0
+    1205449n 0
+    1205450n 1.8
+    1205499n 1.8
+    1205500n 0
+    1205549n 0
+    1205550n 1.8
+    1205599n 1.8
+    1205600n 0
+    1205649n 0
+    1205650n 1.8
+    1205699n 1.8
+    1205700n 0
+    1205749n 0
+    1205750n 1.8
+    1205799n 1.8
+    1205800n 0
+    1205849n 0
+    1205850n 1.8
+    1205899n 1.8
+    1205900n 0
+    1205949n 0
+    1205950n 1.8
+    1205999n 1.8
+    1206000n 0
+    1206049n 0
+    1206050n 1.8
+    1206099n 1.8
+    1206100n 0
+    1206149n 0
+    1206150n 1.8
+    1206199n 1.8
+    1206200n 0
+    1206249n 0
+    1206250n 1.8
+    1206299n 1.8
+    1206300n 0
+    1206349n 0
+    1206350n 1.8
+    1206399n 1.8
+    1206400n 0
+    1206449n 0
+    1206450n 1.8
+    1206499n 1.8
+    1206500n 0
+    1206549n 0
+    1206550n 1.8
+    1206599n 1.8
+    1206600n 0
+    1206649n 0
+    1206650n 1.8
+    1206699n 1.8
+    1206700n 0
+    1206749n 0
+    1206750n 1.8
+    1206799n 1.8
+    1206800n 0
+    1206849n 0
+    1206850n 1.8
+    1206899n 1.8
+    1206900n 0
+    1206949n 0
+    1206950n 1.8
+    1206999n 1.8
+    1207000n 0
+    1207049n 0
+    1207050n 1.8
+    1207099n 1.8
+    1207100n 0
+    1207149n 0
+    1207150n 1.8
+    1207199n 1.8
+    1207200n 0
+    1207249n 0
+    1207250n 1.8
+    1207299n 1.8
+    1207300n 0
+    1207349n 0
+    1207350n 1.8
+    1207399n 1.8
+    1207400n 0
+    1207449n 0
+    1207450n 1.8
+    1207499n 1.8
+    1207500n 0
+    1207549n 0
+    1207550n 1.8
+    1207599n 1.8
+    1207600n 0
+    1207649n 0
+    1207650n 1.8
+    1207699n 1.8
+    1207700n 0
+    1207749n 0
+    1207750n 1.8
+    1207799n 1.8
+    1207800n 0
+    1207849n 0
+    1207850n 1.8
+    1207899n 1.8
+    1207900n 0
+    1207949n 0
+    1207950n 1.8
+    1207999n 1.8
+    1208000n 0
+    1208049n 0
+    1208050n 1.8
+    1208099n 1.8
+    1208100n 0
+    1208149n 0
+    1208150n 1.8
+    1208199n 1.8
+    1208200n 0
+    1208249n 0
+    1208250n 1.8
+    1208299n 1.8
+    1208300n 0
+    1208349n 0
+    1208350n 1.8
+    1208399n 1.8
+    1208400n 0
+    1208449n 0
+    1208450n 1.8
+    1208499n 1.8
+    1208500n 0
+    1208549n 0
+    1208550n 1.8
+    1208599n 1.8
+    1208600n 0
+    1208649n 0
+    1208650n 1.8
+    1208699n 1.8
+    1208700n 0
+    1208749n 0
+    1208750n 1.8
+    1208799n 1.8
+    1208800n 0
+    1208849n 0
+    1208850n 1.8
+    1208899n 1.8
+    1208900n 0
+    1208949n 0
+    1208950n 1.8
+    1208999n 1.8
+    1209000n 0
+    1209049n 0
+    1209050n 1.8
+    1209099n 1.8
+    1209100n 0
+    1209149n 0
+    1209150n 1.8
+    1209199n 1.8
+    1209200n 0
+    1209249n 0
+    1209250n 1.8
+    1209299n 1.8
+    1209300n 0
+    1209349n 0
+    1209350n 1.8
+    1209399n 1.8
+    1209400n 0
+    1209449n 0
+    1209450n 1.8
+    1209499n 1.8
+    1209500n 0
+    1209549n 0
+    1209550n 1.8
+    1209599n 1.8
+    1209600n 0
+    1209649n 0
+    1209650n 1.8
+    1209699n 1.8
+    1209700n 0
+    1209749n 0
+    1209750n 1.8
+    1209799n 1.8
+    1209800n 0
+    1209849n 0
+    1209850n 1.8
+    1209899n 1.8
+    1209900n 0
+    1209949n 0
+    1209950n 1.8
+    1209999n 1.8
+    1210000n 0
+    1210049n 0
+    1210050n 1.8
+    1210099n 1.8
+    1210100n 0
+    1210149n 0
+    1210150n 1.8
+    1210199n 1.8
+    1210200n 0
+    1210249n 0
+    1210250n 1.8
+    1210299n 1.8
+    1210300n 0
+    1210349n 0
+    1210350n 1.8
+    1210399n 1.8
+    1210400n 0
+    1210449n 0
+    1210450n 1.8
+    1210499n 1.8
+    1210500n 0
+    1210549n 0
+    1210550n 1.8
+    1210599n 1.8
+    1210600n 0
+    1210649n 0
+    1210650n 1.8
+    1210699n 1.8
+    1210700n 0
+    1210749n 0
+    1210750n 1.8
+    1210799n 1.8
+    1210800n 0
+    1210849n 0
+    1210850n 1.8
+    1210899n 1.8
+    1210900n 0
+    1210949n 0
+    1210950n 1.8
+    1210999n 1.8
+    1211000n 0
+    1211049n 0
+    1211050n 1.8
+    1211099n 1.8
+    1211100n 0
+    1211149n 0
+    1211150n 1.8
+    1211199n 1.8
+    1211200n 0
+    1211249n 0
+    1211250n 1.8
+    1211299n 1.8
+    1211300n 0
+    1211349n 0
+    1211350n 1.8
+    1211399n 1.8
+    1211400n 0
+    1211449n 0
+    1211450n 1.8
+    1211499n 1.8
+    1211500n 0
+    1211549n 0
+    1211550n 1.8
+    1211599n 1.8
+    1211600n 0
+    1211649n 0
+    1211650n 1.8
+    1211699n 1.8
+    1211700n 0
+    1211749n 0
+    1211750n 1.8
+    1211799n 1.8
+    1211800n 0
+    1211849n 0
+    1211850n 1.8
+    1211899n 1.8
+    1211900n 0
+    1211949n 0
+    1211950n 1.8
+    1211999n 1.8
+    1212000n 0
+    1212049n 0
+    1212050n 1.8
+    1212099n 1.8
+    1212100n 0
+    1212149n 0
+    1212150n 1.8
+    1212199n 1.8
+    1212200n 0
+    1212249n 0
+    1212250n 1.8
+    1212299n 1.8
+    1212300n 0
+    1212349n 0
+    1212350n 1.8
+    1212399n 1.8
+    1212400n 0
+    1212449n 0
+    1212450n 1.8
+    1212499n 1.8
+    1212500n 0
+    1212549n 0
+    1212550n 1.8
+    1212599n 1.8
+    1212600n 0
+    1212649n 0
+    1212650n 1.8
+    1212699n 1.8
+    1212700n 0
+    1212749n 0
+    1212750n 1.8
+    1212799n 1.8
+    1212800n 0
+    1212849n 0
+    1212850n 1.8
+    1212899n 1.8
+    1212900n 0
+    1212949n 0
+    1212950n 1.8
+    1212999n 1.8
+    1213000n 0
+    1213049n 0
+    1213050n 1.8
+    1213099n 1.8
+    1213100n 0
+    1213149n 0
+    1213150n 1.8
+    1213199n 1.8
+    1213200n 0
+    1213249n 0
+    1213250n 1.8
+    1213299n 1.8
+    1213300n 0
+    1213349n 0
+    1213350n 1.8
+    1213399n 1.8
+    1213400n 0
+    1213449n 0
+    1213450n 1.8
+    1213499n 1.8
+    1213500n 0
+    1213549n 0
+    1213550n 1.8
+    1213599n 1.8
+    1213600n 0
+    1213649n 0
+    1213650n 1.8
+    1213699n 1.8
+    1213700n 0
+    1213749n 0
+    1213750n 1.8
+    1213799n 1.8
+    1213800n 0
+    1213849n 0
+    1213850n 1.8
+    1213899n 1.8
+    1213900n 0
+    1213949n 0
+    1213950n 1.8
+    1213999n 1.8
+    1214000n 0
+    1214049n 0
+    1214050n 1.8
+    1214099n 1.8
+    1214100n 0
+    1214149n 0
+    1214150n 1.8
+    1214199n 1.8
+    1214200n 0
+    1214249n 0
+    1214250n 1.8
+    1214299n 1.8
+    1214300n 0
+    1214349n 0
+    1214350n 1.8
+    1214399n 1.8
+    1214400n 0
+    1214449n 0
+    1214450n 1.8
+    1214499n 1.8
+    1214500n 0
+    1214549n 0
+    1214550n 1.8
+    1214599n 1.8
+    1214600n 0
+    1214649n 0
+    1214650n 1.8
+    1214699n 1.8
+    1214700n 0
+    1214749n 0
+    1214750n 1.8
+    1214799n 1.8
+    1214800n 0
+    1214849n 0
+    1214850n 1.8
+    1214899n 1.8
+    1214900n 0
+    1214949n 0
+    1214950n 1.8
+    1214999n 1.8
+    1215000n 0
+    1215049n 0
+    1215050n 1.8
+    1215099n 1.8
+    1215100n 0
+    1215149n 0
+    1215150n 1.8
+    1215199n 1.8
+    1215200n 0
+    1215249n 0
+    1215250n 1.8
+    1215299n 1.8
+    1215300n 0
+    1215349n 0
+    1215350n 1.8
+    1215399n 1.8
+    1215400n 0
+    1215449n 0
+    1215450n 1.8
+    1215499n 1.8
+    1215500n 0
+    1215549n 0
+    1215550n 1.8
+    1215599n 1.8
+    1215600n 0
+    1215649n 0
+    1215650n 1.8
+    1215699n 1.8
+    1215700n 0
+    1215749n 0
+    1215750n 1.8
+    1215799n 1.8
+    1215800n 0
+    1215849n 0
+    1215850n 1.8
+    1215899n 1.8
+    1215900n 0
+    1215949n 0
+    1215950n 1.8
+    1215999n 1.8
+    1216000n 0
+    1216049n 0
+    1216050n 1.8
+    1216099n 1.8
+    1216100n 0
+    1216149n 0
+    1216150n 1.8
+    1216199n 1.8
+    1216200n 0
+    1216249n 0
+    1216250n 1.8
+    1216299n 1.8
+    1216300n 0
+    1216349n 0
+    1216350n 1.8
+    1216399n 1.8
+    1216400n 0
+    1216449n 0
+    1216450n 1.8
+    1216499n 1.8
+    1216500n 0
+    1216549n 0
+    1216550n 1.8
+    1216599n 1.8
+    1216600n 0
+    1216649n 0
+    1216650n 1.8
+    1216699n 1.8
+    1216700n 0
+    1216749n 0
+    1216750n 1.8
+    1216799n 1.8
+    1216800n 0
+    1216849n 0
+    1216850n 1.8
+    1216899n 1.8
+    1216900n 0
+    1216949n 0
+    1216950n 1.8
+    1216999n 1.8
+    1217000n 0
+    1217049n 0
+    1217050n 1.8
+    1217099n 1.8
+    1217100n 0
+    1217149n 0
+    1217150n 1.8
+    1217199n 1.8
+    1217200n 0
+    1217249n 0
+    1217250n 1.8
+    1217299n 1.8
+    1217300n 0
+    1217349n 0
+    1217350n 1.8
+    1217399n 1.8
+    1217400n 0
+    1217449n 0
+    1217450n 1.8
+    1217499n 1.8
+    1217500n 0
+    1217549n 0
+    1217550n 1.8
+    1217599n 1.8
+    1217600n 0
+    1217649n 0
+    1217650n 1.8
+    1217699n 1.8
+    1217700n 0
+    1217749n 0
+    1217750n 1.8
+    1217799n 1.8
+    1217800n 0
+    1217849n 0
+    1217850n 1.8
+    1217899n 1.8
+    1217900n 0
+    1217949n 0
+    1217950n 1.8
+    1217999n 1.8
+    1218000n 0
+    1218049n 0
+    1218050n 1.8
+    1218099n 1.8
+    1218100n 0
+    1218149n 0
+    1218150n 1.8
+    1218199n 1.8
+    1218200n 0
+    1218249n 0
+    1218250n 1.8
+    1218299n 1.8
+    1218300n 0
+    1218349n 0
+    1218350n 1.8
+    1218399n 1.8
+    1218400n 0
+    1218449n 0
+    1218450n 1.8
+    1218499n 1.8
+    1218500n 0
+    1218549n 0
+    1218550n 1.8
+    1218599n 1.8
+    1218600n 0
+    1218649n 0
+    1218650n 1.8
+    1218699n 1.8
+    1218700n 0
+    1218749n 0
+    1218750n 1.8
+    1218799n 1.8
+    1218800n 0
+    1218849n 0
+    1218850n 1.8
+    1218899n 1.8
+    1218900n 0
+    1218949n 0
+    1218950n 1.8
+    1218999n 1.8
+    1219000n 0
+    1219049n 0
+    1219050n 1.8
+    1219099n 1.8
+    1219100n 0
+    1219149n 0
+    1219150n 1.8
+    1219199n 1.8
+    1219200n 0
+    1219249n 0
+    1219250n 1.8
+    1219299n 1.8
+    1219300n 0
+    1219349n 0
+    1219350n 1.8
+    1219399n 1.8
+    1219400n 0
+    1219449n 0
+    1219450n 1.8
+    1219499n 1.8
+    1219500n 0
+    1219549n 0
+    1219550n 1.8
+    1219599n 1.8
+    1219600n 0
+    1219649n 0
+    1219650n 1.8
+    1219699n 1.8
+    1219700n 0
+    1219749n 0
+    1219750n 1.8
+    1219799n 1.8
+    1219800n 0
+    1219849n 0
+    1219850n 1.8
+    1219899n 1.8
+    1219900n 0
+    1219949n 0
+    1219950n 1.8
+    1219999n 1.8
+    1220000n 0
+    1220049n 0
+    1220050n 1.8
+    1220099n 1.8
+    1220100n 0
+    1220149n 0
+    1220150n 1.8
+    1220199n 1.8
+    1220200n 0
+    1220249n 0
+    1220250n 1.8
+    1220299n 1.8
+    1220300n 0
+    1220349n 0
+    1220350n 1.8
+    1220399n 1.8
+    1220400n 0
+    1220449n 0
+    1220450n 1.8
+    1220499n 1.8
+    1220500n 0
+    1220549n 0
+    1220550n 1.8
+    1220599n 1.8
+    1220600n 0
+    1220649n 0
+    1220650n 1.8
+    1220699n 1.8
+    1220700n 0
+    1220749n 0
+    1220750n 1.8
+    1220799n 1.8
+    1220800n 0
+    1220849n 0
+    1220850n 1.8
+    1220899n 1.8
+    1220900n 0
+    1220949n 0
+    1220950n 1.8
+    1220999n 1.8
+    1221000n 0
+    1221049n 0
+    1221050n 1.8
+    1221099n 1.8
+    1221100n 0
+    1221149n 0
+    1221150n 1.8
+    1221199n 1.8
+    1221200n 0
+    1221249n 0
+    1221250n 1.8
+    1221299n 1.8
+    1221300n 0
+    1221349n 0
+    1221350n 1.8
+    1221399n 1.8
+    1221400n 0
+    1221449n 0
+    1221450n 1.8
+    1221499n 1.8
+    1221500n 0
+    1221549n 0
+    1221550n 1.8
+    1221599n 1.8
+    1221600n 0
+    1221649n 0
+    1221650n 1.8
+    1221699n 1.8
+    1221700n 0
+    1221749n 0
+    1221750n 1.8
+    1221799n 1.8
+    1221800n 0
+    1221849n 0
+    1221850n 1.8
+    1221899n 1.8
+    1221900n 0
+    1221949n 0
+    1221950n 1.8
+    1221999n 1.8
+    1222000n 0
+    1222049n 0
+    1222050n 1.8
+    1222099n 1.8
+    1222100n 0
+    1222149n 0
+    1222150n 1.8
+    1222199n 1.8
+    1222200n 0
+    1222249n 0
+    1222250n 1.8
+    1222299n 1.8
+    1222300n 0
+    1222349n 0
+    1222350n 1.8
+    1222399n 1.8
+    1222400n 0
+    1222449n 0
+    1222450n 1.8
+    1222499n 1.8
+    1222500n 0
+    1222549n 0
+    1222550n 1.8
+    1222599n 1.8
+    1222600n 0
+    1222649n 0
+    1222650n 1.8
+    1222699n 1.8
+    1222700n 0
+    1222749n 0
+    1222750n 1.8
+    1222799n 1.8
+    1222800n 0
+    1222849n 0
+    1222850n 1.8
+    1222899n 1.8
+    1222900n 0
+    1222949n 0
+    1222950n 1.8
+    1222999n 1.8
+    1223000n 0
+    1223049n 0
+    1223050n 1.8
+    1223099n 1.8
+    1223100n 0
+    1223149n 0
+    1223150n 1.8
+    1223199n 1.8
+    1223200n 0
+    1223249n 0
+    1223250n 1.8
+    1223299n 1.8
+    1223300n 0
+    1223349n 0
+    1223350n 1.8
+    1223399n 1.8
+    1223400n 0
+    1223449n 0
+    1223450n 1.8
+    1223499n 1.8
+    1223500n 0
+    1223549n 0
+    1223550n 1.8
+    1223599n 1.8
+    1223600n 0
+    1223649n 0
+    1223650n 1.8
+    1223699n 1.8
+    1223700n 0
+    1223749n 0
+    1223750n 1.8
+    1223799n 1.8
+    1223800n 0
+    1223849n 0
+    1223850n 1.8
+    1223899n 1.8
+    1223900n 0
+    1223949n 0
+    1223950n 1.8
+    1223999n 1.8
+    1224000n 0
+    1224049n 0
+    1224050n 1.8
+    1224099n 1.8
+    1224100n 0
+    1224149n 0
+    1224150n 1.8
+    1224199n 1.8
+    1224200n 0
+    1224249n 0
+    1224250n 1.8
+    1224299n 1.8
+    1224300n 0
+    1224349n 0
+    1224350n 1.8
+    1224399n 1.8
+    1224400n 0
+    1224449n 0
+    1224450n 1.8
+    1224499n 1.8
+    1224500n 0
+    1224549n 0
+    1224550n 1.8
+    1224599n 1.8
+    1224600n 0
+    1224649n 0
+    1224650n 1.8
+    1224699n 1.8
+    1224700n 0
+    1224749n 0
+    1224750n 1.8
+    1224799n 1.8
+    1224800n 0
+    1224849n 0
+    1224850n 1.8
+    1224899n 1.8
+    1224900n 0
+    1224949n 0
+    1224950n 1.8
+    1224999n 1.8
+    1225000n 0
+    1225049n 0
+    1225050n 1.8
+    1225099n 1.8
+    1225100n 0
+    1225149n 0
+    1225150n 1.8
+    1225199n 1.8
+    1225200n 0
+    1225249n 0
+    1225250n 1.8
+    1225299n 1.8
+    1225300n 0
+    1225349n 0
+    1225350n 1.8
+    1225399n 1.8
+    1225400n 0
+    1225449n 0
+    1225450n 1.8
+    1225499n 1.8
+    1225500n 0
+    1225549n 0
+    1225550n 1.8
+    1225599n 1.8
+    1225600n 0
+    1225649n 0
+    1225650n 1.8
+    1225699n 1.8
+    1225700n 0
+    1225749n 0
+    1225750n 1.8
+    1225799n 1.8
+    1225800n 0
+    1225849n 0
+    1225850n 1.8
+    1225899n 1.8
+    1225900n 0
+    1225949n 0
+    1225950n 1.8
+    1225999n 1.8
+    1226000n 0
+    1226049n 0
+    1226050n 1.8
+    1226099n 1.8
+    1226100n 0
+    1226149n 0
+    1226150n 1.8
+    1226199n 1.8
+    1226200n 0
+    1226249n 0
+    1226250n 1.8
+    1226299n 1.8
+    1226300n 0
+    1226349n 0
+    1226350n 1.8
+    1226399n 1.8
+    1226400n 0
+    1226449n 0
+    1226450n 1.8
+    1226499n 1.8
+    1226500n 0
+    1226549n 0
+    1226550n 1.8
+    1226599n 1.8
+    1226600n 0
+    1226649n 0
+    1226650n 1.8
+    1226699n 1.8
+    1226700n 0
+    1226749n 0
+    1226750n 1.8
+    1226799n 1.8
+    1226800n 0
+    1226849n 0
+    1226850n 1.8
+    1226899n 1.8
+    1226900n 0
+    1226949n 0
+    1226950n 1.8
+    1226999n 1.8
+    1227000n 0
+    1227049n 0
+    1227050n 1.8
+    1227099n 1.8
+    1227100n 0
+    1227149n 0
+    1227150n 1.8
+    1227199n 1.8
+    1227200n 0
+    1227249n 0
+    1227250n 1.8
+    1227299n 1.8
+    1227300n 0
+    1227349n 0
+    1227350n 1.8
+    1227399n 1.8
+    1227400n 0
+    1227449n 0
+    1227450n 1.8
+    1227499n 1.8
+    1227500n 0
+    1227549n 0
+    1227550n 1.8
+    1227599n 1.8
+    1227600n 0
+    1227649n 0
+    1227650n 1.8
+    1227699n 1.8
+    1227700n 0
+    1227749n 0
+    1227750n 1.8
+    1227799n 1.8
+    1227800n 0
+    1227849n 0
+    1227850n 1.8
+    1227899n 1.8
+    1227900n 0
+    1227949n 0
+    1227950n 1.8
+    1227999n 1.8
+    1228000n 0
+    1228049n 0
+    1228050n 1.8
+    1228099n 1.8
+    1228100n 0
+    1228149n 0
+    1228150n 1.8
+    1228199n 1.8
+    1228200n 0
+    1228249n 0
+    1228250n 1.8
+    1228299n 1.8
+    1228300n 0
+    1228349n 0
+    1228350n 1.8
+    1228399n 1.8
+    1228400n 0
+    1228449n 0
+    1228450n 1.8
+    1228499n 1.8
+    1228500n 0
+    1228549n 0
+    1228550n 1.8
+    1228599n 1.8
+    1228600n 0
+    1228649n 0
+    1228650n 1.8
+    1228699n 1.8
+    1228700n 0
+    1228749n 0
+    1228750n 1.8
+    1228799n 1.8
+    1228800n 0
+    1228849n 0
+    1228850n 1.8
+    1228899n 1.8
+    1228900n 0
+    1228949n 0
+    1228950n 1.8
+    1228999n 1.8
+    1229000n 0
+    1229049n 0
+    1229050n 1.8
+    1229099n 1.8
+    1229100n 0
+    1229149n 0
+    1229150n 1.8
+    1229199n 1.8
+    1229200n 0
+    1229249n 0
+    1229250n 1.8
+    1229299n 1.8
+    1229300n 0
+    1229349n 0
+    1229350n 1.8
+    1229399n 1.8
+    1229400n 0
+    1229449n 0
+    1229450n 1.8
+    1229499n 1.8
+    1229500n 0
+    1229549n 0
+    1229550n 1.8
+    1229599n 1.8
+    1229600n 0
+    1229649n 0
+    1229650n 1.8
+    1229699n 1.8
+    1229700n 0
+    1229749n 0
+    1229750n 1.8
+    1229799n 1.8
+    1229800n 0
+    1229849n 0
+    1229850n 1.8
+    1229899n 1.8
+    1229900n 0
+    1229949n 0
+    1229950n 1.8
+    1229999n 1.8
+    1230000n 0
+    1230049n 0
+    1230050n 1.8
+    1230099n 1.8
+    1230100n 0
+    1230149n 0
+    1230150n 1.8
+    1230199n 1.8
+    1230200n 0
+    1230249n 0
+    1230250n 1.8
+    1230299n 1.8
+    1230300n 0
+    1230349n 0
+    1230350n 1.8
+    1230399n 1.8
+    1230400n 0
+    1230449n 0
+    1230450n 1.8
+    1230499n 1.8
+    1230500n 0
+    1230549n 0
+    1230550n 1.8
+    1230599n 1.8
+    1230600n 0
+    1230649n 0
+    1230650n 1.8
+    1230699n 1.8
+    1230700n 0
+    1230749n 0
+    1230750n 1.8
+    1230799n 1.8
+    1230800n 0
+    1230849n 0
+    1230850n 1.8
+    1230899n 1.8
+    1230900n 0
+    1230949n 0
+    1230950n 1.8
+    1230999n 1.8
+    1231000n 0
+    1231049n 0
+    1231050n 1.8
+    1231099n 1.8
+    1231100n 0
+    1231149n 0
+    1231150n 1.8
+    1231199n 1.8
+    1231200n 0
+    1231249n 0
+    1231250n 1.8
+    1231299n 1.8
+    1231300n 0
+    1231349n 0
+    1231350n 1.8
+    1231399n 1.8
+    1231400n 0
+    1231449n 0
+    1231450n 1.8
+    1231499n 1.8
+    1231500n 0
+    1231549n 0
+    1231550n 1.8
+    1231599n 1.8
+    1231600n 0
+    1231649n 0
+    1231650n 1.8
+    1231699n 1.8
+    1231700n 0
+    1231749n 0
+    1231750n 1.8
+    1231799n 1.8
+    1231800n 0
+    1231849n 0
+    1231850n 1.8
+    1231899n 1.8
+    1231900n 0
+    1231949n 0
+    1231950n 1.8
+    1231999n 1.8
+    1232000n 0
+    1232049n 0
+    1232050n 1.8
+    1232099n 1.8
+    1232100n 0
+    1232149n 0
+    1232150n 1.8
+    1232199n 1.8
+    1232200n 0
+    1232249n 0
+    1232250n 1.8
+    1232299n 1.8
+    1232300n 0
+    1232349n 0
+    1232350n 1.8
+    1232399n 1.8
+    1232400n 0
+    1232449n 0
+    1232450n 1.8
+    1232499n 1.8
+    1232500n 0
+    1232549n 0
+    1232550n 1.8
+    1232599n 1.8
+    1232600n 0
+    1232649n 0
+    1232650n 1.8
+    1232699n 1.8
+    1232700n 0
+    1232749n 0
+    1232750n 1.8
+    1232799n 1.8
+    1232800n 0
+    1232849n 0
+    1232850n 1.8
+    1232899n 1.8
+    1232900n 0
+    1232949n 0
+    1232950n 1.8
+    1232999n 1.8
+    1233000n 0
+    1233049n 0
+    1233050n 1.8
+    1233099n 1.8
+    1233100n 0
+    1233149n 0
+    1233150n 1.8
+    1233199n 1.8
+    1233200n 0
+    1233249n 0
+    1233250n 1.8
+    1233299n 1.8
+    1233300n 0
+    1233349n 0
+    1233350n 1.8
+    1233399n 1.8
+    1233400n 0
+    1233449n 0
+    1233450n 1.8
+    1233499n 1.8
+    1233500n 0
+    1233549n 0
+    1233550n 1.8
+    1233599n 1.8
+    1233600n 0
+    1233649n 0
+    1233650n 1.8
+    1233699n 1.8
+    1233700n 0
+    1233749n 0
+    1233750n 1.8
+    1233799n 1.8
+    1233800n 0
+    1233849n 0
+    1233850n 1.8
+    1233899n 1.8
+    1233900n 0
+    1233949n 0
+    1233950n 1.8
+    1233999n 1.8
+    1234000n 0
+    1234049n 0
+    1234050n 1.8
+    1234099n 1.8
+    1234100n 0
+    1234149n 0
+    1234150n 1.8
+    1234199n 1.8
+    1234200n 0
+    1234249n 0
+    1234250n 1.8
+    1234299n 1.8
+    1234300n 0
+    1234349n 0
+    1234350n 1.8
+    1234399n 1.8
+    1234400n 0
+    1234449n 0
+    1234450n 1.8
+    1234499n 1.8
+    1234500n 0
+    1234549n 0
+    1234550n 1.8
+    1234599n 1.8
+    1234600n 0
+    1234649n 0
+    1234650n 1.8
+    1234699n 1.8
+    1234700n 0
+    1234749n 0
+    1234750n 1.8
+    1234799n 1.8
+    1234800n 0
+    1234849n 0
+    1234850n 1.8
+    1234899n 1.8
+    1234900n 0
+    1234949n 0
+    1234950n 1.8
+    1234999n 1.8
+    1235000n 0
+    1235049n 0
+    1235050n 1.8
+    1235099n 1.8
+    1235100n 0
+    1235149n 0
+    1235150n 1.8
+    1235199n 1.8
+    1235200n 0
+    1235249n 0
+    1235250n 1.8
+    1235299n 1.8
+    1235300n 0
+    1235349n 0
+    1235350n 1.8
+    1235399n 1.8
+    1235400n 0
+    1235449n 0
+    1235450n 1.8
+    1235499n 1.8
+    1235500n 0
+    1235549n 0
+    1235550n 1.8
+    1235599n 1.8
+    1235600n 0
+    1235649n 0
+    1235650n 1.8
+    1235699n 1.8
+    1235700n 0
+    1235749n 0
+    1235750n 1.8
+    1235799n 1.8
+    1235800n 0
+    1235849n 0
+    1235850n 1.8
+    1235899n 1.8
+    1235900n 0
+    1235949n 0
+    1235950n 1.8
+    1235999n 1.8
+    1236000n 0
+    1236049n 0
+    1236050n 1.8
+    1236099n 1.8
+    1236100n 0
+    1236149n 0
+    1236150n 1.8
+    1236199n 1.8
+    1236200n 0
+    1236249n 0
+    1236250n 1.8
+    1236299n 1.8
+    1236300n 0
+    1236349n 0
+    1236350n 1.8
+    1236399n 1.8
+    1236400n 0
+    1236449n 0
+    1236450n 1.8
+    1236499n 1.8
+    1236500n 0
+    1236549n 0
+    1236550n 1.8
+    1236599n 1.8
+    1236600n 0
+    1236649n 0
+    1236650n 1.8
+    1236699n 1.8
+    1236700n 0
+    1236749n 0
+    1236750n 1.8
+    1236799n 1.8
+    1236800n 0
+    1236849n 0
+    1236850n 1.8
+    1236899n 1.8
+    1236900n 0
+    1236949n 0
+    1236950n 1.8
+    1236999n 1.8
+    1237000n 0
+    1237049n 0
+    1237050n 1.8
+    1237099n 1.8
+    1237100n 0
+    1237149n 0
+    1237150n 1.8
+    1237199n 1.8
+    1237200n 0
+    1237249n 0
+    1237250n 1.8
+    1237299n 1.8
+    1237300n 0
+    1237349n 0
+    1237350n 1.8
+    1237399n 1.8
+    1237400n 0
+    1237449n 0
+    1237450n 1.8
+    1237499n 1.8
+    1237500n 0
+    1237549n 0
+    1237550n 1.8
+    1237599n 1.8
+    1237600n 0
+    1237649n 0
+    1237650n 1.8
+    1237699n 1.8
+    1237700n 0
+    1237749n 0
+    1237750n 1.8
+    1237799n 1.8
+    1237800n 0
+    1237849n 0
+    1237850n 1.8
+    1237899n 1.8
+    1237900n 0
+    1237949n 0
+    1237950n 1.8
+    1237999n 1.8
+    1238000n 0
+    1238049n 0
+    1238050n 1.8
+    1238099n 1.8
+    1238100n 0
+    1238149n 0
+    1238150n 1.8
+    1238199n 1.8
+    1238200n 0
+    1238249n 0
+    1238250n 1.8
+    1238299n 1.8
+    1238300n 0
+    1238349n 0
+    1238350n 1.8
+    1238399n 1.8
+    1238400n 0
+    1238449n 0
+    1238450n 1.8
+    1238499n 1.8
+    1238500n 0
+    1238549n 0
+    1238550n 1.8
+    1238599n 1.8
+    1238600n 0
+    1238649n 0
+    1238650n 1.8
+    1238699n 1.8
+    1238700n 0
+    1238749n 0
+    1238750n 1.8
+    1238799n 1.8
+    1238800n 0
+    1238849n 0
+    1238850n 1.8
+    1238899n 1.8
+    1238900n 0
+    1238949n 0
+    1238950n 1.8
+    1238999n 1.8
+    1239000n 0
+    1239049n 0
+    1239050n 1.8
+    1239099n 1.8
+    1239100n 0
+    1239149n 0
+    1239150n 1.8
+    1239199n 1.8
+    1239200n 0
+    1239249n 0
+    1239250n 1.8
+    1239299n 1.8
+    1239300n 0
+    1239349n 0
+    1239350n 1.8
+    1239399n 1.8
+    1239400n 0
+    1239449n 0
+    1239450n 1.8
+    1239499n 1.8
+    1239500n 0
+    1239549n 0
+    1239550n 1.8
+    1239599n 1.8
+    1239600n 0
+    1239649n 0
+    1239650n 1.8
+    1239699n 1.8
+    1239700n 0
+    1239749n 0
+    1239750n 1.8
+    1239799n 1.8
+    1239800n 0
+    1239849n 0
+    1239850n 1.8
+    1239899n 1.8
+    1239900n 0
+    1239949n 0
+    1239950n 1.8
+    1239999n 1.8
+    1240000n 0
+    1240049n 0
+    1240050n 1.8
+    1240099n 1.8
+    1240100n 0
+    1240149n 0
+    1240150n 1.8
+    1240199n 1.8
+    1240200n 0
+    1240249n 0
+    1240250n 1.8
+    1240299n 1.8
+    1240300n 0
+    1240349n 0
+    1240350n 1.8
+    1240399n 1.8
+    1240400n 0
+    1240449n 0
+    1240450n 1.8
+    1240499n 1.8
+    1240500n 0
+    1240549n 0
+    1240550n 1.8
+    1240599n 1.8
+    1240600n 0
+    1240649n 0
+    1240650n 1.8
+    1240699n 1.8
+    1240700n 0
+    1240749n 0
+    1240750n 1.8
+    1240799n 1.8
+    1240800n 0
+    1240849n 0
+    1240850n 1.8
+    1240899n 1.8
+    1240900n 0
+    1240949n 0
+    1240950n 1.8
+    1240999n 1.8
+    1241000n 0
+    1241049n 0
+    1241050n 1.8
+    1241099n 1.8
+    1241100n 0
+    1241149n 0
+    1241150n 1.8
+    1241199n 1.8
+    1241200n 0
+    1241249n 0
+    1241250n 1.8
+    1241299n 1.8
+    1241300n 0
+    1241349n 0
+    1241350n 1.8
+    1241399n 1.8
+    1241400n 0
+    1241449n 0
+    1241450n 1.8
+    1241499n 1.8
+    1241500n 0
+    1241549n 0
+    1241550n 1.8
+    1241599n 1.8
+    1241600n 0
+    1241649n 0
+    1241650n 1.8
+    1241699n 1.8
+    1241700n 0
+    1241749n 0
+    1241750n 1.8
+    1241799n 1.8
+    1241800n 0
+    1241849n 0
+    1241850n 1.8
+    1241899n 1.8
+    1241900n 0
+    1241949n 0
+    1241950n 1.8
+    1241999n 1.8
+    1242000n 0
+    1242049n 0
+    1242050n 1.8
+    1242099n 1.8
+    1242100n 0
+    1242149n 0
+    1242150n 1.8
+    1242199n 1.8
+    1242200n 0
+    1242249n 0
+    1242250n 1.8
+    1242299n 1.8
+    1242300n 0
+    1242349n 0
+    1242350n 1.8
+    1242399n 1.8
+    1242400n 0
+    1242449n 0
+    1242450n 1.8
+    1242499n 1.8
+    1242500n 0
+    1242549n 0
+    1242550n 1.8
+    1242599n 1.8
+    1242600n 0
+    1242649n 0
+    1242650n 1.8
+    1242699n 1.8
+    1242700n 0
+    1242749n 0
+    1242750n 1.8
+    1242799n 1.8
+    1242800n 0
+    1242849n 0
+    1242850n 1.8
+    1242899n 1.8
+    1242900n 0
+    1242949n 0
+    1242950n 1.8
+    1242999n 1.8
+    1243000n 0
+    1243049n 0
+    1243050n 1.8
+    1243099n 1.8
+    1243100n 0
+    1243149n 0
+    1243150n 1.8
+    1243199n 1.8
+    1243200n 0
+    1243249n 0
+    1243250n 1.8
+    1243299n 1.8
+    1243300n 0
+    1243349n 0
+    1243350n 1.8
+    1243399n 1.8
+    1243400n 0
+    1243449n 0
+    1243450n 1.8
+    1243499n 1.8
+    1243500n 0
+    1243549n 0
+    1243550n 1.8
+    1243599n 1.8
+    1243600n 0
+    1243649n 0
+    1243650n 1.8
+    1243699n 1.8
+    1243700n 0
+    1243749n 0
+    1243750n 1.8
+    1243799n 1.8
+    1243800n 0
+    1243849n 0
+    1243850n 1.8
+    1243899n 1.8
+    1243900n 0
+    1243949n 0
+    1243950n 1.8
+    1243999n 1.8
+    1244000n 0
+    1244049n 0
+    1244050n 1.8
+    1244099n 1.8
+    1244100n 0
+    1244149n 0
+    1244150n 1.8
+    1244199n 1.8
+    1244200n 0
+    1244249n 0
+    1244250n 1.8
+    1244299n 1.8
+    1244300n 0
+    1244349n 0
+    1244350n 1.8
+    1244399n 1.8
+    1244400n 0
+    1244449n 0
+    1244450n 1.8
+    1244499n 1.8
+    1244500n 0
+    1244549n 0
+    1244550n 1.8
+    1244599n 1.8
+    1244600n 0
+    1244649n 0
+    1244650n 1.8
+    1244699n 1.8
+    1244700n 0
+    1244749n 0
+    1244750n 1.8
+    1244799n 1.8
+    1244800n 0
+    1244849n 0
+    1244850n 1.8
+    1244899n 1.8
+    1244900n 0
+    1244949n 0
+    1244950n 1.8
+    1244999n 1.8
+    1245000n 0
+    1245049n 0
+    1245050n 1.8
+    1245099n 1.8
+    1245100n 0
+    1245149n 0
+    1245150n 1.8
+    1245199n 1.8
+    1245200n 0
+    1245249n 0
+    1245250n 1.8
+    1245299n 1.8
+    1245300n 0
+    1245349n 0
+    1245350n 1.8
+    1245399n 1.8
+    1245400n 0
+    1245449n 0
+    1245450n 1.8
+    1245499n 1.8
+    1245500n 0
+    1245549n 0
+    1245550n 1.8
+    1245599n 1.8
+    1245600n 0
+    1245649n 0
+    1245650n 1.8
+    1245699n 1.8
+    1245700n 0
+    1245749n 0
+    1245750n 1.8
+    1245799n 1.8
+    1245800n 0
+    1245849n 0
+    1245850n 1.8
+    1245899n 1.8
+    1245900n 0
+    1245949n 0
+    1245950n 1.8
+    1245999n 1.8
+    1246000n 0
+    1246049n 0
+    1246050n 1.8
+    1246099n 1.8
+    1246100n 0
+    1246149n 0
+    1246150n 1.8
+    1246199n 1.8
+    1246200n 0
+    1246249n 0
+    1246250n 1.8
+    1246299n 1.8
+    1246300n 0
+    1246349n 0
+    1246350n 1.8
+    1246399n 1.8
+    1246400n 0
+    1246449n 0
+    1246450n 1.8
+    1246499n 1.8
+    1246500n 0
+    1246549n 0
+    1246550n 1.8
+    1246599n 1.8
+    1246600n 0
+    1246649n 0
+    1246650n 1.8
+    1246699n 1.8
+    1246700n 0
+    1246749n 0
+    1246750n 1.8
+    1246799n 1.8
+    1246800n 0
+    1246849n 0
+    1246850n 1.8
+    1246899n 1.8
+    1246900n 0
+    1246949n 0
+    1246950n 1.8
+    1246999n 1.8
+    1247000n 0
+    1247049n 0
+    1247050n 1.8
+    1247099n 1.8
+    1247100n 0
+    1247149n 0
+    1247150n 1.8
+    1247199n 1.8
+    1247200n 0
+    1247249n 0
+    1247250n 1.8
+    1247299n 1.8
+    1247300n 0
+    1247349n 0
+    1247350n 1.8
+    1247399n 1.8
+    1247400n 0
+    1247449n 0
+    1247450n 1.8
+    1247499n 1.8
+    1247500n 0
+    1247549n 0
+    1247550n 1.8
+    1247599n 1.8
+    1247600n 0
+    1247649n 0
+    1247650n 1.8
+    1247699n 1.8
+    1247700n 0
+    1247749n 0
+    1247750n 1.8
+    1247799n 1.8
+    1247800n 0
+    1247849n 0
+    1247850n 1.8
+    1247899n 1.8
+    1247900n 0
+    1247949n 0
+    1247950n 1.8
+    1247999n 1.8
+    1248000n 0
+    1248049n 0
+    1248050n 1.8
+    1248099n 1.8
+    1248100n 0
+    1248149n 0
+    1248150n 1.8
+    1248199n 1.8
+    1248200n 0
+    1248249n 0
+    1248250n 1.8
+    1248299n 1.8
+    1248300n 0
+    1248349n 0
+    1248350n 1.8
+    1248399n 1.8
+    1248400n 0
+    1248449n 0
+    1248450n 1.8
+    1248499n 1.8
+    1248500n 0
+    1248549n 0
+    1248550n 1.8
+    1248599n 1.8
+    1248600n 0
+    1248649n 0
+    1248650n 1.8
+    1248699n 1.8
+    1248700n 0
+    1248749n 0
+    1248750n 1.8
+    1248799n 1.8
+    1248800n 0
+    1248849n 0
+    1248850n 1.8
+    1248899n 1.8
+    1248900n 0
+    1248949n 0
+    1248950n 1.8
+    1248999n 1.8
+    1249000n 0
+    1249049n 0
+    1249050n 1.8
+    1249099n 1.8
+    1249100n 0
+    1249149n 0
+    1249150n 1.8
+    1249199n 1.8
+    1249200n 0
+    1249249n 0
+    1249250n 1.8
+    1249299n 1.8
+    1249300n 0
+    1249349n 0
+    1249350n 1.8
+    1249399n 1.8
+    1249400n 0
+    1249449n 0
+    1249450n 1.8
+    1249499n 1.8
+    1249500n 0
+    1249549n 0
+    1249550n 1.8
+    1249599n 1.8
+    1249600n 0
+    1249649n 0
+    1249650n 1.8
+    1249699n 1.8
+    1249700n 0
+    1249749n 0
+    1249750n 1.8
+    1249799n 1.8
+    1249800n 0
+    1249849n 0
+    1249850n 1.8
+    1249899n 1.8
+    1249900n 0
+    1249949n 0
+    1249950n 1.8
+    1249999n 1.8
+    1250000n 0
+    1250049n 0
+    1250050n 1.8
+    1250099n 1.8
+    1250100n 0
+    1250149n 0
+    1250150n 1.8
+    1250199n 1.8
+    1250200n 0
+    1250249n 0
+    1250250n 1.8
+    1250299n 1.8
+    1250300n 0
+    1250349n 0
+    1250350n 1.8
+    1250399n 1.8
+    1250400n 0
+    1250449n 0
+    1250450n 1.8
+    1250499n 1.8
+    1250500n 0
+    1250549n 0
+    1250550n 1.8
+    1250599n 1.8
+    1250600n 0
+    1250649n 0
+    1250650n 1.8
+    1250699n 1.8
+    1250700n 0
+    1250749n 0
+    1250750n 1.8
+    1250799n 1.8
+    1250800n 0
+    1250849n 0
+    1250850n 1.8
+    1250899n 1.8
+    1250900n 0
+    1250949n 0
+    1250950n 1.8
+    1250999n 1.8
+    1251000n 0
+    1251049n 0
+    1251050n 1.8
+    1251099n 1.8
+    1251100n 0
+    1251149n 0
+    1251150n 1.8
+    1251199n 1.8
+    1251200n 0
+    1251249n 0
+    1251250n 1.8
+    1251299n 1.8
+    1251300n 0
+    1251349n 0
+    1251350n 1.8
+    1251399n 1.8
+    1251400n 0
+    1251449n 0
+    1251450n 1.8
+    1251499n 1.8
+    1251500n 0
+    1251549n 0
+    1251550n 1.8
+    1251599n 1.8
+    1251600n 0
+    1251649n 0
+    1251650n 1.8
+    1251699n 1.8
+    1251700n 0
+    1251749n 0
+    1251750n 1.8
+    1251799n 1.8
+    1251800n 0
+    1251849n 0
+    1251850n 1.8
+    1251899n 1.8
+    1251900n 0
+    1251949n 0
+    1251950n 1.8
+    1251999n 1.8
+    1252000n 0
+    1252049n 0
+    1252050n 1.8
+    1252099n 1.8
+    1252100n 0
+    1252149n 0
+    1252150n 1.8
+    1252199n 1.8
+    1252200n 0
+    1252249n 0
+    1252250n 1.8
+    1252299n 1.8
+    1252300n 0
+    1252349n 0
+    1252350n 1.8
+    1252399n 1.8
+    1252400n 0
+    1252449n 0
+    1252450n 1.8
+    1252499n 1.8
+    1252500n 0
+    1252549n 0
+    1252550n 1.8
+    1252599n 1.8
+    1252600n 0
+    1252649n 0
+    1252650n 1.8
+    1252699n 1.8
+    1252700n 0
+    1252749n 0
+    1252750n 1.8
+    1252799n 1.8
+    1252800n 0
+    1252849n 0
+    1252850n 1.8
+    1252899n 1.8
+    1252900n 0
+    1252949n 0
+    1252950n 1.8
+    1252999n 1.8
+    1253000n 0
+    1253049n 0
+    1253050n 1.8
+    1253099n 1.8
+    1253100n 0
+    1253149n 0
+    1253150n 1.8
+    1253199n 1.8
+    1253200n 0
+    1253249n 0
+    1253250n 1.8
+    1253299n 1.8
+    1253300n 0
+    1253349n 0
+    1253350n 1.8
+    1253399n 1.8
+    1253400n 0
+    1253449n 0
+    1253450n 1.8
+    1253499n 1.8
+    1253500n 0
+    1253549n 0
+    1253550n 1.8
+    1253599n 1.8
+    1253600n 0
+    1253649n 0
+    1253650n 1.8
+    1253699n 1.8
+    1253700n 0
+    1253749n 0
+    1253750n 1.8
+    1253799n 1.8
+    1253800n 0
+    1253849n 0
+    1253850n 1.8
+    1253899n 1.8
+    1253900n 0
+    1253949n 0
+    1253950n 1.8
+    1253999n 1.8
+    1254000n 0
+    1254049n 0
+    1254050n 1.8
+    1254099n 1.8
+    1254100n 0
+    1254149n 0
+    1254150n 1.8
+    1254199n 1.8
+    1254200n 0
+    1254249n 0
+    1254250n 1.8
+    1254299n 1.8
+    1254300n 0
+    1254349n 0
+    1254350n 1.8
+    1254399n 1.8
+    1254400n 0
+    1254449n 0
+    1254450n 1.8
+    1254499n 1.8
+    1254500n 0
+    1254549n 0
+    1254550n 1.8
+    1254599n 1.8
+    1254600n 0
+    1254649n 0
+    1254650n 1.8
+    1254699n 1.8
+    1254700n 0
+    1254749n 0
+    1254750n 1.8
+    1254799n 1.8
+    1254800n 0
+    1254849n 0
+    1254850n 1.8
+    1254899n 1.8
+    1254900n 0
+    1254949n 0
+    1254950n 1.8
+    1254999n 1.8
+    1255000n 0
+    1255049n 0
+    1255050n 1.8
+    1255099n 1.8
+    1255100n 0
+    1255149n 0
+    1255150n 1.8
+    1255199n 1.8
+    1255200n 0
+    1255249n 0
+    1255250n 1.8
+    1255299n 1.8
+    1255300n 0
+    1255349n 0
+    1255350n 1.8
+    1255399n 1.8
+    1255400n 0
+    1255449n 0
+    1255450n 1.8
+    1255499n 1.8
+    1255500n 0
+    1255549n 0
+    1255550n 1.8
+    1255599n 1.8
+    1255600n 0
+    1255649n 0
+    1255650n 1.8
+    1255699n 1.8
+    1255700n 0
+    1255749n 0
+    1255750n 1.8
+    1255799n 1.8
+    1255800n 0
+    1255849n 0
+    1255850n 1.8
+    1255899n 1.8
+    1255900n 0
+    1255949n 0
+    1255950n 1.8
+    1255999n 1.8
+    1256000n 0
+    1256049n 0
+    1256050n 1.8
+    1256099n 1.8
+    1256100n 0
+    1256149n 0
+    1256150n 1.8
+    1256199n 1.8
+    1256200n 0
+    1256249n 0
+    1256250n 1.8
+    1256299n 1.8
+    1256300n 0
+    1256349n 0
+    1256350n 1.8
+    1256399n 1.8
+    1256400n 0
+    1256449n 0
+    1256450n 1.8
+    1256499n 1.8
+    1256500n 0
+    1256549n 0
+    1256550n 1.8
+    1256599n 1.8
+    1256600n 0
+    1256649n 0
+    1256650n 1.8
+    1256699n 1.8
+    1256700n 0
+    1256749n 0
+    1256750n 1.8
+    1256799n 1.8
+    1256800n 0
+    1256849n 0
+    1256850n 1.8
+    1256899n 1.8
+    1256900n 0
+    1256949n 0
+    1256950n 1.8
+    1256999n 1.8
+    1257000n 0
+    1257049n 0
+    1257050n 1.8
+    1257099n 1.8
+    1257100n 0
+    1257149n 0
+    1257150n 1.8
+    1257199n 1.8
+    1257200n 0
+    1257249n 0
+    1257250n 1.8
+    1257299n 1.8
+    1257300n 0
+    1257349n 0
+    1257350n 1.8
+    1257399n 1.8
+    1257400n 0
+    1257449n 0
+    1257450n 1.8
+    1257499n 1.8
+    1257500n 0
+    1257549n 0
+    1257550n 1.8
+    1257599n 1.8
+    1257600n 0
+    1257649n 0
+    1257650n 1.8
+    1257699n 1.8
+    1257700n 0
+    1257749n 0
+    1257750n 1.8
+    1257799n 1.8
+    1257800n 0
+    1257849n 0
+    1257850n 1.8
+    1257899n 1.8
+    1257900n 0
+    1257949n 0
+    1257950n 1.8
+    1257999n 1.8
+    1258000n 0
+    1258049n 0
+    1258050n 1.8
+    1258099n 1.8
+    1258100n 0
+    1258149n 0
+    1258150n 1.8
+    1258199n 1.8
+    1258200n 0
+    1258249n 0
+    1258250n 1.8
+    1258299n 1.8
+    1258300n 0
+    1258349n 0
+    1258350n 1.8
+    1258399n 1.8
+    1258400n 0
+    1258449n 0
+    1258450n 1.8
+    1258499n 1.8
+    1258500n 0
+    1258549n 0
+    1258550n 1.8
+    1258599n 1.8
+    1258600n 0
+    1258649n 0
+    1258650n 1.8
+    1258699n 1.8
+    1258700n 0
+    1258749n 0
+    1258750n 1.8
+    1258799n 1.8
+    1258800n 0
+    1258849n 0
+    1258850n 1.8
+    1258899n 1.8
+    1258900n 0
+    1258949n 0
+    1258950n 1.8
+    1258999n 1.8
+    1259000n 0
+    1259049n 0
+    1259050n 1.8
+    1259099n 1.8
+    1259100n 0
+    1259149n 0
+    1259150n 1.8
+    1259199n 1.8
+    1259200n 0
+    1259249n 0
+    1259250n 1.8
+    1259299n 1.8
+    1259300n 0
+    1259349n 0
+    1259350n 1.8
+    1259399n 1.8
+    1259400n 0
+    1259449n 0
+    1259450n 1.8
+    1259499n 1.8
+    1259500n 0
+    1259549n 0
+    1259550n 1.8
+    1259599n 1.8
+    1259600n 0
+    1259649n 0
+    1259650n 1.8
+    1259699n 1.8
+    1259700n 0
+    1259749n 0
+    1259750n 1.8
+    1259799n 1.8
+    1259800n 0
+    1259849n 0
+    1259850n 1.8
+    1259899n 1.8
+    1259900n 0
+    1259949n 0
+    1259950n 1.8
+    1259999n 1.8
+    1260000n 0
+    1260049n 0
+    1260050n 1.8
+    1260099n 1.8
+    1260100n 0
+    1260149n 0
+    1260150n 1.8
+    1260199n 1.8
+    1260200n 0
+    1260249n 0
+    1260250n 1.8
+    1260299n 1.8
+    1260300n 0
+    1260349n 0
+    1260350n 1.8
+    1260399n 1.8
+    1260400n 0
+    1260449n 0
+    1260450n 1.8
+    1260499n 1.8
+    1260500n 0
+    1260549n 0
+    1260550n 1.8
+    1260599n 1.8
+    1260600n 0
+    1260649n 0
+    1260650n 1.8
+    1260699n 1.8
+    1260700n 0
+    1260749n 0
+    1260750n 1.8
+    1260799n 1.8
+    1260800n 0
+    1260849n 0
+    1260850n 1.8
+    1260899n 1.8
+    1260900n 0
+    1260949n 0
+    1260950n 1.8
+    1260999n 1.8
+    1261000n 0
+    1261049n 0
+    1261050n 1.8
+    1261099n 1.8
+    1261100n 0
+    1261149n 0
+    1261150n 1.8
+    1261199n 1.8
+    1261200n 0
+    1261249n 0
+    1261250n 1.8
+    1261299n 1.8
+    1261300n 0
+    1261349n 0
+    1261350n 1.8
+    1261399n 1.8
+    1261400n 0
+    1261449n 0
+    1261450n 1.8
+    1261499n 1.8
+    1261500n 0
+    1261549n 0
+    1261550n 1.8
+    1261599n 1.8
+    1261600n 0
+    1261649n 0
+    1261650n 1.8
+    1261699n 1.8
+    1261700n 0
+    1261749n 0
+    1261750n 1.8
+    1261799n 1.8
+    1261800n 0
+    1261849n 0
+    1261850n 1.8
+    1261899n 1.8
+    1261900n 0
+    1261949n 0
+    1261950n 1.8
+    1261999n 1.8
+    1262000n 0
+    1262049n 0
+    1262050n 1.8
+    1262099n 1.8
+    1262100n 0
+    1262149n 0
+    1262150n 1.8
+    1262199n 1.8
+    1262200n 0
+    1262249n 0
+    1262250n 1.8
+    1262299n 1.8
+    1262300n 0
+    1262349n 0
+    1262350n 1.8
+    1262399n 1.8
+    1262400n 0
+    1262449n 0
+    1262450n 1.8
+    1262499n 1.8
+    1262500n 0
+    1262549n 0
+    1262550n 1.8
+    1262599n 1.8
+    1262600n 0
+    1262649n 0
+    1262650n 1.8
+    1262699n 1.8
+    1262700n 0
+    1262749n 0
+    1262750n 1.8
+    1262799n 1.8
+    1262800n 0
+    1262849n 0
+    1262850n 1.8
+    1262899n 1.8
+    1262900n 0
+    1262949n 0
+    1262950n 1.8
+    1262999n 1.8
+    1263000n 0
+    1263049n 0
+    1263050n 1.8
+    1263099n 1.8
+    1263100n 0
+    1263149n 0
+    1263150n 1.8
+    1263199n 1.8
+    1263200n 0
+    1263249n 0
+    1263250n 1.8
+    1263299n 1.8
+    1263300n 0
+    1263349n 0
+    1263350n 1.8
+    1263399n 1.8
+    1263400n 0
+    1263449n 0
+    1263450n 1.8
+    1263499n 1.8
+    1263500n 0
+    1263549n 0
+    1263550n 1.8
+    1263599n 1.8
+    1263600n 0
+    1263649n 0
+    1263650n 1.8
+    1263699n 1.8
+    1263700n 0
+    1263749n 0
+    1263750n 1.8
+    1263799n 1.8
+    1263800n 0
+    1263849n 0
+    1263850n 1.8
+    1263899n 1.8
+    1263900n 0
+    1263949n 0
+    1263950n 1.8
+    1263999n 1.8
+    1264000n 0
+    1264049n 0
+    1264050n 1.8
+    1264099n 1.8
+    1264100n 0
+    1264149n 0
+    1264150n 1.8
+    1264199n 1.8
+    1264200n 0
+    1264249n 0
+    1264250n 1.8
+    1264299n 1.8
+    1264300n 0
+    1264349n 0
+    1264350n 1.8
+    1264399n 1.8
+    1264400n 0
+    1264449n 0
+    1264450n 1.8
+    1264499n 1.8
+    1264500n 0
+    1264549n 0
+    1264550n 1.8
+    1264599n 1.8
+    1264600n 0
+    1264649n 0
+    1264650n 1.8
+    1264699n 1.8
+    1264700n 0
+    1264749n 0
+    1264750n 1.8
+    1264799n 1.8
+    1264800n 0
+    1264849n 0
+    1264850n 1.8
+    1264899n 1.8
+    1264900n 0
+    1264949n 0
+    1264950n 1.8
+    1264999n 1.8
+    1265000n 0
+    1265049n 0
+    1265050n 1.8
+    1265099n 1.8
+    1265100n 0
+    1265149n 0
+    1265150n 1.8
+    1265199n 1.8
+    1265200n 0
+    1265249n 0
+    1265250n 1.8
+    1265299n 1.8
+    1265300n 0
+    1265349n 0
+    1265350n 1.8
+    1265399n 1.8
+    1265400n 0
+    1265449n 0
+    1265450n 1.8
+    1265499n 1.8
+    1265500n 0
+    1265549n 0
+    1265550n 1.8
+    1265599n 1.8
+    1265600n 0
+    1265649n 0
+    1265650n 1.8
+    1265699n 1.8
+    1265700n 0
+    1265749n 0
+    1265750n 1.8
+    1265799n 1.8
+    1265800n 0
+    1265849n 0
+    1265850n 1.8
+    1265899n 1.8
+    1265900n 0
+    1265949n 0
+    1265950n 1.8
+    1265999n 1.8
+    1266000n 0
+    1266049n 0
+    1266050n 1.8
+    1266099n 1.8
+    1266100n 0
+    1266149n 0
+    1266150n 1.8
+    1266199n 1.8
+    1266200n 0
+    1266249n 0
+    1266250n 1.8
+    1266299n 1.8
+    1266300n 0
+    1266349n 0
+    1266350n 1.8
+    1266399n 1.8
+    1266400n 0
+    1266449n 0
+    1266450n 1.8
+    1266499n 1.8
+    1266500n 0
+    1266549n 0
+    1266550n 1.8
+    1266599n 1.8
+    1266600n 0
+    1266649n 0
+    1266650n 1.8
+    1266699n 1.8
+    1266700n 0
+    1266749n 0
+    1266750n 1.8
+    1266799n 1.8
+    1266800n 0
+    1266849n 0
+    1266850n 1.8
+    1266899n 1.8
+    1266900n 0
+    1266949n 0
+    1266950n 1.8
+    1266999n 1.8
+    1267000n 0
+    1267049n 0
+    1267050n 1.8
+    1267099n 1.8
+    1267100n 0
+    1267149n 0
+    1267150n 1.8
+    1267199n 1.8
+    1267200n 0
+    1267249n 0
+    1267250n 1.8
+    1267299n 1.8
+    1267300n 0
+    1267349n 0
+    1267350n 1.8
+    1267399n 1.8
+    1267400n 0
+    1267449n 0
+    1267450n 1.8
+    1267499n 1.8
+    1267500n 0
+    1267549n 0
+    1267550n 1.8
+    1267599n 1.8
+    1267600n 0
+    1267649n 0
+    1267650n 1.8
+    1267699n 1.8
+    1267700n 0
+    1267749n 0
+    1267750n 1.8
+    1267799n 1.8
+    1267800n 0
+    1267849n 0
+    1267850n 1.8
+    1267899n 1.8
+    1267900n 0
+    1267949n 0
+    1267950n 1.8
+    1267999n 1.8
+    1268000n 0
+    1268049n 0
+    1268050n 1.8
+    1268099n 1.8
+    1268100n 0
+    1268149n 0
+    1268150n 1.8
+    1268199n 1.8
+    1268200n 0
+    1268249n 0
+    1268250n 1.8
+    1268299n 1.8
+    1268300n 0
+    1268349n 0
+    1268350n 1.8
+    1268399n 1.8
+    1268400n 0
+    1268449n 0
+    1268450n 1.8
+    1268499n 1.8
+    1268500n 0
+    1268549n 0
+    1268550n 1.8
+    1268599n 1.8
+    1268600n 0
+    1268649n 0
+    1268650n 1.8
+    1268699n 1.8
+    1268700n 0
+    1268749n 0
+    1268750n 1.8
+    1268799n 1.8
+    1268800n 0
+    1268849n 0
+    1268850n 1.8
+    1268899n 1.8
+    1268900n 0
+    1268949n 0
+    1268950n 1.8
+    1268999n 1.8
+    1269000n 0
+    1269049n 0
+    1269050n 1.8
+    1269099n 1.8
+    1269100n 0
+    1269149n 0
+    1269150n 1.8
+    1269199n 1.8
+    1269200n 0
+    1269249n 0
+    1269250n 1.8
+    1269299n 1.8
+    1269300n 0
+    1269349n 0
+    1269350n 1.8
+    1269399n 1.8
+    1269400n 0
+    1269449n 0
+    1269450n 1.8
+    1269499n 1.8
+    1269500n 0
+    1269549n 0
+    1269550n 1.8
+    1269599n 1.8
+    1269600n 0
+    1269649n 0
+    1269650n 1.8
+    1269699n 1.8
+    1269700n 0
+    1269749n 0
+    1269750n 1.8
+    1269799n 1.8
+    1269800n 0
+    1269849n 0
+    1269850n 1.8
+    1269899n 1.8
+    1269900n 0
+    1269949n 0
+    1269950n 1.8
+    1269999n 1.8
+    1270000n 0
+    1270049n 0
+    1270050n 1.8
+    1270099n 1.8
+    1270100n 0
+    1270149n 0
+    1270150n 1.8
+    1270199n 1.8
+    1270200n 0
+    1270249n 0
+    1270250n 1.8
+    1270299n 1.8
+    1270300n 0
+    1270349n 0
+    1270350n 1.8
+    1270399n 1.8
+    1270400n 0
+    1270449n 0
+    1270450n 1.8
+    1270499n 1.8
+    1270500n 0
+    1270549n 0
+    1270550n 1.8
+    1270599n 1.8
+    1270600n 0
+    1270649n 0
+    1270650n 1.8
+    1270699n 1.8
+    1270700n 0
+    1270749n 0
+    1270750n 1.8
+    1270799n 1.8
+    1270800n 0
+    1270849n 0
+    1270850n 1.8
+    1270899n 1.8
+    1270900n 0
+    1270949n 0
+    1270950n 1.8
+    1270999n 1.8
+    1271000n 0
+    1271049n 0
+    1271050n 1.8
+    1271099n 1.8
+    1271100n 0
+    1271149n 0
+    1271150n 1.8
+    1271199n 1.8
+    1271200n 0
+    1271249n 0
+    1271250n 1.8
+    1271299n 1.8
+    1271300n 0
+    1271349n 0
+    1271350n 1.8
+    1271399n 1.8
+    1271400n 0
+    1271449n 0
+    1271450n 1.8
+    1271499n 1.8
+    1271500n 0
+    1271549n 0
+    1271550n 1.8
+    1271599n 1.8
+    1271600n 0
+    1271649n 0
+    1271650n 1.8
+    1271699n 1.8
+    1271700n 0
+    1271749n 0
+    1271750n 1.8
+    1271799n 1.8
+    1271800n 0
+    1271849n 0
+    1271850n 1.8
+    1271899n 1.8
+    1271900n 0
+    1271949n 0
+    1271950n 1.8
+    1271999n 1.8
+    1272000n 0
+    1272049n 0
+    1272050n 1.8
+    1272099n 1.8
+    1272100n 0
+    1272149n 0
+    1272150n 1.8
+    1272199n 1.8
+    1272200n 0
+    1272249n 0
+    1272250n 1.8
+    1272299n 1.8
+    1272300n 0
+    1272349n 0
+    1272350n 1.8
+    1272399n 1.8
+    1272400n 0
+    1272449n 0
+    1272450n 1.8
+    1272499n 1.8
+    1272500n 0
+    1272549n 0
+    1272550n 1.8
+    1272599n 1.8
+    1272600n 0
+    1272649n 0
+    1272650n 1.8
+    1272699n 1.8
+    1272700n 0
+    1272749n 0
+    1272750n 1.8
+    1272799n 1.8
+    1272800n 0
+    1272849n 0
+    1272850n 1.8
+    1272899n 1.8
+    1272900n 0
+    1272949n 0
+    1272950n 1.8
+    1272999n 1.8
+    1273000n 0
+    1273049n 0
+    1273050n 1.8
+    1273099n 1.8
+    1273100n 0
+    1273149n 0
+    1273150n 1.8
+    1273199n 1.8
+    1273200n 0
+    1273249n 0
+    1273250n 1.8
+    1273299n 1.8
+    1273300n 0
+    1273349n 0
+    1273350n 1.8
+    1273399n 1.8
+    1273400n 0
+    1273449n 0
+    1273450n 1.8
+    1273499n 1.8
+    1273500n 0
+    1273549n 0
+    1273550n 1.8
+    1273599n 1.8
+    1273600n 0
+    1273649n 0
+    1273650n 1.8
+    1273699n 1.8
+    1273700n 0
+    1273749n 0
+    1273750n 1.8
+    1273799n 1.8
+    1273800n 0
+    1273849n 0
+    1273850n 1.8
+    1273899n 1.8
+    1273900n 0
+    1273949n 0
+    1273950n 1.8
+    1273999n 1.8
+    1274000n 0
+    1274049n 0
+    1274050n 1.8
+    1274099n 1.8
+    1274100n 0
+    1274149n 0
+    1274150n 1.8
+    1274199n 1.8
+    1274200n 0
+    1274249n 0
+    1274250n 1.8
+    1274299n 1.8
+    1274300n 0
+    1274349n 0
+    1274350n 1.8
+    1274399n 1.8
+    1274400n 0
+    1274449n 0
+    1274450n 1.8
+    1274499n 1.8
+    1274500n 0
+    1274549n 0
+    1274550n 1.8
+    1274599n 1.8
+    1274600n 0
+    1274649n 0
+    1274650n 1.8
+    1274699n 1.8
+    1274700n 0
+    1274749n 0
+    1274750n 1.8
+    1274799n 1.8
+    1274800n 0
+    1274849n 0
+    1274850n 1.8
+    1274899n 1.8
+    1274900n 0
+    1274949n 0
+    1274950n 1.8
+    1274999n 1.8
+    1275000n 0
+    1275049n 0
+    1275050n 1.8
+    1275099n 1.8
+    1275100n 0
+    1275149n 0
+    1275150n 1.8
+    1275199n 1.8
+    1275200n 0
+    1275249n 0
+    1275250n 1.8
+    1275299n 1.8
+    1275300n 0
+    1275349n 0
+    1275350n 1.8
+    1275399n 1.8
+    1275400n 0
+    1275449n 0
+    1275450n 1.8
+    1275499n 1.8
+    1275500n 0
+    1275549n 0
+    1275550n 1.8
+    1275599n 1.8
+    1275600n 0
+    1275649n 0
+    1275650n 1.8
+    1275699n 1.8
+    1275700n 0
+    1275749n 0
+    1275750n 1.8
+    1275799n 1.8
+    1275800n 0
+    1275849n 0
+    1275850n 1.8
+    1275899n 1.8
+    1275900n 0
+    1275949n 0
+    1275950n 1.8
+    1275999n 1.8
+    1276000n 0
+    1276049n 0
+    1276050n 1.8
+    1276099n 1.8
+    1276100n 0
+    1276149n 0
+    1276150n 1.8
+    1276199n 1.8
+    1276200n 0
+    1276249n 0
+    1276250n 1.8
+    1276299n 1.8
+    1276300n 0
+    1276349n 0
+    1276350n 1.8
+    1276399n 1.8
+    1276400n 0
+    1276449n 0
+    1276450n 1.8
+    1276499n 1.8
+    1276500n 0
+    1276549n 0
+    1276550n 1.8
+    1276599n 1.8
+    1276600n 0
+    1276649n 0
+    1276650n 1.8
+    1276699n 1.8
+    1276700n 0
+    1276749n 0
+    1276750n 1.8
+    1276799n 1.8
+    1276800n 0
+    1276849n 0
+    1276850n 1.8
+    1276899n 1.8
+    1276900n 0
+    1276949n 0
+    1276950n 1.8
+    1276999n 1.8
+    1277000n 0
+    1277049n 0
+    1277050n 1.8
+    1277099n 1.8
+    1277100n 0
+    1277149n 0
+    1277150n 1.8
+    1277199n 1.8
+    1277200n 0
+    1277249n 0
+    1277250n 1.8
+    1277299n 1.8
+    1277300n 0
+    1277349n 0
+    1277350n 1.8
+    1277399n 1.8
+    1277400n 0
+    1277449n 0
+    1277450n 1.8
+    1277499n 1.8
+    1277500n 0
+    1277549n 0
+    1277550n 1.8
+    1277599n 1.8
+    1277600n 0
+    1277649n 0
+    1277650n 1.8
+    1277699n 1.8
+    1277700n 0
+    1277749n 0
+    1277750n 1.8
+    1277799n 1.8
+    1277800n 0
+    1277849n 0
+    1277850n 1.8
+    1277899n 1.8
+    1277900n 0
+    1277949n 0
+    1277950n 1.8
+    1277999n 1.8
+    1278000n 0
+    1278049n 0
+    1278050n 1.8
+    1278099n 1.8
+    1278100n 0
+    1278149n 0
+    1278150n 1.8
+    1278199n 1.8
+    1278200n 0
+    1278249n 0
+    1278250n 1.8
+    1278299n 1.8
+    1278300n 0
+    1278349n 0
+    1278350n 1.8
+    1278399n 1.8
+    1278400n 0
+    1278449n 0
+    1278450n 1.8
+    1278499n 1.8
+    1278500n 0
+    1278549n 0
+    1278550n 1.8
+    1278599n 1.8
+    1278600n 0
+    1278649n 0
+    1278650n 1.8
+    1278699n 1.8
+    1278700n 0
+    1278749n 0
+    1278750n 1.8
+    1278799n 1.8
+    1278800n 0
+    1278849n 0
+    1278850n 1.8
+    1278899n 1.8
+    1278900n 0
+    1278949n 0
+    1278950n 1.8
+    1278999n 1.8
+    1279000n 0
+    1279049n 0
+    1279050n 1.8
+    1279099n 1.8
+    1279100n 0
+    1279149n 0
+    1279150n 1.8
+    1279199n 1.8
+    1279200n 0
+    1279249n 0
+    1279250n 1.8
+    1279299n 1.8
+    1279300n 0
+    1279349n 0
+    1279350n 1.8
+    1279399n 1.8
+    1279400n 0
+    1279449n 0
+    1279450n 1.8
+    1279499n 1.8
+    1279500n 0
+    1279549n 0
+    1279550n 1.8
+    1279599n 1.8
+    1279600n 0
+    1279649n 0
+    1279650n 1.8
+    1279699n 1.8
+    1279700n 0
+    1279749n 0
+    1279750n 1.8
+    1279799n 1.8
+    1279800n 0
+    1279849n 0
+    1279850n 1.8
+    1279899n 1.8
+    1279900n 0
+    1279949n 0
+    1279950n 1.8
+    1279999n 1.8
+    1280000n 0
+    1280049n 0
+    1280050n 1.8
+    1280099n 1.8
+    1280100n 0
+    1280149n 0
+    1280150n 1.8
+    1280199n 1.8
+    1280200n 0
+    1280249n 0
+    1280250n 1.8
+    1280299n 1.8
+    1280300n 0
+    1280349n 0
+    1280350n 1.8
+    1280399n 1.8
+    1280400n 0
+    1280449n 0
+    1280450n 1.8
+    1280499n 1.8
+    1280500n 0
+    1280549n 0
+    1280550n 1.8
+    1280599n 1.8
+    1280600n 0
+    1280649n 0
+    1280650n 1.8
+    1280699n 1.8
+    1280700n 0
+    1280749n 0
+    1280750n 1.8
+    1280799n 1.8
+    1280800n 0
+    1280849n 0
+    1280850n 1.8
+    1280899n 1.8
+    1280900n 0
+    1280949n 0
+    1280950n 1.8
+    1280999n 1.8
+    1281000n 0
+    1281049n 0
+    1281050n 1.8
+    1281099n 1.8
+    1281100n 0
+    1281149n 0
+    1281150n 1.8
+    1281199n 1.8
+    1281200n 0
+    1281249n 0
+    1281250n 1.8
+    1281299n 1.8
+    1281300n 0
+    1281349n 0
+    1281350n 1.8
+    1281399n 1.8
+    1281400n 0
+    1281449n 0
+    1281450n 1.8
+    1281499n 1.8
+    1281500n 0
+    1281549n 0
+    1281550n 1.8
+    1281599n 1.8
+    1281600n 0
+    1281649n 0
+    1281650n 1.8
+    1281699n 1.8
+    1281700n 0
+    1281749n 0
+    1281750n 1.8
+    1281799n 1.8
+    1281800n 0
+    1281849n 0
+    1281850n 1.8
+    1281899n 1.8
+    1281900n 0
+    1281949n 0
+    1281950n 1.8
+    1281999n 1.8
+    1282000n 0
+    1282049n 0
+    1282050n 1.8
+    1282099n 1.8
+    1282100n 0
+    1282149n 0
+    1282150n 1.8
+    1282199n 1.8
+    1282200n 0
+    1282249n 0
+    1282250n 1.8
+    1282299n 1.8
+    1282300n 0
+    1282349n 0
+    1282350n 1.8
+    1282399n 1.8
+    1282400n 0
+    1282449n 0
+    1282450n 1.8
+    1282499n 1.8
+    1282500n 0
+    1282549n 0
+    1282550n 1.8
+    1282599n 1.8
+    1282600n 0
+    1282649n 0
+    1282650n 1.8
+    1282699n 1.8
+    1282700n 0
+    1282749n 0
+    1282750n 1.8
+    1282799n 1.8
+    1282800n 0
+    1282849n 0
+    1282850n 1.8
+    1282899n 1.8
+    1282900n 0
+    1282949n 0
+    1282950n 1.8
+    1282999n 1.8
+    1283000n 0
+    1283049n 0
+    1283050n 1.8
+    1283099n 1.8
+    1283100n 0
+    1283149n 0
+    1283150n 1.8
+    1283199n 1.8
+    1283200n 0
+    1283249n 0
+    1283250n 1.8
+    1283299n 1.8
+    1283300n 0
+    1283349n 0
+    1283350n 1.8
+    1283399n 1.8
+    1283400n 0
+    1283449n 0
+    1283450n 1.8
+    1283499n 1.8
+    1283500n 0
+    1283549n 0
+    1283550n 1.8
+    1283599n 1.8
+    1283600n 0
+    1283649n 0
+    1283650n 1.8
+    1283699n 1.8
+    1283700n 0
+    1283749n 0
+    1283750n 1.8
+    1283799n 1.8
+    1283800n 0
+    1283849n 0
+    1283850n 1.8
+    1283899n 1.8
+    1283900n 0
+    1283949n 0
+    1283950n 1.8
+    1283999n 1.8
+    1284000n 0
+    1284049n 0
+    1284050n 1.8
+    1284099n 1.8
+    1284100n 0
+    1284149n 0
+    1284150n 1.8
+    1284199n 1.8
+    1284200n 0
+    1284249n 0
+    1284250n 1.8
+    1284299n 1.8
+    1284300n 0
+    1284349n 0
+    1284350n 1.8
+    1284399n 1.8
+    1284400n 0
+    1284449n 0
+    1284450n 1.8
+    1284499n 1.8
+    1284500n 0
+    1284549n 0
+    1284550n 1.8
+    1284599n 1.8
+    1284600n 0
+    1284649n 0
+    1284650n 1.8
+    1284699n 1.8
+    1284700n 0
+    1284749n 0
+    1284750n 1.8
+    1284799n 1.8
+    1284800n 0
+    1284849n 0
+    1284850n 1.8
+    1284899n 1.8
+    1284900n 0
+    1284949n 0
+    1284950n 1.8
+    1284999n 1.8
+    1285000n 0
+    1285049n 0
+    1285050n 1.8
+    1285099n 1.8
+    1285100n 0
+    1285149n 0
+    1285150n 1.8
+    1285199n 1.8
+    1285200n 0
+    1285249n 0
+    1285250n 1.8
+    1285299n 1.8
+    1285300n 0
+    1285349n 0
+    1285350n 1.8
+    1285399n 1.8
+    1285400n 0
+    1285449n 0
+    1285450n 1.8
+    1285499n 1.8
+    1285500n 0
+    1285549n 0
+    1285550n 1.8
+    1285599n 1.8
+    1285600n 0
+    1285649n 0
+    1285650n 1.8
+    1285699n 1.8
+    1285700n 0
+    1285749n 0
+    1285750n 1.8
+    1285799n 1.8
+    1285800n 0
+    1285849n 0
+    1285850n 1.8
+    1285899n 1.8
+    1285900n 0
+    1285949n 0
+    1285950n 1.8
+    1285999n 1.8
+    1286000n 0
+    1286049n 0
+    1286050n 1.8
+    1286099n 1.8
+    1286100n 0
+    1286149n 0
+    1286150n 1.8
+    1286199n 1.8
+    1286200n 0
+    1286249n 0
+    1286250n 1.8
+    1286299n 1.8
+    1286300n 0
+    1286349n 0
+    1286350n 1.8
+    1286399n 1.8
+    1286400n 0
+    1286449n 0
+    1286450n 1.8
+    1286499n 1.8
+    1286500n 0
+    1286549n 0
+    1286550n 1.8
+    1286599n 1.8
+    1286600n 0
+    1286649n 0
+    1286650n 1.8
+    1286699n 1.8
+    1286700n 0
+    1286749n 0
+    1286750n 1.8
+    1286799n 1.8
+    1286800n 0
+    1286849n 0
+    1286850n 1.8
+    1286899n 1.8
+    1286900n 0
+    1286949n 0
+    1286950n 1.8
+    1286999n 1.8
+    1287000n 0
+    1287049n 0
+    1287050n 1.8
+    1287099n 1.8
+    1287100n 0
+    1287149n 0
+    1287150n 1.8
+    1287199n 1.8
+    1287200n 0
+    1287249n 0
+    1287250n 1.8
+    1287299n 1.8
+    1287300n 0
+    1287349n 0
+    1287350n 1.8
+    1287399n 1.8
+    1287400n 0
+    1287449n 0
+    1287450n 1.8
+    1287499n 1.8
+    1287500n 0
+    1287549n 0
+    1287550n 1.8
+    1287599n 1.8
+    1287600n 0
+    1287649n 0
+    1287650n 1.8
+    1287699n 1.8
+    1287700n 0
+    1287749n 0
+    1287750n 1.8
+    1287799n 1.8
+    1287800n 0
+    1287849n 0
+    1287850n 1.8
+    1287899n 1.8
+    1287900n 0
+    1287949n 0
+    1287950n 1.8
+    1287999n 1.8
+    1288000n 0
+    1288049n 0
+    1288050n 1.8
+    1288099n 1.8
+    1288100n 0
+    1288149n 0
+    1288150n 1.8
+    1288199n 1.8
+    1288200n 0
+    1288249n 0
+    1288250n 1.8
+    1288299n 1.8
+    1288300n 0
+    1288349n 0
+    1288350n 1.8
+    1288399n 1.8
+    1288400n 0
+    1288449n 0
+    1288450n 1.8
+    1288499n 1.8
+    1288500n 0
+    1288549n 0
+    1288550n 1.8
+    1288599n 1.8
+    1288600n 0
+    1288649n 0
+    1288650n 1.8
+    1288699n 1.8
+    1288700n 0
+    1288749n 0
+    1288750n 1.8
+    1288799n 1.8
+    1288800n 0
+    1288849n 0
+    1288850n 1.8
+    1288899n 1.8
+    1288900n 0
+    1288949n 0
+    1288950n 1.8
+    1288999n 1.8
+    1289000n 0
+    1289049n 0
+    1289050n 1.8
+    1289099n 1.8
+    1289100n 0
+    1289149n 0
+    1289150n 1.8
+    1289199n 1.8
+    1289200n 0
+    1289249n 0
+    1289250n 1.8
+    1289299n 1.8
+    1289300n 0
+    1289349n 0
+    1289350n 1.8
+    1289399n 1.8
+    1289400n 0
+    1289449n 0
+    1289450n 1.8
+    1289499n 1.8
+    1289500n 0
+    1289549n 0
+    1289550n 1.8
+    1289599n 1.8
+    1289600n 0
+    1289649n 0
+    1289650n 1.8
+    1289699n 1.8
+    1289700n 0
+    1289749n 0
+    1289750n 1.8
+    1289799n 1.8
+    1289800n 0
+    1289849n 0
+    1289850n 1.8
+    1289899n 1.8
+    1289900n 0
+    1289949n 0
+    1289950n 1.8
+    1289999n 1.8
+    1290000n 0
+    1290049n 0
+    1290050n 1.8
+    1290099n 1.8
+    1290100n 0
+    1290149n 0
+    1290150n 1.8
+    1290199n 1.8
+    1290200n 0
+    1290249n 0
+    1290250n 1.8
+    1290299n 1.8
+    1290300n 0
+    1290349n 0
+    1290350n 1.8
+    1290399n 1.8
+    1290400n 0
+    1290449n 0
+    1290450n 1.8
+    1290499n 1.8
+    1290500n 0
+    1290549n 0
+    1290550n 1.8
+    1290599n 1.8
+    1290600n 0
+    1290649n 0
+    1290650n 1.8
+    1290699n 1.8
+    1290700n 0
+    1290749n 0
+    1290750n 1.8
+    1290799n 1.8
+    1290800n 0
+    1290849n 0
+    1290850n 1.8
+    1290899n 1.8
+    1290900n 0
+    1290949n 0
+    1290950n 1.8
+    1290999n 1.8
+    1291000n 0
+    1291049n 0
+    1291050n 1.8
+    1291099n 1.8
+    1291100n 0
+    1291149n 0
+    1291150n 1.8
+    1291199n 1.8
+    1291200n 0
+    1291249n 0
+    1291250n 1.8
+    1291299n 1.8
+    1291300n 0
+    1291349n 0
+    1291350n 1.8
+    1291399n 1.8
+    1291400n 0
+    1291449n 0
+    1291450n 1.8
+    1291499n 1.8
+    1291500n 0
+    1291549n 0
+    1291550n 1.8
+    1291599n 1.8
+    1291600n 0
+    1291649n 0
+    1291650n 1.8
+    1291699n 1.8
+    1291700n 0
+    1291749n 0
+    1291750n 1.8
+    1291799n 1.8
+    1291800n 0
+    1291849n 0
+    1291850n 1.8
+    1291899n 1.8
+    1291900n 0
+    1291949n 0
+    1291950n 1.8
+    1291999n 1.8
+    1292000n 0
+    1292049n 0
+    1292050n 1.8
+    1292099n 1.8
+    1292100n 0
+    1292149n 0
+    1292150n 1.8
+    1292199n 1.8
+    1292200n 0
+    1292249n 0
+    1292250n 1.8
+    1292299n 1.8
+    1292300n 0
+    1292349n 0
+    1292350n 1.8
+    1292399n 1.8
+    1292400n 0
+    1292449n 0
+    1292450n 1.8
+    1292499n 1.8
+    1292500n 0
+    1292549n 0
+    1292550n 1.8
+    1292599n 1.8
+    1292600n 0
+    1292649n 0
+    1292650n 1.8
+    1292699n 1.8
+    1292700n 0
+    1292749n 0
+    1292750n 1.8
+    1292799n 1.8
+    1292800n 0
+    1292849n 0
+    1292850n 1.8
+    1292899n 1.8
+    1292900n 0
+    1292949n 0
+    1292950n 1.8
+    1292999n 1.8
+    1293000n 0
+    1293049n 0
+    1293050n 1.8
+    1293099n 1.8
+    1293100n 0
+    1293149n 0
+    1293150n 1.8
+    1293199n 1.8
+    1293200n 0
+    1293249n 0
+    1293250n 1.8
+    1293299n 1.8
+    1293300n 0
+    1293349n 0
+    1293350n 1.8
+    1293399n 1.8
+    1293400n 0
+    1293449n 0
+    1293450n 1.8
+    1293499n 1.8
+    1293500n 0
+    1293549n 0
+    1293550n 1.8
+    1293599n 1.8
+    1293600n 0
+    1293649n 0
+    1293650n 1.8
+    1293699n 1.8
+    1293700n 0
+    1293749n 0
+    1293750n 1.8
+    1293799n 1.8
+    1293800n 0
+    1293849n 0
+    1293850n 1.8
+    1293899n 1.8
+    1293900n 0
+    1293949n 0
+    1293950n 1.8
+    1293999n 1.8
+    1294000n 0
+    1294049n 0
+    1294050n 1.8
+    1294099n 1.8
+    1294100n 0
+    1294149n 0
+    1294150n 1.8
+    1294199n 1.8
+    1294200n 0
+    1294249n 0
+    1294250n 1.8
+    1294299n 1.8
+    1294300n 0
+    1294349n 0
+    1294350n 1.8
+    1294399n 1.8
+    1294400n 0
+    1294449n 0
+    1294450n 1.8
+    1294499n 1.8
+    1294500n 0
+    1294549n 0
+    1294550n 1.8
+    1294599n 1.8
+    1294600n 0
+    1294649n 0
+    1294650n 1.8
+    1294699n 1.8
+    1294700n 0
+    1294749n 0
+    1294750n 1.8
+    1294799n 1.8
+    1294800n 0
+    1294849n 0
+    1294850n 1.8
+    1294899n 1.8
+    1294900n 0
+    1294949n 0
+    1294950n 1.8
+    1294999n 1.8
+    1295000n 0
+    1295049n 0
+    1295050n 1.8
+    1295099n 1.8
+    1295100n 0
+    1295149n 0
+    1295150n 1.8
+    1295199n 1.8
+    1295200n 0
+    1295249n 0
+    1295250n 1.8
+    1295299n 1.8
+    1295300n 0
+    1295349n 0
+    1295350n 1.8
+    1295399n 1.8
+    1295400n 0
+    1295449n 0
+    1295450n 1.8
+    1295499n 1.8
+    1295500n 0
+    1295549n 0
+    1295550n 1.8
+    1295599n 1.8
+    1295600n 0
+    1295649n 0
+    1295650n 1.8
+    1295699n 1.8
+    1295700n 0
+    1295749n 0
+    1295750n 1.8
+    1295799n 1.8
+    1295800n 0
+    1295849n 0
+    1295850n 1.8
+    1295899n 1.8
+    1295900n 0
+    1295949n 0
+    1295950n 1.8
+    1295999n 1.8
+    1296000n 0
+    1296049n 0
+    1296050n 1.8
+    1296099n 1.8
+    1296100n 0
+    1296149n 0
+    1296150n 1.8
+    1296199n 1.8
+    1296200n 0
+    1296249n 0
+    1296250n 1.8
+    1296299n 1.8
+    1296300n 0
+    1296349n 0
+    1296350n 1.8
+    1296399n 1.8
+    1296400n 0
+    1296449n 0
+    1296450n 1.8
+    1296499n 1.8
+    1296500n 0
+    1296549n 0
+    1296550n 1.8
+    1296599n 1.8
+    1296600n 0
+    1296649n 0
+    1296650n 1.8
+    1296699n 1.8
+    1296700n 0
+    1296749n 0
+    1296750n 1.8
+    1296799n 1.8
+    1296800n 0
+    1296849n 0
+    1296850n 1.8
+    1296899n 1.8
+    1296900n 0
+    1296949n 0
+    1296950n 1.8
+    1296999n 1.8
+    1297000n 0
+    1297049n 0
+    1297050n 1.8
+    1297099n 1.8
+    1297100n 0
+    1297149n 0
+    1297150n 1.8
+    1297199n 1.8
+    1297200n 0
+    1297249n 0
+    1297250n 1.8
+    1297299n 1.8
+    1297300n 0
+    1297349n 0
+    1297350n 1.8
+    1297399n 1.8
+    1297400n 0
+    1297449n 0
+    1297450n 1.8
+    1297499n 1.8
+    1297500n 0
+    1297549n 0
+    1297550n 1.8
+    1297599n 1.8
+    1297600n 0
+    1297649n 0
+    1297650n 1.8
+    1297699n 1.8
+    1297700n 0
+    1297749n 0
+    1297750n 1.8
+    1297799n 1.8
+    1297800n 0
+    1297849n 0
+    1297850n 1.8
+    1297899n 1.8
+    1297900n 0
+    1297949n 0
+    1297950n 1.8
+    1297999n 1.8
+    1298000n 0
+    1298049n 0
+    1298050n 1.8
+    1298099n 1.8
+    1298100n 0
+    1298149n 0
+    1298150n 1.8
+    1298199n 1.8
+    1298200n 0
+    1298249n 0
+    1298250n 1.8
+    1298299n 1.8
+    1298300n 0
+    1298349n 0
+    1298350n 1.8
+    1298399n 1.8
+    1298400n 0
+    1298449n 0
+    1298450n 1.8
+    1298499n 1.8
+    1298500n 0
+    1298549n 0
+    1298550n 1.8
+    1298599n 1.8
+    1298600n 0
+    1298649n 0
+    1298650n 1.8
+    1298699n 1.8
+    1298700n 0
+    1298749n 0
+    1298750n 1.8
+    1298799n 1.8
+    1298800n 0
+    1298849n 0
+    1298850n 1.8
+    1298899n 1.8
+    1298900n 0
+    1298949n 0
+    1298950n 1.8
+    1298999n 1.8
+    1299000n 0
+    1299049n 0
+    1299050n 1.8
+    1299099n 1.8
+    1299100n 0
+    1299149n 0
+    1299150n 1.8
+    1299199n 1.8
+    1299200n 0
+    1299249n 0
+    1299250n 1.8
+    1299299n 1.8
+    1299300n 0
+    1299349n 0
+    1299350n 1.8
+    1299399n 1.8
+    1299400n 0
+    1299449n 0
+    1299450n 1.8
+    1299499n 1.8
+    1299500n 0
+    1299549n 0
+    1299550n 1.8
+    1299599n 1.8
+    1299600n 0
+    1299649n 0
+    1299650n 1.8
+    1299699n 1.8
+    1299700n 0
+    1299749n 0
+    1299750n 1.8
+    1299799n 1.8
+    1299800n 0
+    1299849n 0
+    1299850n 1.8
+    1299899n 1.8
+    1299900n 0
+    1299949n 0
+    1299950n 1.8
+    1299999n 1.8
+    1300000n 0
+    1300049n 0
+    1300050n 1.8
+    1300099n 1.8
+    1300100n 0
+    1300149n 0
+    1300150n 1.8
+    1300199n 1.8
+    1300200n 0
+    1300249n 0
+    1300250n 1.8
+    1300299n 1.8
+    1300300n 0
+    1300349n 0
+    1300350n 1.8
+    1300399n 1.8
+    1300400n 0
+    1300449n 0
+    1300450n 1.8
+    1300499n 1.8
+    1300500n 0
+    1300549n 0
+    1300550n 1.8
+    1300599n 1.8
+    1300600n 0
+    1300649n 0
+    1300650n 1.8
+    1300699n 1.8
+    1300700n 0
+    1300749n 0
+    1300750n 1.8
+    1300799n 1.8
+    1300800n 0
+    1300849n 0
+    1300850n 1.8
+    1300899n 1.8
+    1300900n 0
+    1300949n 0
+    1300950n 1.8
+    1300999n 1.8
+    1301000n 0
+    1301049n 0
+    1301050n 1.8
+    1301099n 1.8
+    1301100n 0
+    1301149n 0
+    1301150n 1.8
+    1301199n 1.8
+    1301200n 0
+    1301249n 0
+    1301250n 1.8
+    1301299n 1.8
+    1301300n 0
+    1301349n 0
+    1301350n 1.8
+    1301399n 1.8
+    1301400n 0
+    1301449n 0
+    1301450n 1.8
+    1301499n 1.8
+    1301500n 0
+    1301549n 0
+    1301550n 1.8
+    1301599n 1.8
+    1301600n 0
+    1301649n 0
+    1301650n 1.8
+    1301699n 1.8
+    1301700n 0
+    1301749n 0
+    1301750n 1.8
+    1301799n 1.8
+    1301800n 0
+    1301849n 0
+    1301850n 1.8
+    1301899n 1.8
+    1301900n 0
+    1301949n 0
+    1301950n 1.8
+    1301999n 1.8
+    1302000n 0
+    1302049n 0
+    1302050n 1.8
+    1302099n 1.8
+    1302100n 0
+    1302149n 0
+    1302150n 1.8
+    1302199n 1.8
+    1302200n 0
+    1302249n 0
+    1302250n 1.8
+    1302299n 1.8
+    1302300n 0
+    1302349n 0
+    1302350n 1.8
+    1302399n 1.8
+    1302400n 0
+    1302449n 0
+    1302450n 1.8
+    1302499n 1.8
+    1302500n 0
+    1302549n 0
+    1302550n 1.8
+    1302599n 1.8
+    1302600n 0
+    1302649n 0
+    1302650n 1.8
+    1302699n 1.8
+    1302700n 0
+    1302749n 0
+    1302750n 1.8
+    1302799n 1.8
+    1302800n 0
+    1302849n 0
+    1302850n 1.8
+    1302899n 1.8
+    1302900n 0
+    1302949n 0
+    1302950n 1.8
+    1302999n 1.8
+    1303000n 0
+    1303049n 0
+    1303050n 1.8
+    1303099n 1.8
+    1303100n 0
+    1303149n 0
+    1303150n 1.8
+    1303199n 1.8
+    1303200n 0
+    1303249n 0
+    1303250n 1.8
+    1303299n 1.8
+    1303300n 0
+    1303349n 0
+    1303350n 1.8
+    1303399n 1.8
+    1303400n 0
+    1303449n 0
+    1303450n 1.8
+    1303499n 1.8
+    1303500n 0
+    1303549n 0
+    1303550n 1.8
+    1303599n 1.8
+    1303600n 0
+    1303649n 0
+    1303650n 1.8
+    1303699n 1.8
+    1303700n 0
+    1303749n 0
+    1303750n 1.8
+    1303799n 1.8
+    1303800n 0
+    1303849n 0
+    1303850n 1.8
+    1303899n 1.8
+    1303900n 0
+    1303949n 0
+    1303950n 1.8
+    1303999n 1.8
+    1304000n 0
+    1304049n 0
+    1304050n 1.8
+    1304099n 1.8
+    1304100n 0
+    1304149n 0
+    1304150n 1.8
+    1304199n 1.8
+    1304200n 0
+    1304249n 0
+    1304250n 1.8
+    1304299n 1.8
+    1304300n 0
+    1304349n 0
+    1304350n 1.8
+    1304399n 1.8
+    1304400n 0
+    1304449n 0
+    1304450n 1.8
+    1304499n 1.8
+    1304500n 0
+    1304549n 0
+    1304550n 1.8
+    1304599n 1.8
+    1304600n 0
+    1304649n 0
+    1304650n 1.8
+    1304699n 1.8
+    1304700n 0
+    1304749n 0
+    1304750n 1.8
+    1304799n 1.8
+    1304800n 0
+    1304849n 0
+    1304850n 1.8
+    1304899n 1.8
+    1304900n 0
+    1304949n 0
+    1304950n 1.8
+    1304999n 1.8
+    1305000n 0
+    1305049n 0
+    1305050n 1.8
+    1305099n 1.8
+    1305100n 0
+    1305149n 0
+    1305150n 1.8
+    1305199n 1.8
+    1305200n 0
+    1305249n 0
+    1305250n 1.8
+    1305299n 1.8
+    1305300n 0
+    1305349n 0
+    1305350n 1.8
+    1305399n 1.8
+    1305400n 0
+    1305449n 0
+    1305450n 1.8
+    1305499n 1.8
+    1305500n 0
+    1305549n 0
+    1305550n 1.8
+    1305599n 1.8
+    1305600n 0
+    1305649n 0
+    1305650n 1.8
+    1305699n 1.8
+    1305700n 0
+    1305749n 0
+    1305750n 1.8
+    1305799n 1.8
+    1305800n 0
+    1305849n 0
+    1305850n 1.8
+    1305899n 1.8
+    1305900n 0
+    1305949n 0
+    1305950n 1.8
+    1305999n 1.8
+    1306000n 0
+    1306049n 0
+    1306050n 1.8
+    1306099n 1.8
+    1306100n 0
+    1306149n 0
+    1306150n 1.8
+    1306199n 1.8
+    1306200n 0
+    1306249n 0
+    1306250n 1.8
+    1306299n 1.8
+    1306300n 0
+    1306349n 0
+    1306350n 1.8
+    1306399n 1.8
+    1306400n 0
+    1306449n 0
+    1306450n 1.8
+    1306499n 1.8
+    1306500n 0
+    1306549n 0
+    1306550n 1.8
+    1306599n 1.8
+    1306600n 0
+    1306649n 0
+    1306650n 1.8
+    1306699n 1.8
+    1306700n 0
+    1306749n 0
+    1306750n 1.8
+    1306799n 1.8
+    1306800n 0
+    1306849n 0
+    1306850n 1.8
+    1306899n 1.8
+    1306900n 0
+    1306949n 0
+    1306950n 1.8
+    1306999n 1.8
+    1307000n 0
+    1307049n 0
+    1307050n 1.8
+    1307099n 1.8
+    1307100n 0
+    1307149n 0
+    1307150n 1.8
+    1307199n 1.8
+    1307200n 0
+    1307249n 0
+    1307250n 1.8
+    1307299n 1.8
+    1307300n 0
+    1307349n 0
+    1307350n 1.8
+    1307399n 1.8
+    1307400n 0
+    1307449n 0
+    1307450n 1.8
+    1307499n 1.8
+    1307500n 0
+    1307549n 0
+    1307550n 1.8
+    1307599n 1.8
+    1307600n 0
+    1307649n 0
+    1307650n 1.8
+    1307699n 1.8
+    1307700n 0
+    1307749n 0
+    1307750n 1.8
+    1307799n 1.8
+    1307800n 0
+    1307849n 0
+    1307850n 1.8
+    1307899n 1.8
+    1307900n 0
+    1307949n 0
+    1307950n 1.8
+    1307999n 1.8
+    1308000n 0
+    1308049n 0
+    1308050n 1.8
+    1308099n 1.8
+    1308100n 0
+    1308149n 0
+    1308150n 1.8
+    1308199n 1.8
+    1308200n 0
+    1308249n 0
+    1308250n 1.8
+    1308299n 1.8
+    1308300n 0
+    1308349n 0
+    1308350n 1.8
+    1308399n 1.8
+    1308400n 0
+    1308449n 0
+    1308450n 1.8
+    1308499n 1.8
+    1308500n 0
+    1308549n 0
+    1308550n 1.8
+    1308599n 1.8
+    1308600n 0
+    1308649n 0
+    1308650n 1.8
+    1308699n 1.8
+    1308700n 0
+    1308749n 0
+    1308750n 1.8
+    1308799n 1.8
+    1308800n 0
+    1308849n 0
+    1308850n 1.8
+    1308899n 1.8
+    1308900n 0
+    1308949n 0
+    1308950n 1.8
+    1308999n 1.8
+    1309000n 0
+    1309049n 0
+    1309050n 1.8
+    1309099n 1.8
+    1309100n 0
+    1309149n 0
+    1309150n 1.8
+    1309199n 1.8
+    1309200n 0
+    1309249n 0
+    1309250n 1.8
+    1309299n 1.8
+    1309300n 0
+    1309349n 0
+    1309350n 1.8
+    1309399n 1.8
+    1309400n 0
+    1309449n 0
+    1309450n 1.8
+    1309499n 1.8
+    1309500n 0
+    1309549n 0
+    1309550n 1.8
+    1309599n 1.8
+    1309600n 0
+    1309649n 0
+    1309650n 1.8
+    1309699n 1.8
+    1309700n 0
+    1309749n 0
+    1309750n 1.8
+    1309799n 1.8
+    1309800n 0
+    1309849n 0
+    1309850n 1.8
+    1309899n 1.8
+    1309900n 0
+    1309949n 0
+    1309950n 1.8
+    1309999n 1.8
+    1310000n 0
+    1310049n 0
+    1310050n 1.8
+    1310099n 1.8
+    1310100n 0
+    1310149n 0
+    1310150n 1.8
+    1310199n 1.8
+    1310200n 0
+    1310249n 0
+    1310250n 1.8
+    1310299n 1.8
+    1310300n 0
+    1310349n 0
+    1310350n 1.8
+    1310399n 1.8
+    1310400n 0
+    1310449n 0
+    1310450n 1.8
+    1310499n 1.8
+    1310500n 0
+    1310549n 0
+    1310550n 1.8
+    1310599n 1.8
+    1310600n 0
+    1310649n 0
+    1310650n 1.8
+    1310699n 1.8
+    1310700n 0
+    1310749n 0
+    1310750n 1.8
+    1310799n 1.8
+    1310800n 0
+    1310849n 0
+    1310850n 1.8
+    1310899n 1.8
+    1310900n 0
+    1310949n 0
+    1310950n 1.8
+    1310999n 1.8
+    1311000n 0
+    1311049n 0
+    1311050n 1.8
+    1311099n 1.8
+    1311100n 0
+    1311149n 0
+    1311150n 1.8
+    1311199n 1.8
+    1311200n 0
+    1311249n 0
+    1311250n 1.8
+    1311299n 1.8
+    1311300n 0
+    1311349n 0
+    1311350n 1.8
+    1311399n 1.8
+    1311400n 0
+    1311449n 0
+    1311450n 1.8
+    1311499n 1.8
+    1311500n 0
+    1311549n 0
+    1311550n 1.8
+    1311599n 1.8
+    1311600n 0
+    1311649n 0
+    1311650n 1.8
+    1311699n 1.8
+    1311700n 0
+    1311749n 0
+    1311750n 1.8
+    1311799n 1.8
+    1311800n 0
+    1311849n 0
+    1311850n 1.8
+    1311899n 1.8
+    1311900n 0
+    1311949n 0
+    1311950n 1.8
+    1311999n 1.8
+    1312000n 0
+    1312049n 0
+    1312050n 1.8
+    1312099n 1.8
+    1312100n 0
+    1312149n 0
+    1312150n 1.8
+    1312199n 1.8
+    1312200n 0
+    1312249n 0
+    1312250n 1.8
+    1312299n 1.8
+    1312300n 0
+    1312349n 0
+    1312350n 1.8
+    1312399n 1.8
+    1312400n 0
+    1312449n 0
+    1312450n 1.8
+    1312499n 1.8
+    1312500n 0
+    1312549n 0
+    1312550n 1.8
+    1312599n 1.8
+    1312600n 0
+    1312649n 0
+    1312650n 1.8
+    1312699n 1.8
+    1312700n 0
+    1312749n 0
+    1312750n 1.8
+    1312799n 1.8
+    1312800n 0
+    1312849n 0
+    1312850n 1.8
+    1312899n 1.8
+    1312900n 0
+    1312949n 0
+    1312950n 1.8
+    1312999n 1.8
+    1313000n 0
+    1313049n 0
+    1313050n 1.8
+    1313099n 1.8
+    1313100n 0
+    1313149n 0
+    1313150n 1.8
+    1313199n 1.8
+    1313200n 0
+    1313249n 0
+    1313250n 1.8
+    1313299n 1.8
+    1313300n 0
+    1313349n 0
+    1313350n 1.8
+    1313399n 1.8
+    1313400n 0
+    1313449n 0
+    1313450n 1.8
+    1313499n 1.8
+    1313500n 0
+    1313549n 0
+    1313550n 1.8
+    1313599n 1.8
+    1313600n 0
+    1313649n 0
+    1313650n 1.8
+    1313699n 1.8
+    1313700n 0
+    1313749n 0
+    1313750n 1.8
+    1313799n 1.8
+    1313800n 0
+    1313849n 0
+    1313850n 1.8
+    1313899n 1.8
+    1313900n 0
+    1313949n 0
+    1313950n 1.8
+    1313999n 1.8
+    1314000n 0
+    1314049n 0
+    1314050n 1.8
+    1314099n 1.8
+    1314100n 0
+    1314149n 0
+    1314150n 1.8
+    1314199n 1.8
+    1314200n 0
+    1314249n 0
+    1314250n 1.8
+    1314299n 1.8
+    1314300n 0
+    1314349n 0
+    1314350n 1.8
+    1314399n 1.8
+    1314400n 0
+    1314449n 0
+    1314450n 1.8
+    1314499n 1.8
+    1314500n 0
+    1314549n 0
+    1314550n 1.8
+    1314599n 1.8
+    1314600n 0
+    1314649n 0
+    1314650n 1.8
+    1314699n 1.8
+    1314700n 0
+    1314749n 0
+    1314750n 1.8
+    1314799n 1.8
+    1314800n 0
+    1314849n 0
+    1314850n 1.8
+    1314899n 1.8
+    1314900n 0
+    1314949n 0
+    1314950n 1.8
+    1314999n 1.8
+    1315000n 0
+    1315049n 0
+    1315050n 1.8
+    1315099n 1.8
+    1315100n 0
+    1315149n 0
+    1315150n 1.8
+    1315199n 1.8
+    1315200n 0
+    1315249n 0
+    1315250n 1.8
+    1315299n 1.8
+    1315300n 0
+    1315349n 0
+    1315350n 1.8
+    1315399n 1.8
+    1315400n 0
+    1315449n 0
+    1315450n 1.8
+    1315499n 1.8
+    1315500n 0
+    1315549n 0
+    1315550n 1.8
+    1315599n 1.8
+    1315600n 0
+    1315649n 0
+    1315650n 1.8
+    1315699n 1.8
+    1315700n 0
+    1315749n 0
+    1315750n 1.8
+    1315799n 1.8
+    1315800n 0
+    1315849n 0
+    1315850n 1.8
+    1315899n 1.8
+    1315900n 0
+    1315949n 0
+    1315950n 1.8
+    1315999n 1.8
+    1316000n 0
+    1316049n 0
+    1316050n 1.8
+    1316099n 1.8
+    1316100n 0
+    1316149n 0
+    1316150n 1.8
+    1316199n 1.8
+    1316200n 0
+    1316249n 0
+    1316250n 1.8
+    1316299n 1.8
+    1316300n 0
+    1316349n 0
+    1316350n 1.8
+    1316399n 1.8
+    1316400n 0
+    1316449n 0
+    1316450n 1.8
+    1316499n 1.8
+    1316500n 0
+    1316549n 0
+    1316550n 1.8
+    1316599n 1.8
+    1316600n 0
+    1316649n 0
+    1316650n 1.8
+    1316699n 1.8
+    1316700n 0
+    1316749n 0
+    1316750n 1.8
+    1316799n 1.8
+    1316800n 0
+    1316849n 0
+    1316850n 1.8
+    1316899n 1.8
+    1316900n 0
+    1316949n 0
+    1316950n 1.8
+    1316999n 1.8
+    1317000n 0
+    1317049n 0
+    1317050n 1.8
+    1317099n 1.8
+    1317100n 0
+    1317149n 0
+    1317150n 1.8
+    1317199n 1.8
+    1317200n 0
+    1317249n 0
+    1317250n 1.8
+    1317299n 1.8
+    1317300n 0
+    1317349n 0
+    1317350n 1.8
+    1317399n 1.8
+    1317400n 0
+    1317449n 0
+    1317450n 1.8
+    1317499n 1.8
+    1317500n 0
+    1317549n 0
+    1317550n 1.8
+    1317599n 1.8
+    1317600n 0
+    1317649n 0
+    1317650n 1.8
+    1317699n 1.8
+    1317700n 0
+    1317749n 0
+    1317750n 1.8
+    1317799n 1.8
+    1317800n 0
+    1317849n 0
+    1317850n 1.8
+    1317899n 1.8
+    1317900n 0
+    1317949n 0
+    1317950n 1.8
+    1317999n 1.8
+    1318000n 0
+    1318049n 0
+    1318050n 1.8
+    1318099n 1.8
+    1318100n 0
+    1318149n 0
+    1318150n 1.8
+    1318199n 1.8
+    1318200n 0
+    1318249n 0
+    1318250n 1.8
+    1318299n 1.8
+    1318300n 0
+    1318349n 0
+    1318350n 1.8
+    1318399n 1.8
+    1318400n 0
+    1318449n 0
+    1318450n 1.8
+    1318499n 1.8
+    1318500n 0
+    1318549n 0
+    1318550n 1.8
+    1318599n 1.8
+    1318600n 0
+    1318649n 0
+    1318650n 1.8
+    1318699n 1.8
+    1318700n 0
+    1318749n 0
+    1318750n 1.8
+    1318799n 1.8
+    1318800n 0
+    1318849n 0
+    1318850n 1.8
+    1318899n 1.8
+    1318900n 0
+    1318949n 0
+    1318950n 1.8
+    1318999n 1.8
+    1319000n 0
+    1319049n 0
+    1319050n 1.8
+    1319099n 1.8
+    1319100n 0
+    1319149n 0
+    1319150n 1.8
+    1319199n 1.8
+    1319200n 0
+    1319249n 0
+    1319250n 1.8
+    1319299n 1.8
+    1319300n 0
+    1319349n 0
+    1319350n 1.8
+    1319399n 1.8
+    1319400n 0
+    1319449n 0
+    1319450n 1.8
+    1319499n 1.8
+    1319500n 0
+    1319549n 0
+    1319550n 1.8
+    1319599n 1.8
+    1319600n 0
+    1319649n 0
+    1319650n 1.8
+    1319699n 1.8
+    1319700n 0
+    1319749n 0
+    1319750n 1.8
+    1319799n 1.8
+    1319800n 0
+    1319849n 0
+    1319850n 1.8
+    1319899n 1.8
+    1319900n 0
+    1319949n 0
+    1319950n 1.8
+    1319999n 1.8
+    1320000n 0
+    1320049n 0
+    1320050n 1.8
+    1320099n 1.8
+    1320100n 0
+    1320149n 0
+    1320150n 1.8
+    1320199n 1.8
+    1320200n 0
+    1320249n 0
+    1320250n 1.8
+    1320299n 1.8
+    1320300n 0
+    1320349n 0
+    1320350n 1.8
+    1320399n 1.8
+    1320400n 0
+    1320449n 0
+    1320450n 1.8
+    1320499n 1.8
+    1320500n 0
+    1320549n 0
+    1320550n 1.8
+    1320599n 1.8
+    1320600n 0
+    1320649n 0
+    1320650n 1.8
+    1320699n 1.8
+    1320700n 0
+    1320749n 0
+    1320750n 1.8
+    1320799n 1.8
+    1320800n 0
+    1320849n 0
+    1320850n 1.8
+    1320899n 1.8
+    1320900n 0
+    1320949n 0
+    1320950n 1.8
+    1320999n 1.8
+    1321000n 0
+    1321049n 0
+    1321050n 1.8
+    1321099n 1.8
+    1321100n 0
+    1321149n 0
+    1321150n 1.8
+    1321199n 1.8
+    1321200n 0
+    1321249n 0
+    1321250n 1.8
+    1321299n 1.8
+    1321300n 0
+    1321349n 0
+    1321350n 1.8
+    1321399n 1.8
+    1321400n 0
+    1321449n 0
+    1321450n 1.8
+    1321499n 1.8
+    1321500n 0
+    1321549n 0
+    1321550n 1.8
+    1321599n 1.8
+    1321600n 0
+    1321649n 0
+    1321650n 1.8
+    1321699n 1.8
+    1321700n 0
+    1321749n 0
+    1321750n 1.8
+    1321799n 1.8
+    1321800n 0
+    1321849n 0
+    1321850n 1.8
+    1321899n 1.8
+    1321900n 0
+    1321949n 0
+    1321950n 1.8
+    1321999n 1.8
+    1322000n 0
+    1322049n 0
+    1322050n 1.8
+    1322099n 1.8
+    1322100n 0
+    1322149n 0
+    1322150n 1.8
+    1322199n 1.8
+    1322200n 0
+    1322249n 0
+    1322250n 1.8
+    1322299n 1.8
+    1322300n 0
+    1322349n 0
+    1322350n 1.8
+    1322399n 1.8
+    1322400n 0
+    1322449n 0
+    1322450n 1.8
+    1322499n 1.8
+    1322500n 0
+    1322549n 0
+    1322550n 1.8
+    1322599n 1.8
+    1322600n 0
+    1322649n 0
+    1322650n 1.8
+    1322699n 1.8
+    1322700n 0
+    1322749n 0
+    1322750n 1.8
+    1322799n 1.8
+    1322800n 0
+    1322849n 0
+    1322850n 1.8
+    1322899n 1.8
+    1322900n 0
+    1322949n 0
+    1322950n 1.8
+    1322999n 1.8
+    1323000n 0
+    1323049n 0
+    1323050n 1.8
+    1323099n 1.8
+    1323100n 0
+    1323149n 0
+    1323150n 1.8
+    1323199n 1.8
+    1323200n 0
+    1323249n 0
+    1323250n 1.8
+    1323299n 1.8
+    1323300n 0
+    1323349n 0
+    1323350n 1.8
+    1323399n 1.8
+    1323400n 0
+    1323449n 0
+    1323450n 1.8
+    1323499n 1.8
+    1323500n 0
+    1323549n 0
+    1323550n 1.8
+    1323599n 1.8
+    1323600n 0
+    1323649n 0
+    1323650n 1.8
+    1323699n 1.8
+    1323700n 0
+    1323749n 0
+    1323750n 1.8
+    1323799n 1.8
+    1323800n 0
+    1323849n 0
+    1323850n 1.8
+    1323899n 1.8
+    1323900n 0
+    1323949n 0
+    1323950n 1.8
+    1323999n 1.8
+    1324000n 0
+    1324049n 0
+    1324050n 1.8
+    1324099n 1.8
+    1324100n 0
+    1324149n 0
+    1324150n 1.8
+    1324199n 1.8
+    1324200n 0
+    1324249n 0
+    1324250n 1.8
+    1324299n 1.8
+    1324300n 0
+    1324349n 0
+    1324350n 1.8
+    1324399n 1.8
+    1324400n 0
+    1324449n 0
+    1324450n 1.8
+    1324499n 1.8
+    1324500n 0
+    1324549n 0
+    1324550n 1.8
+    1324599n 1.8
+    1324600n 0
+    1324649n 0
+    1324650n 1.8
+    1324699n 1.8
+    1324700n 0
+    1324749n 0
+    1324750n 1.8
+    1324799n 1.8
+    1324800n 0
+    1324849n 0
+    1324850n 1.8
+    1324899n 1.8
+    1324900n 0
+    1324949n 0
+    1324950n 1.8
+    1324999n 1.8
+    1325000n 0
+    1325049n 0
+    1325050n 1.8
+    1325099n 1.8
+    1325100n 0
+    1325149n 0
+    1325150n 1.8
+    1325199n 1.8
+    1325200n 0
+    1325249n 0
+    1325250n 1.8
+    1325299n 1.8
+    1325300n 0
+    1325349n 0
+    1325350n 1.8
+    1325399n 1.8
+    1325400n 0
+    1325449n 0
+    1325450n 1.8
+    1325499n 1.8
+    1325500n 0
+    1325549n 0
+    1325550n 1.8
+    1325599n 1.8
+    1325600n 0
+    1325649n 0
+    1325650n 1.8
+    1325699n 1.8
+    1325700n 0
+    1325749n 0
+    1325750n 1.8
+    1325799n 1.8
+    1325800n 0
+    1325849n 0
+    1325850n 1.8
+    1325899n 1.8
+    1325900n 0
+    1325949n 0
+    1325950n 1.8
+    1325999n 1.8
+    1326000n 0
+    1326049n 0
+    1326050n 1.8
+    1326099n 1.8
+    1326100n 0
+    1326149n 0
+    1326150n 1.8
+    1326199n 1.8
+    1326200n 0
+    1326249n 0
+    1326250n 1.8
+    1326299n 1.8
+    1326300n 0
+    1326349n 0
+    1326350n 1.8
+    1326399n 1.8
+    1326400n 0
+    1326449n 0
+    1326450n 1.8
+    1326499n 1.8
+    1326500n 0
+    1326549n 0
+    1326550n 1.8
+    1326599n 1.8
+    1326600n 0
+    1326649n 0
+    1326650n 1.8
+    1326699n 1.8
+    1326700n 0
+    1326749n 0
+    1326750n 1.8
+    1326799n 1.8
+    1326800n 0
+    1326849n 0
+    1326850n 1.8
+    1326899n 1.8
+    1326900n 0
+    1326949n 0
+    1326950n 1.8
+    1326999n 1.8
+    1327000n 0
+    1327049n 0
+    1327050n 1.8
+    1327099n 1.8
+    1327100n 0
+    1327149n 0
+    1327150n 1.8
+    1327199n 1.8
+    1327200n 0
+    1327249n 0
+    1327250n 1.8
+    1327299n 1.8
+    1327300n 0
+    1327349n 0
+    1327350n 1.8
+    1327399n 1.8
+    1327400n 0
+    1327449n 0
+    1327450n 1.8
+    1327499n 1.8
+    1327500n 0
+    1327549n 0
+    1327550n 1.8
+    1327599n 1.8
+    1327600n 0
+    1327649n 0
+    1327650n 1.8
+    1327699n 1.8
+    1327700n 0
+    1327749n 0
+    1327750n 1.8
+    1327799n 1.8
+    1327800n 0
+    1327849n 0
+    1327850n 1.8
+    1327899n 1.8
+    1327900n 0
+    1327949n 0
+    1327950n 1.8
+    1327999n 1.8
+    1328000n 0
+    1328049n 0
+    1328050n 1.8
+    1328099n 1.8
+    1328100n 0
+    1328149n 0
+    1328150n 1.8
+    1328199n 1.8
+    1328200n 0
+    1328249n 0
+    1328250n 1.8
+    1328299n 1.8
+    1328300n 0
+    1328349n 0
+    1328350n 1.8
+    1328399n 1.8
+    1328400n 0
+    1328449n 0
+    1328450n 1.8
+    1328499n 1.8
+    1328500n 0
+    1328549n 0
+    1328550n 1.8
+    1328599n 1.8
+    1328600n 0
+    1328649n 0
+    1328650n 1.8
+    1328699n 1.8
+    1328700n 0
+    1328749n 0
+    1328750n 1.8
+    1328799n 1.8
+    1328800n 0
+    1328849n 0
+    1328850n 1.8
+    1328899n 1.8
+    1328900n 0
+    1328949n 0
+    1328950n 1.8
+    1328999n 1.8
+    1329000n 0
+    1329049n 0
+    1329050n 1.8
+    1329099n 1.8
+    1329100n 0
+    1329149n 0
+    1329150n 1.8
+    1329199n 1.8
+    1329200n 0
+    1329249n 0
+    1329250n 1.8
+    1329299n 1.8
+    1329300n 0
+    1329349n 0
+    1329350n 1.8
+    1329399n 1.8
+    1329400n 0
+    1329449n 0
+    1329450n 1.8
+    1329499n 1.8
+    1329500n 0
+    1329549n 0
+    1329550n 1.8
+    1329599n 1.8
+    1329600n 0
+    1329649n 0
+    1329650n 1.8
+    1329699n 1.8
+    1329700n 0
+    1329749n 0
+    1329750n 1.8
+    1329799n 1.8
+    1329800n 0
+    1329849n 0
+    1329850n 1.8
+    1329899n 1.8
+    1329900n 0
+    1329949n 0
+    1329950n 1.8
+    1329999n 1.8
+    1330000n 0
+    1330049n 0
+    1330050n 1.8
+    1330099n 1.8
+    1330100n 0
+    1330149n 0
+    1330150n 1.8
+    1330199n 1.8
+    1330200n 0
+    1330249n 0
+    1330250n 1.8
+    1330299n 1.8
+    1330300n 0
+    1330349n 0
+    1330350n 1.8
+    1330399n 1.8
+    1330400n 0
+    1330449n 0
+    1330450n 1.8
+    1330499n 1.8
+    1330500n 0
+    1330549n 0
+    1330550n 1.8
+    1330599n 1.8
+    1330600n 0
+    1330649n 0
+    1330650n 1.8
+    1330699n 1.8
+    1330700n 0
+    1330749n 0
+    1330750n 1.8
+    1330799n 1.8
+    1330800n 0
+    1330849n 0
+    1330850n 1.8
+    1330899n 1.8
+    1330900n 0
+    1330949n 0
+    1330950n 1.8
+    1330999n 1.8
+    1331000n 0
+    1331049n 0
+    1331050n 1.8
+    1331099n 1.8
+    1331100n 0
+    1331149n 0
+    1331150n 1.8
+    1331199n 1.8
+    1331200n 0
+    1331249n 0
+    1331250n 1.8
+    1331299n 1.8
+    1331300n 0
+    1331349n 0
+    1331350n 1.8
+    1331399n 1.8
+    1331400n 0
+    1331449n 0
+    1331450n 1.8
+    1331499n 1.8
+    1331500n 0
+    1331549n 0
+    1331550n 1.8
+    1331599n 1.8
+    1331600n 0
+    1331649n 0
+    1331650n 1.8
+    1331699n 1.8
+    1331700n 0
+    1331749n 0
+    1331750n 1.8
+    1331799n 1.8
+    1331800n 0
+    1331849n 0
+    1331850n 1.8
+    1331899n 1.8
+    1331900n 0
+    1331949n 0
+    1331950n 1.8
+    1331999n 1.8
+    1332000n 0
+    1332049n 0
+    1332050n 1.8
+    1332099n 1.8
+    1332100n 0
+    1332149n 0
+    1332150n 1.8
+    1332199n 1.8
+    1332200n 0
+    1332249n 0
+    1332250n 1.8
+    1332299n 1.8
+    1332300n 0
+    1332349n 0
+    1332350n 1.8
+    1332399n 1.8
+    1332400n 0
+    1332449n 0
+    1332450n 1.8
+    1332499n 1.8
+    1332500n 0
+    1332549n 0
+    1332550n 1.8
+    1332599n 1.8
+    1332600n 0
+    1332649n 0
+    1332650n 1.8
+    1332699n 1.8
+    1332700n 0
+    1332749n 0
+    1332750n 1.8
+    1332799n 1.8
+    1332800n 0
+    1332849n 0
+    1332850n 1.8
+    1332899n 1.8
+    1332900n 0
+    1332949n 0
+    1332950n 1.8
+    1332999n 1.8
+    1333000n 0
+    1333049n 0
+    1333050n 1.8
+    1333099n 1.8
+    1333100n 0
+    1333149n 0
+    1333150n 1.8
+    1333199n 1.8
+    1333200n 0
+    1333249n 0
+    1333250n 1.8
+    1333299n 1.8
+    1333300n 0
+    1333349n 0
+    1333350n 1.8
+    1333399n 1.8
+    1333400n 0
+    1333449n 0
+    1333450n 1.8
+    1333499n 1.8
+    1333500n 0
+    1333549n 0
+    1333550n 1.8
+    1333599n 1.8
+    1333600n 0
+    1333649n 0
+    1333650n 1.8
+    1333699n 1.8
+    1333700n 0
+    1333749n 0
+    1333750n 1.8
+    1333799n 1.8
+    1333800n 0
+    1333849n 0
+    1333850n 1.8
+    1333899n 1.8
+    1333900n 0
+    1333949n 0
+    1333950n 1.8
+    1333999n 1.8
+    1334000n 0
+    1334049n 0
+    1334050n 1.8
+    1334099n 1.8
+    1334100n 0
+    1334149n 0
+    1334150n 1.8
+    1334199n 1.8
+    1334200n 0
+    1334249n 0
+    1334250n 1.8
+    1334299n 1.8
+    1334300n 0
+    1334349n 0
+    1334350n 1.8
+    1334399n 1.8
+    1334400n 0
+    1334449n 0
+    1334450n 1.8
+    1334499n 1.8
+    1334500n 0
+    1334549n 0
+    1334550n 1.8
+    1334599n 1.8
+    1334600n 0
+    1334649n 0
+    1334650n 1.8
+    1334699n 1.8
+    1334700n 0
+    1334749n 0
+    1334750n 1.8
+    1334799n 1.8
+    1334800n 0
+    1334849n 0
+    1334850n 1.8
+    1334899n 1.8
+    1334900n 0
+    1334949n 0
+    1334950n 1.8
+    1334999n 1.8
+    1335000n 0
+    1335049n 0
+    1335050n 1.8
+    1335099n 1.8
+    1335100n 0
+    1335149n 0
+    1335150n 1.8
+    1335199n 1.8
+    1335200n 0
+    1335249n 0
+    1335250n 1.8
+    1335299n 1.8
+    1335300n 0
+    1335349n 0
+    1335350n 1.8
+    1335399n 1.8
+    1335400n 0
+    1335449n 0
+    1335450n 1.8
+    1335499n 1.8
+    1335500n 0
+    1335549n 0
+    1335550n 1.8
+    1335599n 1.8
+    1335600n 0
+    1335649n 0
+    1335650n 1.8
+    1335699n 1.8
+    1335700n 0
+    1335749n 0
+    1335750n 1.8
+    1335799n 1.8
+    1335800n 0
+    1335849n 0
+    1335850n 1.8
+    1335899n 1.8
+    1335900n 0
+    1335949n 0
+    1335950n 1.8
+    1335999n 1.8
+    1336000n 0
+    1336049n 0
+    1336050n 1.8
+    1336099n 1.8
+    1336100n 0
+    1336149n 0
+    1336150n 1.8
+    1336199n 1.8
+    1336200n 0
+    1336249n 0
+    1336250n 1.8
+    1336299n 1.8
+    1336300n 0
+    1336349n 0
+    1336350n 1.8
+    1336399n 1.8
+    1336400n 0
+    1336449n 0
+    1336450n 1.8
+    1336499n 1.8
+    1336500n 0
+    1336549n 0
+    1336550n 1.8
+    1336599n 1.8
+    1336600n 0
+    1336649n 0
+    1336650n 1.8
+    1336699n 1.8
+    1336700n 0
+    1336749n 0
+    1336750n 1.8
+    1336799n 1.8
+    1336800n 0
+    1336849n 0
+    1336850n 1.8
+    1336899n 1.8
+    1336900n 0
+    1336949n 0
+    1336950n 1.8
+    1336999n 1.8
+    1337000n 0
+    1337049n 0
+    1337050n 1.8
+    1337099n 1.8
+    1337100n 0
+    1337149n 0
+    1337150n 1.8
+    1337199n 1.8
+    1337200n 0
+    1337249n 0
+    1337250n 1.8
+    1337299n 1.8
+    1337300n 0
+    1337349n 0
+    1337350n 1.8
+    1337399n 1.8
+    1337400n 0
+    1337449n 0
+    1337450n 1.8
+    1337499n 1.8
+    1337500n 0
+    1337549n 0
+    1337550n 1.8
+    1337599n 1.8
+    1337600n 0
+    1337649n 0
+    1337650n 1.8
+    1337699n 1.8
+    1337700n 0
+    1337749n 0
+    1337750n 1.8
+    1337799n 1.8
+    1337800n 0
+    1337849n 0
+    1337850n 1.8
+    1337899n 1.8
+    1337900n 0
+    1337949n 0
+    1337950n 1.8
+    1337999n 1.8
+    1338000n 0
+    1338049n 0
+    1338050n 1.8
+    1338099n 1.8
+    1338100n 0
+    1338149n 0
+    1338150n 1.8
+    1338199n 1.8
+    1338200n 0
+    1338249n 0
+    1338250n 1.8
+    1338299n 1.8
+    1338300n 0
+    1338349n 0
+    1338350n 1.8
+    1338399n 1.8
+    1338400n 0
+    1338449n 0
+    1338450n 1.8
+    1338499n 1.8
+    1338500n 0
+    1338549n 0
+    1338550n 1.8
+    1338599n 1.8
+    1338600n 0
+    1338649n 0
+    1338650n 1.8
+    1338699n 1.8
+    1338700n 0
+    1338749n 0
+    1338750n 1.8
+    1338799n 1.8
+    1338800n 0
+    1338849n 0
+    1338850n 1.8
+    1338899n 1.8
+    1338900n 0
+    1338949n 0
+    1338950n 1.8
+    1338999n 1.8
+    1339000n 0
+    1339049n 0
+    1339050n 1.8
+    1339099n 1.8
+    1339100n 0
+    1339149n 0
+    1339150n 1.8
+    1339199n 1.8
+    1339200n 0
+    1339249n 0
+    1339250n 1.8
+    1339299n 1.8
+    1339300n 0
+    1339349n 0
+    1339350n 1.8
+    1339399n 1.8
+    1339400n 0
+    1339449n 0
+    1339450n 1.8
+    1339499n 1.8
+    1339500n 0
+    1339549n 0
+    1339550n 1.8
+    1339599n 1.8
+    1339600n 0
+    1339649n 0
+    1339650n 1.8
+    1339699n 1.8
+    1339700n 0
+    1339749n 0
+    1339750n 1.8
+    1339799n 1.8
+    1339800n 0
+    1339849n 0
+    1339850n 1.8
+    1339899n 1.8
+    1339900n 0
+    1339949n 0
+    1339950n 1.8
+    1339999n 1.8
+    1340000n 0
+    1340049n 0
+    1340050n 1.8
+    1340099n 1.8
+    1340100n 0
+    1340149n 0
+    1340150n 1.8
+    1340199n 1.8
+    1340200n 0
+    1340249n 0
+    1340250n 1.8
+    1340299n 1.8
+    1340300n 0
+    1340349n 0
+    1340350n 1.8
+    1340399n 1.8
+    1340400n 0
+    1340449n 0
+    1340450n 1.8
+    1340499n 1.8
+    1340500n 0
+    1340549n 0
+    1340550n 1.8
+    1340599n 1.8
+    1340600n 0
+    1340649n 0
+    1340650n 1.8
+    1340699n 1.8
+    1340700n 0
+    1340749n 0
+    1340750n 1.8
+    1340799n 1.8
+    1340800n 0
+    1340849n 0
+    1340850n 1.8
+    1340899n 1.8
+    1340900n 0
+    1340949n 0
+    1340950n 1.8
+    1340999n 1.8
+    1341000n 0
+    1341049n 0
+    1341050n 1.8
+    1341099n 1.8
+    1341100n 0
+    1341149n 0
+    1341150n 1.8
+    1341199n 1.8
+    1341200n 0
+    1341249n 0
+    1341250n 1.8
+    1341299n 1.8
+    1341300n 0
+    1341349n 0
+    1341350n 1.8
+    1341399n 1.8
+    1341400n 0
+    1341449n 0
+    1341450n 1.8
+    1341499n 1.8
+    1341500n 0
+    1341549n 0
+    1341550n 1.8
+    1341599n 1.8
+    1341600n 0
+    1341649n 0
+    1341650n 1.8
+    1341699n 1.8
+    1341700n 0
+    1341749n 0
+    1341750n 1.8
+    1341799n 1.8
+    1341800n 0
+    1341849n 0
+    1341850n 1.8
+    1341899n 1.8
+    1341900n 0
+    1341949n 0
+    1341950n 1.8
+    1341999n 1.8
+    1342000n 0
+    1342049n 0
+    1342050n 1.8
+    1342099n 1.8
+    1342100n 0
+    1342149n 0
+    1342150n 1.8
+    1342199n 1.8
+    1342200n 0
+    1342249n 0
+    1342250n 1.8
+    1342299n 1.8
+    1342300n 0
+    1342349n 0
+    1342350n 1.8
+    1342399n 1.8
+    1342400n 0
+    1342449n 0
+    1342450n 1.8
+    1342499n 1.8
+    1342500n 0
+    1342549n 0
+    1342550n 1.8
+    1342599n 1.8
+    1342600n 0
+    1342649n 0
+    1342650n 1.8
+    1342699n 1.8
+    1342700n 0
+    1342749n 0
+    1342750n 1.8
+    1342799n 1.8
+    1342800n 0
+    1342849n 0
+    1342850n 1.8
+    1342899n 1.8
+    1342900n 0
+    1342949n 0
+    1342950n 1.8
+    1342999n 1.8
+    1343000n 0
+    1343049n 0
+    1343050n 1.8
+    1343099n 1.8
+    1343100n 0
+    1343149n 0
+    1343150n 1.8
+    1343199n 1.8
+    1343200n 0
+    1343249n 0
+    1343250n 1.8
+    1343299n 1.8
+    1343300n 0
+    1343349n 0
+    1343350n 1.8
+    1343399n 1.8
+    1343400n 0
+    1343449n 0
+    1343450n 1.8
+    1343499n 1.8
+    1343500n 0
+    1343549n 0
+    1343550n 1.8
+    1343599n 1.8
+    1343600n 0
+    1343649n 0
+    1343650n 1.8
+    1343699n 1.8
+    1343700n 0
+    1343749n 0
+    1343750n 1.8
+    1343799n 1.8
+    1343800n 0
+    1343849n 0
+    1343850n 1.8
+    1343899n 1.8
+    1343900n 0
+    1343949n 0
+    1343950n 1.8
+    1343999n 1.8
+    1344000n 0
+    1344049n 0
+    1344050n 1.8
+    1344099n 1.8
+    1344100n 0
+    1344149n 0
+    1344150n 1.8
+    1344199n 1.8
+    1344200n 0
+    1344249n 0
+    1344250n 1.8
+    1344299n 1.8
+    1344300n 0
+    1344349n 0
+    1344350n 1.8
+    1344399n 1.8
+    1344400n 0
+    1344449n 0
+    1344450n 1.8
+    1344499n 1.8
+    1344500n 0
+    1344549n 0
+    1344550n 1.8
+    1344599n 1.8
+    1344600n 0
+    1344649n 0
+    1344650n 1.8
+    1344699n 1.8
+    1344700n 0
+    1344749n 0
+    1344750n 1.8
+    1344799n 1.8
+    1344800n 0
+    1344849n 0
+    1344850n 1.8
+    1344899n 1.8
+    1344900n 0
+    1344949n 0
+    1344950n 1.8
+    1344999n 1.8
+    1345000n 0
+    1345049n 0
+    1345050n 1.8
+    1345099n 1.8
+    1345100n 0
+    1345149n 0
+    1345150n 1.8
+    1345199n 1.8
+    1345200n 0
+    1345249n 0
+    1345250n 1.8
+    1345299n 1.8
+    1345300n 0
+    1345349n 0
+    1345350n 1.8
+    1345399n 1.8
+    1345400n 0
+    1345449n 0
+    1345450n 1.8
+    1345499n 1.8
+    1345500n 0
+    1345549n 0
+    1345550n 1.8
+    1345599n 1.8
+    1345600n 0
+    1345649n 0
+    1345650n 1.8
+    1345699n 1.8
+    1345700n 0
+    1345749n 0
+    1345750n 1.8
+    1345799n 1.8
+    1345800n 0
+    1345849n 0
+    1345850n 1.8
+    1345899n 1.8
+    1345900n 0
+    1345949n 0
+    1345950n 1.8
+    1345999n 1.8
+    1346000n 0
+    1346049n 0
+    1346050n 1.8
+    1346099n 1.8
+    1346100n 0
+    1346149n 0
+    1346150n 1.8
+    1346199n 1.8
+    1346200n 0
+    1346249n 0
+    1346250n 1.8
+    1346299n 1.8
+    1346300n 0
+    1346349n 0
+    1346350n 1.8
+    1346399n 1.8
+    1346400n 0
+    1346449n 0
+    1346450n 1.8
+    1346499n 1.8
+    1346500n 0
+    1346549n 0
+    1346550n 1.8
+    1346599n 1.8
+    1346600n 0
+    1346649n 0
+    1346650n 1.8
+    1346699n 1.8
+    1346700n 0
+    1346749n 0
+    1346750n 1.8
+    1346799n 1.8
+    1346800n 0
+    1346849n 0
+    1346850n 1.8
+    1346899n 1.8
+    1346900n 0
+    1346949n 0
+    1346950n 1.8
+    1346999n 1.8
+    1347000n 0
+    1347049n 0
+    1347050n 1.8
+    1347099n 1.8
+    1347100n 0
+    1347149n 0
+    1347150n 1.8
+    1347199n 1.8
+    1347200n 0
+    1347249n 0
+    1347250n 1.8
+    1347299n 1.8
+    1347300n 0
+    1347349n 0
+    1347350n 1.8
+    1347399n 1.8
+    1347400n 0
+    1347449n 0
+    1347450n 1.8
+    1347499n 1.8
+    1347500n 0
+    1347549n 0
+    1347550n 1.8
+    1347599n 1.8
+    1347600n 0
+    1347649n 0
+    1347650n 1.8
+    1347699n 1.8
+    1347700n 0
+    1347749n 0
+    1347750n 1.8
+    1347799n 1.8
+    1347800n 0
+    1347849n 0
+    1347850n 1.8
+    1347899n 1.8
+    1347900n 0
+    1347949n 0
+    1347950n 1.8
+    1347999n 1.8
+    1348000n 0
+    1348049n 0
+    1348050n 1.8
+    1348099n 1.8
+    1348100n 0
+    1348149n 0
+    1348150n 1.8
+    1348199n 1.8
+    1348200n 0
+    1348249n 0
+    1348250n 1.8
+    1348299n 1.8
+    1348300n 0
+    1348349n 0
+    1348350n 1.8
+    1348399n 1.8
+    1348400n 0
+    1348449n 0
+    1348450n 1.8
+    1348499n 1.8
+    1348500n 0
+    1348549n 0
+    1348550n 1.8
+    1348599n 1.8
+    1348600n 0
+    1348649n 0
+    1348650n 1.8
+    1348699n 1.8
+    1348700n 0
+    1348749n 0
+    1348750n 1.8
+    1348799n 1.8
+    1348800n 0
+    1348849n 0
+    1348850n 1.8
+    1348899n 1.8
+    1348900n 0
+    1348949n 0
+    1348950n 1.8
+    1348999n 1.8
+    1349000n 0
+    1349049n 0
+    1349050n 1.8
+    1349099n 1.8
+    1349100n 0
+    1349149n 0
+    1349150n 1.8
+    1349199n 1.8
+    1349200n 0
+    1349249n 0
+    1349250n 1.8
+    1349299n 1.8
+    1349300n 0
+    1349349n 0
+    1349350n 1.8
+    1349399n 1.8
+    1349400n 0
+    1349449n 0
+    1349450n 1.8
+    1349499n 1.8
+    1349500n 0
+    1349549n 0
+    1349550n 1.8
+    1349599n 1.8
+    1349600n 0
+    1349649n 0
+    1349650n 1.8
+    1349699n 1.8
+    1349700n 0
+    1349749n 0
+    1349750n 1.8
+    1349799n 1.8
+    1349800n 0
+    1349849n 0
+    1349850n 1.8
+    1349899n 1.8
+    1349900n 0
+    1349949n 0
+    1349950n 1.8
+    1349999n 1.8
+    1350000n 0
+    1350049n 0
+    1350050n 1.8
+    1350099n 1.8
+    1350100n 0
+    1350149n 0
+    1350150n 1.8
+    1350199n 1.8
+    1350200n 0
+    1350249n 0
+    1350250n 1.8
+    1350299n 1.8
+    1350300n 0
+    1350349n 0
+    1350350n 1.8
+    1350399n 1.8
+    1350400n 0
+    1350449n 0
+    1350450n 1.8
+    1350499n 1.8
+    1350500n 0
+    1350549n 0
+    1350550n 1.8
+    1350599n 1.8
+    1350600n 0
+    1350649n 0
+    1350650n 1.8
+    1350699n 1.8
+    1350700n 0
+    1350749n 0
+    1350750n 1.8
+    1350799n 1.8
+    1350800n 0
+    1350849n 0
+    1350850n 1.8
+    1350899n 1.8
+    1350900n 0
+    1350949n 0
+    1350950n 1.8
+    1350999n 1.8
+    1351000n 0
+    1351049n 0
+    1351050n 1.8
+    1351099n 1.8
+    1351100n 0
+    1351149n 0
+    1351150n 1.8
+    1351199n 1.8
+    1351200n 0
+    1351249n 0
+    1351250n 1.8
+    1351299n 1.8
+    1351300n 0
+    1351349n 0
+    1351350n 1.8
+    1351399n 1.8
+    1351400n 0
+    1351449n 0
+    1351450n 1.8
+    1351499n 1.8
+    1351500n 0
+    1351549n 0
+    1351550n 1.8
+    1351599n 1.8
+    1351600n 0
+    1351649n 0
+    1351650n 1.8
+    1351699n 1.8
+    1351700n 0
+    1351749n 0
+    1351750n 1.8
+    1351799n 1.8
+    1351800n 0
+    1351849n 0
+    1351850n 1.8
+    1351899n 1.8
+    1351900n 0
+    1351949n 0
+    1351950n 1.8
+    1351999n 1.8
+    1352000n 0
+    1352049n 0
+    1352050n 1.8
+    1352099n 1.8
+    1352100n 0
+    1352149n 0
+    1352150n 1.8
+    1352199n 1.8
+    1352200n 0
+    1352249n 0
+    1352250n 1.8
+    1352299n 1.8
+    1352300n 0
+    1352349n 0
+    1352350n 1.8
+    1352399n 1.8
+    1352400n 0
+    1352449n 0
+    1352450n 1.8
+    1352499n 1.8
+    1352500n 0
+    1352549n 0
+    1352550n 1.8
+    1352599n 1.8
+    1352600n 0
+    1352649n 0
+    1352650n 1.8
+    1352699n 1.8
+    1352700n 0
+    1352749n 0
+    1352750n 1.8
+    1352799n 1.8
+    1352800n 0
+    1352849n 0
+    1352850n 1.8
+    1352899n 1.8
+    1352900n 0
+    1352949n 0
+    1352950n 1.8
+    1352999n 1.8
+    1353000n 0
+    1353049n 0
+    1353050n 1.8
+    1353099n 1.8
+    1353100n 0
+    1353149n 0
+    1353150n 1.8
+    1353199n 1.8
+    1353200n 0
+    1353249n 0
+    1353250n 1.8
+    1353299n 1.8
+    1353300n 0
+    1353349n 0
+    1353350n 1.8
+    1353399n 1.8
+    1353400n 0
+    1353449n 0
+    1353450n 1.8
+    1353499n 1.8
+    1353500n 0
+    1353549n 0
+    1353550n 1.8
+    1353599n 1.8
+    1353600n 0
+    1353649n 0
+    1353650n 1.8
+    1353699n 1.8
+    1353700n 0
+    1353749n 0
+    1353750n 1.8
+    1353799n 1.8
+    1353800n 0
+    1353849n 0
+    1353850n 1.8
+    1353899n 1.8
+    1353900n 0
+    1353949n 0
+    1353950n 1.8
+    1353999n 1.8
+    1354000n 0
+    1354049n 0
+    1354050n 1.8
+    1354099n 1.8
+    1354100n 0
+    1354149n 0
+    1354150n 1.8
+    1354199n 1.8
+    1354200n 0
+    1354249n 0
+    1354250n 1.8
+    1354299n 1.8
+    1354300n 0
+    1354349n 0
+    1354350n 1.8
+    1354399n 1.8
+    1354400n 0
+    1354449n 0
+    1354450n 1.8
+    1354499n 1.8
+    1354500n 0
+    1354549n 0
+    1354550n 1.8
+    1354599n 1.8
+    1354600n 0
+    1354649n 0
+    1354650n 1.8
+    1354699n 1.8
+    1354700n 0
+    1354749n 0
+    1354750n 1.8
+    1354799n 1.8
+    1354800n 0
+    1354849n 0
+    1354850n 1.8
+    1354899n 1.8
+    1354900n 0
+    1354949n 0
+    1354950n 1.8
+    1354999n 1.8
+    1355000n 0
+    1355049n 0
+    1355050n 1.8
+    1355099n 1.8
+    1355100n 0
+    1355149n 0
+    1355150n 1.8
+    1355199n 1.8
+    1355200n 0
+    1355249n 0
+    1355250n 1.8
+    1355299n 1.8
+    1355300n 0
+    1355349n 0
+    1355350n 1.8
+    1355399n 1.8
+    1355400n 0
+    1355449n 0
+    1355450n 1.8
+    1355499n 1.8
+    1355500n 0
+    1355549n 0
+    1355550n 1.8
+    1355599n 1.8
+    1355600n 0
+    1355649n 0
+    1355650n 1.8
+    1355699n 1.8
+    1355700n 0
+    1355749n 0
+    1355750n 1.8
+    1355799n 1.8
+    1355800n 0
+    1355849n 0
+    1355850n 1.8
+    1355899n 1.8
+    1355900n 0
+    1355949n 0
+    1355950n 1.8
+    1355999n 1.8
+    1356000n 0
+    1356049n 0
+    1356050n 1.8
+    1356099n 1.8
+    1356100n 0
+    1356149n 0
+    1356150n 1.8
+    1356199n 1.8
+    1356200n 0
+    1356249n 0
+    1356250n 1.8
+    1356299n 1.8
+    1356300n 0
+    1356349n 0
+    1356350n 1.8
+    1356399n 1.8
+    1356400n 0
+    1356449n 0
+    1356450n 1.8
+    1356499n 1.8
+    1356500n 0
+    1356549n 0
+    1356550n 1.8
+    1356599n 1.8
+    1356600n 0
+    1356649n 0
+    1356650n 1.8
+    1356699n 1.8
+    1356700n 0
+    1356749n 0
+    1356750n 1.8
+    1356799n 1.8
+    1356800n 0
+    1356849n 0
+    1356850n 1.8
+    1356899n 1.8
+    1356900n 0
+    1356949n 0
+    1356950n 1.8
+    1356999n 1.8
+    1357000n 0
+    1357049n 0
+    1357050n 1.8
+    1357099n 1.8
+    1357100n 0
+    1357149n 0
+    1357150n 1.8
+    1357199n 1.8
+    1357200n 0
+    1357249n 0
+    1357250n 1.8
+    1357299n 1.8
+    1357300n 0
+    1357349n 0
+    1357350n 1.8
+    1357399n 1.8
+    1357400n 0
+    1357449n 0
+    1357450n 1.8
+    1357499n 1.8
+    1357500n 0
+    1357549n 0
+    1357550n 1.8
+    1357599n 1.8
+    1357600n 0
+    1357649n 0
+    1357650n 1.8
+    1357699n 1.8
+    1357700n 0
+    1357749n 0
+    1357750n 1.8
+    1357799n 1.8
+    1357800n 0
+    1357849n 0
+    1357850n 1.8
+    1357899n 1.8
+    1357900n 0
+    1357949n 0
+    1357950n 1.8
+    1357999n 1.8
+    1358000n 0
+    1358049n 0
+    1358050n 1.8
+    1358099n 1.8
+    1358100n 0
+    1358149n 0
+    1358150n 1.8
+    1358199n 1.8
+    1358200n 0
+    1358249n 0
+    1358250n 1.8
+    1358299n 1.8
+    1358300n 0
+    1358349n 0
+    1358350n 1.8
+    1358399n 1.8
+    1358400n 0
+    1358449n 0
+    1358450n 1.8
+    1358499n 1.8
+    1358500n 0
+    1358549n 0
+    1358550n 1.8
+    1358599n 1.8
+    1358600n 0
+    1358649n 0
+    1358650n 1.8
+    1358699n 1.8
+    1358700n 0
+    1358749n 0
+    1358750n 1.8
+    1358799n 1.8
+    1358800n 0
+    1358849n 0
+    1358850n 1.8
+    1358899n 1.8
+    1358900n 0
+    1358949n 0
+    1358950n 1.8
+    1358999n 1.8
+    1359000n 0
+    1359049n 0
+    1359050n 1.8
+    1359099n 1.8
+    1359100n 0
+    1359149n 0
+    1359150n 1.8
+    1359199n 1.8
+    1359200n 0
+    1359249n 0
+    1359250n 1.8
+    1359299n 1.8
+    1359300n 0
+    1359349n 0
+    1359350n 1.8
+    1359399n 1.8
+    1359400n 0
+    1359449n 0
+    1359450n 1.8
+    1359499n 1.8
+    1359500n 0
+    1359549n 0
+    1359550n 1.8
+    1359599n 1.8
+    1359600n 0
+    1359649n 0
+    1359650n 1.8
+    1359699n 1.8
+    1359700n 0
+    1359749n 0
+    1359750n 1.8
+    1359799n 1.8
+    1359800n 0
+    1359849n 0
+    1359850n 1.8
+    1359899n 1.8
+    1359900n 0
+    1359949n 0
+    1359950n 1.8
+    1359999n 1.8
+    1360000n 0
+    1360049n 0
+    1360050n 1.8
+    1360099n 1.8
+    1360100n 0
+    1360149n 0
+    1360150n 1.8
+    1360199n 1.8
+    1360200n 0
+    1360249n 0
+    1360250n 1.8
+    1360299n 1.8
+    1360300n 0
+    1360349n 0
+    1360350n 1.8
+    1360399n 1.8
+    1360400n 0
+    1360449n 0
+    1360450n 1.8
+    1360499n 1.8
+    1360500n 0
+    1360549n 0
+    1360550n 1.8
+    1360599n 1.8
+    1360600n 0
+    1360649n 0
+    1360650n 1.8
+    1360699n 1.8
+    1360700n 0
+    1360749n 0
+    1360750n 1.8
+    1360799n 1.8
+    1360800n 0
+    1360849n 0
+    1360850n 1.8
+    1360899n 1.8
+    1360900n 0
+    1360949n 0
+    1360950n 1.8
+    1360999n 1.8
+    1361000n 0
+    1361049n 0
+    1361050n 1.8
+    1361099n 1.8
+    1361100n 0
+    1361149n 0
+    1361150n 1.8
+    1361199n 1.8
+    1361200n 0
+    1361249n 0
+    1361250n 1.8
+    1361299n 1.8
+    1361300n 0
+    1361349n 0
+    1361350n 1.8
+    1361399n 1.8
+    1361400n 0
+    1361449n 0
+    1361450n 1.8
+    1361499n 1.8
+    1361500n 0
+    1361549n 0
+    1361550n 1.8
+    1361599n 1.8
+    1361600n 0
+    1361649n 0
+    1361650n 1.8
+    1361699n 1.8
+    1361700n 0
+    1361749n 0
+    1361750n 1.8
+    1361799n 1.8
+    1361800n 0
+    1361849n 0
+    1361850n 1.8
+    1361899n 1.8
+    1361900n 0
+    1361949n 0
+    1361950n 1.8
+    1361999n 1.8
+    1362000n 0
+    1362049n 0
+    1362050n 1.8
+    1362099n 1.8
+    1362100n 0
+    1362149n 0
+    1362150n 1.8
+    1362199n 1.8
+    1362200n 0
+    1362249n 0
+    1362250n 1.8
+    1362299n 1.8
+    1362300n 0
+    1362349n 0
+    1362350n 1.8
+    1362399n 1.8
+    1362400n 0
+    1362449n 0
+    1362450n 1.8
+    1362499n 1.8
+    1362500n 0
+    1362549n 0
+    1362550n 1.8
+    1362599n 1.8
+    1362600n 0
+    1362649n 0
+    1362650n 1.8
+    1362699n 1.8
+    1362700n 0
+    1362749n 0
+    1362750n 1.8
+    1362799n 1.8
+    1362800n 0
+    1362849n 0
+    1362850n 1.8
+    1362899n 1.8
+    1362900n 0
+    1362949n 0
+    1362950n 1.8
+    1362999n 1.8
+    1363000n 0
+    1363049n 0
+    1363050n 1.8
+    1363099n 1.8
+    1363100n 0
+    1363149n 0
+    1363150n 1.8
+    1363199n 1.8
+    1363200n 0
+    1363249n 0
+    1363250n 1.8
+    1363299n 1.8
+    1363300n 0
+    1363349n 0
+    1363350n 1.8
+    1363399n 1.8
+    1363400n 0
+    1363449n 0
+    1363450n 1.8
+    1363499n 1.8
+    1363500n 0
+    1363549n 0
+    1363550n 1.8
+    1363599n 1.8
+    1363600n 0
+    1363649n 0
+    1363650n 1.8
+    1363699n 1.8
+    1363700n 0
+    1363749n 0
+    1363750n 1.8
+    1363799n 1.8
+    1363800n 0
+    1363849n 0
+    1363850n 1.8
+    1363899n 1.8
+    1363900n 0
+    1363949n 0
+    1363950n 1.8
+    1363999n 1.8
+    1364000n 0
+    1364049n 0
+    1364050n 1.8
+    1364099n 1.8
+    1364100n 0
+    1364149n 0
+    1364150n 1.8
+    1364199n 1.8
+    1364200n 0
+    1364249n 0
+    1364250n 1.8
+    1364299n 1.8
+    1364300n 0
+    1364349n 0
+    1364350n 1.8
+    1364399n 1.8
+    1364400n 0
+    1364449n 0
+    1364450n 1.8
+    1364499n 1.8
+    1364500n 0
+    1364549n 0
+    1364550n 1.8
+    1364599n 1.8
+    1364600n 0
+    1364649n 0
+    1364650n 1.8
+    1364699n 1.8
+    1364700n 0
+    1364749n 0
+    1364750n 1.8
+    1364799n 1.8
+    1364800n 0
+    1364849n 0
+    1364850n 1.8
+    1364899n 1.8
+    1364900n 0
+    1364949n 0
+    1364950n 1.8
+    1364999n 1.8
+    1365000n 0
+    1365049n 0
+    1365050n 1.8
+    1365099n 1.8
+    1365100n 0
+    1365149n 0
+    1365150n 1.8
+    1365199n 1.8
+    1365200n 0
+    1365249n 0
+    1365250n 1.8
+    1365299n 1.8
+    1365300n 0
+    1365349n 0
+    1365350n 1.8
+    1365399n 1.8
+    1365400n 0
+    1365449n 0
+    1365450n 1.8
+    1365499n 1.8
+    1365500n 0
+    1365549n 0
+    1365550n 1.8
+    1365599n 1.8
+    1365600n 0
+    1365649n 0
+    1365650n 1.8
+    1365699n 1.8
+    1365700n 0
+    1365749n 0
+    1365750n 1.8
+    1365799n 1.8
+    1365800n 0
+    1365849n 0
+    1365850n 1.8
+    1365899n 1.8
+    1365900n 0
+    1365949n 0
+    1365950n 1.8
+    1365999n 1.8
+    1366000n 0
+    1366049n 0
+    1366050n 1.8
+    1366099n 1.8
+    1366100n 0
+    1366149n 0
+    1366150n 1.8
+    1366199n 1.8
+    1366200n 0
+    1366249n 0
+    1366250n 1.8
+    1366299n 1.8
+    1366300n 0
+    1366349n 0
+    1366350n 1.8
+    1366399n 1.8
+    1366400n 0
+    1366449n 0
+    1366450n 1.8
+    1366499n 1.8
+    1366500n 0
+    1366549n 0
+    1366550n 1.8
+    1366599n 1.8
+    1366600n 0
+    1366649n 0
+    1366650n 1.8
+    1366699n 1.8
+    1366700n 0
+    1366749n 0
+    1366750n 1.8
+    1366799n 1.8
+    1366800n 0
+    1366849n 0
+    1366850n 1.8
+    1366899n 1.8
+    1366900n 0
+    1366949n 0
+    1366950n 1.8
+    1366999n 1.8
+    1367000n 0
+    1367049n 0
+    1367050n 1.8
+    1367099n 1.8
+    1367100n 0
+    1367149n 0
+    1367150n 1.8
+    1367199n 1.8
+    1367200n 0
+    1367249n 0
+    1367250n 1.8
+    1367299n 1.8
+    1367300n 0
+    1367349n 0
+    1367350n 1.8
+    1367399n 1.8
+    1367400n 0
+    1367449n 0
+    1367450n 1.8
+    1367499n 1.8
+    1367500n 0
+    1367549n 0
+    1367550n 1.8
+    1367599n 1.8
+    1367600n 0
+    1367649n 0
+    1367650n 1.8
+    1367699n 1.8
+    1367700n 0
+    1367749n 0
+    1367750n 1.8
+    1367799n 1.8
+    1367800n 0
+    1367849n 0
+    1367850n 1.8
+    1367899n 1.8
+    1367900n 0
+    1367949n 0
+    1367950n 1.8
+    1367999n 1.8
+    1368000n 0
+    1368049n 0
+    1368050n 1.8
+    1368099n 1.8
+    1368100n 0
+    1368149n 0
+    1368150n 1.8
+    1368199n 1.8
+    1368200n 0
+    1368249n 0
+    1368250n 1.8
+    1368299n 1.8
+    1368300n 0
+    1368349n 0
+    1368350n 1.8
+    1368399n 1.8
+    1368400n 0
+    1368449n 0
+    1368450n 1.8
+    1368499n 1.8
+    1368500n 0
+    1368549n 0
+    1368550n 1.8
+    1368599n 1.8
+    1368600n 0
+    1368649n 0
+    1368650n 1.8
+    1368699n 1.8
+    1368700n 0
+    1368749n 0
+    1368750n 1.8
+    1368799n 1.8
+    1368800n 0
+    1368849n 0
+    1368850n 1.8
+    1368899n 1.8
+    1368900n 0
+    1368949n 0
+    1368950n 1.8
+    1368999n 1.8
+    1369000n 0
+    1369049n 0
+    1369050n 1.8
+    1369099n 1.8
+    1369100n 0
+    1369149n 0
+    1369150n 1.8
+    1369199n 1.8
+    1369200n 0
+    1369249n 0
+    1369250n 1.8
+    1369299n 1.8
+    1369300n 0
+    1369349n 0
+    1369350n 1.8
+    1369399n 1.8
+    1369400n 0
+    1369449n 0
+    1369450n 1.8
+    1369499n 1.8
+    1369500n 0
+    1369549n 0
+    1369550n 1.8
+    1369599n 1.8
+    1369600n 0
+    1369649n 0
+    1369650n 1.8
+    1369699n 1.8
+    1369700n 0
+    1369749n 0
+    1369750n 1.8
+    1369799n 1.8
+    1369800n 0
+    1369849n 0
+    1369850n 1.8
+    1369899n 1.8
+    1369900n 0
+    1369949n 0
+    1369950n 1.8
+    1369999n 1.8
+    1370000n 0
+    1370049n 0
+    1370050n 1.8
+    1370099n 1.8
+    1370100n 0
+    1370149n 0
+    1370150n 1.8
+    1370199n 1.8
+    1370200n 0
+    1370249n 0
+    1370250n 1.8
+    1370299n 1.8
+    1370300n 0
+    1370349n 0
+    1370350n 1.8
+    1370399n 1.8
+    1370400n 0
+    1370449n 0
+    1370450n 1.8
+    1370499n 1.8
+    1370500n 0
+    1370549n 0
+    1370550n 1.8
+    1370599n 1.8
+    1370600n 0
+    1370649n 0
+    1370650n 1.8
+    1370699n 1.8
+    1370700n 0
+    1370749n 0
+    1370750n 1.8
+    1370799n 1.8
+    1370800n 0
+    1370849n 0
+    1370850n 1.8
+    1370899n 1.8
+    1370900n 0
+    1370949n 0
+    1370950n 1.8
+    1370999n 1.8
+    1371000n 0
+    1371049n 0
+    1371050n 1.8
+    1371099n 1.8
+    1371100n 0
+    1371149n 0
+    1371150n 1.8
+    1371199n 1.8
+    1371200n 0
+    1371249n 0
+    1371250n 1.8
+    1371299n 1.8
+    1371300n 0
+    1371349n 0
+    1371350n 1.8
+    1371399n 1.8
+    1371400n 0
+    1371449n 0
+    1371450n 1.8
+    1371499n 1.8
+    1371500n 0
+    1371549n 0
+    1371550n 1.8
+    1371599n 1.8
+    1371600n 0
+    1371649n 0
+    1371650n 1.8
+    1371699n 1.8
+    1371700n 0
+    1371749n 0
+    1371750n 1.8
+    1371799n 1.8
+    1371800n 0
+    1371849n 0
+    1371850n 1.8
+    1371899n 1.8
+    1371900n 0
+    1371949n 0
+    1371950n 1.8
+    1371999n 1.8
+    1372000n 0
+    1372049n 0
+    1372050n 1.8
+    1372099n 1.8
+    1372100n 0
+    1372149n 0
+    1372150n 1.8
+    1372199n 1.8
+    1372200n 0
+    1372249n 0
+    1372250n 1.8
+    1372299n 1.8
+    1372300n 0
+    1372349n 0
+    1372350n 1.8
+    1372399n 1.8
+    1372400n 0
+    1372449n 0
+    1372450n 1.8
+    1372499n 1.8
+    1372500n 0
+    1372549n 0
+    1372550n 1.8
+    1372599n 1.8
+    1372600n 0
+    1372649n 0
+    1372650n 1.8
+    1372699n 1.8
+    1372700n 0
+    1372749n 0
+    1372750n 1.8
+    1372799n 1.8
+    1372800n 0
+    1372849n 0
+    1372850n 1.8
+    1372899n 1.8
+    1372900n 0
+    1372949n 0
+    1372950n 1.8
+    1372999n 1.8
+    1373000n 0
+    1373049n 0
+    1373050n 1.8
+    1373099n 1.8
+    1373100n 0
+    1373149n 0
+    1373150n 1.8
+    1373199n 1.8
+    1373200n 0
+    1373249n 0
+    1373250n 1.8
+    1373299n 1.8
+    1373300n 0
+    1373349n 0
+    1373350n 1.8
+    1373399n 1.8
+    1373400n 0
+    1373449n 0
+    1373450n 1.8
+    1373499n 1.8
+    1373500n 0
+    1373549n 0
+    1373550n 1.8
+    1373599n 1.8
+    1373600n 0
+    1373649n 0
+    1373650n 1.8
+    1373699n 1.8
+    1373700n 0
+    1373749n 0
+    1373750n 1.8
+    1373799n 1.8
+    1373800n 0
+    1373849n 0
+    1373850n 1.8
+    1373899n 1.8
+    1373900n 0
+    1373949n 0
+    1373950n 1.8
+    1373999n 1.8
+    1374000n 0
+    1374049n 0
+    1374050n 1.8
+    1374099n 1.8
+    1374100n 0
+    1374149n 0
+    1374150n 1.8
+    1374199n 1.8
+    1374200n 0
+    1374249n 0
+    1374250n 1.8
+    1374299n 1.8
+    1374300n 0
+    1374349n 0
+    1374350n 1.8
+    1374399n 1.8
+    1374400n 0
+    1374449n 0
+    1374450n 1.8
+    1374499n 1.8
+    1374500n 0
+    1374549n 0
+    1374550n 1.8
+    1374599n 1.8
+    1374600n 0
+    1374649n 0
+    1374650n 1.8
+    1374699n 1.8
+    1374700n 0
+    1374749n 0
+    1374750n 1.8
+    1374799n 1.8
+    1374800n 0
+    1374849n 0
+    1374850n 1.8
+    1374899n 1.8
+    1374900n 0
+    1374949n 0
+    1374950n 1.8
+    1374999n 1.8
+    1375000n 0
+    1375049n 0
+    1375050n 1.8
+    1375099n 1.8
+    1375100n 0
+    1375149n 0
+    1375150n 1.8
+    1375199n 1.8
+    1375200n 0
+    1375249n 0
+    1375250n 1.8
+    1375299n 1.8
+    1375300n 0
+    1375349n 0
+    1375350n 1.8
+    1375399n 1.8
+    1375400n 0
+    1375449n 0
+    1375450n 1.8
+    1375499n 1.8
+    1375500n 0
+    1375549n 0
+    1375550n 1.8
+    1375599n 1.8
+    1375600n 0
+    1375649n 0
+    1375650n 1.8
+    1375699n 1.8
+    1375700n 0
+    1375749n 0
+    1375750n 1.8
+    1375799n 1.8
+    1375800n 0
+    1375849n 0
+    1375850n 1.8
+    1375899n 1.8
+    1375900n 0
+    1375949n 0
+    1375950n 1.8
+    1375999n 1.8
+    1376000n 0
+    1376049n 0
+    1376050n 1.8
+    1376099n 1.8
+    1376100n 0
+    1376149n 0
+    1376150n 1.8
+    1376199n 1.8
+    1376200n 0
+    1376249n 0
+    1376250n 1.8
+    1376299n 1.8
+    1376300n 0
+    1376349n 0
+    1376350n 1.8
+    1376399n 1.8
+    1376400n 0
+    1376449n 0
+    1376450n 1.8
+    1376499n 1.8
+    1376500n 0
+    1376549n 0
+    1376550n 1.8
+    1376599n 1.8
+    1376600n 0
+    1376649n 0
+    1376650n 1.8
+    1376699n 1.8
+    1376700n 0
+    1376749n 0
+    1376750n 1.8
+    1376799n 1.8
+    1376800n 0
+    1376849n 0
+    1376850n 1.8
+    1376899n 1.8
+    1376900n 0
+    1376949n 0
+    1376950n 1.8
+    1376999n 1.8
+    1377000n 0
+    1377049n 0
+    1377050n 1.8
+    1377099n 1.8
+    1377100n 0
+    1377149n 0
+    1377150n 1.8
+    1377199n 1.8
+    1377200n 0
+    1377249n 0
+    1377250n 1.8
+    1377299n 1.8
+    1377300n 0
+    1377349n 0
+    1377350n 1.8
+    1377399n 1.8
+    1377400n 0
+    1377449n 0
+    1377450n 1.8
+    1377499n 1.8
+    1377500n 0
+    1377549n 0
+    1377550n 1.8
+    1377599n 1.8
+    1377600n 0
+    1377649n 0
+    1377650n 1.8
+    1377699n 1.8
+    1377700n 0
+    1377749n 0
+    1377750n 1.8
+    1377799n 1.8
+    1377800n 0
+    1377849n 0
+    1377850n 1.8
+    1377899n 1.8
+    1377900n 0
+    1377949n 0
+    1377950n 1.8
+    1377999n 1.8
+    1378000n 0
+    1378049n 0
+    1378050n 1.8
+    1378099n 1.8
+    1378100n 0
+    1378149n 0
+    1378150n 1.8
+    1378199n 1.8
+    1378200n 0
+    1378249n 0
+    1378250n 1.8
+    1378299n 1.8
+    1378300n 0
+    1378349n 0
+    1378350n 1.8
+    1378399n 1.8
+    1378400n 0
+    1378449n 0
+    1378450n 1.8
+    1378499n 1.8
+    1378500n 0
+    1378549n 0
+    1378550n 1.8
+    1378599n 1.8
+    1378600n 0
+    1378649n 0
+    1378650n 1.8
+    1378699n 1.8
+    1378700n 0
+    1378749n 0
+    1378750n 1.8
+    1378799n 1.8
+    1378800n 0
+    1378849n 0
+    1378850n 1.8
+    1378899n 1.8
+    1378900n 0
+    1378949n 0
+    1378950n 1.8
+    1378999n 1.8
+    1379000n 0
+    1379049n 0
+    1379050n 1.8
+    1379099n 1.8
+    1379100n 0
+    1379149n 0
+    1379150n 1.8
+    1379199n 1.8
+    1379200n 0
+    1379249n 0
+    1379250n 1.8
+    1379299n 1.8
+    1379300n 0
+    1379349n 0
+    1379350n 1.8
+    1379399n 1.8
+    1379400n 0
+    1379449n 0
+    1379450n 1.8
+    1379499n 1.8
+    1379500n 0
+    1379549n 0
+    1379550n 1.8
+    1379599n 1.8
+    1379600n 0
+    1379649n 0
+    1379650n 1.8
+    1379699n 1.8
+    1379700n 0
+    1379749n 0
+    1379750n 1.8
+    1379799n 1.8
+    1379800n 0
+    1379849n 0
+    1379850n 1.8
+    1379899n 1.8
+    1379900n 0
+    1379949n 0
+    1379950n 1.8
+    1379999n 1.8
+    1380000n 0
+    1380049n 0
+    1380050n 1.8
+    1380099n 1.8
+    1380100n 0
+    1380149n 0
+    1380150n 1.8
+    1380199n 1.8
+    1380200n 0
+    1380249n 0
+    1380250n 1.8
+    1380299n 1.8
+    1380300n 0
+    1380349n 0
+    1380350n 1.8
+    1380399n 1.8
+    1380400n 0
+    1380449n 0
+    1380450n 1.8
+    1380499n 1.8
+    1380500n 0
+    1380549n 0
+    1380550n 1.8
+    1380599n 1.8
+    1380600n 0
+    1380649n 0
+    1380650n 1.8
+    1380699n 1.8
+    1380700n 0
+    1380749n 0
+    1380750n 1.8
+    1380799n 1.8
+    1380800n 0
+    1380849n 0
+    1380850n 1.8
+    1380899n 1.8
+    1380900n 0
+    1380949n 0
+    1380950n 1.8
+    1380999n 1.8
+    1381000n 0
+    1381049n 0
+    1381050n 1.8
+    1381099n 1.8
+    1381100n 0
+    1381149n 0
+    1381150n 1.8
+    1381199n 1.8
+    1381200n 0
+    1381249n 0
+    1381250n 1.8
+    1381299n 1.8
+    1381300n 0
+    1381349n 0
+    1381350n 1.8
+    1381399n 1.8
+    1381400n 0
+    1381449n 0
+    1381450n 1.8
+    1381499n 1.8
+    1381500n 0
+    1381549n 0
+    1381550n 1.8
+    1381599n 1.8
+    1381600n 0
+    1381649n 0
+    1381650n 1.8
+    1381699n 1.8
+    1381700n 0
+    1381749n 0
+    1381750n 1.8
+    1381799n 1.8
+    1381800n 0
+    1381849n 0
+    1381850n 1.8
+    1381899n 1.8
+    1381900n 0
+    1381949n 0
+    1381950n 1.8
+    1381999n 1.8
+    1382000n 0
+    1382049n 0
+    1382050n 1.8
+    1382099n 1.8
+    1382100n 0
+    1382149n 0
+    1382150n 1.8
+    1382199n 1.8
+    1382200n 0
+    1382249n 0
+    1382250n 1.8
+    1382299n 1.8
+    1382300n 0
+    1382349n 0
+    1382350n 1.8
+    1382399n 1.8
+    1382400n 0
+    1382449n 0
+    1382450n 1.8
+    1382499n 1.8
+    1382500n 0
+    1382549n 0
+    1382550n 1.8
+    1382599n 1.8
+    1382600n 0
+    1382649n 0
+    1382650n 1.8
+    1382699n 1.8
+    1382700n 0
+    1382749n 0
+    1382750n 1.8
+    1382799n 1.8
+    1382800n 0
+    1382849n 0
+    1382850n 1.8
+    1382899n 1.8
+    1382900n 0
+    1382949n 0
+    1382950n 1.8
+    1382999n 1.8
+    1383000n 0
+    1383049n 0
+    1383050n 1.8
+    1383099n 1.8
+    1383100n 0
+    1383149n 0
+    1383150n 1.8
+    1383199n 1.8
+    1383200n 0
+    1383249n 0
+    1383250n 1.8
+    1383299n 1.8
+    1383300n 0
+    1383349n 0
+    1383350n 1.8
+    1383399n 1.8
+    1383400n 0
+    1383449n 0
+    1383450n 1.8
+    1383499n 1.8
+    1383500n 0
+    1383549n 0
+    1383550n 1.8
+    1383599n 1.8
+    1383600n 0
+    1383649n 0
+    1383650n 1.8
+    1383699n 1.8
+    1383700n 0
+    1383749n 0
+    1383750n 1.8
+    1383799n 1.8
+    1383800n 0
+    1383849n 0
+    1383850n 1.8
+    1383899n 1.8
+    1383900n 0
+    1383949n 0
+    1383950n 1.8
+    1383999n 1.8
+    1384000n 0
+    1384049n 0
+    1384050n 1.8
+    1384099n 1.8
+    1384100n 0
+    1384149n 0
+    1384150n 1.8
+    1384199n 1.8
+    1384200n 0
+    1384249n 0
+    1384250n 1.8
+    1384299n 1.8
+    1384300n 0
+    1384349n 0
+    1384350n 1.8
+    1384399n 1.8
+    1384400n 0
+    1384449n 0
+    1384450n 1.8
+    1384499n 1.8
+    1384500n 0
+    1384549n 0
+    1384550n 1.8
+    1384599n 1.8
+    1384600n 0
+    1384649n 0
+    1384650n 1.8
+    1384699n 1.8
+    1384700n 0
+    1384749n 0
+    1384750n 1.8
+    1384799n 1.8
+    1384800n 0
+    1384849n 0
+    1384850n 1.8
+    1384899n 1.8
+    1384900n 0
+    1384949n 0
+    1384950n 1.8
+    1384999n 1.8
+    1385000n 0
+    1385049n 0
+    1385050n 1.8
+    1385099n 1.8
+    1385100n 0
+    1385149n 0
+    1385150n 1.8
+    1385199n 1.8
+    1385200n 0
+    1385249n 0
+    1385250n 1.8
+    1385299n 1.8
+    1385300n 0
+    1385349n 0
+    1385350n 1.8
+    1385399n 1.8
+    1385400n 0
+    1385449n 0
+    1385450n 1.8
+    1385499n 1.8
+    1385500n 0
+    1385549n 0
+    1385550n 1.8
+    1385599n 1.8
+    1385600n 0
+    1385649n 0
+    1385650n 1.8
+    1385699n 1.8
+    1385700n 0
+    1385749n 0
+    1385750n 1.8
+    1385799n 1.8
+    1385800n 0
+    1385849n 0
+    1385850n 1.8
+    1385899n 1.8
+    1385900n 0
+    1385949n 0
+    1385950n 1.8
+    1385999n 1.8
+    1386000n 0
+    1386049n 0
+    1386050n 1.8
+    1386099n 1.8
+    1386100n 0
+    1386149n 0
+    1386150n 1.8
+    1386199n 1.8
+    1386200n 0
+    1386249n 0
+    1386250n 1.8
+    1386299n 1.8
+    1386300n 0
+    1386349n 0
+    1386350n 1.8
+    1386399n 1.8
+    1386400n 0
+    1386449n 0
+    1386450n 1.8
+    1386499n 1.8
+    1386500n 0
+    1386549n 0
+    1386550n 1.8
+    1386599n 1.8
+    1386600n 0
+    1386649n 0
+    1386650n 1.8
+    1386699n 1.8
+    1386700n 0
+    1386749n 0
+    1386750n 1.8
+    1386799n 1.8
+    1386800n 0
+    1386849n 0
+    1386850n 1.8
+    1386899n 1.8
+    1386900n 0
+    1386949n 0
+    1386950n 1.8
+    1386999n 1.8
+    1387000n 0
+    1387049n 0
+    1387050n 1.8
+    1387099n 1.8
+    1387100n 0
+    1387149n 0
+    1387150n 1.8
+    1387199n 1.8
+    1387200n 0
+    1387249n 0
+    1387250n 1.8
+    1387299n 1.8
+    1387300n 0
+    1387349n 0
+    1387350n 1.8
+    1387399n 1.8
+    1387400n 0
+    1387449n 0
+    1387450n 1.8
+    1387499n 1.8
+    1387500n 0
+    1387549n 0
+    1387550n 1.8
+    1387599n 1.8
+    1387600n 0
+    1387649n 0
+    1387650n 1.8
+    1387699n 1.8
+    1387700n 0
+    1387749n 0
+    1387750n 1.8
+    1387799n 1.8
+    1387800n 0
+    1387849n 0
+    1387850n 1.8
+    1387899n 1.8
+    1387900n 0
+    1387949n 0
+    1387950n 1.8
+    1387999n 1.8
+    1388000n 0
+    1388049n 0
+    1388050n 1.8
+    1388099n 1.8
+    1388100n 0
+    1388149n 0
+    1388150n 1.8
+    1388199n 1.8
+    1388200n 0
+    1388249n 0
+    1388250n 1.8
+    1388299n 1.8
+    1388300n 0
+    1388349n 0
+    1388350n 1.8
+    1388399n 1.8
+    1388400n 0
+    1388449n 0
+    1388450n 1.8
+    1388499n 1.8
+    1388500n 0
+    1388549n 0
+    1388550n 1.8
+    1388599n 1.8
+    1388600n 0
+    1388649n 0
+    1388650n 1.8
+    1388699n 1.8
+    1388700n 0
+    1388749n 0
+    1388750n 1.8
+    1388799n 1.8
+    1388800n 0
+    1388849n 0
+    1388850n 1.8
+    1388899n 1.8
+    1388900n 0
+    1388949n 0
+    1388950n 1.8
+    1388999n 1.8
+    1389000n 0
+    1389049n 0
+    1389050n 1.8
+    1389099n 1.8
+    1389100n 0
+    1389149n 0
+    1389150n 1.8
+    1389199n 1.8
+    1389200n 0
+    1389249n 0
+    1389250n 1.8
+    1389299n 1.8
+    1389300n 0
+    1389349n 0
+    1389350n 1.8
+    1389399n 1.8
+    1389400n 0
+    1389449n 0
+    1389450n 1.8
+    1389499n 1.8
+    1389500n 0
+    1389549n 0
+    1389550n 1.8
+    1389599n 1.8
+    1389600n 0
+    1389649n 0
+    1389650n 1.8
+    1389699n 1.8
+    1389700n 0
+    1389749n 0
+    1389750n 1.8
+    1389799n 1.8
+    1389800n 0
+    1389849n 0
+    1389850n 1.8
+    1389899n 1.8
+    1389900n 0
+    1389949n 0
+    1389950n 1.8
+    1389999n 1.8
+    1390000n 0
+    1390049n 0
+    1390050n 1.8
+    1390099n 1.8
+    1390100n 0
+    1390149n 0
+    1390150n 1.8
+    1390199n 1.8
+    1390200n 0
+    1390249n 0
+    1390250n 1.8
+    1390299n 1.8
+    1390300n 0
+    1390349n 0
+    1390350n 1.8
+    1390399n 1.8
+    1390400n 0
+    1390449n 0
+    1390450n 1.8
+    1390499n 1.8
+    1390500n 0
+    1390549n 0
+    1390550n 1.8
+    1390599n 1.8
+    1390600n 0
+    1390649n 0
+    1390650n 1.8
+    1390699n 1.8
+    1390700n 0
+    1390749n 0
+    1390750n 1.8
+    1390799n 1.8
+    1390800n 0
+    1390849n 0
+    1390850n 1.8
+    1390899n 1.8
+    1390900n 0
+    1390949n 0
+    1390950n 1.8
+    1390999n 1.8
+    1391000n 0
+    1391049n 0
+    1391050n 1.8
+    1391099n 1.8
+    1391100n 0
+    1391149n 0
+    1391150n 1.8
+    1391199n 1.8
+    1391200n 0
+    1391249n 0
+    1391250n 1.8
+    1391299n 1.8
+    1391300n 0
+    1391349n 0
+    1391350n 1.8
+    1391399n 1.8
+    1391400n 0
+    1391449n 0
+    1391450n 1.8
+    1391499n 1.8
+    1391500n 0
+    1391549n 0
+    1391550n 1.8
+    1391599n 1.8
+    1391600n 0
+    1391649n 0
+    1391650n 1.8
+    1391699n 1.8
+    1391700n 0
+    1391749n 0
+    1391750n 1.8
+    1391799n 1.8
+    1391800n 0
+    1391849n 0
+    1391850n 1.8
+    1391899n 1.8
+    1391900n 0
+    1391949n 0
+    1391950n 1.8
+    1391999n 1.8
+    1392000n 0
+    1392049n 0
+    1392050n 1.8
+    1392099n 1.8
+    1392100n 0
+    1392149n 0
+    1392150n 1.8
+    1392199n 1.8
+    1392200n 0
+    1392249n 0
+    1392250n 1.8
+    1392299n 1.8
+    1392300n 0
+    1392349n 0
+    1392350n 1.8
+    1392399n 1.8
+    1392400n 0
+    1392449n 0
+    1392450n 1.8
+    1392499n 1.8
+    1392500n 0
+    1392549n 0
+    1392550n 1.8
+    1392599n 1.8
+    1392600n 0
+    1392649n 0
+    1392650n 1.8
+    1392699n 1.8
+    1392700n 0
+    1392749n 0
+    1392750n 1.8
+    1392799n 1.8
+    1392800n 0
+    1392849n 0
+    1392850n 1.8
+    1392899n 1.8
+    1392900n 0
+    1392949n 0
+    1392950n 1.8
+    1392999n 1.8
+    1393000n 0
+    1393049n 0
+    1393050n 1.8
+    1393099n 1.8
+    1393100n 0
+    1393149n 0
+    1393150n 1.8
+    1393199n 1.8
+    1393200n 0
+    1393249n 0
+    1393250n 1.8
+    1393299n 1.8
+    1393300n 0
+    1393349n 0
+    1393350n 1.8
+    1393399n 1.8
+    1393400n 0
+    1393449n 0
+    1393450n 1.8
+    1393499n 1.8
+    1393500n 0
+    1393549n 0
+    1393550n 1.8
+    1393599n 1.8
+    1393600n 0
+    1393649n 0
+    1393650n 1.8
+    1393699n 1.8
+    1393700n 0
+    1393749n 0
+    1393750n 1.8
+    1393799n 1.8
+    1393800n 0
+    1393849n 0
+    1393850n 1.8
+    1393899n 1.8
+    1393900n 0
+    1393949n 0
+    1393950n 1.8
+    1393999n 1.8
+    1394000n 0
+    1394049n 0
+    1394050n 1.8
+    1394099n 1.8
+    1394100n 0
+    1394149n 0
+    1394150n 1.8
+    1394199n 1.8
+    1394200n 0
+    1394249n 0
+    1394250n 1.8
+    1394299n 1.8
+    1394300n 0
+    1394349n 0
+    1394350n 1.8
+    1394399n 1.8
+    1394400n 0
+    1394449n 0
+    1394450n 1.8
+    1394499n 1.8
+    1394500n 0
+    1394549n 0
+    1394550n 1.8
+    1394599n 1.8
+    1394600n 0
+    1394649n 0
+    1394650n 1.8
+    1394699n 1.8
+    1394700n 0
+    1394749n 0
+    1394750n 1.8
+    1394799n 1.8
+    1394800n 0
+    1394849n 0
+    1394850n 1.8
+    1394899n 1.8
+    1394900n 0
+    1394949n 0
+    1394950n 1.8
+    1394999n 1.8
+    1395000n 0
+    1395049n 0
+    1395050n 1.8
+    1395099n 1.8
+    1395100n 0
+    1395149n 0
+    1395150n 1.8
+    1395199n 1.8
+    1395200n 0
+    1395249n 0
+    1395250n 1.8
+    1395299n 1.8
+    1395300n 0
+    1395349n 0
+    1395350n 1.8
+    1395399n 1.8
+    1395400n 0
+    1395449n 0
+    1395450n 1.8
+    1395499n 1.8
+    1395500n 0
+    1395549n 0
+    1395550n 1.8
+    1395599n 1.8
+    1395600n 0
+    1395649n 0
+    1395650n 1.8
+    1395699n 1.8
+    1395700n 0
+    1395749n 0
+    1395750n 1.8
+    1395799n 1.8
+    1395800n 0
+    1395849n 0
+    1395850n 1.8
+    1395899n 1.8
+    1395900n 0
+    1395949n 0
+    1395950n 1.8
+    1395999n 1.8
+    1396000n 0
+    1396049n 0
+    1396050n 1.8
+    1396099n 1.8
+    1396100n 0
+    1396149n 0
+    1396150n 1.8
+    1396199n 1.8
+    1396200n 0
+    1396249n 0
+    1396250n 1.8
+    1396299n 1.8
+    1396300n 0
+    1396349n 0
+    1396350n 1.8
+    1396399n 1.8
+    1396400n 0
+    1396449n 0
+    1396450n 1.8
+    1396499n 1.8
+    1396500n 0
+    1396549n 0
+    1396550n 1.8
+    1396599n 1.8
+    1396600n 0
+    1396649n 0
+    1396650n 1.8
+    1396699n 1.8
+    1396700n 0
+    1396749n 0
+    1396750n 1.8
+    1396799n 1.8
+    1396800n 0
+    1396849n 0
+    1396850n 1.8
+    1396899n 1.8
+    1396900n 0
+    1396949n 0
+    1396950n 1.8
+    1396999n 1.8
+    1397000n 0
+    1397049n 0
+    1397050n 1.8
+    1397099n 1.8
+    1397100n 0
+    1397149n 0
+    1397150n 1.8
+    1397199n 1.8
+    1397200n 0
+    1397249n 0
+    1397250n 1.8
+    1397299n 1.8
+    1397300n 0
+    1397349n 0
+    1397350n 1.8
+    1397399n 1.8
+    1397400n 0
+    1397449n 0
+    1397450n 1.8
+    1397499n 1.8
+    1397500n 0
+    1397549n 0
+    1397550n 1.8
+    1397599n 1.8
+    1397600n 0
+    1397649n 0
+    1397650n 1.8
+    1397699n 1.8
+    1397700n 0
+    1397749n 0
+    1397750n 1.8
+    1397799n 1.8
+    1397800n 0
+    1397849n 0
+    1397850n 1.8
+    1397899n 1.8
+    1397900n 0
+    1397949n 0
+    1397950n 1.8
+    1397999n 1.8
+    1398000n 0
+    1398049n 0
+    1398050n 1.8
+    1398099n 1.8
+    1398100n 0
+    1398149n 0
+    1398150n 1.8
+    1398199n 1.8
+    1398200n 0
+    1398249n 0
+    1398250n 1.8
+    1398299n 1.8
+    1398300n 0
+    1398349n 0
+    1398350n 1.8
+    1398399n 1.8
+    1398400n 0
+    1398449n 0
+    1398450n 1.8
+    1398499n 1.8
+    1398500n 0
+    1398549n 0
+    1398550n 1.8
+    1398599n 1.8
+    1398600n 0
+    1398649n 0
+    1398650n 1.8
+    1398699n 1.8
+    1398700n 0
+    1398749n 0
+    1398750n 1.8
+    1398799n 1.8
+    1398800n 0
+    1398849n 0
+    1398850n 1.8
+    1398899n 1.8
+    1398900n 0
+    1398949n 0
+    1398950n 1.8
+    1398999n 1.8
+    1399000n 0
+    1399049n 0
+    1399050n 1.8
+    1399099n 1.8
+    1399100n 0
+    1399149n 0
+    1399150n 1.8
+    1399199n 1.8
+    1399200n 0
+    1399249n 0
+    1399250n 1.8
+    1399299n 1.8
+    1399300n 0
+    1399349n 0
+    1399350n 1.8
+    1399399n 1.8
+    1399400n 0
+    1399449n 0
+    1399450n 1.8
+    1399499n 1.8
+    1399500n 0
+    1399549n 0
+    1399550n 1.8
+    1399599n 1.8
+    1399600n 0
+    1399649n 0
+    1399650n 1.8
+    1399699n 1.8
+    1399700n 0
+    1399749n 0
+    1399750n 1.8
+    1399799n 1.8
+    1399800n 0
+    1399849n 0
+    1399850n 1.8
+    1399899n 1.8
+    1399900n 0
+    1399949n 0
+    1399950n 1.8
+    1399999n 1.8
+    1400000n 0
+    1400049n 0
+    1400050n 1.8
+    1400099n 1.8
+    1400100n 0
+    1400149n 0
+    1400150n 1.8
+    1400199n 1.8
+    1400200n 0
+    1400249n 0
+    1400250n 1.8
+    1400299n 1.8
+    1400300n 0
+    1400349n 0
+    1400350n 1.8
+    1400399n 1.8
+    1400400n 0
+    1400449n 0
+    1400450n 1.8
+    1400499n 1.8
+    1400500n 0
+    1400549n 0
+    1400550n 1.8
+    1400599n 1.8
+    1400600n 0
+    1400649n 0
+    1400650n 1.8
+    1400699n 1.8
+    1400700n 0
+    1400749n 0
+    1400750n 1.8
+    1400799n 1.8
+    1400800n 0
+    1400849n 0
+    1400850n 1.8
+    1400899n 1.8
+    1400900n 0
+    1400949n 0
+    1400950n 1.8
+    1400999n 1.8
+    1401000n 0
+    1401049n 0
+    1401050n 1.8
+    1401099n 1.8
+    1401100n 0
+    1401149n 0
+    1401150n 1.8
+    1401199n 1.8
+    1401200n 0
+    1401249n 0
+    1401250n 1.8
+    1401299n 1.8
+    1401300n 0
+    1401349n 0
+    1401350n 1.8
+    1401399n 1.8
+    1401400n 0
+    1401449n 0
+    1401450n 1.8
+    1401499n 1.8
+    1401500n 0
+    1401549n 0
+    1401550n 1.8
+    1401599n 1.8
+    1401600n 0
+    1401649n 0
+    1401650n 1.8
+    1401699n 1.8
+    1401700n 0
+    1401749n 0
+    1401750n 1.8
+    1401799n 1.8
+    1401800n 0
+    1401849n 0
+    1401850n 1.8
+    1401899n 1.8
+    1401900n 0
+    1401949n 0
+    1401950n 1.8
+    1401999n 1.8
+    1402000n 0
+    1402049n 0
+    1402050n 1.8
+    1402099n 1.8
+    1402100n 0
+    1402149n 0
+    1402150n 1.8
+    1402199n 1.8
+    1402200n 0
+    1402249n 0
+    1402250n 1.8
+    1402299n 1.8
+    1402300n 0
+    1402349n 0
+    1402350n 1.8
+    1402399n 1.8
+    1402400n 0
+    1402449n 0
+    1402450n 1.8
+    1402499n 1.8
+    1402500n 0
+    1402549n 0
+    1402550n 1.8
+    1402599n 1.8
+    1402600n 0
+    1402649n 0
+    1402650n 1.8
+    1402699n 1.8
+    1402700n 0
+    1402749n 0
+    1402750n 1.8
+    1402799n 1.8
+    1402800n 0
+    1402849n 0
+    1402850n 1.8
+    1402899n 1.8
+    1402900n 0
+    1402949n 0
+    1402950n 1.8
+    1402999n 1.8
+    1403000n 0
+    1403049n 0
+    1403050n 1.8
+    1403099n 1.8
+    1403100n 0
+    1403149n 0
+    1403150n 1.8
+    1403199n 1.8
+    1403200n 0
+    1403249n 0
+    1403250n 1.8
+    1403299n 1.8
+    1403300n 0
+    1403349n 0
+    1403350n 1.8
+    1403399n 1.8
+    1403400n 0
+    1403449n 0
+    1403450n 1.8
+    1403499n 1.8
+    1403500n 0
+    1403549n 0
+    1403550n 1.8
+    1403599n 1.8
+    1403600n 0
+    1403649n 0
+    1403650n 1.8
+    1403699n 1.8
+    1403700n 0
+    1403749n 0
+    1403750n 1.8
+    1403799n 1.8
+    1403800n 0
+    1403849n 0
+    1403850n 1.8
+    1403899n 1.8
+    1403900n 0
+    1403949n 0
+    1403950n 1.8
+    1403999n 1.8
+    1404000n 0
+    1404049n 0
+    1404050n 1.8
+    1404099n 1.8
+    1404100n 0
+    1404149n 0
+    1404150n 1.8
+    1404199n 1.8
+    1404200n 0
+    1404249n 0
+    1404250n 1.8
+    1404299n 1.8
+    1404300n 0
+    1404349n 0
+    1404350n 1.8
+    1404399n 1.8
+    1404400n 0
+    1404449n 0
+    1404450n 1.8
+    1404499n 1.8
+    1404500n 0
+    1404549n 0
+    1404550n 1.8
+    1404599n 1.8
+    1404600n 0
+    1404649n 0
+    1404650n 1.8
+    1404699n 1.8
+    1404700n 0
+    1404749n 0
+    1404750n 1.8
+    1404799n 1.8
+    1404800n 0
+    1404849n 0
+    1404850n 1.8
+    1404899n 1.8
+    1404900n 0
+    1404949n 0
+    1404950n 1.8
+    1404999n 1.8
+    1405000n 0
+    1405049n 0
+    1405050n 1.8
+    1405099n 1.8
+    1405100n 0
+    1405149n 0
+    1405150n 1.8
+    1405199n 1.8
+    1405200n 0
+    1405249n 0
+    1405250n 1.8
+    1405299n 1.8
+    1405300n 0
+    1405349n 0
+    1405350n 1.8
+    1405399n 1.8
+    1405400n 0
+    1405449n 0
+    1405450n 1.8
+    1405499n 1.8
+    1405500n 0
+    1405549n 0
+    1405550n 1.8
+    1405599n 1.8
+    1405600n 0
+    1405649n 0
+    1405650n 1.8
+    1405699n 1.8
+    1405700n 0
+    1405749n 0
+    1405750n 1.8
+    1405799n 1.8
+    1405800n 0
+    1405849n 0
+    1405850n 1.8
+    1405899n 1.8
+    1405900n 0
+    1405949n 0
+    1405950n 1.8
+    1405999n 1.8
+    1406000n 0
+    1406049n 0
+    1406050n 1.8
+    1406099n 1.8
+    1406100n 0
+    1406149n 0
+    1406150n 1.8
+    1406199n 1.8
+    1406200n 0
+    1406249n 0
+    1406250n 1.8
+    1406299n 1.8
+    1406300n 0
+    1406349n 0
+    1406350n 1.8
+    1406399n 1.8
+    1406400n 0
+    1406449n 0
+    1406450n 1.8
+    1406499n 1.8
+    1406500n 0
+    1406549n 0
+    1406550n 1.8
+    1406599n 1.8
+    1406600n 0
+    1406649n 0
+    1406650n 1.8
+    1406699n 1.8
+    1406700n 0
+    1406749n 0
+    1406750n 1.8
+    1406799n 1.8
+    1406800n 0
+    1406849n 0
+    1406850n 1.8
+    1406899n 1.8
+    1406900n 0
+    1406949n 0
+    1406950n 1.8
+    1406999n 1.8
+    1407000n 0
+    1407049n 0
+    1407050n 1.8
+    1407099n 1.8
+    1407100n 0
+    1407149n 0
+    1407150n 1.8
+    1407199n 1.8
+    1407200n 0
+    1407249n 0
+    1407250n 1.8
+    1407299n 1.8
+    1407300n 0
+    1407349n 0
+    1407350n 1.8
+    1407399n 1.8
+    1407400n 0
+    1407449n 0
+    1407450n 1.8
+    1407499n 1.8
+    1407500n 0
+    1407549n 0
+    1407550n 1.8
+    1407599n 1.8
+    1407600n 0
+    1407649n 0
+    1407650n 1.8
+    1407699n 1.8
+    1407700n 0
+    1407749n 0
+    1407750n 1.8
+    1407799n 1.8
+    1407800n 0
+    1407849n 0
+    1407850n 1.8
+    1407899n 1.8
+    1407900n 0
+    1407949n 0
+    1407950n 1.8
+    1407999n 1.8
+    1408000n 0
+    1408049n 0
+    1408050n 1.8
+    1408099n 1.8
+    1408100n 0
+    1408149n 0
+    1408150n 1.8
+    1408199n 1.8
+    1408200n 0
+    1408249n 0
+    1408250n 1.8
+    1408299n 1.8
+    1408300n 0
+    1408349n 0
+    1408350n 1.8
+    1408399n 1.8
+    1408400n 0
+    1408449n 0
+    1408450n 1.8
+    1408499n 1.8
+    1408500n 0
+    1408549n 0
+    1408550n 1.8
+    1408599n 1.8
+    1408600n 0
+    1408649n 0
+    1408650n 1.8
+    1408699n 1.8
+    1408700n 0
+    1408749n 0
+    1408750n 1.8
+    1408799n 1.8
+    1408800n 0
+    1408849n 0
+    1408850n 1.8
+    1408899n 1.8
+    1408900n 0
+    1408949n 0
+    1408950n 1.8
+    1408999n 1.8
+    1409000n 0
+    1409049n 0
+    1409050n 1.8
+    1409099n 1.8
+    1409100n 0
+    1409149n 0
+    1409150n 1.8
+    1409199n 1.8
+    1409200n 0
+    1409249n 0
+    1409250n 1.8
+    1409299n 1.8
+    1409300n 0
+    1409349n 0
+    1409350n 1.8
+    1409399n 1.8
+    1409400n 0
+    1409449n 0
+    1409450n 1.8
+    1409499n 1.8
+    1409500n 0
+    1409549n 0
+    1409550n 1.8
+    1409599n 1.8
+    1409600n 0
+    1409649n 0
+    1409650n 1.8
+    1409699n 1.8
+    1409700n 0
+    1409749n 0
+    1409750n 1.8
+    1409799n 1.8
+    1409800n 0
+    1409849n 0
+    1409850n 1.8
+    1409899n 1.8
+    1409900n 0
+    1409949n 0
+    1409950n 1.8
+    1409999n 1.8
+    1410000n 0
+    1410049n 0
+    1410050n 1.8
+    1410099n 1.8
+    1410100n 0
+    1410149n 0
+    1410150n 1.8
+    1410199n 1.8
+    1410200n 0
+    1410249n 0
+    1410250n 1.8
+    1410299n 1.8
+    1410300n 0
+    1410349n 0
+    1410350n 1.8
+    1410399n 1.8
+    1410400n 0
+    1410449n 0
+    1410450n 1.8
+    1410499n 1.8
+    1410500n 0
+    1410549n 0
+    1410550n 1.8
+    1410599n 1.8
+    1410600n 0
+    1410649n 0
+    1410650n 1.8
+    1410699n 1.8
+    1410700n 0
+    1410749n 0
+    1410750n 1.8
+    1410799n 1.8
+    1410800n 0
+    1410849n 0
+    1410850n 1.8
+    1410899n 1.8
+    1410900n 0
+    1410949n 0
+    1410950n 1.8
+    1410999n 1.8
+    1411000n 0
+    1411049n 0
+    1411050n 1.8
+    1411099n 1.8
+    1411100n 0
+    1411149n 0
+    1411150n 1.8
+    1411199n 1.8
+    1411200n 0
+    1411249n 0
+    1411250n 1.8
+    1411299n 1.8
+    1411300n 0
+    1411349n 0
+    1411350n 1.8
+    1411399n 1.8
+    1411400n 0
+    1411449n 0
+    1411450n 1.8
+    1411499n 1.8
+    1411500n 0
+    1411549n 0
+    1411550n 1.8
+    1411599n 1.8
+    1411600n 0
+    1411649n 0
+    1411650n 1.8
+    1411699n 1.8
+    1411700n 0
+    1411749n 0
+    1411750n 1.8
+    1411799n 1.8
+    1411800n 0
+    1411849n 0
+    1411850n 1.8
+    1411899n 1.8
+    1411900n 0
+    1411949n 0
+    1411950n 1.8
+    1411999n 1.8
+    1412000n 0
+    1412049n 0
+    1412050n 1.8
+    1412099n 1.8
+    1412100n 0
+    1412149n 0
+    1412150n 1.8
+    1412199n 1.8
+    1412200n 0
+    1412249n 0
+    1412250n 1.8
+    1412299n 1.8
+    1412300n 0
+    1412349n 0
+    1412350n 1.8
+    1412399n 1.8
+    1412400n 0
+    1412449n 0
+    1412450n 1.8
+    1412499n 1.8
+    1412500n 0
+    1412549n 0
+    1412550n 1.8
+    1412599n 1.8
+    1412600n 0
+    1412649n 0
+    1412650n 1.8
+    1412699n 1.8
+    1412700n 0
+    1412749n 0
+    1412750n 1.8
+    1412799n 1.8
+    1412800n 0
+    1412849n 0
+    1412850n 1.8
+    1412899n 1.8
+    1412900n 0
+    1412949n 0
+    1412950n 1.8
+    1412999n 1.8
+    1413000n 0
+    1413049n 0
+    1413050n 1.8
+    1413099n 1.8
+    1413100n 0
+    1413149n 0
+    1413150n 1.8
+    1413199n 1.8
+    1413200n 0
+    1413249n 0
+    1413250n 1.8
+    1413299n 1.8
+    1413300n 0
+    1413349n 0
+    1413350n 1.8
+    1413399n 1.8
+    1413400n 0
+    1413449n 0
+    1413450n 1.8
+    1413499n 1.8
+    1413500n 0
+    1413549n 0
+    1413550n 1.8
+    1413599n 1.8
+    1413600n 0
+    1413649n 0
+    1413650n 1.8
+    1413699n 1.8
+    1413700n 0
+    1413749n 0
+    1413750n 1.8
+    1413799n 1.8
+    1413800n 0
+    1413849n 0
+    1413850n 1.8
+    1413899n 1.8
+    1413900n 0
+    1413949n 0
+    1413950n 1.8
+    1413999n 1.8
+    1414000n 0
+    1414049n 0
+    1414050n 1.8
+    1414099n 1.8
+    1414100n 0
+    1414149n 0
+    1414150n 1.8
+    1414199n 1.8
+    1414200n 0
+    1414249n 0
+    1414250n 1.8
+    1414299n 1.8
+    1414300n 0
+    1414349n 0
+    1414350n 1.8
+    1414399n 1.8
+    1414400n 0
+    1414449n 0
+    1414450n 1.8
+    1414499n 1.8
+    1414500n 0
+    1414549n 0
+    1414550n 1.8
+    1414599n 1.8
+    1414600n 0
+    1414649n 0
+    1414650n 1.8
+    1414699n 1.8
+    1414700n 0
+    1414749n 0
+    1414750n 1.8
+    1414799n 1.8
+    1414800n 0
+    1414849n 0
+    1414850n 1.8
+    1414899n 1.8
+    1414900n 0
+    1414949n 0
+    1414950n 1.8
+    1414999n 1.8
+    1415000n 0
+    1415049n 0
+    1415050n 1.8
+    1415099n 1.8
+    1415100n 0
+    1415149n 0
+    1415150n 1.8
+    1415199n 1.8
+    1415200n 0
+    1415249n 0
+    1415250n 1.8
+    1415299n 1.8
+    1415300n 0
+    1415349n 0
+    1415350n 1.8
+    1415399n 1.8
+    1415400n 0
+    1415449n 0
+    1415450n 1.8
+    1415499n 1.8
+    1415500n 0
+    1415549n 0
+    1415550n 1.8
+    1415599n 1.8
+    1415600n 0
+    1415649n 0
+    1415650n 1.8
+    1415699n 1.8
+    1415700n 0
+    1415749n 0
+    1415750n 1.8
+    1415799n 1.8
+    1415800n 0
+    1415849n 0
+    1415850n 1.8
+    1415899n 1.8
+    1415900n 0
+    1415949n 0
+    1415950n 1.8
+    1415999n 1.8
+    1416000n 0
+    1416049n 0
+    1416050n 1.8
+    1416099n 1.8
+    1416100n 0
+    1416149n 0
+    1416150n 1.8
+    1416199n 1.8
+    1416200n 0
+    1416249n 0
+    1416250n 1.8
+    1416299n 1.8
+    1416300n 0
+    1416349n 0
+    1416350n 1.8
+    1416399n 1.8
+    1416400n 0
+    1416449n 0
+    1416450n 1.8
+    1416499n 1.8
+    1416500n 0
+    1416549n 0
+    1416550n 1.8
+    1416599n 1.8
+    1416600n 0
+    1416649n 0
+    1416650n 1.8
+    1416699n 1.8
+    1416700n 0
+    1416749n 0
+    1416750n 1.8
+    1416799n 1.8
+    1416800n 0
+    1416849n 0
+    1416850n 1.8
+    1416899n 1.8
+    1416900n 0
+    1416949n 0
+    1416950n 1.8
+    1416999n 1.8
+    1417000n 0
+    1417049n 0
+    1417050n 1.8
+    1417099n 1.8
+    1417100n 0
+    1417149n 0
+    1417150n 1.8
+    1417199n 1.8
+    1417200n 0
+    1417249n 0
+    1417250n 1.8
+    1417299n 1.8
+    1417300n 0
+    1417349n 0
+    1417350n 1.8
+    1417399n 1.8
+    1417400n 0
+    1417449n 0
+    1417450n 1.8
+    1417499n 1.8
+    1417500n 0
+    1417549n 0
+    1417550n 1.8
+    1417599n 1.8
+    1417600n 0
+    1417649n 0
+    1417650n 1.8
+    1417699n 1.8
+    1417700n 0
+    1417749n 0
+    1417750n 1.8
+    1417799n 1.8
+    1417800n 0
+    1417849n 0
+    1417850n 1.8
+    1417899n 1.8
+    1417900n 0
+    1417949n 0
+    1417950n 1.8
+    1417999n 1.8
+    1418000n 0
+    1418049n 0
+    1418050n 1.8
+    1418099n 1.8
+    1418100n 0
+    1418149n 0
+    1418150n 1.8
+    1418199n 1.8
+    1418200n 0
+    1418249n 0
+    1418250n 1.8
+    1418299n 1.8
+    1418300n 0
+    1418349n 0
+    1418350n 1.8
+    1418399n 1.8
+    1418400n 0
+    1418449n 0
+    1418450n 1.8
+    1418499n 1.8
+    1418500n 0
+    1418549n 0
+    1418550n 1.8
+    1418599n 1.8
+    1418600n 0
+    1418649n 0
+    1418650n 1.8
+    1418699n 1.8
+    1418700n 0
+    1418749n 0
+    1418750n 1.8
+    1418799n 1.8
+    1418800n 0
+    1418849n 0
+    1418850n 1.8
+    1418899n 1.8
+    1418900n 0
+    1418949n 0
+    1418950n 1.8
+    1418999n 1.8
+    1419000n 0
+    1419049n 0
+    1419050n 1.8
+    1419099n 1.8
+    1419100n 0
+    1419149n 0
+    1419150n 1.8
+    1419199n 1.8
+    1419200n 0
+    1419249n 0
+    1419250n 1.8
+    1419299n 1.8
+    1419300n 0
+    1419349n 0
+    1419350n 1.8
+    1419399n 1.8
+    1419400n 0
+    1419449n 0
+    1419450n 1.8
+    1419499n 1.8
+    1419500n 0
+    1419549n 0
+    1419550n 1.8
+    1419599n 1.8
+    1419600n 0
+    1419649n 0
+    1419650n 1.8
+    1419699n 1.8
+    1419700n 0
+    1419749n 0
+    1419750n 1.8
+    1419799n 1.8
+    1419800n 0
+    1419849n 0
+    1419850n 1.8
+    1419899n 1.8
+    1419900n 0
+    1419949n 0
+    1419950n 1.8
+    1419999n 1.8
+    1420000n 0
+    1420049n 0
+    1420050n 1.8
+    1420099n 1.8
+    1420100n 0
+    1420149n 0
+    1420150n 1.8
+    1420199n 1.8
+    1420200n 0
+    1420249n 0
+    1420250n 1.8
+    1420299n 1.8
+    1420300n 0
+    1420349n 0
+    1420350n 1.8
+    1420399n 1.8
+    1420400n 0
+    1420449n 0
+    1420450n 1.8
+    1420499n 1.8
+    1420500n 0
+    1420549n 0
+    1420550n 1.8
+    1420599n 1.8
+    1420600n 0
+    1420649n 0
+    1420650n 1.8
+    1420699n 1.8
+    1420700n 0
+    1420749n 0
+    1420750n 1.8
+    1420799n 1.8
+    1420800n 0
+    1420849n 0
+    1420850n 1.8
+    1420899n 1.8
+    1420900n 0
+    1420949n 0
+    1420950n 1.8
+    1420999n 1.8
+    1421000n 0
+    1421049n 0
+    1421050n 1.8
+    1421099n 1.8
+    1421100n 0
+    1421149n 0
+    1421150n 1.8
+    1421199n 1.8
+    1421200n 0
+    1421249n 0
+    1421250n 1.8
+    1421299n 1.8
+    1421300n 0
+    1421349n 0
+    1421350n 1.8
+    1421399n 1.8
+    1421400n 0
+    1421449n 0
+    1421450n 1.8
+    1421499n 1.8
+    1421500n 0
+    1421549n 0
+    1421550n 1.8
+    1421599n 1.8
+    1421600n 0
+    1421649n 0
+    1421650n 1.8
+    1421699n 1.8
+    1421700n 0
+    1421749n 0
+    1421750n 1.8
+    1421799n 1.8
+    1421800n 0
+    1421849n 0
+    1421850n 1.8
+    1421899n 1.8
+    1421900n 0
+    1421949n 0
+    1421950n 1.8
+    1421999n 1.8
+    1422000n 0
+    1422049n 0
+    1422050n 1.8
+    1422099n 1.8
+    1422100n 0
+    1422149n 0
+    1422150n 1.8
+    1422199n 1.8
+    1422200n 0
+    1422249n 0
+    1422250n 1.8
+    1422299n 1.8
+    1422300n 0
+    1422349n 0
+    1422350n 1.8
+    1422399n 1.8
+    1422400n 0
+    1422449n 0
+    1422450n 1.8
+    1422499n 1.8
+    1422500n 0
+    1422549n 0
+    1422550n 1.8
+    1422599n 1.8
+    1422600n 0
+    1422649n 0
+    1422650n 1.8
+    1422699n 1.8
+    1422700n 0
+    1422749n 0
+    1422750n 1.8
+    1422799n 1.8
+    1422800n 0
+    1422849n 0
+    1422850n 1.8
+    1422899n 1.8
+    1422900n 0
+    1422949n 0
+    1422950n 1.8
+    1422999n 1.8
+    1423000n 0
+    1423049n 0
+    1423050n 1.8
+    1423099n 1.8
+    1423100n 0
+    1423149n 0
+    1423150n 1.8
+    1423199n 1.8
+    1423200n 0
+    1423249n 0
+    1423250n 1.8
+    1423299n 1.8
+    1423300n 0
+    1423349n 0
+    1423350n 1.8
+    1423399n 1.8
+    1423400n 0
+    1423449n 0
+    1423450n 1.8
+    1423499n 1.8
+    1423500n 0
+    1423549n 0
+    1423550n 1.8
+    1423599n 1.8
+    1423600n 0
+    1423649n 0
+    1423650n 1.8
+    1423699n 1.8
+    1423700n 0
+    1423749n 0
+    1423750n 1.8
+    1423799n 1.8
+    1423800n 0
+    1423849n 0
+    1423850n 1.8
+    1423899n 1.8
+    1423900n 0
+    1423949n 0
+    1423950n 1.8
+    1423999n 1.8
+    1424000n 0
+    1424049n 0
+    1424050n 1.8
+    1424099n 1.8
+    1424100n 0
+    1424149n 0
+    1424150n 1.8
+    1424199n 1.8
+    1424200n 0
+    1424249n 0
+    1424250n 1.8
+    1424299n 1.8
+    1424300n 0
+    1424349n 0
+    1424350n 1.8
+    1424399n 1.8
+    1424400n 0
+    1424449n 0
+    1424450n 1.8
+    1424499n 1.8
+    1424500n 0
+    1424549n 0
+    1424550n 1.8
+    1424599n 1.8
+    1424600n 0
+    1424649n 0
+    1424650n 1.8
+    1424699n 1.8
+    1424700n 0
+    1424749n 0
+    1424750n 1.8
+    1424799n 1.8
+    1424800n 0
+    1424849n 0
+    1424850n 1.8
+    1424899n 1.8
+    1424900n 0
+    1424949n 0
+    1424950n 1.8
+    1424999n 1.8
+    1425000n 0
+    1425049n 0
+    1425050n 1.8
+    1425099n 1.8
+    1425100n 0
+    1425149n 0
+    1425150n 1.8
+    1425199n 1.8
+    1425200n 0
+    1425249n 0
+    1425250n 1.8
+    1425299n 1.8
+    1425300n 0
+    1425349n 0
+    1425350n 1.8
+    1425399n 1.8
+    1425400n 0
+    1425449n 0
+    1425450n 1.8
+    1425499n 1.8
+    1425500n 0
+    1425549n 0
+    1425550n 1.8
+    1425599n 1.8
+    1425600n 0
+    1425649n 0
+    1425650n 1.8
+    1425699n 1.8
+    1425700n 0
+    1425749n 0
+    1425750n 1.8
+    1425799n 1.8
+    1425800n 0
+    1425849n 0
+    1425850n 1.8
+    1425899n 1.8
+    1425900n 0
+    1425949n 0
+    1425950n 1.8
+    1425999n 1.8
+    1426000n 0
+    1426049n 0
+    1426050n 1.8
+    1426099n 1.8
+    1426100n 0
+    1426149n 0
+    1426150n 1.8
+    1426199n 1.8
+    1426200n 0
+    1426249n 0
+    1426250n 1.8
+    1426299n 1.8
+    1426300n 0
+    1426349n 0
+    1426350n 1.8
+    1426399n 1.8
+    1426400n 0
+    1426449n 0
+    1426450n 1.8
+    1426499n 1.8
+    1426500n 0
+    1426549n 0
+    1426550n 1.8
+    1426599n 1.8
+    1426600n 0
+    1426649n 0
+    1426650n 1.8
+    1426699n 1.8
+    1426700n 0
+    1426749n 0
+    1426750n 1.8
+    1426799n 1.8
+    1426800n 0
+    1426849n 0
+    1426850n 1.8
+    1426899n 1.8
+    1426900n 0
+    1426949n 0
+    1426950n 1.8
+    1426999n 1.8
+    1427000n 0
+    1427049n 0
+    1427050n 1.8
+    1427099n 1.8
+    1427100n 0
+    1427149n 0
+    1427150n 1.8
+    1427199n 1.8
+    1427200n 0
+    1427249n 0
+    1427250n 1.8
+    1427299n 1.8
+    1427300n 0
+    1427349n 0
+    1427350n 1.8
+    1427399n 1.8
+    1427400n 0
+    1427449n 0
+    1427450n 1.8
+    1427499n 1.8
+    1427500n 0
+    1427549n 0
+    1427550n 1.8
+    1427599n 1.8
+    1427600n 0
+    1427649n 0
+    1427650n 1.8
+    1427699n 1.8
+    1427700n 0
+    1427749n 0
+    1427750n 1.8
+    1427799n 1.8
+    1427800n 0
+    1427849n 0
+    1427850n 1.8
+    1427899n 1.8
+    1427900n 0
+    1427949n 0
+    1427950n 1.8
+    1427999n 1.8
+    1428000n 0
+    1428049n 0
+    1428050n 1.8
+    1428099n 1.8
+    1428100n 0
+    1428149n 0
+    1428150n 1.8
+    1428199n 1.8
+    1428200n 0
+    1428249n 0
+    1428250n 1.8
+    1428299n 1.8
+    1428300n 0
+    1428349n 0
+    1428350n 1.8
+    1428399n 1.8
+    1428400n 0
+    1428449n 0
+    1428450n 1.8
+    1428499n 1.8
+    1428500n 0
+    1428549n 0
+    1428550n 1.8
+    1428599n 1.8
+    1428600n 0
+    1428649n 0
+    1428650n 1.8
+    1428699n 1.8
+    1428700n 0
+    1428749n 0
+    1428750n 1.8
+    1428799n 1.8
+    1428800n 0
+    1428849n 0
+    1428850n 1.8
+    1428899n 1.8
+    1428900n 0
+    1428949n 0
+    1428950n 1.8
+    1428999n 1.8
+    1429000n 0
+    1429049n 0
+    1429050n 1.8
+    1429099n 1.8
+    1429100n 0
+    1429149n 0
+    1429150n 1.8
+    1429199n 1.8
+    1429200n 0
+    1429249n 0
+    1429250n 1.8
+    1429299n 1.8
+    1429300n 0
+    1429349n 0
+    1429350n 1.8
+    1429399n 1.8
+    1429400n 0
+    1429449n 0
+    1429450n 1.8
+    1429499n 1.8
+    1429500n 0
+    1429549n 0
+    1429550n 1.8
+    1429599n 1.8
+    1429600n 0
+    1429649n 0
+    1429650n 1.8
+    1429699n 1.8
+    1429700n 0
+    1429749n 0
+    1429750n 1.8
+    1429799n 1.8
+    1429800n 0
+    1429849n 0
+    1429850n 1.8
+    1429899n 1.8
+    1429900n 0
+    1429949n 0
+    1429950n 1.8
+    1429999n 1.8
+    1430000n 0
+    1430049n 0
+    1430050n 1.8
+    1430099n 1.8
+    1430100n 0
+    1430149n 0
+    1430150n 1.8
+    1430199n 1.8
+    1430200n 0
+    1430249n 0
+    1430250n 1.8
+    1430299n 1.8
+    1430300n 0
+    1430349n 0
+    1430350n 1.8
+    1430399n 1.8
+    1430400n 0
+    1430449n 0
+    1430450n 1.8
+    1430499n 1.8
+    1430500n 0
+    1430549n 0
+    1430550n 1.8
+    1430599n 1.8
+    1430600n 0
+    1430649n 0
+    1430650n 1.8
+    1430699n 1.8
+    1430700n 0
+    1430749n 0
+    1430750n 1.8
+    1430799n 1.8
+    1430800n 0
+    1430849n 0
+    1430850n 1.8
+    1430899n 1.8
+    1430900n 0
+    1430949n 0
+    1430950n 1.8
+    1430999n 1.8
+    1431000n 0
+    1431049n 0
+    1431050n 1.8
+    1431099n 1.8
+    1431100n 0
+    1431149n 0
+    1431150n 1.8
+    1431199n 1.8
+    1431200n 0
+    1431249n 0
+    1431250n 1.8
+    1431299n 1.8
+    1431300n 0
+    1431349n 0
+    1431350n 1.8
+    1431399n 1.8
+    1431400n 0
+    1431449n 0
+    1431450n 1.8
+    1431499n 1.8
+    1431500n 0
+    1431549n 0
+    1431550n 1.8
+    1431599n 1.8
+    1431600n 0
+    1431649n 0
+    1431650n 1.8
+    1431699n 1.8
+    1431700n 0
+    1431749n 0
+    1431750n 1.8
+    1431799n 1.8
+    1431800n 0
+    1431849n 0
+    1431850n 1.8
+    1431899n 1.8
+    1431900n 0
+    1431949n 0
+    1431950n 1.8
+    1431999n 1.8
+    1432000n 0
+    1432049n 0
+    1432050n 1.8
+    1432099n 1.8
+    1432100n 0
+    1432149n 0
+    1432150n 1.8
+    1432199n 1.8
+    1432200n 0
+    1432249n 0
+    1432250n 1.8
+    1432299n 1.8
+    1432300n 0
+    1432349n 0
+    1432350n 1.8
+    1432399n 1.8
+    1432400n 0
+    1432449n 0
+    1432450n 1.8
+    1432499n 1.8
+    1432500n 0
+    1432549n 0
+    1432550n 1.8
+    1432599n 1.8
+    1432600n 0
+    1432649n 0
+    1432650n 1.8
+    1432699n 1.8
+    1432700n 0
+    1432749n 0
+    1432750n 1.8
+    1432799n 1.8
+    1432800n 0
+    1432849n 0
+    1432850n 1.8
+    1432899n 1.8
+    1432900n 0
+    1432949n 0
+    1432950n 1.8
+    1432999n 1.8
+    1433000n 0
+    1433049n 0
+    1433050n 1.8
+    1433099n 1.8
+    1433100n 0
+    1433149n 0
+    1433150n 1.8
+    1433199n 1.8
+    1433200n 0
+    1433249n 0
+    1433250n 1.8
+    1433299n 1.8
+    1433300n 0
+    1433349n 0
+    1433350n 1.8
+    1433399n 1.8
+    1433400n 0
+    1433449n 0
+    1433450n 1.8
+    1433499n 1.8
+    1433500n 0
+    1433549n 0
+    1433550n 1.8
+    1433599n 1.8
+    1433600n 0
+    1433649n 0
+    1433650n 1.8
+    1433699n 1.8
+    1433700n 0
+    1433749n 0
+    1433750n 1.8
+    1433799n 1.8
+    1433800n 0
+    1433849n 0
+    1433850n 1.8
+    1433899n 1.8
+    1433900n 0
+    1433949n 0
+    1433950n 1.8
+    1433999n 1.8
+    1434000n 0
+    1434049n 0
+    1434050n 1.8
+    1434099n 1.8
+    1434100n 0
+    1434149n 0
+    1434150n 1.8
+    1434199n 1.8
+    1434200n 0
+    1434249n 0
+    1434250n 1.8
+    1434299n 1.8
+    1434300n 0
+    1434349n 0
+    1434350n 1.8
+    1434399n 1.8
+    1434400n 0
+    1434449n 0
+    1434450n 1.8
+    1434499n 1.8
+    1434500n 0
+    1434549n 0
+    1434550n 1.8
+    1434599n 1.8
+    1434600n 0
+    1434649n 0
+    1434650n 1.8
+    1434699n 1.8
+    1434700n 0
+    1434749n 0
+    1434750n 1.8
+    1434799n 1.8
+    1434800n 0
+    1434849n 0
+    1434850n 1.8
+    1434899n 1.8
+    1434900n 0
+    1434949n 0
+    1434950n 1.8
+    1434999n 1.8
+    1435000n 0
+    1435049n 0
+    1435050n 1.8
+    1435099n 1.8
+    1435100n 0
+    1435149n 0
+    1435150n 1.8
+    1435199n 1.8
+    1435200n 0
+    1435249n 0
+    1435250n 1.8
+    1435299n 1.8
+    1435300n 0
+    1435349n 0
+    1435350n 1.8
+    1435399n 1.8
+    1435400n 0
+    1435449n 0
+    1435450n 1.8
+    1435499n 1.8
+    1435500n 0
+    1435549n 0
+    1435550n 1.8
+    1435599n 1.8
+    1435600n 0
+    1435649n 0
+    1435650n 1.8
+    1435699n 1.8
+    1435700n 0
+    1435749n 0
+    1435750n 1.8
+    1435799n 1.8
+    1435800n 0
+    1435849n 0
+    1435850n 1.8
+    1435899n 1.8
+    1435900n 0
+    1435949n 0
+    1435950n 1.8
+    1435999n 1.8
+    1436000n 0
+    1436049n 0
+    1436050n 1.8
+    1436099n 1.8
+    1436100n 0
+    1436149n 0
+    1436150n 1.8
+    1436199n 1.8
+    1436200n 0
+    1436249n 0
+    1436250n 1.8
+    1436299n 1.8
+    1436300n 0
+    1436349n 0
+    1436350n 1.8
+    1436399n 1.8
+    1436400n 0
+    1436449n 0
+    1436450n 1.8
+    1436499n 1.8
+    1436500n 0
+    1436549n 0
+    1436550n 1.8
+    1436599n 1.8
+    1436600n 0
+    1436649n 0
+    1436650n 1.8
+    1436699n 1.8
+    1436700n 0
+    1436749n 0
+    1436750n 1.8
+    1436799n 1.8
+    1436800n 0
+    1436849n 0
+    1436850n 1.8
+    1436899n 1.8
+    1436900n 0
+    1436949n 0
+    1436950n 1.8
+    1436999n 1.8
+    1437000n 0
+    1437049n 0
+    1437050n 1.8
+    1437099n 1.8
+    1437100n 0
+    1437149n 0
+    1437150n 1.8
+    1437199n 1.8
+    1437200n 0
+    1437249n 0
+    1437250n 1.8
+    1437299n 1.8
+    1437300n 0
+    1437349n 0
+    1437350n 1.8
+    1437399n 1.8
+    1437400n 0
+    1437449n 0
+    1437450n 1.8
+    1437499n 1.8
+    1437500n 0
+    1437549n 0
+    1437550n 1.8
+    1437599n 1.8
+    1437600n 0
+    1437649n 0
+    1437650n 1.8
+    1437699n 1.8
+    1437700n 0
+    1437749n 0
+    1437750n 1.8
+    1437799n 1.8
+    1437800n 0
+    1437849n 0
+    1437850n 1.8
+    1437899n 1.8
+    1437900n 0
+    1437949n 0
+    1437950n 1.8
+    1437999n 1.8
+    1438000n 0
+    1438049n 0
+    1438050n 1.8
+    1438099n 1.8
+    1438100n 0
+    1438149n 0
+    1438150n 1.8
+    1438199n 1.8
+    1438200n 0
+    1438249n 0
+    1438250n 1.8
+    1438299n 1.8
+    1438300n 0
+    1438349n 0
+    1438350n 1.8
+    1438399n 1.8
+    1438400n 0
+    1438449n 0
+    1438450n 1.8
+    1438499n 1.8
+    1438500n 0
+    1438549n 0
+    1438550n 1.8
+    1438599n 1.8
+    1438600n 0
+    1438649n 0
+    1438650n 1.8
+    1438699n 1.8
+    1438700n 0
+    1438749n 0
+    1438750n 1.8
+    1438799n 1.8
+    1438800n 0
+    1438849n 0
+    1438850n 1.8
+    1438899n 1.8
+    1438900n 0
+    1438949n 0
+    1438950n 1.8
+    1438999n 1.8
+    1439000n 0
+    1439049n 0
+    1439050n 1.8
+    1439099n 1.8
+    1439100n 0
+    1439149n 0
+    1439150n 1.8
+    1439199n 1.8
+    1439200n 0
+    1439249n 0
+    1439250n 1.8
+    1439299n 1.8
+    1439300n 0
+    1439349n 0
+    1439350n 1.8
+    1439399n 1.8
+    1439400n 0
+    1439449n 0
+    1439450n 1.8
+    1439499n 1.8
+    1439500n 0
+    1439549n 0
+    1439550n 1.8
+    1439599n 1.8
+    1439600n 0
+    1439649n 0
+    1439650n 1.8
+    1439699n 1.8
+    1439700n 0
+    1439749n 0
+    1439750n 1.8
+    1439799n 1.8
+    1439800n 0
+    1439849n 0
+    1439850n 1.8
+    1439899n 1.8
+    1439900n 0
+    1439949n 0
+    1439950n 1.8
+    1439999n 1.8
+    1440000n 0
+    1440049n 0
+    1440050n 1.8
+    1440099n 1.8
+    1440100n 0
+    1440149n 0
+    1440150n 1.8
+    1440199n 1.8
+    1440200n 0
+    1440249n 0
+    1440250n 1.8
+    1440299n 1.8
+    1440300n 0
+    1440349n 0
+    1440350n 1.8
+    1440399n 1.8
+    1440400n 0
+    1440449n 0
+    1440450n 1.8
+    1440499n 1.8
+    1440500n 0
+    1440549n 0
+    1440550n 1.8
+    1440599n 1.8
+    1440600n 0
+    1440649n 0
+    1440650n 1.8
+    1440699n 1.8
+    1440700n 0
+    1440749n 0
+    1440750n 1.8
+    1440799n 1.8
+    1440800n 0
+    1440849n 0
+    1440850n 1.8
+    1440899n 1.8
+    1440900n 0
+    1440949n 0
+    1440950n 1.8
+    1440999n 1.8
+    1441000n 0
+    1441049n 0
+    1441050n 1.8
+    1441099n 1.8
+    1441100n 0
+    1441149n 0
+    1441150n 1.8
+    1441199n 1.8
+    1441200n 0
+    1441249n 0
+    1441250n 1.8
+    1441299n 1.8
+    1441300n 0
+    1441349n 0
+    1441350n 1.8
+    1441399n 1.8
+    1441400n 0
+    1441449n 0
+    1441450n 1.8
+    1441499n 1.8
+    1441500n 0
+    1441549n 0
+    1441550n 1.8
+    1441599n 1.8
+    1441600n 0
+    1441649n 0
+    1441650n 1.8
+    1441699n 1.8
+    1441700n 0
+    1441749n 0
+    1441750n 1.8
+    1441799n 1.8
+    1441800n 0
+    1441849n 0
+    1441850n 1.8
+    1441899n 1.8
+    1441900n 0
+    1441949n 0
+    1441950n 1.8
+    1441999n 1.8
+    1442000n 0
+    1442049n 0
+    1442050n 1.8
+    1442099n 1.8
+    1442100n 0
+    1442149n 0
+    1442150n 1.8
+    1442199n 1.8
+    1442200n 0
+    1442249n 0
+    1442250n 1.8
+    1442299n 1.8
+    1442300n 0
+    1442349n 0
+    1442350n 1.8
+    1442399n 1.8
+    1442400n 0
+    1442449n 0
+    1442450n 1.8
+    1442499n 1.8
+    1442500n 0
+    1442549n 0
+    1442550n 1.8
+    1442599n 1.8
+    1442600n 0
+    1442649n 0
+    1442650n 1.8
+    1442699n 1.8
+    1442700n 0
+    1442749n 0
+    1442750n 1.8
+    1442799n 1.8
+    1442800n 0
+    1442849n 0
+    1442850n 1.8
+    1442899n 1.8
+    1442900n 0
+    1442949n 0
+    1442950n 1.8
+    1442999n 1.8
+    1443000n 0
+    1443049n 0
+    1443050n 1.8
+    1443099n 1.8
+    1443100n 0
+    1443149n 0
+    1443150n 1.8
+    1443199n 1.8
+    1443200n 0
+    1443249n 0
+    1443250n 1.8
+    1443299n 1.8
+    1443300n 0
+    1443349n 0
+    1443350n 1.8
+    1443399n 1.8
+    1443400n 0
+    1443449n 0
+    1443450n 1.8
+    1443499n 1.8
+    1443500n 0
+    1443549n 0
+    1443550n 1.8
+    1443599n 1.8
+    1443600n 0
+    1443649n 0
+    1443650n 1.8
+    1443699n 1.8
+    1443700n 0
+    1443749n 0
+    1443750n 1.8
+    1443799n 1.8
+    1443800n 0
+    1443849n 0
+    1443850n 1.8
+    1443899n 1.8
+    1443900n 0
+    1443949n 0
+    1443950n 1.8
+    1443999n 1.8
+    1444000n 0
+    1444049n 0
+    1444050n 1.8
+    1444099n 1.8
+    1444100n 0
+    1444149n 0
+    1444150n 1.8
+    1444199n 1.8
+    1444200n 0
+    1444249n 0
+    1444250n 1.8
+    1444299n 1.8
+    1444300n 0
+    1444349n 0
+    1444350n 1.8
+    1444399n 1.8
+    1444400n 0
+    1444449n 0
+    1444450n 1.8
+    1444499n 1.8
+    1444500n 0
+    1444549n 0
+    1444550n 1.8
+    1444599n 1.8
+    1444600n 0
+    1444649n 0
+    1444650n 1.8
+    1444699n 1.8
+    1444700n 0
+    1444749n 0
+    1444750n 1.8
+    1444799n 1.8
+    1444800n 0
+    1444849n 0
+    1444850n 1.8
+    1444899n 1.8
+    1444900n 0
+    1444949n 0
+    1444950n 1.8
+    1444999n 1.8
+    1445000n 0
+    1445049n 0
+    1445050n 1.8
+    1445099n 1.8
+    1445100n 0
+    1445149n 0
+    1445150n 1.8
+    1445199n 1.8
+    1445200n 0
+    1445249n 0
+    1445250n 1.8
+    1445299n 1.8
+    1445300n 0
+    1445349n 0
+    1445350n 1.8
+    1445399n 1.8
+    1445400n 0
+    1445449n 0
+    1445450n 1.8
+    1445499n 1.8
+    1445500n 0
+    1445549n 0
+    1445550n 1.8
+    1445599n 1.8
+    1445600n 0
+    1445649n 0
+    1445650n 1.8
+    1445699n 1.8
+    1445700n 0
+    1445749n 0
+    1445750n 1.8
+    1445799n 1.8
+    1445800n 0
+    1445849n 0
+    1445850n 1.8
+    1445899n 1.8
+    1445900n 0
+    1445949n 0
+    1445950n 1.8
+    1445999n 1.8
+    1446000n 0
+    1446049n 0
+    1446050n 1.8
+    1446099n 1.8
+    1446100n 0
+    1446149n 0
+    1446150n 1.8
+    1446199n 1.8
+    1446200n 0
+    1446249n 0
+    1446250n 1.8
+    1446299n 1.8
+    1446300n 0
+    1446349n 0
+    1446350n 1.8
+    1446399n 1.8
+    1446400n 0
+    1446449n 0
+    1446450n 1.8
+    1446499n 1.8
+    1446500n 0
+    1446549n 0
+    1446550n 1.8
+    1446599n 1.8
+    1446600n 0
+    1446649n 0
+    1446650n 1.8
+    1446699n 1.8
+    1446700n 0
+    1446749n 0
+    1446750n 1.8
+    1446799n 1.8
+    1446800n 0
+    1446849n 0
+    1446850n 1.8
+    1446899n 1.8
+    1446900n 0
+    1446949n 0
+    1446950n 1.8
+    1446999n 1.8
+    1447000n 0
+    1447049n 0
+    1447050n 1.8
+    1447099n 1.8
+    1447100n 0
+    1447149n 0
+    1447150n 1.8
+    1447199n 1.8
+    1447200n 0
+    1447249n 0
+    1447250n 1.8
+    1447299n 1.8
+    1447300n 0
+    1447349n 0
+    1447350n 1.8
+    1447399n 1.8
+    1447400n 0
+    1447449n 0
+    1447450n 1.8
+    1447499n 1.8
+    1447500n 0
+    1447549n 0
+    1447550n 1.8
+    1447599n 1.8
+    1447600n 0
+    1447649n 0
+    1447650n 1.8
+    1447699n 1.8
+    1447700n 0
+    1447749n 0
+    1447750n 1.8
+    1447799n 1.8
+    1447800n 0
+    1447849n 0
+    1447850n 1.8
+    1447899n 1.8
+    1447900n 0
+    1447949n 0
+    1447950n 1.8
+    1447999n 1.8
+    1448000n 0
+    1448049n 0
+    1448050n 1.8
+    1448099n 1.8
+    1448100n 0
+    1448149n 0
+    1448150n 1.8
+    1448199n 1.8
+    1448200n 0
+    1448249n 0
+    1448250n 1.8
+    1448299n 1.8
+    1448300n 0
+    1448349n 0
+    1448350n 1.8
+    1448399n 1.8
+    1448400n 0
+    1448449n 0
+    1448450n 1.8
+    1448499n 1.8
+    1448500n 0
+    1448549n 0
+    1448550n 1.8
+    1448599n 1.8
+    1448600n 0
+    1448649n 0
+    1448650n 1.8
+    1448699n 1.8
+    1448700n 0
+    1448749n 0
+    1448750n 1.8
+    1448799n 1.8
+    1448800n 0
+    1448849n 0
+    1448850n 1.8
+    1448899n 1.8
+    1448900n 0
+    1448949n 0
+    1448950n 1.8
+    1448999n 1.8
+    1449000n 0
+    1449049n 0
+    1449050n 1.8
+    1449099n 1.8
+    1449100n 0
+    1449149n 0
+    1449150n 1.8
+    1449199n 1.8
+    1449200n 0
+    1449249n 0
+    1449250n 1.8
+    1449299n 1.8
+    1449300n 0
+    1449349n 0
+    1449350n 1.8
+    1449399n 1.8
+    1449400n 0
+    1449449n 0
+    1449450n 1.8
+    1449499n 1.8
+    1449500n 0
+    1449549n 0
+    1449550n 1.8
+    1449599n 1.8
+    1449600n 0
+    1449649n 0
+    1449650n 1.8
+    1449699n 1.8
+    1449700n 0
+    1449749n 0
+    1449750n 1.8
+    1449799n 1.8
+    1449800n 0
+    1449849n 0
+    1449850n 1.8
+    1449899n 1.8
+    1449900n 0
+    1449949n 0
+    1449950n 1.8
+    1449999n 1.8
+    1450000n 0
+    1450049n 0
+    1450050n 1.8
+    1450099n 1.8
+    1450100n 0
+    1450149n 0
+    1450150n 1.8
+    1450199n 1.8
+    1450200n 0
+    1450249n 0
+    1450250n 1.8
+    1450299n 1.8
+    1450300n 0
+    1450349n 0
+    1450350n 1.8
+    1450399n 1.8
+    1450400n 0
+    1450449n 0
+    1450450n 1.8
+    1450499n 1.8
+    1450500n 0
+    1450549n 0
+    1450550n 1.8
+    1450599n 1.8
+    1450600n 0
+    1450649n 0
+    1450650n 1.8
+    1450699n 1.8
+    1450700n 0
+    1450749n 0
+    1450750n 1.8
+    1450799n 1.8
+    1450800n 0
+    1450849n 0
+    1450850n 1.8
+    1450899n 1.8
+    1450900n 0
+    1450949n 0
+    1450950n 1.8
+    1450999n 1.8
+    1451000n 0
+    1451049n 0
+    1451050n 1.8
+    1451099n 1.8
+    1451100n 0
+    1451149n 0
+    1451150n 1.8
+    1451199n 1.8
+    1451200n 0
+    1451249n 0
+    1451250n 1.8
+    1451299n 1.8
+    1451300n 0
+    1451349n 0
+    1451350n 1.8
+    1451399n 1.8
+    1451400n 0
+    1451449n 0
+    1451450n 1.8
+    1451499n 1.8
+    1451500n 0
+    1451549n 0
+    1451550n 1.8
+    1451599n 1.8
+    1451600n 0
+    1451649n 0
+    1451650n 1.8
+    1451699n 1.8
+    1451700n 0
+    1451749n 0
+    1451750n 1.8
+    1451799n 1.8
+    1451800n 0
+    1451849n 0
+    1451850n 1.8
+    1451899n 1.8
+    1451900n 0
+    1451949n 0
+    1451950n 1.8
+    1451999n 1.8
+    1452000n 0
+    1452049n 0
+    1452050n 1.8
+    1452099n 1.8
+    1452100n 0
+    1452149n 0
+    1452150n 1.8
+    1452199n 1.8
+    1452200n 0
+    1452249n 0
+    1452250n 1.8
+    1452299n 1.8
+    1452300n 0
+    1452349n 0
+    1452350n 1.8
+    1452399n 1.8
+    1452400n 0
+    1452449n 0
+    1452450n 1.8
+    1452499n 1.8
+    1452500n 0
+    1452549n 0
+    1452550n 1.8
+    1452599n 1.8
+    1452600n 0
+    1452649n 0
+    1452650n 1.8
+    1452699n 1.8
+    1452700n 0
+    1452749n 0
+    1452750n 1.8
+    1452799n 1.8
+    1452800n 0
+    1452849n 0
+    1452850n 1.8
+    1452899n 1.8
+    1452900n 0
+    1452949n 0
+    1452950n 1.8
+    1452999n 1.8
+    1453000n 0
+    1453049n 0
+    1453050n 1.8
+    1453099n 1.8
+    1453100n 0
+    1453149n 0
+    1453150n 1.8
+    1453199n 1.8
+    1453200n 0
+    1453249n 0
+    1453250n 1.8
+    1453299n 1.8
+    1453300n 0
+    1453349n 0
+    1453350n 1.8
+    1453399n 1.8
+    1453400n 0
+    1453449n 0
+    1453450n 1.8
+    1453499n 1.8
+    1453500n 0
+    1453549n 0
+    1453550n 1.8
+    1453599n 1.8
+    1453600n 0
+    1453649n 0
+    1453650n 1.8
+    1453699n 1.8
+    1453700n 0
+    1453749n 0
+    1453750n 1.8
+    1453799n 1.8
+    1453800n 0
+    1453849n 0
+    1453850n 1.8
+    1453899n 1.8
+    1453900n 0
+    1453949n 0
+    1453950n 1.8
+    1453999n 1.8
+    1454000n 0
+    1454049n 0
+    1454050n 1.8
+    1454099n 1.8
+    1454100n 0
+    1454149n 0
+    1454150n 1.8
+    1454199n 1.8
+    1454200n 0
+    1454249n 0
+    1454250n 1.8
+    1454299n 1.8
+    1454300n 0
+    1454349n 0
+    1454350n 1.8
+    1454399n 1.8
+    1454400n 0
+    1454449n 0
+    1454450n 1.8
+    1454499n 1.8
+    1454500n 0
+    1454549n 0
+    1454550n 1.8
+    1454599n 1.8
+    1454600n 0
+    1454649n 0
+    1454650n 1.8
+    1454699n 1.8
+    1454700n 0
+    1454749n 0
+    1454750n 1.8
+    1454799n 1.8
+    1454800n 0
+    1454849n 0
+    1454850n 1.8
+    1454899n 1.8
+    1454900n 0
+    1454949n 0
+    1454950n 1.8
+    1454999n 1.8
+    1455000n 0
+    1455049n 0
+    1455050n 1.8
+    1455099n 1.8
+    1455100n 0
+    1455149n 0
+    1455150n 1.8
+    1455199n 1.8
+    1455200n 0
+    1455249n 0
+    1455250n 1.8
+    1455299n 1.8
+    1455300n 0
+    1455349n 0
+    1455350n 1.8
+    1455399n 1.8
+    1455400n 0
+    1455449n 0
+    1455450n 1.8
+    1455499n 1.8
+    1455500n 0
+    1455549n 0
+    1455550n 1.8
+    1455599n 1.8
+    1455600n 0
+    1455649n 0
+    1455650n 1.8
+    1455699n 1.8
+    1455700n 0
+    1455749n 0
+    1455750n 1.8
+    1455799n 1.8
+    1455800n 0
+    1455849n 0
+    1455850n 1.8
+    1455899n 1.8
+    1455900n 0
+    1455949n 0
+    1455950n 1.8
+    1455999n 1.8
+    1456000n 0
+    1456049n 0
+    1456050n 1.8
+    1456099n 1.8
+    1456100n 0
+    1456149n 0
+    1456150n 1.8
+    1456199n 1.8
+    1456200n 0
+    1456249n 0
+    1456250n 1.8
+    1456299n 1.8
+    1456300n 0
+    1456349n 0
+    1456350n 1.8
+    1456399n 1.8
+    1456400n 0
+    1456449n 0
+    1456450n 1.8
+    1456499n 1.8
+    1456500n 0
+    1456549n 0
+    1456550n 1.8
+    1456599n 1.8
+    1456600n 0
+    1456649n 0
+    1456650n 1.8
+    1456699n 1.8
+    1456700n 0
+    1456749n 0
+    1456750n 1.8
+    1456799n 1.8
+    1456800n 0
+    1456849n 0
+    1456850n 1.8
+    1456899n 1.8
+    1456900n 0
+    1456949n 0
+    1456950n 1.8
+    1456999n 1.8
+    1457000n 0
+    1457049n 0
+    1457050n 1.8
+    1457099n 1.8
+    1457100n 0
+    1457149n 0
+    1457150n 1.8
+    1457199n 1.8
+    1457200n 0
+    1457249n 0
+    1457250n 1.8
+    1457299n 1.8
+    1457300n 0
+    1457349n 0
+    1457350n 1.8
+    1457399n 1.8
+    1457400n 0
+    1457449n 0
+    1457450n 1.8
+    1457499n 1.8
+    1457500n 0
+    1457549n 0
+    1457550n 1.8
+    1457599n 1.8
+    1457600n 0
+    1457649n 0
+    1457650n 1.8
+    1457699n 1.8
+    1457700n 0
+    1457749n 0
+    1457750n 1.8
+    1457799n 1.8
+    1457800n 0
+    1457849n 0
+    1457850n 1.8
+    1457899n 1.8
+    1457900n 0
+    1457949n 0
+    1457950n 1.8
+    1457999n 1.8
+    1458000n 0
+    1458049n 0
+    1458050n 1.8
+    1458099n 1.8
+    1458100n 0
+    1458149n 0
+    1458150n 1.8
+    1458199n 1.8
+    1458200n 0
+    1458249n 0
+    1458250n 1.8
+    1458299n 1.8
+    1458300n 0
+    1458349n 0
+    1458350n 1.8
+    1458399n 1.8
+    1458400n 0
+    1458449n 0
+    1458450n 1.8
+    1458499n 1.8
+    1458500n 0
+    1458549n 0
+    1458550n 1.8
+    1458599n 1.8
+    1458600n 0
+    1458649n 0
+    1458650n 1.8
+    1458699n 1.8
+    1458700n 0
+    1458749n 0
+    1458750n 1.8
+    1458799n 1.8
+    1458800n 0
+    1458849n 0
+    1458850n 1.8
+    1458899n 1.8
+    1458900n 0
+    1458949n 0
+    1458950n 1.8
+    1458999n 1.8
+    1459000n 0
+    1459049n 0
+    1459050n 1.8
+    1459099n 1.8
+    1459100n 0
+    1459149n 0
+    1459150n 1.8
+    1459199n 1.8
+    1459200n 0
+    1459249n 0
+    1459250n 1.8
+    1459299n 1.8
+    1459300n 0
+    1459349n 0
+    1459350n 1.8
+    1459399n 1.8
+    1459400n 0
+    1459449n 0
+    1459450n 1.8
+    1459499n 1.8
+    1459500n 0
+    1459549n 0
+    1459550n 1.8
+    1459599n 1.8
+    1459600n 0
+    1459649n 0
+    1459650n 1.8
+    1459699n 1.8
+    1459700n 0
+    1459749n 0
+    1459750n 1.8
+    1459799n 1.8
+    1459800n 0
+    1459849n 0
+    1459850n 1.8
+    1459899n 1.8
+    1459900n 0
+    1459949n 0
+    1459950n 1.8
+    1459999n 1.8
+    1460000n 0
+    1460049n 0
+    1460050n 1.8
+    1460099n 1.8
+    1460100n 0
+    1460149n 0
+    1460150n 1.8
+    1460199n 1.8
+    1460200n 0
+    1460249n 0
+    1460250n 1.8
+    1460299n 1.8
+    1460300n 0
+    1460349n 0
+    1460350n 1.8
+    1460399n 1.8
+    1460400n 0
+    1460449n 0
+    1460450n 1.8
+    1460499n 1.8
+    1460500n 0
+    1460549n 0
+    1460550n 1.8
+    1460599n 1.8
+    1460600n 0
+    1460649n 0
+    1460650n 1.8
+    1460699n 1.8
+    1460700n 0
+    1460749n 0
+    1460750n 1.8
+    1460799n 1.8
+    1460800n 0
+    1460849n 0
+    1460850n 1.8
+    1460899n 1.8
+    1460900n 0
+    1460949n 0
+    1460950n 1.8
+    1460999n 1.8
+    1461000n 0
+    1461049n 0
+    1461050n 1.8
+    1461099n 1.8
+    1461100n 0
+    1461149n 0
+    1461150n 1.8
+    1461199n 1.8
+    1461200n 0
+    1461249n 0
+    1461250n 1.8
+    1461299n 1.8
+    1461300n 0
+    1461349n 0
+    1461350n 1.8
+    1461399n 1.8
+    1461400n 0
+    1461449n 0
+    1461450n 1.8
+    1461499n 1.8
+    1461500n 0
+    1461549n 0
+    1461550n 1.8
+    1461599n 1.8
+    1461600n 0
+    1461649n 0
+    1461650n 1.8
+    1461699n 1.8
+    1461700n 0
+    1461749n 0
+    1461750n 1.8
+    1461799n 1.8
+    1461800n 0
+    1461849n 0
+    1461850n 1.8
+    1461899n 1.8
+    1461900n 0
+    1461949n 0
+    1461950n 1.8
+    1461999n 1.8
+    1462000n 0
+    1462049n 0
+    1462050n 1.8
+    1462099n 1.8
+    1462100n 0
+    1462149n 0
+    1462150n 1.8
+    1462199n 1.8
+    1462200n 0
+    1462249n 0
+    1462250n 1.8
+    1462299n 1.8
+    1462300n 0
+    1462349n 0
+    1462350n 1.8
+    1462399n 1.8
+    1462400n 0
+    1462449n 0
+    1462450n 1.8
+    1462499n 1.8
+    1462500n 0
+    1462549n 0
+    1462550n 1.8
+    1462599n 1.8
+    1462600n 0
+    1462649n 0
+    1462650n 1.8
+    1462699n 1.8
+    1462700n 0
+    1462749n 0
+    1462750n 1.8
+    1462799n 1.8
+    1462800n 0
+    1462849n 0
+    1462850n 1.8
+    1462899n 1.8
+    1462900n 0
+    1462949n 0
+    1462950n 1.8
+    1462999n 1.8
+    1463000n 0
+    1463049n 0
+    1463050n 1.8
+    1463099n 1.8
+    1463100n 0
+    1463149n 0
+    1463150n 1.8
+    1463199n 1.8
+    1463200n 0
+    1463249n 0
+    1463250n 1.8
+    1463299n 1.8
+    1463300n 0
+    1463349n 0
+    1463350n 1.8
+    1463399n 1.8
+    1463400n 0
+    1463449n 0
+    1463450n 1.8
+    1463499n 1.8
+    1463500n 0
+    1463549n 0
+    1463550n 1.8
+    1463599n 1.8
+    1463600n 0
+    1463649n 0
+    1463650n 1.8
+    1463699n 1.8
+    1463700n 0
+    1463749n 0
+    1463750n 1.8
+    1463799n 1.8
+    1463800n 0
+    1463849n 0
+    1463850n 1.8
+    1463899n 1.8
+    1463900n 0
+    1463949n 0
+    1463950n 1.8
+    1463999n 1.8
+    1464000n 0
+    1464049n 0
+    1464050n 1.8
+    1464099n 1.8
+    1464100n 0
+    1464149n 0
+    1464150n 1.8
+    1464199n 1.8
+    1464200n 0
+    1464249n 0
+    1464250n 1.8
+    1464299n 1.8
+    1464300n 0
+    1464349n 0
+    1464350n 1.8
+    1464399n 1.8
+    1464400n 0
+    1464449n 0
+    1464450n 1.8
+    1464499n 1.8
+    1464500n 0
+    1464549n 0
+    1464550n 1.8
+    1464599n 1.8
+    1464600n 0
+    1464649n 0
+    1464650n 1.8
+    1464699n 1.8
+    1464700n 0
+    1464749n 0
+    1464750n 1.8
+    1464799n 1.8
+    1464800n 0
+    1464849n 0
+    1464850n 1.8
+    1464899n 1.8
+    1464900n 0
+    1464949n 0
+    1464950n 1.8
+    1464999n 1.8
+    1465000n 0
+    1465049n 0
+    1465050n 1.8
+    1465099n 1.8
+    1465100n 0
+    1465149n 0
+    1465150n 1.8
+    1465199n 1.8
+    1465200n 0
+    1465249n 0
+    1465250n 1.8
+    1465299n 1.8
+    1465300n 0
+    1465349n 0
+    1465350n 1.8
+    1465399n 1.8
+    1465400n 0
+    1465449n 0
+    1465450n 1.8
+    1465499n 1.8
+    1465500n 0
+    1465549n 0
+    1465550n 1.8
+    1465599n 1.8
+    1465600n 0
+    1465649n 0
+    1465650n 1.8
+    1465699n 1.8
+    1465700n 0
+    1465749n 0
+    1465750n 1.8
+    1465799n 1.8
+    1465800n 0
+    1465849n 0
+    1465850n 1.8
+    1465899n 1.8
+    1465900n 0
+    1465949n 0
+    1465950n 1.8
+    1465999n 1.8
+    1466000n 0
+    1466049n 0
+    1466050n 1.8
+    1466099n 1.8
+    1466100n 0
+    1466149n 0
+    1466150n 1.8
+    1466199n 1.8
+    1466200n 0
+    1466249n 0
+    1466250n 1.8
+    1466299n 1.8
+    1466300n 0
+    1466349n 0
+    1466350n 1.8
+    1466399n 1.8
+    1466400n 0
+    1466449n 0
+    1466450n 1.8
+    1466499n 1.8
+    1466500n 0
+    1466549n 0
+    1466550n 1.8
+    1466599n 1.8
+    1466600n 0
+    1466649n 0
+    1466650n 1.8
+    1466699n 1.8
+    1466700n 0
+    1466749n 0
+    1466750n 1.8
+    1466799n 1.8
+    1466800n 0
+    1466849n 0
+    1466850n 1.8
+    1466899n 1.8
+    1466900n 0
+    1466949n 0
+    1466950n 1.8
+    1466999n 1.8
+    1467000n 0
+    1467049n 0
+    1467050n 1.8
+    1467099n 1.8
+    1467100n 0
+    1467149n 0
+    1467150n 1.8
+    1467199n 1.8
+    1467200n 0
+    1467249n 0
+    1467250n 1.8
+    1467299n 1.8
+    1467300n 0
+    1467349n 0
+    1467350n 1.8
+    1467399n 1.8
+    1467400n 0
+    1467449n 0
+    1467450n 1.8
+    1467499n 1.8
+    1467500n 0
+    1467549n 0
+    1467550n 1.8
+    1467599n 1.8
+    1467600n 0
+    1467649n 0
+    1467650n 1.8
+    1467699n 1.8
+    1467700n 0
+    1467749n 0
+    1467750n 1.8
+    1467799n 1.8
+    1467800n 0
+    1467849n 0
+    1467850n 1.8
+    1467899n 1.8
+    1467900n 0
+    1467949n 0
+    1467950n 1.8
+    1467999n 1.8
+    1468000n 0
+    1468049n 0
+    1468050n 1.8
+    1468099n 1.8
+    1468100n 0
+    1468149n 0
+    1468150n 1.8
+    1468199n 1.8
+    1468200n 0
+    1468249n 0
+    1468250n 1.8
+    1468299n 1.8
+    1468300n 0
+    1468349n 0
+    1468350n 1.8
+    1468399n 1.8
+    1468400n 0
+    1468449n 0
+    1468450n 1.8
+    1468499n 1.8
+    1468500n 0
+    1468549n 0
+    1468550n 1.8
+    1468599n 1.8
+    1468600n 0
+    1468649n 0
+    1468650n 1.8
+    1468699n 1.8
+    1468700n 0
+    1468749n 0
+    1468750n 1.8
+    1468799n 1.8
+    1468800n 0
+    1468849n 0
+    1468850n 1.8
+    1468899n 1.8
+    1468900n 0
+    1468949n 0
+    1468950n 1.8
+    1468999n 1.8
+    1469000n 0
+    1469049n 0
+    1469050n 1.8
+    1469099n 1.8
+    1469100n 0
+    1469149n 0
+    1469150n 1.8
+    1469199n 1.8
+    1469200n 0
+    1469249n 0
+    1469250n 1.8
+    1469299n 1.8
+    1469300n 0
+    1469349n 0
+    1469350n 1.8
+    1469399n 1.8
+    1469400n 0
+    1469449n 0
+    1469450n 1.8
+    1469499n 1.8
+    1469500n 0
+    1469549n 0
+    1469550n 1.8
+    1469599n 1.8
+    1469600n 0
+    1469649n 0
+    1469650n 1.8
+    1469699n 1.8
+    1469700n 0
+    1469749n 0
+    1469750n 1.8
+    1469799n 1.8
+    1469800n 0
+    1469849n 0
+    1469850n 1.8
+    1469899n 1.8
+    1469900n 0
+    1469949n 0
+    1469950n 1.8
+    1469999n 1.8
+    1470000n 0
+    1470049n 0
+    1470050n 1.8
+    1470099n 1.8
+    1470100n 0
+    1470149n 0
+    1470150n 1.8
+    1470199n 1.8
+    1470200n 0
+    1470249n 0
+    1470250n 1.8
+    1470299n 1.8
+    1470300n 0
+    1470349n 0
+    1470350n 1.8
+    1470399n 1.8
+    1470400n 0
+    1470449n 0
+    1470450n 1.8
+    1470499n 1.8
+    1470500n 0
+    1470549n 0
+    1470550n 1.8
+    1470599n 1.8
+    1470600n 0
+    1470649n 0
+    1470650n 1.8
+    1470699n 1.8
+    1470700n 0
+    1470749n 0
+    1470750n 1.8
+    1470799n 1.8
+    1470800n 0
+    1470849n 0
+    1470850n 1.8
+    1470899n 1.8
+    1470900n 0
+    1470949n 0
+    1470950n 1.8
+    1470999n 1.8
+    1471000n 0
+    1471049n 0
+    1471050n 1.8
+    1471099n 1.8
+    1471100n 0
+    1471149n 0
+    1471150n 1.8
+    1471199n 1.8
+    1471200n 0
+    1471249n 0
+    1471250n 1.8
+    1471299n 1.8
+    1471300n 0
+    1471349n 0
+    1471350n 1.8
+    1471399n 1.8
+    1471400n 0
+    1471449n 0
+    1471450n 1.8
+    1471499n 1.8
+    1471500n 0
+    1471549n 0
+    1471550n 1.8
+    1471599n 1.8
+    1471600n 0
+    1471649n 0
+    1471650n 1.8
+    1471699n 1.8
+    1471700n 0
+    1471749n 0
+    1471750n 1.8
+    1471799n 1.8
+    1471800n 0
+    1471849n 0
+    1471850n 1.8
+    1471899n 1.8
+    1471900n 0
+    1471949n 0
+    1471950n 1.8
+    1471999n 1.8
+    1472000n 0
+    1472049n 0
+    1472050n 1.8
+    1472099n 1.8
+    1472100n 0
+    1472149n 0
+    1472150n 1.8
+    1472199n 1.8
+    1472200n 0
+    1472249n 0
+    1472250n 1.8
+    1472299n 1.8
+    1472300n 0
+    1472349n 0
+    1472350n 1.8
+    1472399n 1.8
+    1472400n 0
+    1472449n 0
+    1472450n 1.8
+    1472499n 1.8
+    1472500n 0
+    1472549n 0
+    1472550n 1.8
+    1472599n 1.8
+    1472600n 0
+    1472649n 0
+    1472650n 1.8
+    1472699n 1.8
+    1472700n 0
+    1472749n 0
+    1472750n 1.8
+    1472799n 1.8
+    1472800n 0
+    1472849n 0
+    1472850n 1.8
+    1472899n 1.8
+    1472900n 0
+    1472949n 0
+    1472950n 1.8
+    1472999n 1.8
+    1473000n 0
+    1473049n 0
+    1473050n 1.8
+    1473099n 1.8
+    1473100n 0
+    1473149n 0
+    1473150n 1.8
+    1473199n 1.8
+    1473200n 0
+    1473249n 0
+    1473250n 1.8
+    1473299n 1.8
+    1473300n 0
+    1473349n 0
+    1473350n 1.8
+    1473399n 1.8
+    1473400n 0
+    1473449n 0
+    1473450n 1.8
+    1473499n 1.8
+    1473500n 0
+    1473549n 0
+    1473550n 1.8
+    1473599n 1.8
+    1473600n 0
+    1473649n 0
+    1473650n 1.8
+    1473699n 1.8
+    1473700n 0
+    1473749n 0
+    1473750n 1.8
+    1473799n 1.8
+    1473800n 0
+    1473849n 0
+    1473850n 1.8
+    1473899n 1.8
+    1473900n 0
+    1473949n 0
+    1473950n 1.8
+    1473999n 1.8
+    1474000n 0
+    1474049n 0
+    1474050n 1.8
+    1474099n 1.8
+    1474100n 0
+    1474149n 0
+    1474150n 1.8
+    1474199n 1.8
+    1474200n 0
+    1474249n 0
+    1474250n 1.8
+    1474299n 1.8
+    1474300n 0
+    1474349n 0
+    1474350n 1.8
+    1474399n 1.8
+    1474400n 0
+    1474449n 0
+    1474450n 1.8
+    1474499n 1.8
+    1474500n 0
+    1474549n 0
+    1474550n 1.8
+    1474599n 1.8
+    1474600n 0
+    1474649n 0
+    1474650n 1.8
+    1474699n 1.8
+    1474700n 0
+    1474749n 0
+    1474750n 1.8
+    1474799n 1.8
+    1474800n 0
+    1474849n 0
+    1474850n 1.8
+    1474899n 1.8
+    1474900n 0
+    1474949n 0
+    1474950n 1.8
+    1474999n 1.8
+    1475000n 0
+    1475049n 0
+    1475050n 1.8
+    1475099n 1.8
+    1475100n 0
+    1475149n 0
+    1475150n 1.8
+    1475199n 1.8
+    1475200n 0
+    1475249n 0
+    1475250n 1.8
+    1475299n 1.8
+    1475300n 0
+    1475349n 0
+    1475350n 1.8
+    1475399n 1.8
+    1475400n 0
+    1475449n 0
+    1475450n 1.8
+    1475499n 1.8
+    1475500n 0
+    1475549n 0
+    1475550n 1.8
+    1475599n 1.8
+    1475600n 0
+    1475649n 0
+    1475650n 1.8
+    1475699n 1.8
+    1475700n 0
+    1475749n 0
+    1475750n 1.8
+    1475799n 1.8
+    1475800n 0
+    1475849n 0
+    1475850n 1.8
+    1475899n 1.8
+    1475900n 0
+    1475949n 0
+    1475950n 1.8
+    1475999n 1.8
+    1476000n 0
+    1476049n 0
+    1476050n 1.8
+    1476099n 1.8
+    1476100n 0
+    1476149n 0
+    1476150n 1.8
+    1476199n 1.8
+    1476200n 0
+    1476249n 0
+    1476250n 1.8
+    1476299n 1.8
+    1476300n 0
+    1476349n 0
+    1476350n 1.8
+    1476399n 1.8
+    1476400n 0
+    1476449n 0
+    1476450n 1.8
+    1476499n 1.8
+    1476500n 0
+    1476549n 0
+    1476550n 1.8
+    1476599n 1.8
+    1476600n 0
+    1476649n 0
+    1476650n 1.8
+    1476699n 1.8
+    1476700n 0
+    1476749n 0
+    1476750n 1.8
+    1476799n 1.8
+    1476800n 0
+    1476849n 0
+    1476850n 1.8
+    1476899n 1.8
+    1476900n 0
+    1476949n 0
+    1476950n 1.8
+    1476999n 1.8
+    1477000n 0
+    1477049n 0
+    1477050n 1.8
+    1477099n 1.8
+    1477100n 0
+    1477149n 0
+    1477150n 1.8
+    1477199n 1.8
+    1477200n 0
+    1477249n 0
+    1477250n 1.8
+    1477299n 1.8
+    1477300n 0
+    1477349n 0
+    1477350n 1.8
+    1477399n 1.8
+    1477400n 0
+    1477449n 0
+    1477450n 1.8
+    1477499n 1.8
+    1477500n 0
+    1477549n 0
+    1477550n 1.8
+    1477599n 1.8
+    1477600n 0
+    1477649n 0
+    1477650n 1.8
+    1477699n 1.8
+    1477700n 0
+    1477749n 0
+    1477750n 1.8
+    1477799n 1.8
+    1477800n 0
+    1477849n 0
+    1477850n 1.8
+    1477899n 1.8
+    1477900n 0
+    1477949n 0
+    1477950n 1.8
+    1477999n 1.8
+    1478000n 0
+    1478049n 0
+    1478050n 1.8
+    1478099n 1.8
+    1478100n 0
+    1478149n 0
+    1478150n 1.8
+    1478199n 1.8
+    1478200n 0
+    1478249n 0
+    1478250n 1.8
+    1478299n 1.8
+    1478300n 0
+    1478349n 0
+    1478350n 1.8
+    1478399n 1.8
+    1478400n 0
+    1478449n 0
+    1478450n 1.8
+    1478499n 1.8
+    1478500n 0
+    1478549n 0
+    1478550n 1.8
+    1478599n 1.8
+    1478600n 0
+    1478649n 0
+    1478650n 1.8
+    1478699n 1.8
+    1478700n 0
+    1478749n 0
+    1478750n 1.8
+    1478799n 1.8
+    1478800n 0
+    1478849n 0
+    1478850n 1.8
+    1478899n 1.8
+    1478900n 0
+    1478949n 0
+    1478950n 1.8
+    1478999n 1.8
+    1479000n 0
+    1479049n 0
+    1479050n 1.8
+    1479099n 1.8
+    1479100n 0
+    1479149n 0
+    1479150n 1.8
+    1479199n 1.8
+    1479200n 0
+    1479249n 0
+    1479250n 1.8
+    1479299n 1.8
+    1479300n 0
+    1479349n 0
+    1479350n 1.8
+    1479399n 1.8
+    1479400n 0
+    1479449n 0
+    1479450n 1.8
+    1479499n 1.8
+    1479500n 0
+    1479549n 0
+    1479550n 1.8
+    1479599n 1.8
+    1479600n 0
+    1479649n 0
+    1479650n 1.8
+    1479699n 1.8
+    1479700n 0
+    1479749n 0
+    1479750n 1.8
+    1479799n 1.8
+    1479800n 0
+    1479849n 0
+    1479850n 1.8
+    1479899n 1.8
+    1479900n 0
+    1479949n 0
+    1479950n 1.8
+    1479999n 1.8
+    1480000n 0
+    1480049n 0
+    1480050n 1.8
+    1480099n 1.8
+    1480100n 0
+    1480149n 0
+    1480150n 1.8
+    1480199n 1.8
+    1480200n 0
+    1480249n 0
+    1480250n 1.8
+    1480299n 1.8
+    1480300n 0
+    1480349n 0
+    1480350n 1.8
+    1480399n 1.8
+    1480400n 0
+    1480449n 0
+    1480450n 1.8
+    1480499n 1.8
+    1480500n 0
+    1480549n 0
+    1480550n 1.8
+    1480599n 1.8
+    1480600n 0
+    1480649n 0
+    1480650n 1.8
+    1480699n 1.8
+    1480700n 0
+    1480749n 0
+    1480750n 1.8
+    1480799n 1.8
+    1480800n 0
+    1480849n 0
+    1480850n 1.8
+    1480899n 1.8
+    1480900n 0
+    1480949n 0
+    1480950n 1.8
+    1480999n 1.8
+    1481000n 0
+    1481049n 0
+    1481050n 1.8
+    1481099n 1.8
+    1481100n 0
+    1481149n 0
+    1481150n 1.8
+    1481199n 1.8
+    1481200n 0
+    1481249n 0
+    1481250n 1.8
+    1481299n 1.8
+    1481300n 0
+    1481349n 0
+    1481350n 1.8
+    1481399n 1.8
+    1481400n 0
+    1481449n 0
+    1481450n 1.8
+    1481499n 1.8
+    1481500n 0
+    1481549n 0
+    1481550n 1.8
+    1481599n 1.8
+    1481600n 0
+    1481649n 0
+    1481650n 1.8
+    1481699n 1.8
+    1481700n 0
+    1481749n 0
+    1481750n 1.8
+    1481799n 1.8
+    1481800n 0
+    1481849n 0
+    1481850n 1.8
+    1481899n 1.8
+    1481900n 0
+    1481949n 0
+    1481950n 1.8
+    1481999n 1.8
+    1482000n 0
+    1482049n 0
+    1482050n 1.8
+    1482099n 1.8
+    1482100n 0
+    1482149n 0
+    1482150n 1.8
+    1482199n 1.8
+    1482200n 0
+    1482249n 0
+    1482250n 1.8
+    1482299n 1.8
+    1482300n 0
+    1482349n 0
+    1482350n 1.8
+    1482399n 1.8
+    1482400n 0
+    1482449n 0
+    1482450n 1.8
+    1482499n 1.8
+    1482500n 0
+    1482549n 0
+    1482550n 1.8
+    1482599n 1.8
+    1482600n 0
+    1482649n 0
+    1482650n 1.8
+    1482699n 1.8
+    1482700n 0
+    1482749n 0
+    1482750n 1.8
+    1482799n 1.8
+    1482800n 0
+    1482849n 0
+    1482850n 1.8
+    1482899n 1.8
+    1482900n 0
+    1482949n 0
+    1482950n 1.8
+    1482999n 1.8
+    1483000n 0
+    1483049n 0
+    1483050n 1.8
+    1483099n 1.8
+    1483100n 0
+    1483149n 0
+    1483150n 1.8
+    1483199n 1.8
+    1483200n 0
+    1483249n 0
+    1483250n 1.8
+    1483299n 1.8
+    1483300n 0
+    1483349n 0
+    1483350n 1.8
+    1483399n 1.8
+    1483400n 0
+    1483449n 0
+    1483450n 1.8
+    1483499n 1.8
+    1483500n 0
+    1483549n 0
+    1483550n 1.8
+    1483599n 1.8
+    1483600n 0
+    1483649n 0
+    1483650n 1.8
+    1483699n 1.8
+    1483700n 0
+    1483749n 0
+    1483750n 1.8
+    1483799n 1.8
+    1483800n 0
+    1483849n 0
+    1483850n 1.8
+    1483899n 1.8
+    1483900n 0
+    1483949n 0
+    1483950n 1.8
+    1483999n 1.8
+    1484000n 0
+    1484049n 0
+    1484050n 1.8
+    1484099n 1.8
+    1484100n 0
+    1484149n 0
+    1484150n 1.8
+    1484199n 1.8
+    1484200n 0
+    1484249n 0
+    1484250n 1.8
+    1484299n 1.8
+    1484300n 0
+    1484349n 0
+    1484350n 1.8
+    1484399n 1.8
+    1484400n 0
+    1484449n 0
+    1484450n 1.8
+    1484499n 1.8
+    1484500n 0
+    1484549n 0
+    1484550n 1.8
+    1484599n 1.8
+    1484600n 0
+    1484649n 0
+    1484650n 1.8
+    1484699n 1.8
+    1484700n 0
+    1484749n 0
+    1484750n 1.8
+    1484799n 1.8
+    1484800n 0
+    1484849n 0
+    1484850n 1.8
+    1484899n 1.8
+    1484900n 0
+    1484949n 0
+    1484950n 1.8
+    1484999n 1.8
+    1485000n 0
+    1485049n 0
+    1485050n 1.8
+    1485099n 1.8
+    1485100n 0
+    1485149n 0
+    1485150n 1.8
+    1485199n 1.8
+    1485200n 0
+    1485249n 0
+    1485250n 1.8
+    1485299n 1.8
+    1485300n 0
+    1485349n 0
+    1485350n 1.8
+    1485399n 1.8
+    1485400n 0
+    1485449n 0
+    1485450n 1.8
+    1485499n 1.8
+    1485500n 0
+    1485549n 0
+    1485550n 1.8
+    1485599n 1.8
+    1485600n 0
+    1485649n 0
+    1485650n 1.8
+    1485699n 1.8
+    1485700n 0
+    1485749n 0
+    1485750n 1.8
+    1485799n 1.8
+    1485800n 0
+    1485849n 0
+    1485850n 1.8
+    1485899n 1.8
+    1485900n 0
+    1485949n 0
+    1485950n 1.8
+    1485999n 1.8
+    1486000n 0
+    1486049n 0
+    1486050n 1.8
+    1486099n 1.8
+    1486100n 0
+    1486149n 0
+    1486150n 1.8
+    1486199n 1.8
+    1486200n 0
+    1486249n 0
+    1486250n 1.8
+    1486299n 1.8
+    1486300n 0
+    1486349n 0
+    1486350n 1.8
+    1486399n 1.8
+    1486400n 0
+    1486449n 0
+    1486450n 1.8
+    1486499n 1.8
+    1486500n 0
+    1486549n 0
+    1486550n 1.8
+    1486599n 1.8
+    1486600n 0
+    1486649n 0
+    1486650n 1.8
+    1486699n 1.8
+    1486700n 0
+    1486749n 0
+    1486750n 1.8
+    1486799n 1.8
+    1486800n 0
+    1486849n 0
+    1486850n 1.8
+    1486899n 1.8
+    1486900n 0
+    1486949n 0
+    1486950n 1.8
+    1486999n 1.8
+    1487000n 0
+    1487049n 0
+    1487050n 1.8
+    1487099n 1.8
+    1487100n 0
+    1487149n 0
+    1487150n 1.8
+    1487199n 1.8
+    1487200n 0
+    1487249n 0
+    1487250n 1.8
+    1487299n 1.8
+    1487300n 0
+    1487349n 0
+    1487350n 1.8
+    1487399n 1.8
+    1487400n 0
+    1487449n 0
+    1487450n 1.8
+    1487499n 1.8
+    1487500n 0
+    1487549n 0
+    1487550n 1.8
+    1487599n 1.8
+    1487600n 0
+    1487649n 0
+    1487650n 1.8
+    1487699n 1.8
+    1487700n 0
+    1487749n 0
+    1487750n 1.8
+    1487799n 1.8
+    1487800n 0
+    1487849n 0
+    1487850n 1.8
+    1487899n 1.8
+    1487900n 0
+    1487949n 0
+    1487950n 1.8
+    1487999n 1.8
+    1488000n 0
+    1488049n 0
+    1488050n 1.8
+    1488099n 1.8
+    1488100n 0
+    1488149n 0
+    1488150n 1.8
+    1488199n 1.8
+    1488200n 0
+    1488249n 0
+    1488250n 1.8
+    1488299n 1.8
+    1488300n 0
+    1488349n 0
+    1488350n 1.8
+    1488399n 1.8
+    1488400n 0
+    1488449n 0
+    1488450n 1.8
+    1488499n 1.8
+    1488500n 0
+    1488549n 0
+    1488550n 1.8
+    1488599n 1.8
+    1488600n 0
+    1488649n 0
+    1488650n 1.8
+    1488699n 1.8
+    1488700n 0
+    1488749n 0
+    1488750n 1.8
+    1488799n 1.8
+    1488800n 0
+    1488849n 0
+    1488850n 1.8
+    1488899n 1.8
+    1488900n 0
+    1488949n 0
+    1488950n 1.8
+    1488999n 1.8
+    1489000n 0
+    1489049n 0
+    1489050n 1.8
+    1489099n 1.8
+    1489100n 0
+    1489149n 0
+    1489150n 1.8
+    1489199n 1.8
+    1489200n 0
+    1489249n 0
+    1489250n 1.8
+    1489299n 1.8
+    1489300n 0
+    1489349n 0
+    1489350n 1.8
+    1489399n 1.8
+    1489400n 0
+    1489449n 0
+    1489450n 1.8
+    1489499n 1.8
+    1489500n 0
+    1489549n 0
+    1489550n 1.8
+    1489599n 1.8
+    1489600n 0
+    1489649n 0
+    1489650n 1.8
+    1489699n 1.8
+    1489700n 0
+    1489749n 0
+    1489750n 1.8
+    1489799n 1.8
+    1489800n 0
+    1489849n 0
+    1489850n 1.8
+    1489899n 1.8
+    1489900n 0
+    1489949n 0
+    1489950n 1.8
+    1489999n 1.8
+    1490000n 0
+    1490049n 0
+    1490050n 1.8
+    1490099n 1.8
+    1490100n 0
+    1490149n 0
+    1490150n 1.8
+    1490199n 1.8
+    1490200n 0
+    1490249n 0
+    1490250n 1.8
+    1490299n 1.8
+    1490300n 0
+    1490349n 0
+    1490350n 1.8
+    1490399n 1.8
+    1490400n 0
+    1490449n 0
+    1490450n 1.8
+    1490499n 1.8
+    1490500n 0
+    1490549n 0
+    1490550n 1.8
+    1490599n 1.8
+    1490600n 0
+    1490649n 0
+    1490650n 1.8
+    1490699n 1.8
+    1490700n 0
+    1490749n 0
+    1490750n 1.8
+    1490799n 1.8
+    1490800n 0
+    1490849n 0
+    1490850n 1.8
+    1490899n 1.8
+    1490900n 0
+    1490949n 0
+    1490950n 1.8
+    1490999n 1.8
+    1491000n 0
+    1491049n 0
+    1491050n 1.8
+    1491099n 1.8
+    1491100n 0
+    1491149n 0
+    1491150n 1.8
+    1491199n 1.8
+    1491200n 0
+    1491249n 0
+    1491250n 1.8
+    1491299n 1.8
+    1491300n 0
+    1491349n 0
+    1491350n 1.8
+    1491399n 1.8
+    1491400n 0
+    1491449n 0
+    1491450n 1.8
+    1491499n 1.8
+    1491500n 0
+    1491549n 0
+    1491550n 1.8
+    1491599n 1.8
+    1491600n 0
+    1491649n 0
+    1491650n 1.8
+    1491699n 1.8
+    1491700n 0
+    1491749n 0
+    1491750n 1.8
+    1491799n 1.8
+    1491800n 0
+    1491849n 0
+    1491850n 1.8
+    1491899n 1.8
+    1491900n 0
+    1491949n 0
+    1491950n 1.8
+    1491999n 1.8
+    1492000n 0
+    1492049n 0
+    1492050n 1.8
+    1492099n 1.8
+    1492100n 0
+    1492149n 0
+    1492150n 1.8
+    1492199n 1.8
+    1492200n 0
+    1492249n 0
+    1492250n 1.8
+    1492299n 1.8
+    1492300n 0
+    1492349n 0
+    1492350n 1.8
+    1492399n 1.8
+    1492400n 0
+    1492449n 0
+    1492450n 1.8
+    1492499n 1.8
+    1492500n 0
+    1492549n 0
+    1492550n 1.8
+    1492599n 1.8
+    1492600n 0
+    1492649n 0
+    1492650n 1.8
+    1492699n 1.8
+    1492700n 0
+    1492749n 0
+    1492750n 1.8
+    1492799n 1.8
+    1492800n 0
+    1492849n 0
+    1492850n 1.8
+    1492899n 1.8
+    1492900n 0
+    1492949n 0
+    1492950n 1.8
+    1492999n 1.8
+    1493000n 0
+    1493049n 0
+    1493050n 1.8
+    1493099n 1.8
+    1493100n 0
+    1493149n 0
+    1493150n 1.8
+    1493199n 1.8
+    1493200n 0
+    1493249n 0
+    1493250n 1.8
+    1493299n 1.8
+    1493300n 0
+    1493349n 0
+    1493350n 1.8
+    1493399n 1.8
+    1493400n 0
+    1493449n 0
+    1493450n 1.8
+    1493499n 1.8
+    1493500n 0
+    1493549n 0
+    1493550n 1.8
+    1493599n 1.8
+    1493600n 0
+    1493649n 0
+    1493650n 1.8
+    1493699n 1.8
+    1493700n 0
+    1493749n 0
+    1493750n 1.8
+    1493799n 1.8
+    1493800n 0
+    1493849n 0
+    1493850n 1.8
+    1493899n 1.8
+    1493900n 0
+    1493949n 0
+    1493950n 1.8
+    1493999n 1.8
+    1494000n 0
+    1494049n 0
+    1494050n 1.8
+    1494099n 1.8
+    1494100n 0
+    1494149n 0
+    1494150n 1.8
+    1494199n 1.8
+    1494200n 0
+    1494249n 0
+    1494250n 1.8
+    1494299n 1.8
+    1494300n 0
+    1494349n 0
+    1494350n 1.8
+    1494399n 1.8
+    1494400n 0
+    1494449n 0
+    1494450n 1.8
+    1494499n 1.8
+    1494500n 0
+    1494549n 0
+    1494550n 1.8
+    1494599n 1.8
+    1494600n 0
+    1494649n 0
+    1494650n 1.8
+    1494699n 1.8
+    1494700n 0
+    1494749n 0
+    1494750n 1.8
+    1494799n 1.8
+    1494800n 0
+    1494849n 0
+    1494850n 1.8
+    1494899n 1.8
+    1494900n 0
+    1494949n 0
+    1494950n 1.8
+    1494999n 1.8
+    1495000n 0
+    1495049n 0
+    1495050n 1.8
+    1495099n 1.8
+    1495100n 0
+    1495149n 0
+    1495150n 1.8
+    1495199n 1.8
+    1495200n 0
+    1495249n 0
+    1495250n 1.8
+    1495299n 1.8
+    1495300n 0
+    1495349n 0
+    1495350n 1.8
+    1495399n 1.8
+    1495400n 0
+    1495449n 0
+    1495450n 1.8
+    1495499n 1.8
+    1495500n 0
+    1495549n 0
+    1495550n 1.8
+    1495599n 1.8
+    1495600n 0
+    1495649n 0
+    1495650n 1.8
+    1495699n 1.8
+    1495700n 0
+    1495749n 0
+    1495750n 1.8
+    1495799n 1.8
+    1495800n 0
+    1495849n 0
+    1495850n 1.8
+    1495899n 1.8
+    1495900n 0
+    1495949n 0
+    1495950n 1.8
+    1495999n 1.8
+    1496000n 0
+    1496049n 0
+    1496050n 1.8
+    1496099n 1.8
+    1496100n 0
+    1496149n 0
+    1496150n 1.8
+    1496199n 1.8
+    1496200n 0
+    1496249n 0
+    1496250n 1.8
+    1496299n 1.8
+    1496300n 0
+    1496349n 0
+    1496350n 1.8
+    1496399n 1.8
+    1496400n 0
+    1496449n 0
+    1496450n 1.8
+    1496499n 1.8
+    1496500n 0
+    1496549n 0
+    1496550n 1.8
+    1496599n 1.8
+    1496600n 0
+    1496649n 0
+    1496650n 1.8
+    1496699n 1.8
+    1496700n 0
+    1496749n 0
+    1496750n 1.8
+    1496799n 1.8
+    1496800n 0
+    1496849n 0
+    1496850n 1.8
+    1496899n 1.8
+    1496900n 0
+    1496949n 0
+    1496950n 1.8
+    1496999n 1.8
+    1497000n 0
+    1497049n 0
+    1497050n 1.8
+    1497099n 1.8
+    1497100n 0
+    1497149n 0
+    1497150n 1.8
+    1497199n 1.8
+    1497200n 0
+    1497249n 0
+    1497250n 1.8
+    1497299n 1.8
+    1497300n 0
+    1497349n 0
+    1497350n 1.8
+    1497399n 1.8
+    1497400n 0
+    1497449n 0
+    1497450n 1.8
+    1497499n 1.8
+    1497500n 0
+    1497549n 0
+    1497550n 1.8
+    1497599n 1.8
+    1497600n 0
+    1497649n 0
+    1497650n 1.8
+    1497699n 1.8
+    1497700n 0
+    1497749n 0
+    1497750n 1.8
+    1497799n 1.8
+    1497800n 0
+    1497849n 0
+    1497850n 1.8
+    1497899n 1.8
+    1497900n 0
+    1497949n 0
+    1497950n 1.8
+    1497999n 1.8
+    1498000n 0
+    1498049n 0
+    1498050n 1.8
+    1498099n 1.8
+    1498100n 0
+    1498149n 0
+    1498150n 1.8
+    1498199n 1.8
+    1498200n 0
+    1498249n 0
+    1498250n 1.8
+    1498299n 1.8
+    1498300n 0
+    1498349n 0
+    1498350n 1.8
+    1498399n 1.8
+    1498400n 0
+    1498449n 0
+    1498450n 1.8
+    1498499n 1.8
+    1498500n 0
+    1498549n 0
+    1498550n 1.8
+    1498599n 1.8
+    1498600n 0
+    1498649n 0
+    1498650n 1.8
+    1498699n 1.8
+    1498700n 0
+    1498749n 0
+    1498750n 1.8
+    1498799n 1.8
+    1498800n 0
+    1498849n 0
+    1498850n 1.8
+    1498899n 1.8
+    1498900n 0
+    1498949n 0
+    1498950n 1.8
+    1498999n 1.8
+    1499000n 0
+    1499049n 0
+    1499050n 1.8
+    1499099n 1.8
+    1499100n 0
+    1499149n 0
+    1499150n 1.8
+    1499199n 1.8
+    1499200n 0
+    1499249n 0
+    1499250n 1.8
+    1499299n 1.8
+    1499300n 0
+    1499349n 0
+    1499350n 1.8
+    1499399n 1.8
+    1499400n 0
+    1499449n 0
+    1499450n 1.8
+    1499499n 1.8
+    1499500n 0
+    1499549n 0
+    1499550n 1.8
+    1499599n 1.8
+    1499600n 0
+    1499649n 0
+    1499650n 1.8
+    1499699n 1.8
+    1499700n 0
+    1499749n 0
+    1499750n 1.8
+    1499799n 1.8
+    1499800n 0
+    1499849n 0
+    1499850n 1.8
+    1499899n 1.8
+    1499900n 0
+    1499949n 0
+    1499950n 1.8
+    1499999n 1.8
+    1500000n 0
+    1500049n 0
+    1500050n 1.8
+    1500099n 1.8
+    1500100n 0
+    1500149n 0
+    1500150n 1.8
+    1500199n 1.8
+    1500200n 0
+    1500249n 0
+    1500250n 1.8
+    1500299n 1.8
+    1500300n 0
+    1500349n 0
+    1500350n 1.8
+    1500399n 1.8
+    1500400n 0
+    1500449n 0
+    1500450n 1.8
+    1500499n 1.8
+    1500500n 0
+    1500549n 0
+    1500550n 1.8
+    1500599n 1.8
+    1500600n 0
+    1500649n 0
+    1500650n 1.8
+    1500699n 1.8
+    1500700n 0
+    1500749n 0
+    1500750n 1.8
+    1500799n 1.8
+    1500800n 0
+    1500849n 0
+    1500850n 1.8
+    1500899n 1.8
+    1500900n 0
+    1500949n 0
+    1500950n 1.8
+    1500999n 1.8
+    1501000n 0
+    1501049n 0
+    1501050n 1.8
+    1501099n 1.8
+    1501100n 0
+    1501149n 0
+    1501150n 1.8
+    1501199n 1.8
+    1501200n 0
+    1501249n 0
+    1501250n 1.8
+    1501299n 1.8
+    1501300n 0
+    1501349n 0
+    1501350n 1.8
+    1501399n 1.8
+    1501400n 0
+    1501449n 0
+    1501450n 1.8
+    1501499n 1.8
+    1501500n 0
+    1501549n 0
+    1501550n 1.8
+    1501599n 1.8
+    1501600n 0
+    1501649n 0
+    1501650n 1.8
+    1501699n 1.8
+    1501700n 0
+    1501749n 0
+    1501750n 1.8
+    1501799n 1.8
+    1501800n 0
+    1501849n 0
+    1501850n 1.8
+    1501899n 1.8
+    1501900n 0
+    1501949n 0
+    1501950n 1.8
+    1501999n 1.8
+    1502000n 0
+    1502049n 0
+    1502050n 1.8
+    1502099n 1.8
+    1502100n 0
+    1502149n 0
+    1502150n 1.8
+    1502199n 1.8
+    1502200n 0
+    1502249n 0
+    1502250n 1.8
+    1502299n 1.8
+    1502300n 0
+    1502349n 0
+    1502350n 1.8
+    1502399n 1.8
+    1502400n 0
+    1502449n 0
+    1502450n 1.8
+    1502499n 1.8
+    1502500n 0
+    1502549n 0
+    1502550n 1.8
+    1502599n 1.8
+    1502600n 0
+    1502649n 0
+    1502650n 1.8
+    1502699n 1.8
+    1502700n 0
+    1502749n 0
+    1502750n 1.8
+    1502799n 1.8
+    1502800n 0
+    1502849n 0
+    1502850n 1.8
+    1502899n 1.8
+    1502900n 0
+    1502949n 0
+    1502950n 1.8
+    1502999n 1.8
+    1503000n 0
+    1503049n 0
+    1503050n 1.8
+    1503099n 1.8
+    1503100n 0
+    1503149n 0
+    1503150n 1.8
+    1503199n 1.8
+    1503200n 0
+    1503249n 0
+    1503250n 1.8
+    1503299n 1.8
+    1503300n 0
+    1503349n 0
+    1503350n 1.8
+    1503399n 1.8
+    1503400n 0
+    1503449n 0
+    1503450n 1.8
+    1503499n 1.8
+    1503500n 0
+    1503549n 0
+    1503550n 1.8
+    1503599n 1.8
+    1503600n 0
+    1503649n 0
+    1503650n 1.8
+    1503699n 1.8
+    1503700n 0
+    1503749n 0
+    1503750n 1.8
+    1503799n 1.8
+    1503800n 0
+    1503849n 0
+    1503850n 1.8
+    1503899n 1.8
+    1503900n 0
+    1503949n 0
+    1503950n 1.8
+    1503999n 1.8
+    1504000n 0
+    1504049n 0
+    1504050n 1.8
+    1504099n 1.8
+    1504100n 0
+    1504149n 0
+    1504150n 1.8
+    1504199n 1.8
+    1504200n 0
+    1504249n 0
+    1504250n 1.8
+    1504299n 1.8
+    1504300n 0
+    1504349n 0
+    1504350n 1.8
+    1504399n 1.8
+    1504400n 0
+    1504449n 0
+    1504450n 1.8
+    1504499n 1.8
+    1504500n 0
+    1504549n 0
+    1504550n 1.8
+    1504599n 1.8
+    1504600n 0
+    1504649n 0
+    1504650n 1.8
+    1504699n 1.8
+    1504700n 0
+    1504749n 0
+    1504750n 1.8
+    1504799n 1.8
+    1504800n 0
+    1504849n 0
+    1504850n 1.8
+    1504899n 1.8
+    1504900n 0
+    1504949n 0
+    1504950n 1.8
+    1504999n 1.8
+    1505000n 0
+    1505049n 0
+    1505050n 1.8
+    1505099n 1.8
+    1505100n 0
+    1505149n 0
+    1505150n 1.8
+    1505199n 1.8
+    1505200n 0
+    1505249n 0
+    1505250n 1.8
+    1505299n 1.8
+    1505300n 0
+    1505349n 0
+    1505350n 1.8
+    1505399n 1.8
+    1505400n 0
+    1505449n 0
+    1505450n 1.8
+    1505499n 1.8
+    1505500n 0
+    1505549n 0
+    1505550n 1.8
+    1505599n 1.8
+    1505600n 0
+    1505649n 0
+    1505650n 1.8
+    1505699n 1.8
+    1505700n 0
+    1505749n 0
+    1505750n 1.8
+    1505799n 1.8
+    1505800n 0
+    1505849n 0
+    1505850n 1.8
+    1505899n 1.8
+    1505900n 0
+    1505949n 0
+    1505950n 1.8
+    1505999n 1.8
+    1506000n 0
+    1506049n 0
+    1506050n 1.8
+    1506099n 1.8
+    1506100n 0
+    1506149n 0
+    1506150n 1.8
+    1506199n 1.8
+    1506200n 0
+    1506249n 0
+    1506250n 1.8
+    1506299n 1.8
+    1506300n 0
+    1506349n 0
+    1506350n 1.8
+    1506399n 1.8
+    1506400n 0
+    1506449n 0
+    1506450n 1.8
+    1506499n 1.8
+    1506500n 0
+    1506549n 0
+    1506550n 1.8
+    1506599n 1.8
+    1506600n 0
+    1506649n 0
+    1506650n 1.8
+    1506699n 1.8
+    1506700n 0
+    1506749n 0
+    1506750n 1.8
+    1506799n 1.8
+    1506800n 0
+    1506849n 0
+    1506850n 1.8
+    1506899n 1.8
+    1506900n 0
+    1506949n 0
+    1506950n 1.8
+    1506999n 1.8
+    1507000n 0
+    1507049n 0
+    1507050n 1.8
+    1507099n 1.8
+    1507100n 0
+    1507149n 0
+    1507150n 1.8
+    1507199n 1.8
+    1507200n 0
+    1507249n 0
+    1507250n 1.8
+    1507299n 1.8
+    1507300n 0
+    1507349n 0
+    1507350n 1.8
+    1507399n 1.8
+    1507400n 0
+    1507449n 0
+    1507450n 1.8
+    1507499n 1.8
+    1507500n 0
+    1507549n 0
+    1507550n 1.8
+    1507599n 1.8
+    1507600n 0
+    1507649n 0
+    1507650n 1.8
+    1507699n 1.8
+    1507700n 0
+    1507749n 0
+    1507750n 1.8
+    1507799n 1.8
+    1507800n 0
+    1507849n 0
+    1507850n 1.8
+    1507899n 1.8
+    1507900n 0
+    1507949n 0
+    1507950n 1.8
+    1507999n 1.8
+    1508000n 0
+    1508049n 0
+    1508050n 1.8
+    1508099n 1.8
+    1508100n 0
+    1508149n 0
+    1508150n 1.8
+    1508199n 1.8
+    1508200n 0
+    1508249n 0
+    1508250n 1.8
+    1508299n 1.8
+    1508300n 0
+    1508349n 0
+    1508350n 1.8
+    1508399n 1.8
+    1508400n 0
+    1508449n 0
+    1508450n 1.8
+    1508499n 1.8
+    1508500n 0
+    1508549n 0
+    1508550n 1.8
+    1508599n 1.8
+    1508600n 0
+    1508649n 0
+    1508650n 1.8
+    1508699n 1.8
+    1508700n 0
+    1508749n 0
+    1508750n 1.8
+    1508799n 1.8
+    1508800n 0
+    1508849n 0
+    1508850n 1.8
+    1508899n 1.8
+    1508900n 0
+    1508949n 0
+    1508950n 1.8
+    1508999n 1.8
+    1509000n 0
+    1509049n 0
+    1509050n 1.8
+    1509099n 1.8
+    1509100n 0
+    1509149n 0
+    1509150n 1.8
+    1509199n 1.8
+    1509200n 0
+    1509249n 0
+    1509250n 1.8
+    1509299n 1.8
+    1509300n 0
+    1509349n 0
+    1509350n 1.8
+    1509399n 1.8
+    1509400n 0
+    1509449n 0
+    1509450n 1.8
+    1509499n 1.8
+    1509500n 0
+    1509549n 0
+    1509550n 1.8
+    1509599n 1.8
+    1509600n 0
+    1509649n 0
+    1509650n 1.8
+    1509699n 1.8
+    1509700n 0
+    1509749n 0
+    1509750n 1.8
+    1509799n 1.8
+    1509800n 0
+    1509849n 0
+    1509850n 1.8
+    1509899n 1.8
+    1509900n 0
+    1509949n 0
+    1509950n 1.8
+    1509999n 1.8
+    1510000n 0
+    1510049n 0
+    1510050n 1.8
+    1510099n 1.8
+    1510100n 0
+    1510149n 0
+    1510150n 1.8
+    1510199n 1.8
+    1510200n 0
+    1510249n 0
+    1510250n 1.8
+    1510299n 1.8
+    1510300n 0
+    1510349n 0
+    1510350n 1.8
+    1510399n 1.8
+    1510400n 0
+    1510449n 0
+    1510450n 1.8
+    1510499n 1.8
+    1510500n 0
+    1510549n 0
+    1510550n 1.8
+    1510599n 1.8
+    1510600n 0
+    1510649n 0
+    1510650n 1.8
+    1510699n 1.8
+    1510700n 0
+    1510749n 0
+    1510750n 1.8
+    1510799n 1.8
+    1510800n 0
+    1510849n 0
+    1510850n 1.8
+    1510899n 1.8
+    1510900n 0
+    1510949n 0
+    1510950n 1.8
+    1510999n 1.8
+    1511000n 0
+    1511049n 0
+    1511050n 1.8
+    1511099n 1.8
+    1511100n 0
+    1511149n 0
+    1511150n 1.8
+    1511199n 1.8
+    1511200n 0
+    1511249n 0
+    1511250n 1.8
+    1511299n 1.8
+    1511300n 0
+    1511349n 0
+    1511350n 1.8
+    1511399n 1.8
+    1511400n 0
+    1511449n 0
+    1511450n 1.8
+    1511499n 1.8
+    1511500n 0
+    1511549n 0
+    1511550n 1.8
+    1511599n 1.8
+    1511600n 0
+    1511649n 0
+    1511650n 1.8
+    1511699n 1.8
+    1511700n 0
+    1511749n 0
+    1511750n 1.8
+    1511799n 1.8
+    1511800n 0
+    1511849n 0
+    1511850n 1.8
+    1511899n 1.8
+    1511900n 0
+    1511949n 0
+    1511950n 1.8
+    1511999n 1.8
+    1512000n 0
+    1512049n 0
+    1512050n 1.8
+    1512099n 1.8
+    1512100n 0
+    1512149n 0
+    1512150n 1.8
+    1512199n 1.8
+    1512200n 0
+    1512249n 0
+    1512250n 1.8
+    1512299n 1.8
+    1512300n 0
+    1512349n 0
+    1512350n 1.8
+    1512399n 1.8
+    1512400n 0
+    1512449n 0
+    1512450n 1.8
+    1512499n 1.8
+    1512500n 0
+    1512549n 0
+    1512550n 1.8
+    1512599n 1.8
+    1512600n 0
+    1512649n 0
+    1512650n 1.8
+    1512699n 1.8
+    1512700n 0
+    1512749n 0
+    1512750n 1.8
+    1512799n 1.8
+    1512800n 0
+    1512849n 0
+    1512850n 1.8
+    1512899n 1.8
+    1512900n 0
+    1512949n 0
+    1512950n 1.8
+    1512999n 1.8
+    1513000n 0
+    1513049n 0
+    1513050n 1.8
+    1513099n 1.8
+    1513100n 0
+    1513149n 0
+    1513150n 1.8
+    1513199n 1.8
+    1513200n 0
+    1513249n 0
+    1513250n 1.8
+    1513299n 1.8
+    1513300n 0
+    1513349n 0
+    1513350n 1.8
+    1513399n 1.8
+    1513400n 0
+    1513449n 0
+    1513450n 1.8
+    1513499n 1.8
+    1513500n 0
+    1513549n 0
+    1513550n 1.8
+    1513599n 1.8
+    1513600n 0
+    1513649n 0
+    1513650n 1.8
+    1513699n 1.8
+    1513700n 0
+    1513749n 0
+    1513750n 1.8
+    1513799n 1.8
+    1513800n 0
+    1513849n 0
+    1513850n 1.8
+    1513899n 1.8
+    1513900n 0
+    1513949n 0
+    1513950n 1.8
+    1513999n 1.8
+    1514000n 0
+    1514049n 0
+    1514050n 1.8
+    1514099n 1.8
+    1514100n 0
+    1514149n 0
+    1514150n 1.8
+    1514199n 1.8
+    1514200n 0
+    1514249n 0
+    1514250n 1.8
+    1514299n 1.8
+    1514300n 0
+    1514349n 0
+    1514350n 1.8
+    1514399n 1.8
+    1514400n 0
+    1514449n 0
+    1514450n 1.8
+    1514499n 1.8
+    1514500n 0
+    1514549n 0
+    1514550n 1.8
+    1514599n 1.8
+    1514600n 0
+    1514649n 0
+    1514650n 1.8
+    1514699n 1.8
+    1514700n 0
+    1514749n 0
+    1514750n 1.8
+    1514799n 1.8
+    1514800n 0
+    1514849n 0
+    1514850n 1.8
+    1514899n 1.8
+    1514900n 0
+    1514949n 0
+    1514950n 1.8
+    1514999n 1.8
+    1515000n 0
+    1515049n 0
+    1515050n 1.8
+    1515099n 1.8
+    1515100n 0
+    1515149n 0
+    1515150n 1.8
+    1515199n 1.8
+    1515200n 0
+    1515249n 0
+    1515250n 1.8
+    1515299n 1.8
+    1515300n 0
+    1515349n 0
+    1515350n 1.8
+    1515399n 1.8
+    1515400n 0
+    1515449n 0
+    1515450n 1.8
+    1515499n 1.8
+    1515500n 0
+    1515549n 0
+    1515550n 1.8
+    1515599n 1.8
+    1515600n 0
+    1515649n 0
+    1515650n 1.8
+    1515699n 1.8
+    1515700n 0
+    1515749n 0
+    1515750n 1.8
+    1515799n 1.8
+    1515800n 0
+    1515849n 0
+    1515850n 1.8
+    1515899n 1.8
+    1515900n 0
+    1515949n 0
+    1515950n 1.8
+    1515999n 1.8
+    1516000n 0
+    1516049n 0
+    1516050n 1.8
+    1516099n 1.8
+    1516100n 0
+    1516149n 0
+    1516150n 1.8
+    1516199n 1.8
+    1516200n 0
+    1516249n 0
+    1516250n 1.8
+    1516299n 1.8
+    1516300n 0
+    1516349n 0
+    1516350n 1.8
+    1516399n 1.8
+    1516400n 0
+    1516449n 0
+    1516450n 1.8
+    1516499n 1.8
+    1516500n 0
+    1516549n 0
+    1516550n 1.8
+    1516599n 1.8
+    1516600n 0
+    1516649n 0
+    1516650n 1.8
+    1516699n 1.8
+    1516700n 0
+    1516749n 0
+    1516750n 1.8
+    1516799n 1.8
+    1516800n 0
+    1516849n 0
+    1516850n 1.8
+    1516899n 1.8
+    1516900n 0
+    1516949n 0
+    1516950n 1.8
+    1516999n 1.8
+    1517000n 0
+    1517049n 0
+    1517050n 1.8
+    1517099n 1.8
+    1517100n 0
+    1517149n 0
+    1517150n 1.8
+    1517199n 1.8
+    1517200n 0
+    1517249n 0
+    1517250n 1.8
+    1517299n 1.8
+    1517300n 0
+    1517349n 0
+    1517350n 1.8
+    1517399n 1.8
+    1517400n 0
+    1517449n 0
+    1517450n 1.8
+    1517499n 1.8
+    1517500n 0
+    1517549n 0
+    1517550n 1.8
+    1517599n 1.8
+    1517600n 0
+    1517649n 0
+    1517650n 1.8
+    1517699n 1.8
+    1517700n 0
+    1517749n 0
+    1517750n 1.8
+    1517799n 1.8
+    1517800n 0
+    1517849n 0
+    1517850n 1.8
+    1517899n 1.8
+    1517900n 0
+    1517949n 0
+    1517950n 1.8
+    1517999n 1.8
+    1518000n 0
+    1518049n 0
+    1518050n 1.8
+    1518099n 1.8
+    1518100n 0
+    1518149n 0
+    1518150n 1.8
+    1518199n 1.8
+    1518200n 0
+    1518249n 0
+    1518250n 1.8
+    1518299n 1.8
+    1518300n 0
+    1518349n 0
+    1518350n 1.8
+    1518399n 1.8
+    1518400n 0
+    1518449n 0
+    1518450n 1.8
+    1518499n 1.8
+    1518500n 0
+    1518549n 0
+    1518550n 1.8
+    1518599n 1.8
+    1518600n 0
+    1518649n 0
+    1518650n 1.8
+    1518699n 1.8
+    1518700n 0
+    1518749n 0
+    1518750n 1.8
+    1518799n 1.8
+    1518800n 0
+    1518849n 0
+    1518850n 1.8
+    1518899n 1.8
+    1518900n 0
+    1518949n 0
+    1518950n 1.8
+    1518999n 1.8
+    1519000n 0
+    1519049n 0
+    1519050n 1.8
+    1519099n 1.8
+    1519100n 0
+    1519149n 0
+    1519150n 1.8
+    1519199n 1.8
+    1519200n 0
+    1519249n 0
+    1519250n 1.8
+    1519299n 1.8
+    1519300n 0
+    1519349n 0
+    1519350n 1.8
+    1519399n 1.8
+    1519400n 0
+    1519449n 0
+    1519450n 1.8
+    1519499n 1.8
+    1519500n 0
+    1519549n 0
+    1519550n 1.8
+    1519599n 1.8
+    1519600n 0
+    1519649n 0
+    1519650n 1.8
+    1519699n 1.8
+    1519700n 0
+    1519749n 0
+    1519750n 1.8
+    1519799n 1.8
+    1519800n 0
+    1519849n 0
+    1519850n 1.8
+    1519899n 1.8
+    1519900n 0
+    1519949n 0
+    1519950n 1.8
+    1519999n 1.8
+    1520000n 0
+    1520049n 0
+    1520050n 1.8
+    1520099n 1.8
+    1520100n 0
+    1520149n 0
+    1520150n 1.8
+    1520199n 1.8
+    1520200n 0
+    1520249n 0
+    1520250n 1.8
+    1520299n 1.8
+    1520300n 0
+    1520349n 0
+    1520350n 1.8
+    1520399n 1.8
+    1520400n 0
+    1520449n 0
+    1520450n 1.8
+    1520499n 1.8
+    1520500n 0
+    1520549n 0
+    1520550n 1.8
+    1520599n 1.8
+    1520600n 0
+    1520649n 0
+    1520650n 1.8
+    1520699n 1.8
+    1520700n 0
+    1520749n 0
+    1520750n 1.8
+    1520799n 1.8
+    1520800n 0
+    1520849n 0
+    1520850n 1.8
+    1520899n 1.8
+    1520900n 0
+    1520949n 0
+    1520950n 1.8
+    1520999n 1.8
+    1521000n 0
+    1521049n 0
+    1521050n 1.8
+    1521099n 1.8
+    1521100n 0
+    1521149n 0
+    1521150n 1.8
+    1521199n 1.8
+    1521200n 0
+    1521249n 0
+    1521250n 1.8
+    1521299n 1.8
+    1521300n 0
+    1521349n 0
+    1521350n 1.8
+    1521399n 1.8
+    1521400n 0
+    1521449n 0
+    1521450n 1.8
+    1521499n 1.8
+    1521500n 0
+    1521549n 0
+    1521550n 1.8
+    1521599n 1.8
+    1521600n 0
+    1521649n 0
+    1521650n 1.8
+    1521699n 1.8
+    1521700n 0
+    1521749n 0
+    1521750n 1.8
+    1521799n 1.8
+    1521800n 0
+    1521849n 0
+    1521850n 1.8
+    1521899n 1.8
+    1521900n 0
+    1521949n 0
+    1521950n 1.8
+    1521999n 1.8
+    1522000n 0
+    1522049n 0
+    1522050n 1.8
+    1522099n 1.8
+    1522100n 0
+    1522149n 0
+    1522150n 1.8
+    1522199n 1.8
+    1522200n 0
+    1522249n 0
+    1522250n 1.8
+    1522299n 1.8
+    1522300n 0
+    1522349n 0
+    1522350n 1.8
+    1522399n 1.8
+    1522400n 0
+    1522449n 0
+    1522450n 1.8
+    1522499n 1.8
+    1522500n 0
+    1522549n 0
+    1522550n 1.8
+    1522599n 1.8
+    1522600n 0
+    1522649n 0
+    1522650n 1.8
+    1522699n 1.8
+    1522700n 0
+    1522749n 0
+    1522750n 1.8
+    1522799n 1.8
+    1522800n 0
+    1522849n 0
+    1522850n 1.8
+    1522899n 1.8
+    1522900n 0
+    1522949n 0
+    1522950n 1.8
+    1522999n 1.8
+    1523000n 0
+    1523049n 0
+    1523050n 1.8
+    1523099n 1.8
+    1523100n 0
+    1523149n 0
+    1523150n 1.8
+    1523199n 1.8
+    1523200n 0
+    1523249n 0
+    1523250n 1.8
+    1523299n 1.8
+    1523300n 0
+    1523349n 0
+    1523350n 1.8
+    1523399n 1.8
+    1523400n 0
+    1523449n 0
+    1523450n 1.8
+    1523499n 1.8
+    1523500n 0
+    1523549n 0
+    1523550n 1.8
+    1523599n 1.8
+    1523600n 0
+    1523649n 0
+    1523650n 1.8
+    1523699n 1.8
+    1523700n 0
+    1523749n 0
+    1523750n 1.8
+    1523799n 1.8
+    1523800n 0
+    1523849n 0
+    1523850n 1.8
+    1523899n 1.8
+    1523900n 0
+    1523949n 0
+    1523950n 1.8
+    1523999n 1.8
+    1524000n 0
+    1524049n 0
+    1524050n 1.8
+    1524099n 1.8
+    1524100n 0
+    1524149n 0
+    1524150n 1.8
+    1524199n 1.8
+    1524200n 0
+    1524249n 0
+    1524250n 1.8
+    1524299n 1.8
+    1524300n 0
+    1524349n 0
+    1524350n 1.8
+    1524399n 1.8
+    1524400n 0
+    1524449n 0
+    1524450n 1.8
+    1524499n 1.8
+    1524500n 0
+    1524549n 0
+    1524550n 1.8
+    1524599n 1.8
+    1524600n 0
+    1524649n 0
+    1524650n 1.8
+    1524699n 1.8
+    1524700n 0
+    1524749n 0
+    1524750n 1.8
+    1524799n 1.8
+    1524800n 0
+    1524849n 0
+    1524850n 1.8
+    1524899n 1.8
+    1524900n 0
+    1524949n 0
+    1524950n 1.8
+    1524999n 1.8
+    1525000n 0
+    1525049n 0
+    1525050n 1.8
+    1525099n 1.8
+    1525100n 0
+    1525149n 0
+    1525150n 1.8
+    1525199n 1.8
+    1525200n 0
+    1525249n 0
+    1525250n 1.8
+    1525299n 1.8
+    1525300n 0
+    1525349n 0
+    1525350n 1.8
+    1525399n 1.8
+    1525400n 0
+    1525449n 0
+    1525450n 1.8
+    1525499n 1.8
+    1525500n 0
+    1525549n 0
+    1525550n 1.8
+    1525599n 1.8
+    1525600n 0
+    1525649n 0
+    1525650n 1.8
+    1525699n 1.8
+    1525700n 0
+    1525749n 0
+    1525750n 1.8
+    1525799n 1.8
+    1525800n 0
+    1525849n 0
+    1525850n 1.8
+    1525899n 1.8
+    1525900n 0
+    1525949n 0
+    1525950n 1.8
+    1525999n 1.8
+    1526000n 0
+    1526049n 0
+    1526050n 1.8
+    1526099n 1.8
+    1526100n 0
+    1526149n 0
+    1526150n 1.8
+    1526199n 1.8
+    1526200n 0
+    1526249n 0
+    1526250n 1.8
+    1526299n 1.8
+    1526300n 0
+    1526349n 0
+    1526350n 1.8
+    1526399n 1.8
+    1526400n 0
+    1526449n 0
+    1526450n 1.8
+    1526499n 1.8
+    1526500n 0
+    1526549n 0
+    1526550n 1.8
+    1526599n 1.8
+    1526600n 0
+    1526649n 0
+    1526650n 1.8
+    1526699n 1.8
+    1526700n 0
+    1526749n 0
+    1526750n 1.8
+    1526799n 1.8
+    1526800n 0
+    1526849n 0
+    1526850n 1.8
+    1526899n 1.8
+    1526900n 0
+    1526949n 0
+    1526950n 1.8
+    1526999n 1.8
+    1527000n 0
+    1527049n 0
+    1527050n 1.8
+    1527099n 1.8
+    1527100n 0
+    1527149n 0
+    1527150n 1.8
+    1527199n 1.8
+    1527200n 0
+    1527249n 0
+    1527250n 1.8
+    1527299n 1.8
+    1527300n 0
+    1527349n 0
+    1527350n 1.8
+    1527399n 1.8
+    1527400n 0
+    1527449n 0
+    1527450n 1.8
+    1527499n 1.8
+    1527500n 0
+    1527549n 0
+    1527550n 1.8
+    1527599n 1.8
+    1527600n 0
+    1527649n 0
+    1527650n 1.8
+    1527699n 1.8
+    1527700n 0
+    1527749n 0
+    1527750n 1.8
+    1527799n 1.8
+    1527800n 0
+    1527849n 0
+    1527850n 1.8
+    1527899n 1.8
+    1527900n 0
+    1527949n 0
+    1527950n 1.8
+    1527999n 1.8
+    1528000n 0
+    1528049n 0
+    1528050n 1.8
+    1528099n 1.8
+    1528100n 0
+    1528149n 0
+    1528150n 1.8
+    1528199n 1.8
+    1528200n 0
+    1528249n 0
+    1528250n 1.8
+    1528299n 1.8
+    1528300n 0
+    1528349n 0
+    1528350n 1.8
+    1528399n 1.8
+    1528400n 0
+    1528449n 0
+    1528450n 1.8
+    1528499n 1.8
+    1528500n 0
+    1528549n 0
+    1528550n 1.8
+    1528599n 1.8
+    1528600n 0
+    1528649n 0
+    1528650n 1.8
+    1528699n 1.8
+    1528700n 0
+    1528749n 0
+    1528750n 1.8
+    1528799n 1.8
+    1528800n 0
+    1528849n 0
+    1528850n 1.8
+    1528899n 1.8
+    1528900n 0
+    1528949n 0
+    1528950n 1.8
+    1528999n 1.8
+    1529000n 0
+    1529049n 0
+    1529050n 1.8
+    1529099n 1.8
+    1529100n 0
+    1529149n 0
+    1529150n 1.8
+    1529199n 1.8
+    1529200n 0
+    1529249n 0
+    1529250n 1.8
+    1529299n 1.8
+    1529300n 0
+    1529349n 0
+    1529350n 1.8
+    1529399n 1.8
+    1529400n 0
+    1529449n 0
+    1529450n 1.8
+    1529499n 1.8
+    1529500n 0
+    1529549n 0
+    1529550n 1.8
+    1529599n 1.8
+    1529600n 0
+    1529649n 0
+    1529650n 1.8
+    1529699n 1.8
+    1529700n 0
+    1529749n 0
+    1529750n 1.8
+    1529799n 1.8
+    1529800n 0
+    1529849n 0
+    1529850n 1.8
+    1529899n 1.8
+    1529900n 0
+    1529949n 0
+    1529950n 1.8
+    1529999n 1.8
+    1530000n 0
+    1530049n 0
+    1530050n 1.8
+    1530099n 1.8
+    1530100n 0
+    1530149n 0
+    1530150n 1.8
+    1530199n 1.8
+    1530200n 0
+    1530249n 0
+    1530250n 1.8
+    1530299n 1.8
+    1530300n 0
+    1530349n 0
+    1530350n 1.8
+    1530399n 1.8
+    1530400n 0
+    1530449n 0
+    1530450n 1.8
+    1530499n 1.8
+    1530500n 0
+    1530549n 0
+    1530550n 1.8
+    1530599n 1.8
+    1530600n 0
+    1530649n 0
+    1530650n 1.8
+    1530699n 1.8
+    1530700n 0
+    1530749n 0
+    1530750n 1.8
+    1530799n 1.8
+    1530800n 0
+    1530849n 0
+    1530850n 1.8
+    1530899n 1.8
+    1530900n 0
+    1530949n 0
+    1530950n 1.8
+    1530999n 1.8
+    1531000n 0
+    1531049n 0
+    1531050n 1.8
+    1531099n 1.8
+    1531100n 0
+    1531149n 0
+    1531150n 1.8
+    1531199n 1.8
+    1531200n 0
+    1531249n 0
+    1531250n 1.8
+    1531299n 1.8
+    1531300n 0
+    1531349n 0
+    1531350n 1.8
+    1531399n 1.8
+    1531400n 0
+    1531449n 0
+    1531450n 1.8
+    1531499n 1.8
+    1531500n 0
+    1531549n 0
+    1531550n 1.8
+    1531599n 1.8
+    1531600n 0
+    1531649n 0
+    1531650n 1.8
+    1531699n 1.8
+    1531700n 0
+    1531749n 0
+    1531750n 1.8
+    1531799n 1.8
+    1531800n 0
+    1531849n 0
+    1531850n 1.8
+    1531899n 1.8
+    1531900n 0
+    1531949n 0
+    1531950n 1.8
+    1531999n 1.8
+    1532000n 0
+    1532049n 0
+    1532050n 1.8
+    1532099n 1.8
+    1532100n 0
+    1532149n 0
+    1532150n 1.8
+    1532199n 1.8
+    1532200n 0
+    1532249n 0
+    1532250n 1.8
+    1532299n 1.8
+    1532300n 0
+    1532349n 0
+    1532350n 1.8
+    1532399n 1.8
+    1532400n 0
+    1532449n 0
+    1532450n 1.8
+    1532499n 1.8
+    1532500n 0
+    1532549n 0
+    1532550n 1.8
+    1532599n 1.8
+    1532600n 0
+    1532649n 0
+    1532650n 1.8
+    1532699n 1.8
+    1532700n 0
+    1532749n 0
+    1532750n 1.8
+    1532799n 1.8
+    1532800n 0
+    1532849n 0
+    1532850n 1.8
+    1532899n 1.8
+    1532900n 0
+    1532949n 0
+    1532950n 1.8
+    1532999n 1.8
+    1533000n 0
+    1533049n 0
+    1533050n 1.8
+    1533099n 1.8
+    1533100n 0
+    1533149n 0
+    1533150n 1.8
+    1533199n 1.8
+    1533200n 0
+    1533249n 0
+    1533250n 1.8
+    1533299n 1.8
+    1533300n 0
+    1533349n 0
+    1533350n 1.8
+    1533399n 1.8
+    1533400n 0
+    1533449n 0
+    1533450n 1.8
+    1533499n 1.8
+    1533500n 0
+    1533549n 0
+    1533550n 1.8
+    1533599n 1.8
+    1533600n 0
+    1533649n 0
+    1533650n 1.8
+    1533699n 1.8
+    1533700n 0
+    1533749n 0
+    1533750n 1.8
+    1533799n 1.8
+    1533800n 0
+    1533849n 0
+    1533850n 1.8
+    1533899n 1.8
+    1533900n 0
+    1533949n 0
+    1533950n 1.8
+    1533999n 1.8
+    1534000n 0
+    1534049n 0
+    1534050n 1.8
+    1534099n 1.8
+    1534100n 0
+    1534149n 0
+    1534150n 1.8
+    1534199n 1.8
+    1534200n 0
+    1534249n 0
+    1534250n 1.8
+    1534299n 1.8
+    1534300n 0
+    1534349n 0
+    1534350n 1.8
+    1534399n 1.8
+    1534400n 0
+    1534449n 0
+    1534450n 1.8
+    1534499n 1.8
+    1534500n 0
+    1534549n 0
+    1534550n 1.8
+    1534599n 1.8
+    1534600n 0
+    1534649n 0
+    1534650n 1.8
+    1534699n 1.8
+    1534700n 0
+    1534749n 0
+    1534750n 1.8
+    1534799n 1.8
+    1534800n 0
+    1534849n 0
+    1534850n 1.8
+    1534899n 1.8
+    1534900n 0
+    1534949n 0
+    1534950n 1.8
+    1534999n 1.8
+    1535000n 0
+    1535049n 0
+    1535050n 1.8
+    1535099n 1.8
+    1535100n 0
+    1535149n 0
+    1535150n 1.8
+    1535199n 1.8
+    1535200n 0
+    1535249n 0
+    1535250n 1.8
+    1535299n 1.8
+    1535300n 0
+    1535349n 0
+    1535350n 1.8
+    1535399n 1.8
+    1535400n 0
+    1535449n 0
+    1535450n 1.8
+    1535499n 1.8
+    1535500n 0
+    1535549n 0
+    1535550n 1.8
+    1535599n 1.8
+    1535600n 0
+    1535649n 0
+    1535650n 1.8
+    1535699n 1.8
+    1535700n 0
+    1535749n 0
+    1535750n 1.8
+    1535799n 1.8
+    1535800n 0
+    1535849n 0
+    1535850n 1.8
+    1535899n 1.8
+    1535900n 0
+    1535949n 0
+    1535950n 1.8
+    1535999n 1.8
+    1536000n 0
+    1536049n 0
+    1536050n 1.8
+    1536099n 1.8
+    1536100n 0
+    1536149n 0
+    1536150n 1.8
+    1536199n 1.8
+    1536200n 0
+    1536249n 0
+    1536250n 1.8
+    1536299n 1.8
+    1536300n 0
+    1536349n 0
+    1536350n 1.8
+    1536399n 1.8
+    1536400n 0
+    1536449n 0
+    1536450n 1.8
+    1536499n 1.8
+    1536500n 0
+    1536549n 0
+    1536550n 1.8
+    1536599n 1.8
+    1536600n 0
+    1536649n 0
+    1536650n 1.8
+    1536699n 1.8
+    1536700n 0
+    1536749n 0
+    1536750n 1.8
+    1536799n 1.8
+    1536800n 0
+    1536849n 0
+    1536850n 1.8
+    1536899n 1.8
+    1536900n 0
+    1536949n 0
+    1536950n 1.8
+    1536999n 1.8
+    1537000n 0
+    1537049n 0
+    1537050n 1.8
+    1537099n 1.8
+    1537100n 0
+    1537149n 0
+    1537150n 1.8
+    1537199n 1.8
+    1537200n 0
+    1537249n 0
+    1537250n 1.8
+    1537299n 1.8
+    1537300n 0
+    1537349n 0
+    1537350n 1.8
+    1537399n 1.8
+    1537400n 0
+    1537449n 0
+    1537450n 1.8
+    1537499n 1.8
+    1537500n 0
+    1537549n 0
+    1537550n 1.8
+    1537599n 1.8
+    1537600n 0
+    1537649n 0
+    1537650n 1.8
+    1537699n 1.8
+    1537700n 0
+    1537749n 0
+    1537750n 1.8
+    1537799n 1.8
+    1537800n 0
+    1537849n 0
+    1537850n 1.8
+    1537899n 1.8
+    1537900n 0
+    1537949n 0
+    1537950n 1.8
+    1537999n 1.8
+    1538000n 0
+    1538049n 0
+    1538050n 1.8
+    1538099n 1.8
+    1538100n 0
+    1538149n 0
+    1538150n 1.8
+    1538199n 1.8
+    1538200n 0
+    1538249n 0
+    1538250n 1.8
+    1538299n 1.8
+    1538300n 0
+    1538349n 0
+    1538350n 1.8
+    1538399n 1.8
+    1538400n 0
+    1538449n 0
+    1538450n 1.8
+    1538499n 1.8
+    1538500n 0
+    1538549n 0
+    1538550n 1.8
+    1538599n 1.8
+    1538600n 0
+    1538649n 0
+    1538650n 1.8
+    1538699n 1.8
+    1538700n 0
+    1538749n 0
+    1538750n 1.8
+    1538799n 1.8
+    1538800n 0
+    1538849n 0
+    1538850n 1.8
+    1538899n 1.8
+    1538900n 0
+    1538949n 0
+    1538950n 1.8
+    1538999n 1.8
+    1539000n 0
+    1539049n 0
+    1539050n 1.8
+    1539099n 1.8
+    1539100n 0
+    1539149n 0
+    1539150n 1.8
+    1539199n 1.8
+    1539200n 0
+    1539249n 0
+    1539250n 1.8
+    1539299n 1.8
+    1539300n 0
+    1539349n 0
+    1539350n 1.8
+    1539399n 1.8
+    1539400n 0
+    1539449n 0
+    1539450n 1.8
+    1539499n 1.8
+    1539500n 0
+    1539549n 0
+    1539550n 1.8
+    1539599n 1.8
+    1539600n 0
+    1539649n 0
+    1539650n 1.8
+    1539699n 1.8
+    1539700n 0
+    1539749n 0
+    1539750n 1.8
+    1539799n 1.8
+    1539800n 0
+    1539849n 0
+    1539850n 1.8
+    1539899n 1.8
+    1539900n 0
+    1539949n 0
+    1539950n 1.8
+    1539999n 1.8
+    1540000n 0
+    1540049n 0
+    1540050n 1.8
+    1540099n 1.8
+    1540100n 0
+    1540149n 0
+    1540150n 1.8
+    1540199n 1.8
+    1540200n 0
+    1540249n 0
+    1540250n 1.8
+    1540299n 1.8
+    1540300n 0
+    1540349n 0
+    1540350n 1.8
+    1540399n 1.8
+    1540400n 0
+    1540449n 0
+    1540450n 1.8
+    1540499n 1.8
+    1540500n 0
+    1540549n 0
+    1540550n 1.8
+    1540599n 1.8
+    1540600n 0
+    1540649n 0
+    1540650n 1.8
+    1540699n 1.8
+    1540700n 0
+    1540749n 0
+    1540750n 1.8
+    1540799n 1.8
+    1540800n 0
+    1540849n 0
+    1540850n 1.8
+    1540899n 1.8
+    1540900n 0
+    1540949n 0
+    1540950n 1.8
+    1540999n 1.8
+    1541000n 0
+    1541049n 0
+    1541050n 1.8
+    1541099n 1.8
+    1541100n 0
+    1541149n 0
+    1541150n 1.8
+    1541199n 1.8
+    1541200n 0
+    1541249n 0
+    1541250n 1.8
+    1541299n 1.8
+    1541300n 0
+    1541349n 0
+    1541350n 1.8
+    1541399n 1.8
+    1541400n 0
+    1541449n 0
+    1541450n 1.8
+    1541499n 1.8
+    1541500n 0
+    1541549n 0
+    1541550n 1.8
+    1541599n 1.8
+    1541600n 0
+    1541649n 0
+    1541650n 1.8
+    1541699n 1.8
+    1541700n 0
+    1541749n 0
+    1541750n 1.8
+    1541799n 1.8
+    1541800n 0
+    1541849n 0
+    1541850n 1.8
+    1541899n 1.8
+    1541900n 0
+    1541949n 0
+    1541950n 1.8
+    1541999n 1.8
+    1542000n 0
+    1542049n 0
+    1542050n 1.8
+    1542099n 1.8
+    1542100n 0
+    1542149n 0
+    1542150n 1.8
+    1542199n 1.8
+    1542200n 0
+    1542249n 0
+    1542250n 1.8
+    1542299n 1.8
+    1542300n 0
+    1542349n 0
+    1542350n 1.8
+    1542399n 1.8
+    1542400n 0
+    1542449n 0
+    1542450n 1.8
+    1542499n 1.8
+    1542500n 0
+    1542549n 0
+    1542550n 1.8
+    1542599n 1.8
+    1542600n 0
+    1542649n 0
+    1542650n 1.8
+    1542699n 1.8
+    1542700n 0
+    1542749n 0
+    1542750n 1.8
+    1542799n 1.8
+    1542800n 0
+    1542849n 0
+    1542850n 1.8
+    1542899n 1.8
+    1542900n 0
+    1542949n 0
+    1542950n 1.8
+    1542999n 1.8
+    1543000n 0
+    1543049n 0
+    1543050n 1.8
+    1543099n 1.8
+    1543100n 0
+    1543149n 0
+    1543150n 1.8
+    1543199n 1.8
+    1543200n 0
+    1543249n 0
+    1543250n 1.8
+    1543299n 1.8
+    1543300n 0
+    1543349n 0
+    1543350n 1.8
+    1543399n 1.8
+    1543400n 0
+    1543449n 0
+    1543450n 1.8
+    1543499n 1.8
+    1543500n 0
+    1543549n 0
+    1543550n 1.8
+    1543599n 1.8
+    1543600n 0
+    1543649n 0
+    1543650n 1.8
+    1543699n 1.8
+    1543700n 0
+    1543749n 0
+    1543750n 1.8
+    1543799n 1.8
+    1543800n 0
+    1543849n 0
+    1543850n 1.8
+    1543899n 1.8
+    1543900n 0
+    1543949n 0
+    1543950n 1.8
+    1543999n 1.8
+    1544000n 0
+    1544049n 0
+    1544050n 1.8
+    1544099n 1.8
+    1544100n 0
+    1544149n 0
+    1544150n 1.8
+    1544199n 1.8
+    1544200n 0
+    1544249n 0
+    1544250n 1.8
+    1544299n 1.8
+    1544300n 0
+    1544349n 0
+    1544350n 1.8
+    1544399n 1.8
+    1544400n 0
+    1544449n 0
+    1544450n 1.8
+    1544499n 1.8
+    1544500n 0
+    1544549n 0
+    1544550n 1.8
+    1544599n 1.8
+    1544600n 0
+    1544649n 0
+    1544650n 1.8
+    1544699n 1.8
+    1544700n 0
+    1544749n 0
+    1544750n 1.8
+    1544799n 1.8
+    1544800n 0
+    1544849n 0
+    1544850n 1.8
+    1544899n 1.8
+    1544900n 0
+    1544949n 0
+    1544950n 1.8
+    1544999n 1.8
+    1545000n 0
+    1545049n 0
+    1545050n 1.8
+    1545099n 1.8
+    1545100n 0
+    1545149n 0
+    1545150n 1.8
+    1545199n 1.8
+    1545200n 0
+    1545249n 0
+    1545250n 1.8
+    1545299n 1.8
+    1545300n 0
+    1545349n 0
+    1545350n 1.8
+    1545399n 1.8
+    1545400n 0
+    1545449n 0
+    1545450n 1.8
+    1545499n 1.8
+    1545500n 0
+    1545549n 0
+    1545550n 1.8
+    1545599n 1.8
+    1545600n 0
+    1545649n 0
+    1545650n 1.8
+    1545699n 1.8
+    1545700n 0
+    1545749n 0
+    1545750n 1.8
+    1545799n 1.8
+    1545800n 0
+    1545849n 0
+    1545850n 1.8
+    1545899n 1.8
+    1545900n 0
+    1545949n 0
+    1545950n 1.8
+    1545999n 1.8
+    1546000n 0
+    1546049n 0
+    1546050n 1.8
+    1546099n 1.8
+    1546100n 0
+    1546149n 0
+    1546150n 1.8
+    1546199n 1.8
+    1546200n 0
+    1546249n 0
+    1546250n 1.8
+    1546299n 1.8
+    1546300n 0
+    1546349n 0
+    1546350n 1.8
+    1546399n 1.8
+    1546400n 0
+    1546449n 0
+    1546450n 1.8
+    1546499n 1.8
+    1546500n 0
+    1546549n 0
+    1546550n 1.8
+    1546599n 1.8
+    1546600n 0
+    1546649n 0
+    1546650n 1.8
+    1546699n 1.8
+    1546700n 0
+    1546749n 0
+    1546750n 1.8
+    1546799n 1.8
+    1546800n 0
+    1546849n 0
+    1546850n 1.8
+    1546899n 1.8
+    1546900n 0
+    1546949n 0
+    1546950n 1.8
+    1546999n 1.8
+    1547000n 0
+    1547049n 0
+    1547050n 1.8
+    1547099n 1.8
+    1547100n 0
+    1547149n 0
+    1547150n 1.8
+    1547199n 1.8
+    1547200n 0
+    1547249n 0
+    1547250n 1.8
+    1547299n 1.8
+    1547300n 0
+    1547349n 0
+    1547350n 1.8
+    1547399n 1.8
+    1547400n 0
+    1547449n 0
+    1547450n 1.8
+    1547499n 1.8
+    1547500n 0
+    1547549n 0
+    1547550n 1.8
+    1547599n 1.8
+    1547600n 0
+    1547649n 0
+    1547650n 1.8
+    1547699n 1.8
+    1547700n 0
+    1547749n 0
+    1547750n 1.8
+    1547799n 1.8
+    1547800n 0
+    1547849n 0
+    1547850n 1.8
+    1547899n 1.8
+    1547900n 0
+    1547949n 0
+    1547950n 1.8
+    1547999n 1.8
+    1548000n 0
+    1548049n 0
+    1548050n 1.8
+    1548099n 1.8
+    1548100n 0
+    1548149n 0
+    1548150n 1.8
+    1548199n 1.8
+    1548200n 0
+    1548249n 0
+    1548250n 1.8
+    1548299n 1.8
+    1548300n 0
+    1548349n 0
+    1548350n 1.8
+    1548399n 1.8
+    1548400n 0
+    1548449n 0
+    1548450n 1.8
+    1548499n 1.8
+    1548500n 0
+    1548549n 0
+    1548550n 1.8
+    1548599n 1.8
+    1548600n 0
+    1548649n 0
+    1548650n 1.8
+    1548699n 1.8
+    1548700n 0
+    1548749n 0
+    1548750n 1.8
+    1548799n 1.8
+    1548800n 0
+    1548849n 0
+    1548850n 1.8
+    1548899n 1.8
+    1548900n 0
+    1548949n 0
+    1548950n 1.8
+    1548999n 1.8
+    1549000n 0
+    1549049n 0
+    1549050n 1.8
+    1549099n 1.8
+    1549100n 0
+    1549149n 0
+    1549150n 1.8
+    1549199n 1.8
+    1549200n 0
+    1549249n 0
+    1549250n 1.8
+    1549299n 1.8
+    1549300n 0
+    1549349n 0
+    1549350n 1.8
+    1549399n 1.8
+    1549400n 0
+    1549449n 0
+    1549450n 1.8
+    1549499n 1.8
+    1549500n 0
+    1549549n 0
+    1549550n 1.8
+    1549599n 1.8
+    1549600n 0
+    1549649n 0
+    1549650n 1.8
+    1549699n 1.8
+    1549700n 0
+    1549749n 0
+    1549750n 1.8
+    1549799n 1.8
+    1549800n 0
+    1549849n 0
+    1549850n 1.8
+    1549899n 1.8
+    1549900n 0
+    1549949n 0
+    1549950n 1.8
+    1549999n 1.8
+    1550000n 0
+    1550049n 0
+    1550050n 1.8
+    1550099n 1.8
+    1550100n 0
+    1550149n 0
+    1550150n 1.8
+    1550199n 1.8
+    1550200n 0
+    1550249n 0
+    1550250n 1.8
+    1550299n 1.8
+    1550300n 0
+    1550349n 0
+    1550350n 1.8
+    1550399n 1.8
+    1550400n 0
+    1550449n 0
+    1550450n 1.8
+    1550499n 1.8
+    1550500n 0
+    1550549n 0
+    1550550n 1.8
+    1550599n 1.8
+    1550600n 0
+    1550649n 0
+    1550650n 1.8
+    1550699n 1.8
+    1550700n 0
+    1550749n 0
+    1550750n 1.8
+    1550799n 1.8
+    1550800n 0
+    1550849n 0
+    1550850n 1.8
+    1550899n 1.8
+    1550900n 0
+    1550949n 0
+    1550950n 1.8
+    1550999n 1.8
+    1551000n 0
+    1551049n 0
+    1551050n 1.8
+    1551099n 1.8
+    1551100n 0
+    1551149n 0
+    1551150n 1.8
+    1551199n 1.8
+    1551200n 0
+    1551249n 0
+    1551250n 1.8
+    1551299n 1.8
+    1551300n 0
+    1551349n 0
+    1551350n 1.8
+    1551399n 1.8
+    1551400n 0
+    1551449n 0
+    1551450n 1.8
+    1551499n 1.8
+    1551500n 0
+    1551549n 0
+    1551550n 1.8
+    1551599n 1.8
+    1551600n 0
+    1551649n 0
+    1551650n 1.8
+    1551699n 1.8
+    1551700n 0
+    1551749n 0
+    1551750n 1.8
+    1551799n 1.8
+    1551800n 0
+    1551849n 0
+    1551850n 1.8
+    1551899n 1.8
+    1551900n 0
+    1551949n 0
+    1551950n 1.8
+    1551999n 1.8
+    1552000n 0
+    1552049n 0
+    1552050n 1.8
+    1552099n 1.8
+    1552100n 0
+    1552149n 0
+    1552150n 1.8
+    1552199n 1.8
+    1552200n 0
+    1552249n 0
+    1552250n 1.8
+    1552299n 1.8
+    1552300n 0
+    1552349n 0
+    1552350n 1.8
+    1552399n 1.8
+    1552400n 0
+    1552449n 0
+    1552450n 1.8
+    1552499n 1.8
+    1552500n 0
+    1552549n 0
+    1552550n 1.8
+    1552599n 1.8
+    1552600n 0
+    1552649n 0
+    1552650n 1.8
+    1552699n 1.8
+    1552700n 0
+    1552749n 0
+    1552750n 1.8
+    1552799n 1.8
+    1552800n 0
+    1552849n 0
+    1552850n 1.8
+    1552899n 1.8
+    1552900n 0
+    1552949n 0
+    1552950n 1.8
+    1552999n 1.8
+    1553000n 0
+    1553049n 0
+    1553050n 1.8
+    1553099n 1.8
+    1553100n 0
+    1553149n 0
+    1553150n 1.8
+    1553199n 1.8
+    1553200n 0
+    1553249n 0
+    1553250n 1.8
+    1553299n 1.8
+    1553300n 0
+    1553349n 0
+    1553350n 1.8
+    1553399n 1.8
+    1553400n 0
+    1553449n 0
+    1553450n 1.8
+    1553499n 1.8
+    1553500n 0
+    1553549n 0
+    1553550n 1.8
+    1553599n 1.8
+    1553600n 0
+    1553649n 0
+    1553650n 1.8
+    1553699n 1.8
+    1553700n 0
+    1553749n 0
+    1553750n 1.8
+    1553799n 1.8
+    1553800n 0
+    1553849n 0
+    1553850n 1.8
+    1553899n 1.8
+    1553900n 0
+    1553949n 0
+    1553950n 1.8
+    1553999n 1.8
+    1554000n 0
+    1554049n 0
+    1554050n 1.8
+    1554099n 1.8
+    1554100n 0
+    1554149n 0
+    1554150n 1.8
+    1554199n 1.8
+    1554200n 0
+    1554249n 0
+    1554250n 1.8
+    1554299n 1.8
+    1554300n 0
+    1554349n 0
+    1554350n 1.8
+    1554399n 1.8
+    1554400n 0
+    1554449n 0
+    1554450n 1.8
+    1554499n 1.8
+    1554500n 0
+    1554549n 0
+    1554550n 1.8
+    1554599n 1.8
+    1554600n 0
+    1554649n 0
+    1554650n 1.8
+    1554699n 1.8
+    1554700n 0
+    1554749n 0
+    1554750n 1.8
+    1554799n 1.8
+    1554800n 0
+    1554849n 0
+    1554850n 1.8
+    1554899n 1.8
+    1554900n 0
+    1554949n 0
+    1554950n 1.8
+    1554999n 1.8
+    1555000n 0
+    1555049n 0
+    1555050n 1.8
+    1555099n 1.8
+    1555100n 0
+    1555149n 0
+    1555150n 1.8
+    1555199n 1.8
+    1555200n 0
+    1555249n 0
+    1555250n 1.8
+    1555299n 1.8
+    1555300n 0
+    1555349n 0
+    1555350n 1.8
+    1555399n 1.8
+    1555400n 0
+    1555449n 0
+    1555450n 1.8
+    1555499n 1.8
+    1555500n 0
+    1555549n 0
+    1555550n 1.8
+    1555599n 1.8
+    1555600n 0
+    1555649n 0
+    1555650n 1.8
+    1555699n 1.8
+    1555700n 0
+    1555749n 0
+    1555750n 1.8
+    1555799n 1.8
+    1555800n 0
+    1555849n 0
+    1555850n 1.8
+    1555899n 1.8
+    1555900n 0
+    1555949n 0
+    1555950n 1.8
+    1555999n 1.8
+    1556000n 0
+    1556049n 0
+    1556050n 1.8
+    1556099n 1.8
+    1556100n 0
+    1556149n 0
+    1556150n 1.8
+    1556199n 1.8
+    1556200n 0
+    1556249n 0
+    1556250n 1.8
+    1556299n 1.8
+    1556300n 0
+    1556349n 0
+    1556350n 1.8
+    1556399n 1.8
+    1556400n 0
+    1556449n 0
+    1556450n 1.8
+    1556499n 1.8
+    1556500n 0
+    1556549n 0
+    1556550n 1.8
+    1556599n 1.8
+    1556600n 0
+    1556649n 0
+    1556650n 1.8
+    1556699n 1.8
+    1556700n 0
+    1556749n 0
+    1556750n 1.8
+    1556799n 1.8
+    1556800n 0
+    1556849n 0
+    1556850n 1.8
+    1556899n 1.8
+    1556900n 0
+    1556949n 0
+    1556950n 1.8
+    1556999n 1.8
+    1557000n 0
+    1557049n 0
+    1557050n 1.8
+    1557099n 1.8
+    1557100n 0
+    1557149n 0
+    1557150n 1.8
+    1557199n 1.8
+    1557200n 0
+    1557249n 0
+    1557250n 1.8
+    1557299n 1.8
+    1557300n 0
+    1557349n 0
+    1557350n 1.8
+    1557399n 1.8
+    1557400n 0
+    1557449n 0
+    1557450n 1.8
+    1557499n 1.8
+    1557500n 0
+    1557549n 0
+    1557550n 1.8
+    1557599n 1.8
+    1557600n 0
+    1557649n 0
+    1557650n 1.8
+    1557699n 1.8
+    1557700n 0
+    1557749n 0
+    1557750n 1.8
+    1557799n 1.8
+    1557800n 0
+    1557849n 0
+    1557850n 1.8
+    1557899n 1.8
+    1557900n 0
+    1557949n 0
+    1557950n 1.8
+    1557999n 1.8
+    1558000n 0
+    1558049n 0
+    1558050n 1.8
+    1558099n 1.8
+    1558100n 0
+    1558149n 0
+    1558150n 1.8
+    1558199n 1.8
+    1558200n 0
+    1558249n 0
+    1558250n 1.8
+    1558299n 1.8
+    1558300n 0
+    1558349n 0
+    1558350n 1.8
+    1558399n 1.8
+    1558400n 0
+    1558449n 0
+    1558450n 1.8
+    1558499n 1.8
+    1558500n 0
+    1558549n 0
+    1558550n 1.8
+    1558599n 1.8
+    1558600n 0
+    1558649n 0
+    1558650n 1.8
+    1558699n 1.8
+    1558700n 0
+    1558749n 0
+    1558750n 1.8
+    1558799n 1.8
+    1558800n 0
+    1558849n 0
+    1558850n 1.8
+    1558899n 1.8
+    1558900n 0
+    1558949n 0
+    1558950n 1.8
+    1558999n 1.8
+    1559000n 0
+    1559049n 0
+    1559050n 1.8
+    1559099n 1.8
+    1559100n 0
+    1559149n 0
+    1559150n 1.8
+    1559199n 1.8
+    1559200n 0
+    1559249n 0
+    1559250n 1.8
+    1559299n 1.8
+    1559300n 0
+    1559349n 0
+    1559350n 1.8
+    1559399n 1.8
+    1559400n 0
+    1559449n 0
+    1559450n 1.8
+    1559499n 1.8
+    1559500n 0
+    1559549n 0
+    1559550n 1.8
+    1559599n 1.8
+    1559600n 0
+    1559649n 0
+    1559650n 1.8
+    1559699n 1.8
+    1559700n 0
+    1559749n 0
+    1559750n 1.8
+    1559799n 1.8
+    1559800n 0
+    1559849n 0
+    1559850n 1.8
+    1559899n 1.8
+    1559900n 0
+    1559949n 0
+    1559950n 1.8
+    1559999n 1.8
+    1560000n 0
+    1560049n 0
+    1560050n 1.8
+    1560099n 1.8
+    1560100n 0
+    1560149n 0
+    1560150n 1.8
+    1560199n 1.8
+    1560200n 0
+    1560249n 0
+    1560250n 1.8
+    1560299n 1.8
+    1560300n 0
+    1560349n 0
+    1560350n 1.8
+    1560399n 1.8
+    1560400n 0
+    1560449n 0
+    1560450n 1.8
+    1560499n 1.8
+    1560500n 0
+    1560549n 0
+    1560550n 1.8
+    1560599n 1.8
+    1560600n 0
+    1560649n 0
+    1560650n 1.8
+    1560699n 1.8
+    1560700n 0
+    1560749n 0
+    1560750n 1.8
+    1560799n 1.8
+    1560800n 0
+    1560849n 0
+    1560850n 1.8
+    1560899n 1.8
+    1560900n 0
+    1560949n 0
+    1560950n 1.8
+    1560999n 1.8
+    1561000n 0
+    1561049n 0
+    1561050n 1.8
+    1561099n 1.8
+    1561100n 0
+    1561149n 0
+    1561150n 1.8
+    1561199n 1.8
+    1561200n 0
+    1561249n 0
+    1561250n 1.8
+    1561299n 1.8
+    1561300n 0
+    1561349n 0
+    1561350n 1.8
+    1561399n 1.8
+    1561400n 0
+    1561449n 0
+    1561450n 1.8
+    1561499n 1.8
+    1561500n 0
+    1561549n 0
+    1561550n 1.8
+    1561599n 1.8
+    1561600n 0
+    1561649n 0
+    1561650n 1.8
+    1561699n 1.8
+    1561700n 0
+    1561749n 0
+    1561750n 1.8
+    1561799n 1.8
+    1561800n 0
+    1561849n 0
+    1561850n 1.8
+    1561899n 1.8
+    1561900n 0
+    1561949n 0
+    1561950n 1.8
+    1561999n 1.8
+    1562000n 0
+    1562049n 0
+    1562050n 1.8
+    1562099n 1.8
+    1562100n 0
+    1562149n 0
+    1562150n 1.8
+    1562199n 1.8
+    1562200n 0
+    1562249n 0
+    1562250n 1.8
+    1562299n 1.8
+    1562300n 0
+    1562349n 0
+    1562350n 1.8
+    1562399n 1.8
+    1562400n 0
+    1562449n 0
+    1562450n 1.8
+    1562499n 1.8
+    1562500n 0
+    1562549n 0
+    1562550n 1.8
+    1562599n 1.8
+    1562600n 0
+    1562649n 0
+    1562650n 1.8
+    1562699n 1.8
+    1562700n 0
+    1562749n 0
+    1562750n 1.8
+    1562799n 1.8
+    1562800n 0
+    1562849n 0
+    1562850n 1.8
+    1562899n 1.8
+    1562900n 0
+    1562949n 0
+    1562950n 1.8
+    1562999n 1.8
+    1563000n 0
+    1563049n 0
+    1563050n 1.8
+    1563099n 1.8
+    1563100n 0
+    1563149n 0
+    1563150n 1.8
+    1563199n 1.8
+    1563200n 0
+    1563249n 0
+    1563250n 1.8
+    1563299n 1.8
+    1563300n 0
+    1563349n 0
+    1563350n 1.8
+    1563399n 1.8
+    1563400n 0
+    1563449n 0
+    1563450n 1.8
+    1563499n 1.8
+    1563500n 0
+    1563549n 0
+    1563550n 1.8
+    1563599n 1.8
+    1563600n 0
+    1563649n 0
+    1563650n 1.8
+    1563699n 1.8
+    1563700n 0
+    1563749n 0
+    1563750n 1.8
+    1563799n 1.8
+    1563800n 0
+    1563849n 0
+    1563850n 1.8
+    1563899n 1.8
+    1563900n 0
+    1563949n 0
+    1563950n 1.8
+    1563999n 1.8
+    1564000n 0
+    1564049n 0
+    1564050n 1.8
+    1564099n 1.8
+    1564100n 0
+    1564149n 0
+    1564150n 1.8
+    1564199n 1.8
+    1564200n 0
+    1564249n 0
+    1564250n 1.8
+    1564299n 1.8
+    1564300n 0
+    1564349n 0
+    1564350n 1.8
+    1564399n 1.8
+    1564400n 0
+    1564449n 0
+    1564450n 1.8
+    1564499n 1.8
+    1564500n 0
+    1564549n 0
+    1564550n 1.8
+    1564599n 1.8
+    1564600n 0
+    1564649n 0
+    1564650n 1.8
+    1564699n 1.8
+    1564700n 0
+    1564749n 0
+    1564750n 1.8
+    1564799n 1.8
+    1564800n 0
+    1564849n 0
+    1564850n 1.8
+    1564899n 1.8
+    1564900n 0
+    1564949n 0
+    1564950n 1.8
+    1564999n 1.8
+    1565000n 0
+    1565049n 0
+    1565050n 1.8
+    1565099n 1.8
+    1565100n 0
+    1565149n 0
+    1565150n 1.8
+    1565199n 1.8
+    1565200n 0
+    1565249n 0
+    1565250n 1.8
+    1565299n 1.8
+    1565300n 0
+    1565349n 0
+    1565350n 1.8
+    1565399n 1.8
+    1565400n 0
+    1565449n 0
+    1565450n 1.8
+    1565499n 1.8
+    1565500n 0
+    1565549n 0
+    1565550n 1.8
+    1565599n 1.8
+    1565600n 0
+    1565649n 0
+    1565650n 1.8
+    1565699n 1.8
+    1565700n 0
+    1565749n 0
+    1565750n 1.8
+    1565799n 1.8
+    1565800n 0
+    1565849n 0
+    1565850n 1.8
+    1565899n 1.8
+    1565900n 0
+    1565949n 0
+    1565950n 1.8
+    1565999n 1.8
+    1566000n 0
+    1566049n 0
+    1566050n 1.8
+    1566099n 1.8
+    1566100n 0
+    1566149n 0
+    1566150n 1.8
+    1566199n 1.8
+    1566200n 0
+    1566249n 0
+    1566250n 1.8
+    1566299n 1.8
+    1566300n 0
+    1566349n 0
+    1566350n 1.8
+    1566399n 1.8
+    1566400n 0
+    1566449n 0
+    1566450n 1.8
+    1566499n 1.8
+    1566500n 0
+    1566549n 0
+    1566550n 1.8
+    1566599n 1.8
+    1566600n 0
+    1566649n 0
+    1566650n 1.8
+    1566699n 1.8
+    1566700n 0
+    1566749n 0
+    1566750n 1.8
+    1566799n 1.8
+    1566800n 0
+    1566849n 0
+    1566850n 1.8
+    1566899n 1.8
+    1566900n 0
+    1566949n 0
+    1566950n 1.8
+    1566999n 1.8
+    1567000n 0
+    1567049n 0
+    1567050n 1.8
+    1567099n 1.8
+    1567100n 0
+    1567149n 0
+    1567150n 1.8
+    1567199n 1.8
+    1567200n 0
+    1567249n 0
+    1567250n 1.8
+    1567299n 1.8
+    1567300n 0
+    1567349n 0
+    1567350n 1.8
+    1567399n 1.8
+    1567400n 0
+    1567449n 0
+    1567450n 1.8
+    1567499n 1.8
+    1567500n 0
+    1567549n 0
+    1567550n 1.8
+    1567599n 1.8
+    1567600n 0
+    1567649n 0
+    1567650n 1.8
+    1567699n 1.8
+    1567700n 0
+    1567749n 0
+    1567750n 1.8
+    1567799n 1.8
+    1567800n 0
+    1567849n 0
+    1567850n 1.8
+    1567899n 1.8
+    1567900n 0
+    1567949n 0
+    1567950n 1.8
+    1567999n 1.8
+    1568000n 0
+    1568049n 0
+    1568050n 1.8
+    1568099n 1.8
+    1568100n 0
+    1568149n 0
+    1568150n 1.8
+    1568199n 1.8
+    1568200n 0
+    1568249n 0
+    1568250n 1.8
+    1568299n 1.8
+    1568300n 0
+    1568349n 0
+    1568350n 1.8
+    1568399n 1.8
+    1568400n 0
+    1568449n 0
+    1568450n 1.8
+    1568499n 1.8
+    1568500n 0
+    1568549n 0
+    1568550n 1.8
+    1568599n 1.8
+    1568600n 0
+    1568649n 0
+    1568650n 1.8
+    1568699n 1.8
+    1568700n 0
+    1568749n 0
+    1568750n 1.8
+    1568799n 1.8
+    1568800n 0
+    1568849n 0
+    1568850n 1.8
+    1568899n 1.8
+    1568900n 0
+    1568949n 0
+    1568950n 1.8
+    1568999n 1.8
+    1569000n 0
+    1569049n 0
+    1569050n 1.8
+    1569099n 1.8
+    1569100n 0
+    1569149n 0
+    1569150n 1.8
+    1569199n 1.8
+    1569200n 0
+    1569249n 0
+    1569250n 1.8
+    1569299n 1.8
+    1569300n 0
+    1569349n 0
+    1569350n 1.8
+    1569399n 1.8
+    1569400n 0
+    1569449n 0
+    1569450n 1.8
+    1569499n 1.8
+    1569500n 0
+    1569549n 0
+    1569550n 1.8
+    1569599n 1.8
+    1569600n 0
+    1569649n 0
+    1569650n 1.8
+    1569699n 1.8
+    1569700n 0
+    1569749n 0
+    1569750n 1.8
+    1569799n 1.8
+    1569800n 0
+    1569849n 0
+    1569850n 1.8
+    1569899n 1.8
+    1569900n 0
+    1569949n 0
+    1569950n 1.8
+    1569999n 1.8
+    1570000n 0
+    1570049n 0
+    1570050n 1.8
+    1570099n 1.8
+    1570100n 0
+    1570149n 0
+    1570150n 1.8
+    1570199n 1.8
+    1570200n 0
+    1570249n 0
+    1570250n 1.8
+    1570299n 1.8
+    1570300n 0
+    1570349n 0
+    1570350n 1.8
+    1570399n 1.8
+    1570400n 0
+    1570449n 0
+    1570450n 1.8
+    1570499n 1.8
+    1570500n 0
+    1570549n 0
+    1570550n 1.8
+    1570599n 1.8
+    1570600n 0
+    1570649n 0
+    1570650n 1.8
+    1570699n 1.8
+    1570700n 0
+    1570749n 0
+    1570750n 1.8
+    1570799n 1.8
+    1570800n 0
+    1570849n 0
+    1570850n 1.8
+    1570899n 1.8
+    1570900n 0
+    1570949n 0
+    1570950n 1.8
+    1570999n 1.8
+    1571000n 0
+    1571049n 0
+    1571050n 1.8
+    1571099n 1.8
+    1571100n 0
+    1571149n 0
+    1571150n 1.8
+    1571199n 1.8
+    1571200n 0
+    1571249n 0
+    1571250n 1.8
+    1571299n 1.8
+    1571300n 0
+    1571349n 0
+    1571350n 1.8
+    1571399n 1.8
+    1571400n 0
+    1571449n 0
+    1571450n 1.8
+    1571499n 1.8
+    1571500n 0
+    1571549n 0
+    1571550n 1.8
+    1571599n 1.8
+    1571600n 0
+    1571649n 0
+    1571650n 1.8
+    1571699n 1.8
+    1571700n 0
+    1571749n 0
+    1571750n 1.8
+    1571799n 1.8
+    1571800n 0
+    1571849n 0
+    1571850n 1.8
+    1571899n 1.8
+    1571900n 0
+    1571949n 0
+    1571950n 1.8
+    1571999n 1.8
+    1572000n 0
+    1572049n 0
+    1572050n 1.8
+    1572099n 1.8
+    1572100n 0
+    1572149n 0
+    1572150n 1.8
+    1572199n 1.8
+    1572200n 0
+    1572249n 0
+    1572250n 1.8
+    1572299n 1.8
+    1572300n 0
+    1572349n 0
+    1572350n 1.8
+    1572399n 1.8
+    1572400n 0
+    1572449n 0
+    1572450n 1.8
+    1572499n 1.8
+    1572500n 0
+    1572549n 0
+    1572550n 1.8
+    1572599n 1.8
+    1572600n 0
+    1572649n 0
+    1572650n 1.8
+    1572699n 1.8
+    1572700n 0
+    1572749n 0
+    1572750n 1.8
+    1572799n 1.8
+    1572800n 0
+    1572849n 0
+    1572850n 1.8
+    1572899n 1.8
+    1572900n 0
+    1572949n 0
+    1572950n 1.8
+    1572999n 1.8
+    1573000n 0
+    1573049n 0
+    1573050n 1.8
+    1573099n 1.8
+    1573100n 0
+    1573149n 0
+    1573150n 1.8
+    1573199n 1.8
+    1573200n 0
+    1573249n 0
+    1573250n 1.8
+    1573299n 1.8
+    1573300n 0
+    1573349n 0
+    1573350n 1.8
+    1573399n 1.8
+    1573400n 0
+    1573449n 0
+    1573450n 1.8
+    1573499n 1.8
+    1573500n 0
+    1573549n 0
+    1573550n 1.8
+    1573599n 1.8
+    1573600n 0
+    1573649n 0
+    1573650n 1.8
+    1573699n 1.8
+    1573700n 0
+    1573749n 0
+    1573750n 1.8
+    1573799n 1.8
+    1573800n 0
+    1573849n 0
+    1573850n 1.8
+    1573899n 1.8
+    1573900n 0
+    1573949n 0
+    1573950n 1.8
+    1573999n 1.8
+    1574000n 0
+    1574049n 0
+    1574050n 1.8
+    1574099n 1.8
+    1574100n 0
+    1574149n 0
+    1574150n 1.8
+    1574199n 1.8
+    1574200n 0
+    1574249n 0
+    1574250n 1.8
+    1574299n 1.8
+    1574300n 0
+    1574349n 0
+    1574350n 1.8
+    1574399n 1.8
+    1574400n 0
+    1574449n 0
+    1574450n 1.8
+    1574499n 1.8
+    1574500n 0
+    1574549n 0
+    1574550n 1.8
+    1574599n 1.8
+    1574600n 0
+    1574649n 0
+    1574650n 1.8
+    1574699n 1.8
+    1574700n 0
+    1574749n 0
+    1574750n 1.8
+    1574799n 1.8
+    1574800n 0
+    1574849n 0
+    1574850n 1.8
+    1574899n 1.8
+    1574900n 0
+    1574949n 0
+    1574950n 1.8
+    1574999n 1.8
+    1575000n 0
+    1575049n 0
+    1575050n 1.8
+    1575099n 1.8
+    1575100n 0
+    1575149n 0
+    1575150n 1.8
+    1575199n 1.8
+    1575200n 0
+    1575249n 0
+    1575250n 1.8
+    1575299n 1.8
+    1575300n 0
+    1575349n 0
+    1575350n 1.8
+    1575399n 1.8
+    1575400n 0
+    1575449n 0
+    1575450n 1.8
+    1575499n 1.8
+    1575500n 0
+    1575549n 0
+    1575550n 1.8
+    1575599n 1.8
+    1575600n 0
+    1575649n 0
+    1575650n 1.8
+    1575699n 1.8
+    1575700n 0
+    1575749n 0
+    1575750n 1.8
+    1575799n 1.8
+    1575800n 0
+    1575849n 0
+    1575850n 1.8
+    1575899n 1.8
+    1575900n 0
+    1575949n 0
+    1575950n 1.8
+    1575999n 1.8
+    1576000n 0
+    1576049n 0
+    1576050n 1.8
+    1576099n 1.8
+    1576100n 0
+    1576149n 0
+    1576150n 1.8
+    1576199n 1.8
+    1576200n 0
+    1576249n 0
+    1576250n 1.8
+    1576299n 1.8
+    1576300n 0
+    1576349n 0
+    1576350n 1.8
+    1576399n 1.8
+    1576400n 0
+    1576449n 0
+    1576450n 1.8
+    1576499n 1.8
+    1576500n 0
+    1576549n 0
+    1576550n 1.8
+    1576599n 1.8
+    1576600n 0
+    1576649n 0
+    1576650n 1.8
+    1576699n 1.8
+    1576700n 0
+    1576749n 0
+    1576750n 1.8
+    1576799n 1.8
+    1576800n 0
+    1576849n 0
+    1576850n 1.8
+    1576899n 1.8
+    1576900n 0
+    1576949n 0
+    1576950n 1.8
+    1576999n 1.8
+    1577000n 0
+    1577049n 0
+    1577050n 1.8
+    1577099n 1.8
+    1577100n 0
+    1577149n 0
+    1577150n 1.8
+    1577199n 1.8
+    1577200n 0
+    1577249n 0
+    1577250n 1.8
+    1577299n 1.8
+    1577300n 0
+    1577349n 0
+    1577350n 1.8
+    1577399n 1.8
+    1577400n 0
+    1577449n 0
+    1577450n 1.8
+    1577499n 1.8
+    1577500n 0
+    1577549n 0
+    1577550n 1.8
+    1577599n 1.8
+    1577600n 0
+    1577649n 0
+    1577650n 1.8
+    1577699n 1.8
+    1577700n 0
+    1577749n 0
+    1577750n 1.8
+    1577799n 1.8
+    1577800n 0
+    1577849n 0
+    1577850n 1.8
+    1577899n 1.8
+    1577900n 0
+    1577949n 0
+    1577950n 1.8
+    1577999n 1.8
+    1578000n 0
+    1578049n 0
+    1578050n 1.8
+    1578099n 1.8
+    1578100n 0
+    1578149n 0
+    1578150n 1.8
+    1578199n 1.8
+    1578200n 0
+    1578249n 0
+    1578250n 1.8
+    1578299n 1.8
+    1578300n 0
+    1578349n 0
+    1578350n 1.8
+    1578399n 1.8
+    1578400n 0
+    1578449n 0
+    1578450n 1.8
+    1578499n 1.8
+    1578500n 0
+    1578549n 0
+    1578550n 1.8
+    1578599n 1.8
+    1578600n 0
+    1578649n 0
+    1578650n 1.8
+    1578699n 1.8
+    1578700n 0
+    1578749n 0
+    1578750n 1.8
+    1578799n 1.8
+    1578800n 0
+    1578849n 0
+    1578850n 1.8
+    1578899n 1.8
+    1578900n 0
+    1578949n 0
+    1578950n 1.8
+    1578999n 1.8
+    1579000n 0
+    1579049n 0
+    1579050n 1.8
+    1579099n 1.8
+    1579100n 0
+    1579149n 0
+    1579150n 1.8
+    1579199n 1.8
+    1579200n 0
+    1579249n 0
+    1579250n 1.8
+    1579299n 1.8
+    1579300n 0
+    1579349n 0
+    1579350n 1.8
+    1579399n 1.8
+    1579400n 0
+    1579449n 0
+    1579450n 1.8
+    1579499n 1.8
+    1579500n 0
+    1579549n 0
+    1579550n 1.8
+    1579599n 1.8
+    1579600n 0
+    1579649n 0
+    1579650n 1.8
+    1579699n 1.8
+    1579700n 0
+    1579749n 0
+    1579750n 1.8
+    1579799n 1.8
+    1579800n 0
+    1579849n 0
+    1579850n 1.8
+    1579899n 1.8
+    1579900n 0
+    1579949n 0
+    1579950n 1.8
+    1579999n 1.8
+    1580000n 0
+    1580049n 0
+    1580050n 1.8
+    1580099n 1.8
+    1580100n 0
+    1580149n 0
+    1580150n 1.8
+    1580199n 1.8
+    1580200n 0
+    1580249n 0
+    1580250n 1.8
+    1580299n 1.8
+    1580300n 0
+    1580349n 0
+    1580350n 1.8
+    1580399n 1.8
+    1580400n 0
+    1580449n 0
+    1580450n 1.8
+    1580499n 1.8
+    1580500n 0
+    1580549n 0
+    1580550n 1.8
+    1580599n 1.8
+    1580600n 0
+    1580649n 0
+    1580650n 1.8
+    1580699n 1.8
+    1580700n 0
+    1580749n 0
+    1580750n 1.8
+    1580799n 1.8
+    1580800n 0
+    1580849n 0
+    1580850n 1.8
+    1580899n 1.8
+    1580900n 0
+    1580949n 0
+    1580950n 1.8
+    1580999n 1.8
+    1581000n 0
+    1581049n 0
+    1581050n 1.8
+    1581099n 1.8
+    1581100n 0
+    1581149n 0
+    1581150n 1.8
+    1581199n 1.8
+    1581200n 0
+    1581249n 0
+    1581250n 1.8
+    1581299n 1.8
+    1581300n 0
+    1581349n 0
+    1581350n 1.8
+    1581399n 1.8
+    1581400n 0
+    1581449n 0
+    1581450n 1.8
+    1581499n 1.8
+    1581500n 0
+    1581549n 0
+    1581550n 1.8
+    1581599n 1.8
+    1581600n 0
+    1581649n 0
+    1581650n 1.8
+    1581699n 1.8
+    1581700n 0
+    1581749n 0
+    1581750n 1.8
+    1581799n 1.8
+    1581800n 0
+    1581849n 0
+    1581850n 1.8
+    1581899n 1.8
+    1581900n 0
+    1581949n 0
+    1581950n 1.8
+    1581999n 1.8
+    1582000n 0
+    1582049n 0
+    1582050n 1.8
+    1582099n 1.8
+    1582100n 0
+    1582149n 0
+    1582150n 1.8
+    1582199n 1.8
+    1582200n 0
+    1582249n 0
+    1582250n 1.8
+    1582299n 1.8
+    1582300n 0
+    1582349n 0
+    1582350n 1.8
+    1582399n 1.8
+    1582400n 0
+    1582449n 0
+    1582450n 1.8
+    1582499n 1.8
+    1582500n 0
+    1582549n 0
+    1582550n 1.8
+    1582599n 1.8
+    1582600n 0
+    1582649n 0
+    1582650n 1.8
+    1582699n 1.8
+    1582700n 0
+    1582749n 0
+    1582750n 1.8
+    1582799n 1.8
+    1582800n 0
+    1582849n 0
+    1582850n 1.8
+    1582899n 1.8
+    1582900n 0
+    1582949n 0
+    1582950n 1.8
+    1582999n 1.8
+    1583000n 0
+    1583049n 0
+    1583050n 1.8
+    1583099n 1.8
+    1583100n 0
+    1583149n 0
+    1583150n 1.8
+    1583199n 1.8
+    1583200n 0
+    1583249n 0
+    1583250n 1.8
+    1583299n 1.8
+    1583300n 0
+    1583349n 0
+    1583350n 1.8
+    1583399n 1.8
+    1583400n 0
+    1583449n 0
+    1583450n 1.8
+    1583499n 1.8
+    1583500n 0
+    1583549n 0
+    1583550n 1.8
+    1583599n 1.8
+    1583600n 0
+    1583649n 0
+    1583650n 1.8
+    1583699n 1.8
+    1583700n 0
+    1583749n 0
+    1583750n 1.8
+    1583799n 1.8
+    1583800n 0
+    1583849n 0
+    1583850n 1.8
+    1583899n 1.8
+    1583900n 0
+    1583949n 0
+    1583950n 1.8
+    1583999n 1.8
+    1584000n 0
+    1584049n 0
+    1584050n 1.8
+    1584099n 1.8
+    1584100n 0
+    1584149n 0
+    1584150n 1.8
+    1584199n 1.8
+    1584200n 0
+    1584249n 0
+    1584250n 1.8
+    1584299n 1.8
+    1584300n 0
+    1584349n 0
+    1584350n 1.8
+    1584399n 1.8
+    1584400n 0
+    1584449n 0
+    1584450n 1.8
+    1584499n 1.8
+    1584500n 0
+    1584549n 0
+    1584550n 1.8
+    1584599n 1.8
+    1584600n 0
+    1584649n 0
+    1584650n 1.8
+    1584699n 1.8
+    1584700n 0
+    1584749n 0
+    1584750n 1.8
+    1584799n 1.8
+    1584800n 0
+    1584849n 0
+    1584850n 1.8
+    1584899n 1.8
+    1584900n 0
+    1584949n 0
+    1584950n 1.8
+    1584999n 1.8
+    1585000n 0
+    1585049n 0
+    1585050n 1.8
+    1585099n 1.8
+    1585100n 0
+    1585149n 0
+    1585150n 1.8
+    1585199n 1.8
+    1585200n 0
+    1585249n 0
+    1585250n 1.8
+    1585299n 1.8
+    1585300n 0
+    1585349n 0
+    1585350n 1.8
+    1585399n 1.8
+    1585400n 0
+    1585449n 0
+    1585450n 1.8
+    1585499n 1.8
+    1585500n 0
+    1585549n 0
+    1585550n 1.8
+    1585599n 1.8
+    1585600n 0
+    1585649n 0
+    1585650n 1.8
+    1585699n 1.8
+    1585700n 0
+    1585749n 0
+    1585750n 1.8
+    1585799n 1.8
+    1585800n 0
+    1585849n 0
+    1585850n 1.8
+    1585899n 1.8
+    1585900n 0
+    1585949n 0
+    1585950n 1.8
+    1585999n 1.8
+    1586000n 0
+    1586049n 0
+    1586050n 1.8
+    1586099n 1.8
+    1586100n 0
+    1586149n 0
+    1586150n 1.8
+    1586199n 1.8
+    1586200n 0
+    1586249n 0
+    1586250n 1.8
+    1586299n 1.8
+    1586300n 0
+    1586349n 0
+    1586350n 1.8
+    1586399n 1.8
+    1586400n 0
+    1586449n 0
+    1586450n 1.8
+    1586499n 1.8
+    1586500n 0
+    1586549n 0
+    1586550n 1.8
+    1586599n 1.8
+    1586600n 0
+    1586649n 0
+    1586650n 1.8
+    1586699n 1.8
+    1586700n 0
+    1586749n 0
+    1586750n 1.8
+    1586799n 1.8
+    1586800n 0
+    1586849n 0
+    1586850n 1.8
+    1586899n 1.8
+    1586900n 0
+    1586949n 0
+    1586950n 1.8
+    1586999n 1.8
+    1587000n 0
+    1587049n 0
+    1587050n 1.8
+    1587099n 1.8
+    1587100n 0
+    1587149n 0
+    1587150n 1.8
+    1587199n 1.8
+    1587200n 0
+    1587249n 0
+    1587250n 1.8
+    1587299n 1.8
+    1587300n 0
+    1587349n 0
+    1587350n 1.8
+    1587399n 1.8
+    1587400n 0
+    1587449n 0
+    1587450n 1.8
+    1587499n 1.8
+    1587500n 0
+    1587549n 0
+    1587550n 1.8
+    1587599n 1.8
+    1587600n 0
+    1587649n 0
+    1587650n 1.8
+    1587699n 1.8
+    1587700n 0
+    1587749n 0
+    1587750n 1.8
+    1587799n 1.8
+    1587800n 0
+    1587849n 0
+    1587850n 1.8
+    1587899n 1.8
+    1587900n 0
+    1587949n 0
+    1587950n 1.8
+    1587999n 1.8
+    1588000n 0
+    1588049n 0
+    1588050n 1.8
+    1588099n 1.8
+    1588100n 0
+    1588149n 0
+    1588150n 1.8
+    1588199n 1.8
+    1588200n 0
+    1588249n 0
+    1588250n 1.8
+    1588299n 1.8
+    1588300n 0
+    1588349n 0
+    1588350n 1.8
+    1588399n 1.8
+    1588400n 0
+    1588449n 0
+    1588450n 1.8
+    1588499n 1.8
+    1588500n 0
+    1588549n 0
+    1588550n 1.8
+    1588599n 1.8
+    1588600n 0
+    1588649n 0
+    1588650n 1.8
+    1588699n 1.8
+    1588700n 0
+    1588749n 0
+    1588750n 1.8
+    1588799n 1.8
+    1588800n 0
+    1588849n 0
+    1588850n 1.8
+    1588899n 1.8
+    1588900n 0
+    1588949n 0
+    1588950n 1.8
+    1588999n 1.8
+    1589000n 0
+    1589049n 0
+    1589050n 1.8
+    1589099n 1.8
+    1589100n 0
+    1589149n 0
+    1589150n 1.8
+    1589199n 1.8
+    1589200n 0
+    1589249n 0
+    1589250n 1.8
+    1589299n 1.8
+    1589300n 0
+    1589349n 0
+    1589350n 1.8
+    1589399n 1.8
+    1589400n 0
+    1589449n 0
+    1589450n 1.8
+    1589499n 1.8
+    1589500n 0
+    1589549n 0
+    1589550n 1.8
+    1589599n 1.8
+    1589600n 0
+    1589649n 0
+    1589650n 1.8
+    1589699n 1.8
+    1589700n 0
+    1589749n 0
+    1589750n 1.8
+    1589799n 1.8
+    1589800n 0
+    1589849n 0
+    1589850n 1.8
+    1589899n 1.8
+    1589900n 0
+    1589949n 0
+    1589950n 1.8
+    1589999n 1.8
+    1590000n 0
+    1590049n 0
+    1590050n 1.8
+    1590099n 1.8
+    1590100n 0
+    1590149n 0
+    1590150n 1.8
+    1590199n 1.8
+    1590200n 0
+    1590249n 0
+    1590250n 1.8
+    1590299n 1.8
+    1590300n 0
+    1590349n 0
+    1590350n 1.8
+    1590399n 1.8
+    1590400n 0
+    1590449n 0
+    1590450n 1.8
+    1590499n 1.8
+    1590500n 0
+    1590549n 0
+    1590550n 1.8
+    1590599n 1.8
+    1590600n 0
+    1590649n 0
+    1590650n 1.8
+    1590699n 1.8
+    1590700n 0
+    1590749n 0
+    1590750n 1.8
+    1590799n 1.8
+    1590800n 0
+    1590849n 0
+    1590850n 1.8
+    1590899n 1.8
+    1590900n 0
+    1590949n 0
+    1590950n 1.8
+    1590999n 1.8
+    1591000n 0
+    1591049n 0
+    1591050n 1.8
+    1591099n 1.8
+    1591100n 0
+    1591149n 0
+    1591150n 1.8
+    1591199n 1.8
+    1591200n 0
+    1591249n 0
+    1591250n 1.8
+    1591299n 1.8
+    1591300n 0
+    1591349n 0
+    1591350n 1.8
+    1591399n 1.8
+    1591400n 0
+    1591449n 0
+    1591450n 1.8
+    1591499n 1.8
+    1591500n 0
+    1591549n 0
+    1591550n 1.8
+    1591599n 1.8
+    1591600n 0
+    1591649n 0
+    1591650n 1.8
+    1591699n 1.8
+    1591700n 0
+    1591749n 0
+    1591750n 1.8
+    1591799n 1.8
+    1591800n 0
+    1591849n 0
+    1591850n 1.8
+    1591899n 1.8
+    1591900n 0
+    1591949n 0
+    1591950n 1.8
+    1591999n 1.8
+    1592000n 0
+    1592049n 0
+    1592050n 1.8
+    1592099n 1.8
+    1592100n 0
+    1592149n 0
+    1592150n 1.8
+    1592199n 1.8
+    1592200n 0
+    1592249n 0
+    1592250n 1.8
+    1592299n 1.8
+    1592300n 0
+    1592349n 0
+    1592350n 1.8
+    1592399n 1.8
+    1592400n 0
+    1592449n 0
+    1592450n 1.8
+    1592499n 1.8
+    1592500n 0
+    1592549n 0
+    1592550n 1.8
+    1592599n 1.8
+    1592600n 0
+    1592649n 0
+    1592650n 1.8
+    1592699n 1.8
+    1592700n 0
+    1592749n 0
+    1592750n 1.8
+    1592799n 1.8
+    1592800n 0
+    1592849n 0
+    1592850n 1.8
+    1592899n 1.8
+    1592900n 0
+    1592949n 0
+    1592950n 1.8
+    1592999n 1.8
+    1593000n 0
+    1593049n 0
+    1593050n 1.8
+    1593099n 1.8
+    1593100n 0
+    1593149n 0
+    1593150n 1.8
+    1593199n 1.8
+    1593200n 0
+    1593249n 0
+    1593250n 1.8
+    1593299n 1.8
+    1593300n 0
+    1593349n 0
+    1593350n 1.8
+    1593399n 1.8
+    1593400n 0
+    1593449n 0
+    1593450n 1.8
+    1593499n 1.8
+    1593500n 0
+    1593549n 0
+    1593550n 1.8
+    1593599n 1.8
+    1593600n 0
+    1593649n 0
+    1593650n 1.8
+    1593699n 1.8
+    1593700n 0
+    1593749n 0
+    1593750n 1.8
+    1593799n 1.8
+    1593800n 0
+    1593849n 0
+    1593850n 1.8
+    1593899n 1.8
+    1593900n 0
+    1593949n 0
+    1593950n 1.8
+    1593999n 1.8
+    1594000n 0
+    1594049n 0
+    1594050n 1.8
+    1594099n 1.8
+    1594100n 0
+    1594149n 0
+    1594150n 1.8
+    1594199n 1.8
+    1594200n 0
+    1594249n 0
+    1594250n 1.8
+    1594299n 1.8
+    1594300n 0
+    1594349n 0
+    1594350n 1.8
+    1594399n 1.8
+    1594400n 0
+    1594449n 0
+    1594450n 1.8
+    1594499n 1.8
+    1594500n 0
+    1594549n 0
+    1594550n 1.8
+    1594599n 1.8
+    1594600n 0
+    1594649n 0
+    1594650n 1.8
+    1594699n 1.8
+    1594700n 0
+    1594749n 0
+    1594750n 1.8
+    1594799n 1.8
+    1594800n 0
+    1594849n 0
+    1594850n 1.8
+    1594899n 1.8
+    1594900n 0
+    1594949n 0
+    1594950n 1.8
+    1594999n 1.8
+    1595000n 0
+    1595049n 0
+    1595050n 1.8
+    1595099n 1.8
+    1595100n 0
+    1595149n 0
+    1595150n 1.8
+    1595199n 1.8
+    1595200n 0
+    1595249n 0
+    1595250n 1.8
+    1595299n 1.8
+    1595300n 0
+    1595349n 0
+    1595350n 1.8
+    1595399n 1.8
+    1595400n 0
+    1595449n 0
+    1595450n 1.8
+    1595499n 1.8
+    1595500n 0
+    1595549n 0
+    1595550n 1.8
+    1595599n 1.8
+    1595600n 0
+    1595649n 0
+    1595650n 1.8
+    1595699n 1.8
+    1595700n 0
+    1595749n 0
+    1595750n 1.8
+    1595799n 1.8
+    1595800n 0
+    1595849n 0
+    1595850n 1.8
+    1595899n 1.8
+    1595900n 0
+    1595949n 0
+    1595950n 1.8
+    1595999n 1.8
+    1596000n 0
+    1596049n 0
+    1596050n 1.8
+    1596099n 1.8
+    1596100n 0
+    1596149n 0
+    1596150n 1.8
+    1596199n 1.8
+    1596200n 0
+    1596249n 0
+    1596250n 1.8
+    1596299n 1.8
+    1596300n 0
+    1596349n 0
+    1596350n 1.8
+    1596399n 1.8
+    1596400n 0
+    1596449n 0
+    1596450n 1.8
+    1596499n 1.8
+    1596500n 0
+    1596549n 0
+    1596550n 1.8
+    1596599n 1.8
+    1596600n 0
+    1596649n 0
+    1596650n 1.8
+    1596699n 1.8
+    1596700n 0
+    1596749n 0
+    1596750n 1.8
+    1596799n 1.8
+    1596800n 0
+    1596849n 0
+    1596850n 1.8
+    1596899n 1.8
+    1596900n 0
+    1596949n 0
+    1596950n 1.8
+    1596999n 1.8
+    1597000n 0
+    1597049n 0
+    1597050n 1.8
+    1597099n 1.8
+    1597100n 0
+    1597149n 0
+    1597150n 1.8
+    1597199n 1.8
+    1597200n 0
+    1597249n 0
+    1597250n 1.8
+    1597299n 1.8
+    1597300n 0
+    1597349n 0
+    1597350n 1.8
+    1597399n 1.8
+    1597400n 0
+    1597449n 0
+    1597450n 1.8
+    1597499n 1.8
+    1597500n 0
+    1597549n 0
+    1597550n 1.8
+    1597599n 1.8
+    1597600n 0
+    1597649n 0
+    1597650n 1.8
+    1597699n 1.8
+    1597700n 0
+    1597749n 0
+    1597750n 1.8
+    1597799n 1.8
+    1597800n 0
+    1597849n 0
+    1597850n 1.8
+    1597899n 1.8
+    1597900n 0
+    1597949n 0
+    1597950n 1.8
+    1597999n 1.8
+    1598000n 0
+    1598049n 0
+    1598050n 1.8
+    1598099n 1.8
+    1598100n 0
+    1598149n 0
+    1598150n 1.8
+    1598199n 1.8
+    1598200n 0
+    1598249n 0
+    1598250n 1.8
+    1598299n 1.8
+    1598300n 0
+    1598349n 0
+    1598350n 1.8
+    1598399n 1.8
+    1598400n 0
+    1598449n 0
+    1598450n 1.8
+    1598499n 1.8
+    1598500n 0
+    1598549n 0
+    1598550n 1.8
+    1598599n 1.8
+    1598600n 0
+    1598649n 0
+    1598650n 1.8
+    1598699n 1.8
+    1598700n 0
+    1598749n 0
+    1598750n 1.8
+    1598799n 1.8
+    1598800n 0
+    1598849n 0
+    1598850n 1.8
+    1598899n 1.8
+    1598900n 0
+    1598949n 0
+    1598950n 1.8
+    1598999n 1.8
+    1599000n 0
+    1599049n 0
+    1599050n 1.8
+    1599099n 1.8
+    1599100n 0
+    1599149n 0
+    1599150n 1.8
+    1599199n 1.8
+    1599200n 0
+    1599249n 0
+    1599250n 1.8
+    1599299n 1.8
+    1599300n 0
+    1599349n 0
+    1599350n 1.8
+    1599399n 1.8
+    1599400n 0
+    1599449n 0
+    1599450n 1.8
+    1599499n 1.8
+    1599500n 0
+    1599549n 0
+    1599550n 1.8
+    1599599n 1.8
+    1599600n 0
+    1599649n 0
+    1599650n 1.8
+    1599699n 1.8
+    1599700n 0
+    1599749n 0
+    1599750n 1.8
+    1599799n 1.8
+    1599800n 0
+    1599849n 0
+    1599850n 1.8
+    1599899n 1.8
+    1599900n 0
+    1599949n 0
+    1599950n 1.8
+    1599999n 1.8
+    1600000n 0
+    1600049n 0
+    1600050n 1.8
+    1600099n 1.8
+    1600100n 0
+    1600149n 0
+    1600150n 1.8
+    1600199n 1.8
+    1600200n 0
+    1600249n 0
+    1600250n 1.8
+    1600299n 1.8
+    1600300n 0
+    1600349n 0
+    1600350n 1.8
+    1600399n 1.8
+    1600400n 0
+    1600449n 0
+    1600450n 1.8
+    1600499n 1.8
+    1600500n 0
+    1600549n 0
+    1600550n 1.8
+    1600599n 1.8
+    1600600n 0
+    1600649n 0
+    1600650n 1.8
+    1600699n 1.8
+    1600700n 0
+    1600749n 0
+    1600750n 1.8
+    1600799n 1.8
+    1600800n 0
+    1600849n 0
+    1600850n 1.8
+    1600899n 1.8
+    1600900n 0
+    1600949n 0
+    1600950n 1.8
+    1600999n 1.8
+    1601000n 0
+    1601049n 0
+    1601050n 1.8
+    1601099n 1.8
+    1601100n 0
+    1601149n 0
+    1601150n 1.8
+    1601199n 1.8
+    1601200n 0
+    1601249n 0
+    1601250n 1.8
+    1601299n 1.8
+    1601300n 0
+    1601349n 0
+    1601350n 1.8
+    1601399n 1.8
+    1601400n 0
+    1601449n 0
+    1601450n 1.8
+    1601499n 1.8
+    1601500n 0
+    1601549n 0
+    1601550n 1.8
+    1601599n 1.8
+    1601600n 0
+    1601649n 0
+    1601650n 1.8
+    1601699n 1.8
+    1601700n 0
+    1601749n 0
+    1601750n 1.8
+    1601799n 1.8
+    1601800n 0
+    1601849n 0
+    1601850n 1.8
+    1601899n 1.8
+    1601900n 0
+    1601949n 0
+    1601950n 1.8
+    1601999n 1.8
+    1602000n 0
+    1602049n 0
+    1602050n 1.8
+    1602099n 1.8
+    1602100n 0
+    1602149n 0
+    1602150n 1.8
+    1602199n 1.8
+    1602200n 0
+    1602249n 0
+    1602250n 1.8
+    1602299n 1.8
+    1602300n 0
+    1602349n 0
+    1602350n 1.8
+    1602399n 1.8
+    1602400n 0
+    1602449n 0
+    1602450n 1.8
+    1602499n 1.8
+    1602500n 0
+    1602549n 0
+    1602550n 1.8
+    1602599n 1.8
+    1602600n 0
+    1602649n 0
+    1602650n 1.8
+    1602699n 1.8
+    1602700n 0
+    1602749n 0
+    1602750n 1.8
+    1602799n 1.8
+    1602800n 0
+    1602849n 0
+    1602850n 1.8
+    1602899n 1.8
+    1602900n 0
+    1602949n 0
+    1602950n 1.8
+    1602999n 1.8
+    1603000n 0
+    1603049n 0
+    1603050n 1.8
+    1603099n 1.8
+    1603100n 0
+    1603149n 0
+    1603150n 1.8
+    1603199n 1.8
+    1603200n 0
+    1603249n 0
+    1603250n 1.8
+    1603299n 1.8
+    1603300n 0
+    1603349n 0
+    1603350n 1.8
+    1603399n 1.8
+    1603400n 0
+    1603449n 0
+    1603450n 1.8
+    1603499n 1.8
+    1603500n 0
+    1603549n 0
+    1603550n 1.8
+    1603599n 1.8
+    1603600n 0
+    1603649n 0
+    1603650n 1.8
+    1603699n 1.8
+    1603700n 0
+    1603749n 0
+    1603750n 1.8
+    1603799n 1.8
+    1603800n 0
+    1603849n 0
+    1603850n 1.8
+    1603899n 1.8
+    1603900n 0
+    1603949n 0
+    1603950n 1.8
+    1603999n 1.8
+    1604000n 0
+    1604049n 0
+    1604050n 1.8
+    1604099n 1.8
+    1604100n 0
+    1604149n 0
+    1604150n 1.8
+    1604199n 1.8
+    1604200n 0
+    1604249n 0
+    1604250n 1.8
+    1604299n 1.8
+    1604300n 0
+    1604349n 0
+    1604350n 1.8
+    1604399n 1.8
+    1604400n 0
+    1604449n 0
+    1604450n 1.8
+    1604499n 1.8
+    1604500n 0
+    1604549n 0
+    1604550n 1.8
+    1604599n 1.8
+    1604600n 0
+    1604649n 0
+    1604650n 1.8
+    1604699n 1.8
+    1604700n 0
+    1604749n 0
+    1604750n 1.8
+    1604799n 1.8
+    1604800n 0
+    1604849n 0
+    1604850n 1.8
+    1604899n 1.8
+    1604900n 0
+    1604949n 0
+    1604950n 1.8
+    1604999n 1.8
+    1605000n 0
+    1605049n 0
+    1605050n 1.8
+    1605099n 1.8
+    1605100n 0
+    1605149n 0
+    1605150n 1.8
+    1605199n 1.8
+    1605200n 0
+    1605249n 0
+    1605250n 1.8
+    1605299n 1.8
+    1605300n 0
+    1605349n 0
+    1605350n 1.8
+    1605399n 1.8
+    1605400n 0
+    1605449n 0
+    1605450n 1.8
+    1605499n 1.8
+    1605500n 0
+    1605549n 0
+    1605550n 1.8
+    1605599n 1.8
+    1605600n 0
+    1605649n 0
+    1605650n 1.8
+    1605699n 1.8
+    1605700n 0
+    1605749n 0
+    1605750n 1.8
+    1605799n 1.8
+    1605800n 0
+    1605849n 0
+    1605850n 1.8
+    1605899n 1.8
+    1605900n 0
+    1605949n 0
+    1605950n 1.8
+    1605999n 1.8
+    1606000n 0
+    1606049n 0
+    1606050n 1.8
+    1606099n 1.8
+    1606100n 0
+    1606149n 0
+    1606150n 1.8
+    1606199n 1.8
+    1606200n 0
+    1606249n 0
+    1606250n 1.8
+    1606299n 1.8
+    1606300n 0
+    1606349n 0
+    1606350n 1.8
+    1606399n 1.8
+    1606400n 0
+    1606449n 0
+    1606450n 1.8
+    1606499n 1.8
+    1606500n 0
+    1606549n 0
+    1606550n 1.8
+    1606599n 1.8
+    1606600n 0
+    1606649n 0
+    1606650n 1.8
+    1606699n 1.8
+    1606700n 0
+    1606749n 0
+    1606750n 1.8
+    1606799n 1.8
+    1606800n 0
+    1606849n 0
+    1606850n 1.8
+    1606899n 1.8
+    1606900n 0
+    1606949n 0
+    1606950n 1.8
+    1606999n 1.8
+    1607000n 0
+    1607049n 0
+    1607050n 1.8
+    1607099n 1.8
+    1607100n 0
+    1607149n 0
+    1607150n 1.8
+    1607199n 1.8
+    1607200n 0
+    1607249n 0
+    1607250n 1.8
+    1607299n 1.8
+    1607300n 0
+    1607349n 0
+    1607350n 1.8
+    1607399n 1.8
+    1607400n 0
+    1607449n 0
+    1607450n 1.8
+    1607499n 1.8
+    1607500n 0
+    1607549n 0
+    1607550n 1.8
+    1607599n 1.8
+    1607600n 0
+    1607649n 0
+    1607650n 1.8
+    1607699n 1.8
+    1607700n 0
+    1607749n 0
+    1607750n 1.8
+    1607799n 1.8
+    1607800n 0
+    1607849n 0
+    1607850n 1.8
+    1607899n 1.8
+    1607900n 0
+    1607949n 0
+    1607950n 1.8
+    1607999n 1.8
+    1608000n 0
+    1608049n 0
+    1608050n 1.8
+    1608099n 1.8
+    1608100n 0
+    1608149n 0
+    1608150n 1.8
+    1608199n 1.8
+    1608200n 0
+    1608249n 0
+    1608250n 1.8
+    1608299n 1.8
+    1608300n 0
+    1608349n 0
+    1608350n 1.8
+    1608399n 1.8
+    1608400n 0
+    1608449n 0
+    1608450n 1.8
+    1608499n 1.8
+    1608500n 0
+    1608549n 0
+    1608550n 1.8
+    1608599n 1.8
+    1608600n 0
+    1608649n 0
+    1608650n 1.8
+    1608699n 1.8
+    1608700n 0
+    1608749n 0
+    1608750n 1.8
+    1608799n 1.8
+    1608800n 0
+    1608849n 0
+    1608850n 1.8
+    1608899n 1.8
+    1608900n 0
+    1608949n 0
+    1608950n 1.8
+    1608999n 1.8
+    1609000n 0
+    1609049n 0
+    1609050n 1.8
+    1609099n 1.8
+    1609100n 0
+    1609149n 0
+    1609150n 1.8
+    1609199n 1.8
+    1609200n 0
+    1609249n 0
+    1609250n 1.8
+    1609299n 1.8
+    1609300n 0
+    1609349n 0
+    1609350n 1.8
+    1609399n 1.8
+    1609400n 0
+    1609449n 0
+    1609450n 1.8
+    1609499n 1.8
+    1609500n 0
+    1609549n 0
+    1609550n 1.8
+    1609599n 1.8
+    1609600n 0
+    1609649n 0
+    1609650n 1.8
+    1609699n 1.8
+    1609700n 0
+    1609749n 0
+    1609750n 1.8
+    1609799n 1.8
+    1609800n 0
+    1609849n 0
+    1609850n 1.8
+    1609899n 1.8
+    1609900n 0
+    1609949n 0
+    1609950n 1.8
+    1609999n 1.8
+    1610000n 0
+    1610049n 0
+    1610050n 1.8
+    1610099n 1.8
+    1610100n 0
+    1610149n 0
+    1610150n 1.8
+    1610199n 1.8
+    1610200n 0
+    1610249n 0
+    1610250n 1.8
+    1610299n 1.8
+    1610300n 0
+    1610349n 0
+    1610350n 1.8
+    1610399n 1.8
+    1610400n 0
+    1610449n 0
+    1610450n 1.8
+    1610499n 1.8
+    1610500n 0
+    1610549n 0
+    1610550n 1.8
+    1610599n 1.8
+    1610600n 0
+    1610649n 0
+    1610650n 1.8
+    1610699n 1.8
+    1610700n 0
+    1610749n 0
+    1610750n 1.8
+    1610799n 1.8
+    1610800n 0
+    1610849n 0
+    1610850n 1.8
+    1610899n 1.8
+    1610900n 0
+    1610949n 0
+    1610950n 1.8
+    1610999n 1.8
+    1611000n 0
+    1611049n 0
+    1611050n 1.8
+    1611099n 1.8
+    1611100n 0
+    1611149n 0
+    1611150n 1.8
+    1611199n 1.8
+    1611200n 0
+    1611249n 0
+    1611250n 1.8
+    1611299n 1.8
+    1611300n 0
+    1611349n 0
+    1611350n 1.8
+    1611399n 1.8
+    1611400n 0
+    1611449n 0
+    1611450n 1.8
+    1611499n 1.8
+    1611500n 0
+    1611549n 0
+    1611550n 1.8
+    1611599n 1.8
+    1611600n 0
+    1611649n 0
+    1611650n 1.8
+    1611699n 1.8
+    1611700n 0
+    1611749n 0
+    1611750n 1.8
+    1611799n 1.8
+    1611800n 0
+    1611849n 0
+    1611850n 1.8
+    1611899n 1.8
+    1611900n 0
+    1611949n 0
+    1611950n 1.8
+    1611999n 1.8
+    1612000n 0
+    1612049n 0
+    1612050n 1.8
+    1612099n 1.8
+    1612100n 0
+    1612149n 0
+    1612150n 1.8
+    1612199n 1.8
+    1612200n 0
+    1612249n 0
+    1612250n 1.8
+    1612299n 1.8
+    1612300n 0
+    1612349n 0
+    1612350n 1.8
+    1612399n 1.8
+    1612400n 0
+    1612449n 0
+    1612450n 1.8
+    1612499n 1.8
+    1612500n 0
+    1612549n 0
+    1612550n 1.8
+    1612599n 1.8
+    1612600n 0
+    1612649n 0
+    1612650n 1.8
+    1612699n 1.8
+    1612700n 0
+    1612749n 0
+    1612750n 1.8
+    1612799n 1.8
+    1612800n 0
+    1612849n 0
+    1612850n 1.8
+    1612899n 1.8
+    1612900n 0
+    1612949n 0
+    1612950n 1.8
+    1612999n 1.8
+    1613000n 0
+    1613049n 0
+    1613050n 1.8
+    1613099n 1.8
+    1613100n 0
+    1613149n 0
+    1613150n 1.8
+    1613199n 1.8
+    1613200n 0
+    1613249n 0
+    1613250n 1.8
+    1613299n 1.8
+    1613300n 0
+    1613349n 0
+    1613350n 1.8
+    1613399n 1.8
+    1613400n 0
+    1613449n 0
+    1613450n 1.8
+    1613499n 1.8
+    1613500n 0
+    1613549n 0
+    1613550n 1.8
+    1613599n 1.8
+    1613600n 0
+    1613649n 0
+    1613650n 1.8
+    1613699n 1.8
+    1613700n 0
+    1613749n 0
+    1613750n 1.8
+    1613799n 1.8
+    1613800n 0
+    1613849n 0
+    1613850n 1.8
+    1613899n 1.8
+    1613900n 0
+    1613949n 0
+    1613950n 1.8
+    1613999n 1.8
+    1614000n 0
+    1614049n 0
+    1614050n 1.8
+    1614099n 1.8
+    1614100n 0
+    1614149n 0
+    1614150n 1.8
+    1614199n 1.8
+    1614200n 0
+    1614249n 0
+    1614250n 1.8
+    1614299n 1.8
+    1614300n 0
+    1614349n 0
+    1614350n 1.8
+    1614399n 1.8
+    1614400n 0
+    1614449n 0
+    1614450n 1.8
+    1614499n 1.8
+    1614500n 0
+    1614549n 0
+    1614550n 1.8
+    1614599n 1.8
+    1614600n 0
+    1614649n 0
+    1614650n 1.8
+    1614699n 1.8
+    1614700n 0
+    1614749n 0
+    1614750n 1.8
+    1614799n 1.8
+    1614800n 0
+    1614849n 0
+    1614850n 1.8
+    1614899n 1.8
+    1614900n 0
+    1614949n 0
+    1614950n 1.8
+    1614999n 1.8
+    1615000n 0
+    1615049n 0
+    1615050n 1.8
+    1615099n 1.8
+    1615100n 0
+    1615149n 0
+    1615150n 1.8
+    1615199n 1.8
+    1615200n 0
+    1615249n 0
+    1615250n 1.8
+    1615299n 1.8
+    1615300n 0
+    1615349n 0
+    1615350n 1.8
+    1615399n 1.8
+    1615400n 0
+    1615449n 0
+    1615450n 1.8
+    1615499n 1.8
+    1615500n 0
+    1615549n 0
+    1615550n 1.8
+    1615599n 1.8
+    1615600n 0
+    1615649n 0
+    1615650n 1.8
+    1615699n 1.8
+    1615700n 0
+    1615749n 0
+    1615750n 1.8
+    1615799n 1.8
+    1615800n 0
+    1615849n 0
+    1615850n 1.8
+    1615899n 1.8
+    1615900n 0
+    1615949n 0
+    1615950n 1.8
+    1615999n 1.8
+    1616000n 0
+    1616049n 0
+    1616050n 1.8
+    1616099n 1.8
+    1616100n 0
+    1616149n 0
+    1616150n 1.8
+    1616199n 1.8
+    1616200n 0
+    1616249n 0
+    1616250n 1.8
+    1616299n 1.8
+    1616300n 0
+    1616349n 0
+    1616350n 1.8
+    1616399n 1.8
+    1616400n 0
+    1616449n 0
+    1616450n 1.8
+    1616499n 1.8
+    1616500n 0
+    1616549n 0
+    1616550n 1.8
+    1616599n 1.8
+    1616600n 0
+    1616649n 0
+    1616650n 1.8
+    1616699n 1.8
+    1616700n 0
+    1616749n 0
+    1616750n 1.8
+    1616799n 1.8
+    1616800n 0
+    1616849n 0
+    1616850n 1.8
+    1616899n 1.8
+    1616900n 0
+    1616949n 0
+    1616950n 1.8
+    1616999n 1.8
+    1617000n 0
+    1617049n 0
+    1617050n 1.8
+    1617099n 1.8
+    1617100n 0
+    1617149n 0
+    1617150n 1.8
+    1617199n 1.8
+    1617200n 0
+    1617249n 0
+    1617250n 1.8
+    1617299n 1.8
+    1617300n 0
+    1617349n 0
+    1617350n 1.8
+    1617399n 1.8
+    1617400n 0
+    1617449n 0
+    1617450n 1.8
+    1617499n 1.8
+    1617500n 0
+    1617549n 0
+    1617550n 1.8
+    1617599n 1.8
+    1617600n 0
+    1617649n 0
+    1617650n 1.8
+    1617699n 1.8
+    1617700n 0
+    1617749n 0
+    1617750n 1.8
+    1617799n 1.8
+    1617800n 0
+    1617849n 0
+    1617850n 1.8
+    1617899n 1.8
+    1617900n 0
+    1617949n 0
+    1617950n 1.8
+    1617999n 1.8
+    1618000n 0
+    1618049n 0
+    1618050n 1.8
+    1618099n 1.8
+    1618100n 0
+    1618149n 0
+    1618150n 1.8
+    1618199n 1.8
+    1618200n 0
+    1618249n 0
+    1618250n 1.8
+    1618299n 1.8
+    1618300n 0
+    1618349n 0
+    1618350n 1.8
+    1618399n 1.8
+    1618400n 0
+    1618449n 0
+    1618450n 1.8
+    1618499n 1.8
+    1618500n 0
+    1618549n 0
+    1618550n 1.8
+    1618599n 1.8
+    1618600n 0
+    1618649n 0
+    1618650n 1.8
+    1618699n 1.8
+    1618700n 0
+    1618749n 0
+    1618750n 1.8
+    1618799n 1.8
+    1618800n 0
+    1618849n 0
+    1618850n 1.8
+    1618899n 1.8
+    1618900n 0
+    1618949n 0
+    1618950n 1.8
+    1618999n 1.8
+    1619000n 0
+    1619049n 0
+    1619050n 1.8
+    1619099n 1.8
+    1619100n 0
+    1619149n 0
+    1619150n 1.8
+    1619199n 1.8
+    1619200n 0
+    1619249n 0
+    1619250n 1.8
+    1619299n 1.8
+    1619300n 0
+    1619349n 0
+    1619350n 1.8
+    1619399n 1.8
+    1619400n 0
+    1619449n 0
+    1619450n 1.8
+    1619499n 1.8
+    1619500n 0
+    1619549n 0
+    1619550n 1.8
+    1619599n 1.8
+    1619600n 0
+    1619649n 0
+    1619650n 1.8
+    1619699n 1.8
+    1619700n 0
+    1619749n 0
+    1619750n 1.8
+    1619799n 1.8
+    1619800n 0
+    1619849n 0
+    1619850n 1.8
+    1619899n 1.8
+    1619900n 0
+    1619949n 0
+    1619950n 1.8
+    1619999n 1.8
+    1620000n 0
+    1620049n 0
+    1620050n 1.8
+    1620099n 1.8
+    1620100n 0
+    1620149n 0
+    1620150n 1.8
+    1620199n 1.8
+    1620200n 0
+    1620249n 0
+    1620250n 1.8
+    1620299n 1.8
+    1620300n 0
+    1620349n 0
+    1620350n 1.8
+    1620399n 1.8
+    1620400n 0
+    1620449n 0
+    1620450n 1.8
+    1620499n 1.8
+    1620500n 0
+    1620549n 0
+    1620550n 1.8
+    1620599n 1.8
+    1620600n 0
+    1620649n 0
+    1620650n 1.8
+    1620699n 1.8
+    1620700n 0
+    1620749n 0
+    1620750n 1.8
+    1620799n 1.8
+    1620800n 0
+    1620849n 0
+    1620850n 1.8
+    1620899n 1.8
+    1620900n 0
+    1620949n 0
+    1620950n 1.8
+    1620999n 1.8
+    1621000n 0
+    1621049n 0
+    1621050n 1.8
+    1621099n 1.8
+    1621100n 0
+    1621149n 0
+    1621150n 1.8
+    1621199n 1.8
+    1621200n 0
+    1621249n 0
+    1621250n 1.8
+    1621299n 1.8
+    1621300n 0
+    1621349n 0
+    1621350n 1.8
+    1621399n 1.8
+    1621400n 0
+    1621449n 0
+    1621450n 1.8
+    1621499n 1.8
+    1621500n 0
+    1621549n 0
+    1621550n 1.8
+    1621599n 1.8
+    1621600n 0
+    1621649n 0
+    1621650n 1.8
+    1621699n 1.8
+    1621700n 0
+    1621749n 0
+    1621750n 1.8
+    1621799n 1.8
+    1621800n 0
+    1621849n 0
+    1621850n 1.8
+    1621899n 1.8
+    1621900n 0
+    1621949n 0
+    1621950n 1.8
+    1621999n 1.8
+    1622000n 0
+    1622049n 0
+    1622050n 1.8
+    1622099n 1.8
+    1622100n 0
+    1622149n 0
+    1622150n 1.8
+    1622199n 1.8
+    1622200n 0
+    1622249n 0
+    1622250n 1.8
+    1622299n 1.8
+    1622300n 0
+    1622349n 0
+    1622350n 1.8
+    1622399n 1.8
+    1622400n 0
+    1622449n 0
+    1622450n 1.8
+    1622499n 1.8
+    1622500n 0
+    1622549n 0
+    1622550n 1.8
+    1622599n 1.8
+    1622600n 0
+    1622649n 0
+    1622650n 1.8
+    1622699n 1.8
+    1622700n 0
+    1622749n 0
+    1622750n 1.8
+    1622799n 1.8
+    1622800n 0
+    1622849n 0
+    1622850n 1.8
+    1622899n 1.8
+    1622900n 0
+    1622949n 0
+    1622950n 1.8
+    1622999n 1.8
+    1623000n 0
+    1623049n 0
+    1623050n 1.8
+    1623099n 1.8
+    1623100n 0
+    1623149n 0
+    1623150n 1.8
+    1623199n 1.8
+    1623200n 0
+    1623249n 0
+    1623250n 1.8
+    1623299n 1.8
+    1623300n 0
+    1623349n 0
+    1623350n 1.8
+    1623399n 1.8
+    1623400n 0
+    1623449n 0
+    1623450n 1.8
+    1623499n 1.8
+    1623500n 0
+    1623549n 0
+    1623550n 1.8
+    1623599n 1.8
+    1623600n 0
+    1623649n 0
+    1623650n 1.8
+    1623699n 1.8
+    1623700n 0
+    1623749n 0
+    1623750n 1.8
+    1623799n 1.8
+    1623800n 0
+    1623849n 0
+    1623850n 1.8
+    1623899n 1.8
+    1623900n 0
+    1623949n 0
+    1623950n 1.8
+    1623999n 1.8
+    1624000n 0
+    1624049n 0
+    1624050n 1.8
+    1624099n 1.8
+    1624100n 0
+    1624149n 0
+    1624150n 1.8
+    1624199n 1.8
+    1624200n 0
+    1624249n 0
+    1624250n 1.8
+    1624299n 1.8
+    1624300n 0
+    1624349n 0
+    1624350n 1.8
+    1624399n 1.8
+    1624400n 0
+    1624449n 0
+    1624450n 1.8
+    1624499n 1.8
+    1624500n 0
+    1624549n 0
+    1624550n 1.8
+    1624599n 1.8
+    1624600n 0
+    1624649n 0
+    1624650n 1.8
+    1624699n 1.8
+    1624700n 0
+    1624749n 0
+    1624750n 1.8
+    1624799n 1.8
+    1624800n 0
+    1624849n 0
+    1624850n 1.8
+    1624899n 1.8
+    1624900n 0
+    1624949n 0
+    1624950n 1.8
+    1624999n 1.8
+    1625000n 0
+    1625049n 0
+    1625050n 1.8
+    1625099n 1.8
+    1625100n 0
+    1625149n 0
+    1625150n 1.8
+    1625199n 1.8
+    1625200n 0
+    1625249n 0
+    1625250n 1.8
+    1625299n 1.8
+    1625300n 0
+    1625349n 0
+    1625350n 1.8
+    1625399n 1.8
+    1625400n 0
+    1625449n 0
+    1625450n 1.8
+    1625499n 1.8
+    1625500n 0
+    1625549n 0
+    1625550n 1.8
+    1625599n 1.8
+    1625600n 0
+    1625649n 0
+    1625650n 1.8
+    1625699n 1.8
+    1625700n 0
+    1625749n 0
+    1625750n 1.8
+    1625799n 1.8
+    1625800n 0
+    1625849n 0
+    1625850n 1.8
+    1625899n 1.8
+    1625900n 0
+    1625949n 0
+    1625950n 1.8
+    1625999n 1.8
+    1626000n 0
+    1626049n 0
+    1626050n 1.8
+    1626099n 1.8
+    1626100n 0
+    1626149n 0
+    1626150n 1.8
+    1626199n 1.8
+    1626200n 0
+    1626249n 0
+    1626250n 1.8
+    1626299n 1.8
+    1626300n 0
+    1626349n 0
+    1626350n 1.8
+    1626399n 1.8
+    1626400n 0
+    1626449n 0
+    1626450n 1.8
+    1626499n 1.8
+    1626500n 0
+    1626549n 0
+    1626550n 1.8
+    1626599n 1.8
+    1626600n 0
+    1626649n 0
+    1626650n 1.8
+    1626699n 1.8
+    1626700n 0
+    1626749n 0
+    1626750n 1.8
+    1626799n 1.8
+    1626800n 0
+    1626849n 0
+    1626850n 1.8
+    1626899n 1.8
+    1626900n 0
+    1626949n 0
+    1626950n 1.8
+    1626999n 1.8
+    1627000n 0
+    1627049n 0
+    1627050n 1.8
+    1627099n 1.8
+    1627100n 0
+    1627149n 0
+    1627150n 1.8
+    1627199n 1.8
+    1627200n 0
+    1627249n 0
+    1627250n 1.8
+    1627299n 1.8
+    1627300n 0
+    1627349n 0
+    1627350n 1.8
+    1627399n 1.8
+    1627400n 0
+    1627449n 0
+    1627450n 1.8
+    1627499n 1.8
+    1627500n 0
+    1627549n 0
+    1627550n 1.8
+    1627599n 1.8
+    1627600n 0
+    1627649n 0
+    1627650n 1.8
+    1627699n 1.8
+    1627700n 0
+    1627749n 0
+    1627750n 1.8
+    1627799n 1.8
+    1627800n 0
+    1627849n 0
+    1627850n 1.8
+    1627899n 1.8
+    1627900n 0
+    1627949n 0
+    1627950n 1.8
+    1627999n 1.8
+    1628000n 0
+    1628049n 0
+    1628050n 1.8
+    1628099n 1.8
+    1628100n 0
+    1628149n 0
+    1628150n 1.8
+    1628199n 1.8
+    1628200n 0
+    1628249n 0
+    1628250n 1.8
+    1628299n 1.8
+    1628300n 0
+    1628349n 0
+    1628350n 1.8
+    1628399n 1.8
+    1628400n 0
+    1628449n 0
+    1628450n 1.8
+    1628499n 1.8
+    1628500n 0
+    1628549n 0
+    1628550n 1.8
+    1628599n 1.8
+    1628600n 0
+    1628649n 0
+    1628650n 1.8
+    1628699n 1.8
+    1628700n 0
+    1628749n 0
+    1628750n 1.8
+    1628799n 1.8
+    1628800n 0
+    1628849n 0
+    1628850n 1.8
+    1628899n 1.8
+    1628900n 0
+    1628949n 0
+    1628950n 1.8
+    1628999n 1.8
+    1629000n 0
+    1629049n 0
+    1629050n 1.8
+    1629099n 1.8
+    1629100n 0
+    1629149n 0
+    1629150n 1.8
+    1629199n 1.8
+    1629200n 0
+    1629249n 0
+    1629250n 1.8
+    1629299n 1.8
+    1629300n 0
+    1629349n 0
+    1629350n 1.8
+    1629399n 1.8
+    1629400n 0
+    1629449n 0
+    1629450n 1.8
+    1629499n 1.8
+    1629500n 0
+    1629549n 0
+    1629550n 1.8
+    1629599n 1.8
+    1629600n 0
+    1629649n 0
+    1629650n 1.8
+    1629699n 1.8
+    1629700n 0
+    1629749n 0
+    1629750n 1.8
+    1629799n 1.8
+    1629800n 0
+    1629849n 0
+    1629850n 1.8
+    1629899n 1.8
+    1629900n 0
+    1629949n 0
+    1629950n 1.8
+    1629999n 1.8
+    1630000n 0
+    1630049n 0
+    1630050n 1.8
+    1630099n 1.8
+    1630100n 0
+    1630149n 0
+    1630150n 1.8
+    1630199n 1.8
+    1630200n 0
+    1630249n 0
+    1630250n 1.8
+    1630299n 1.8
+    1630300n 0
+    1630349n 0
+    1630350n 1.8
+    1630399n 1.8
+    1630400n 0
+    1630449n 0
+    1630450n 1.8
+    1630499n 1.8
+    1630500n 0
+    1630549n 0
+    1630550n 1.8
+    1630599n 1.8
+    1630600n 0
+    1630649n 0
+    1630650n 1.8
+    1630699n 1.8
+    1630700n 0
+    1630749n 0
+    1630750n 1.8
+    1630799n 1.8
+    1630800n 0
+    1630849n 0
+    1630850n 1.8
+    1630899n 1.8
+    1630900n 0
+    1630949n 0
+    1630950n 1.8
+    1630999n 1.8
+    1631000n 0
+    1631049n 0
+    1631050n 1.8
+    1631099n 1.8
+    1631100n 0
+    1631149n 0
+    1631150n 1.8
+    1631199n 1.8
+    1631200n 0
+    1631249n 0
+    1631250n 1.8
+    1631299n 1.8
+    1631300n 0
+    1631349n 0
+    1631350n 1.8
+    1631399n 1.8
+    1631400n 0
+    1631449n 0
+    1631450n 1.8
+    1631499n 1.8
+    1631500n 0
+    1631549n 0
+    1631550n 1.8
+    1631599n 1.8
+    1631600n 0
+    1631649n 0
+    1631650n 1.8
+    1631699n 1.8
+    1631700n 0
+    1631749n 0
+    1631750n 1.8
+    1631799n 1.8
+    1631800n 0
+    1631849n 0
+    1631850n 1.8
+    1631899n 1.8
+    1631900n 0
+    1631949n 0
+    1631950n 1.8
+    1631999n 1.8
+    1632000n 0
+    1632049n 0
+    1632050n 1.8
+    1632099n 1.8
+    1632100n 0
+    1632149n 0
+    1632150n 1.8
+    1632199n 1.8
+    1632200n 0
+    1632249n 0
+    1632250n 1.8
+    1632299n 1.8
+    1632300n 0
+    1632349n 0
+    1632350n 1.8
+    1632399n 1.8
+    1632400n 0
+    1632449n 0
+    1632450n 1.8
+    1632499n 1.8
+    1632500n 0
+    1632549n 0
+    1632550n 1.8
+    1632599n 1.8
+    1632600n 0
+    1632649n 0
+    1632650n 1.8
+    1632699n 1.8
+    1632700n 0
+    1632749n 0
+    1632750n 1.8
+    1632799n 1.8
+    1632800n 0
+    1632849n 0
+    1632850n 1.8
+    1632899n 1.8
+    1632900n 0
+    1632949n 0
+    1632950n 1.8
+    1632999n 1.8
+    1633000n 0
+    1633049n 0
+    1633050n 1.8
+    1633099n 1.8
+    1633100n 0
+    1633149n 0
+    1633150n 1.8
+    1633199n 1.8
+    1633200n 0
+    1633249n 0
+    1633250n 1.8
+    1633299n 1.8
+    1633300n 0
+    1633349n 0
+    1633350n 1.8
+    1633399n 1.8
+    1633400n 0
+    1633449n 0
+    1633450n 1.8
+    1633499n 1.8
+    1633500n 0
+    1633549n 0
+    1633550n 1.8
+    1633599n 1.8
+    1633600n 0
+    1633649n 0
+    1633650n 1.8
+    1633699n 1.8
+    1633700n 0
+    1633749n 0
+    1633750n 1.8
+    1633799n 1.8
+    1633800n 0
+    1633849n 0
+    1633850n 1.8
+    1633899n 1.8
+    1633900n 0
+    1633949n 0
+    1633950n 1.8
+    1633999n 1.8
+    1634000n 0
+    1634049n 0
+    1634050n 1.8
+    1634099n 1.8
+    1634100n 0
+    1634149n 0
+    1634150n 1.8
+    1634199n 1.8
+    1634200n 0
+    1634249n 0
+    1634250n 1.8
+    1634299n 1.8
+    1634300n 0
+    1634349n 0
+    1634350n 1.8
+    1634399n 1.8
+    1634400n 0
+    1634449n 0
+    1634450n 1.8
+    1634499n 1.8
+    1634500n 0
+    1634549n 0
+    1634550n 1.8
+    1634599n 1.8
+    1634600n 0
+    1634649n 0
+    1634650n 1.8
+    1634699n 1.8
+    1634700n 0
+    1634749n 0
+    1634750n 1.8
+    1634799n 1.8
+    1634800n 0
+    1634849n 0
+    1634850n 1.8
+    1634899n 1.8
+    1634900n 0
+    1634949n 0
+    1634950n 1.8
+    1634999n 1.8
+    1635000n 0
+    1635049n 0
+    1635050n 1.8
+    1635099n 1.8
+    1635100n 0
+    1635149n 0
+    1635150n 1.8
+    1635199n 1.8
+    1635200n 0
+    1635249n 0
+    1635250n 1.8
+    1635299n 1.8
+    1635300n 0
+    1635349n 0
+    1635350n 1.8
+    1635399n 1.8
+    1635400n 0
+    1635449n 0
+    1635450n 1.8
+    1635499n 1.8
+    1635500n 0
+    1635549n 0
+    1635550n 1.8
+    1635599n 1.8
+    1635600n 0
+    1635649n 0
+    1635650n 1.8
+    1635699n 1.8
+    1635700n 0
+    1635749n 0
+    1635750n 1.8
+    1635799n 1.8
+    1635800n 0
+    1635849n 0
+    1635850n 1.8
+    1635899n 1.8
+    1635900n 0
+    1635949n 0
+    1635950n 1.8
+    1635999n 1.8
+    1636000n 0
+    1636049n 0
+    1636050n 1.8
+    1636099n 1.8
+    1636100n 0
+    1636149n 0
+    1636150n 1.8
+    1636199n 1.8
+    1636200n 0
+    1636249n 0
+    1636250n 1.8
+    1636299n 1.8
+    1636300n 0
+    1636349n 0
+    1636350n 1.8
+    1636399n 1.8
+    1636400n 0
+    1636449n 0
+    1636450n 1.8
+    1636499n 1.8
+    1636500n 0
+    1636549n 0
+    1636550n 1.8
+    1636599n 1.8
+    1636600n 0
+    1636649n 0
+    1636650n 1.8
+    1636699n 1.8
+    1636700n 0
+    1636749n 0
+    1636750n 1.8
+    1636799n 1.8
+    1636800n 0
+    1636849n 0
+    1636850n 1.8
+    1636899n 1.8
+    1636900n 0
+    1636949n 0
+    1636950n 1.8
+    1636999n 1.8
+    1637000n 0
+    1637049n 0
+    1637050n 1.8
+    1637099n 1.8
+    1637100n 0
+    1637149n 0
+    1637150n 1.8
+    1637199n 1.8
+    1637200n 0
+    1637249n 0
+    1637250n 1.8
+    1637299n 1.8
+    1637300n 0
+    1637349n 0
+    1637350n 1.8
+    1637399n 1.8
+    1637400n 0
+    1637449n 0
+    1637450n 1.8
+    1637499n 1.8
+    1637500n 0
+    1637549n 0
+    1637550n 1.8
+    1637599n 1.8
+    1637600n 0
+    1637649n 0
+    1637650n 1.8
+    1637699n 1.8
+    1637700n 0
+    1637749n 0
+    1637750n 1.8
+    1637799n 1.8
+    1637800n 0
+    1637849n 0
+    1637850n 1.8
+    1637899n 1.8
+    1637900n 0
+    1637949n 0
+    1637950n 1.8
+    1637999n 1.8
+    1638000n 0
+    1638049n 0
+    1638050n 1.8
+    1638099n 1.8
+    1638100n 0
+    1638149n 0
+    1638150n 1.8
+    1638199n 1.8
+    1638200n 0
+    1638249n 0
+    1638250n 1.8
+    1638299n 1.8
+    1638300n 0
+    1638349n 0
+    1638350n 1.8
+    1638399n 1.8
+    1638400n 0
+    1638449n 0
+    1638450n 1.8
+    1638499n 1.8
+    1638500n 0
+    1638549n 0
+    1638550n 1.8
+    1638599n 1.8
+    1638600n 0
+    1638649n 0
+    1638650n 1.8
+    1638699n 1.8
+    1638700n 0
+    1638749n 0
+    1638750n 1.8
+    1638799n 1.8
+    1638800n 0
+    1638849n 0
+    1638850n 1.8
+    1638899n 1.8
+    1638900n 0
+    1638949n 0
+    1638950n 1.8
+    1638999n 1.8
+    1639000n 0
+    1639049n 0
+    1639050n 1.8
+    1639099n 1.8
+    1639100n 0
+    1639149n 0
+    1639150n 1.8
+    1639199n 1.8
+    1639200n 0
+    1639249n 0
+    1639250n 1.8
+    1639299n 1.8
+    1639300n 0
+    1639349n 0
+    1639350n 1.8
+    1639399n 1.8
+    1639400n 0
+    1639449n 0
+    1639450n 1.8
+    1639499n 1.8
+    1639500n 0
+    1639549n 0
+    1639550n 1.8
+    1639599n 1.8
+    1639600n 0
+    1639649n 0
+    1639650n 1.8
+    1639699n 1.8
+    1639700n 0
+    1639749n 0
+    1639750n 1.8
+    1639799n 1.8
+    1639800n 0
+    1639849n 0
+    1639850n 1.8
+    1639899n 1.8
+    1639900n 0
+    1639949n 0
+    1639950n 1.8
+    1639999n 1.8
+    1640000n 0
+    1640049n 0
+    1640050n 1.8
+    1640099n 1.8
+    1640100n 0
+    1640149n 0
+    1640150n 1.8
+    1640199n 1.8
+    1640200n 0
+    1640249n 0
+    1640250n 1.8
+    1640299n 1.8
+    1640300n 0
+    1640349n 0
+    1640350n 1.8
+    1640399n 1.8
+    1640400n 0
+    1640449n 0
+    1640450n 1.8
+    1640499n 1.8
+    1640500n 0
+    1640549n 0
+    1640550n 1.8
+    1640599n 1.8
+    1640600n 0
+    1640649n 0
+    1640650n 1.8
+    1640699n 1.8
+    1640700n 0
+    1640749n 0
+    1640750n 1.8
+    1640799n 1.8
+    1640800n 0
+    1640849n 0
+    1640850n 1.8
+    1640899n 1.8
+    1640900n 0
+    1640949n 0
+    1640950n 1.8
+    1640999n 1.8
+    1641000n 0
+    1641049n 0
+    1641050n 1.8
+    1641099n 1.8
+    1641100n 0
+    1641149n 0
+    1641150n 1.8
+    1641199n 1.8
+    1641200n 0
+    1641249n 0
+    1641250n 1.8
+    1641299n 1.8
+    1641300n 0
+    1641349n 0
+    1641350n 1.8
+    1641399n 1.8
+    1641400n 0
+    1641449n 0
+    1641450n 1.8
+    1641499n 1.8
+    1641500n 0
+    1641549n 0
+    1641550n 1.8
+    1641599n 1.8
+    1641600n 0
+    1641649n 0
+    1641650n 1.8
+    1641699n 1.8
+    1641700n 0
+    1641749n 0
+    1641750n 1.8
+    1641799n 1.8
+    1641800n 0
+    1641849n 0
+    1641850n 1.8
+    1641899n 1.8
+    1641900n 0
+    1641949n 0
+    1641950n 1.8
+    1641999n 1.8
+    1642000n 0
+    1642049n 0
+    1642050n 1.8
+    1642099n 1.8
+    1642100n 0
+    1642149n 0
+    1642150n 1.8
+    1642199n 1.8
+    1642200n 0
+    1642249n 0
+    1642250n 1.8
+    1642299n 1.8
+    1642300n 0
+    1642349n 0
+    1642350n 1.8
+    1642399n 1.8
+    1642400n 0
+    1642449n 0
+    1642450n 1.8
+    1642499n 1.8
+    1642500n 0
+    1642549n 0
+    1642550n 1.8
+    1642599n 1.8
+    1642600n 0
+    1642649n 0
+    1642650n 1.8
+    1642699n 1.8
+    1642700n 0
+    1642749n 0
+    1642750n 1.8
+    1642799n 1.8
+    1642800n 0
+    1642849n 0
+    1642850n 1.8
+    1642899n 1.8
+    1642900n 0
+    1642949n 0
+    1642950n 1.8
+    1642999n 1.8
+    1643000n 0
+    1643049n 0
+    1643050n 1.8
+    1643099n 1.8
+    1643100n 0
+    1643149n 0
+    1643150n 1.8
+    1643199n 1.8
+    1643200n 0
+    1643249n 0
+    1643250n 1.8
+    1643299n 1.8
+    1643300n 0
+    1643349n 0
+    1643350n 1.8
+    1643399n 1.8
+    1643400n 0
+    1643449n 0
+    1643450n 1.8
+    1643499n 1.8
+    1643500n 0
+    1643549n 0
+    1643550n 1.8
+    1643599n 1.8
+    1643600n 0
+    1643649n 0
+    1643650n 1.8
+    1643699n 1.8
+    1643700n 0
+    1643749n 0
+    1643750n 1.8
+    1643799n 1.8
+    1643800n 0
+    1643849n 0
+    1643850n 1.8
+    1643899n 1.8
+    1643900n 0
+    1643949n 0
+    1643950n 1.8
+    1643999n 1.8
+    1644000n 0
+    1644049n 0
+    1644050n 1.8
+    1644099n 1.8
+    1644100n 0
+    1644149n 0
+    1644150n 1.8
+    1644199n 1.8
+    1644200n 0
+    1644249n 0
+    1644250n 1.8
+    1644299n 1.8
+    1644300n 0
+    1644349n 0
+    1644350n 1.8
+    1644399n 1.8
+    1644400n 0
+    1644449n 0
+    1644450n 1.8
+    1644499n 1.8
+    1644500n 0
+    1644549n 0
+    1644550n 1.8
+    1644599n 1.8
+    1644600n 0
+    1644649n 0
+    1644650n 1.8
+    1644699n 1.8
+    1644700n 0
+    1644749n 0
+    1644750n 1.8
+    1644799n 1.8
+    1644800n 0
+    1644849n 0
+    1644850n 1.8
+    1644899n 1.8
+    1644900n 0
+    1644949n 0
+    1644950n 1.8
+    1644999n 1.8
+    1645000n 0
+    1645049n 0
+    1645050n 1.8
+    1645099n 1.8
+    1645100n 0
+    1645149n 0
+    1645150n 1.8
+    1645199n 1.8
+    1645200n 0
+    1645249n 0
+    1645250n 1.8
+    1645299n 1.8
+    1645300n 0
+    1645349n 0
+    1645350n 1.8
+    1645399n 1.8
+    1645400n 0
+    1645449n 0
+    1645450n 1.8
+    1645499n 1.8
+    1645500n 0
+    1645549n 0
+    1645550n 1.8
+    1645599n 1.8
+    1645600n 0
+    1645649n 0
+    1645650n 1.8
+    1645699n 1.8
+    1645700n 0
+    1645749n 0
+    1645750n 1.8
+    1645799n 1.8
+    1645800n 0
+    1645849n 0
+    1645850n 1.8
+    1645899n 1.8
+    1645900n 0
+    1645949n 0
+    1645950n 1.8
+    1645999n 1.8
+    1646000n 0
+    1646049n 0
+    1646050n 1.8
+    1646099n 1.8
+    1646100n 0
+    1646149n 0
+    1646150n 1.8
+    1646199n 1.8
+    1646200n 0
+    1646249n 0
+    1646250n 1.8
+    1646299n 1.8
+    1646300n 0
+    1646349n 0
+    1646350n 1.8
+    1646399n 1.8
+    1646400n 0
+    1646449n 0
+    1646450n 1.8
+    1646499n 1.8
+    1646500n 0
+    1646549n 0
+    1646550n 1.8
+    1646599n 1.8
+    1646600n 0
+    1646649n 0
+    1646650n 1.8
+    1646699n 1.8
+    1646700n 0
+    1646749n 0
+    1646750n 1.8
+    1646799n 1.8
+    1646800n 0
+    1646849n 0
+    1646850n 1.8
+    1646899n 1.8
+    1646900n 0
+    1646949n 0
+    1646950n 1.8
+    1646999n 1.8
+    1647000n 0
+    1647049n 0
+    1647050n 1.8
+    1647099n 1.8
+    1647100n 0
+    1647149n 0
+    1647150n 1.8
+    1647199n 1.8
+    1647200n 0
+    1647249n 0
+    1647250n 1.8
+    1647299n 1.8
+    1647300n 0
+    1647349n 0
+    1647350n 1.8
+    1647399n 1.8
+    1647400n 0
+    1647449n 0
+    1647450n 1.8
+    1647499n 1.8
+    1647500n 0
+    1647549n 0
+    1647550n 1.8
+    1647599n 1.8
+    1647600n 0
+    1647649n 0
+    1647650n 1.8
+    1647699n 1.8
+    1647700n 0
+    1647749n 0
+    1647750n 1.8
+    1647799n 1.8
+    1647800n 0
+    1647849n 0
+    1647850n 1.8
+    1647899n 1.8
+    1647900n 0
+    1647949n 0
+    1647950n 1.8
+    1647999n 1.8
+    1648000n 0
+    1648049n 0
+    1648050n 1.8
+    1648099n 1.8
+    1648100n 0
+    1648149n 0
+    1648150n 1.8
+    1648199n 1.8
+    1648200n 0
+    1648249n 0
+    1648250n 1.8
+    1648299n 1.8
+    1648300n 0
+    1648349n 0
+    1648350n 1.8
+    1648399n 1.8
+    1648400n 0
+    1648449n 0
+    1648450n 1.8
+    1648499n 1.8
+    1648500n 0
+    1648549n 0
+    1648550n 1.8
+    1648599n 1.8
+    1648600n 0
+    1648649n 0
+    1648650n 1.8
+    1648699n 1.8
+    1648700n 0
+    1648749n 0
+    1648750n 1.8
+    1648799n 1.8
+    1648800n 0
+    1648849n 0
+    1648850n 1.8
+    1648899n 1.8
+    1648900n 0
+    1648949n 0
+    1648950n 1.8
+    1648999n 1.8
+    1649000n 0
+    1649049n 0
+    1649050n 1.8
+    1649099n 1.8
+    1649100n 0
+    1649149n 0
+    1649150n 1.8
+    1649199n 1.8
+    1649200n 0
+    1649249n 0
+    1649250n 1.8
+    1649299n 1.8
+    1649300n 0
+    1649349n 0
+    1649350n 1.8
+    1649399n 1.8
+    1649400n 0
+    1649449n 0
+    1649450n 1.8
+    1649499n 1.8
+    1649500n 0
+    1649549n 0
+    1649550n 1.8
+    1649599n 1.8
+    1649600n 0
+    1649649n 0
+    1649650n 1.8
+    1649699n 1.8
+    1649700n 0
+    1649749n 0
+    1649750n 1.8
+    1649799n 1.8
+    1649800n 0
+    1649849n 0
+    1649850n 1.8
+    1649899n 1.8
+    1649900n 0
+    1649949n 0
+    1649950n 1.8
+    1649999n 1.8
+    1650000n 0
+    1650049n 0
+    1650050n 1.8
+    1650099n 1.8
+    1650100n 0
+    1650149n 0
+    1650150n 1.8
+    1650199n 1.8
+    1650200n 0
+    1650249n 0
+    1650250n 1.8
+    1650299n 1.8
+    1650300n 0
+    1650349n 0
+    1650350n 1.8
+    1650399n 1.8
+    1650400n 0
+    1650449n 0
+    1650450n 1.8
+    1650499n 1.8
+    1650500n 0
+    1650549n 0
+    1650550n 1.8
+    1650599n 1.8
+    1650600n 0
+    1650649n 0
+    1650650n 1.8
+    1650699n 1.8
+    1650700n 0
+    1650749n 0
+    1650750n 1.8
+    1650799n 1.8
+    1650800n 0
+    1650849n 0
+    1650850n 1.8
+    1650899n 1.8
+    1650900n 0
+    1650949n 0
+    1650950n 1.8
+    1650999n 1.8
+    1651000n 0
+    1651049n 0
+    1651050n 1.8
+    1651099n 1.8
+    1651100n 0
+    1651149n 0
+    1651150n 1.8
+    1651199n 1.8
+    1651200n 0
+    1651249n 0
+    1651250n 1.8
+    1651299n 1.8
+    1651300n 0
+    1651349n 0
+    1651350n 1.8
+    1651399n 1.8
+    1651400n 0
+    1651449n 0
+    1651450n 1.8
+    1651499n 1.8
+    1651500n 0
+    1651549n 0
+    1651550n 1.8
+    1651599n 1.8
+    1651600n 0
+    1651649n 0
+    1651650n 1.8
+    1651699n 1.8
+    1651700n 0
+    1651749n 0
+    1651750n 1.8
+    1651799n 1.8
+    1651800n 0
+    1651849n 0
+    1651850n 1.8
+    1651899n 1.8
+    1651900n 0
+    1651949n 0
+    1651950n 1.8
+    1651999n 1.8
+    1652000n 0
+    1652049n 0
+    1652050n 1.8
+    1652099n 1.8
+    1652100n 0
+    1652149n 0
+    1652150n 1.8
+    1652199n 1.8
+    1652200n 0
+    1652249n 0
+    1652250n 1.8
+    1652299n 1.8
+    1652300n 0
+    1652349n 0
+    1652350n 1.8
+    1652399n 1.8
+    1652400n 0
+    1652449n 0
+    1652450n 1.8
+    1652499n 1.8
+    1652500n 0
+    1652549n 0
+    1652550n 1.8
+    1652599n 1.8
+    1652600n 0
+    1652649n 0
+    1652650n 1.8
+    1652699n 1.8
+    1652700n 0
+    1652749n 0
+    1652750n 1.8
+    1652799n 1.8
+    1652800n 0
+    1652849n 0
+    1652850n 1.8
+    1652899n 1.8
+    1652900n 0
+    1652949n 0
+    1652950n 1.8
+    1652999n 1.8
+    1653000n 0
+    1653049n 0
+    1653050n 1.8
+    1653099n 1.8
+    1653100n 0
+    1653149n 0
+    1653150n 1.8
+    1653199n 1.8
+    1653200n 0
+    1653249n 0
+    1653250n 1.8
+    1653299n 1.8
+    1653300n 0
+    1653349n 0
+    1653350n 1.8
+    1653399n 1.8
+    1653400n 0
+    1653449n 0
+    1653450n 1.8
+    1653499n 1.8
+    1653500n 0
+    1653549n 0
+    1653550n 1.8
+    1653599n 1.8
+    1653600n 0
+    1653649n 0
+    1653650n 1.8
+    1653699n 1.8
+    1653700n 0
+    1653749n 0
+    1653750n 1.8
+    1653799n 1.8
+    1653800n 0
+    1653849n 0
+    1653850n 1.8
+    1653899n 1.8
+    1653900n 0
+    1653949n 0
+    1653950n 1.8
+    1653999n 1.8
+    1654000n 0
+    1654049n 0
+    1654050n 1.8
+    1654099n 1.8
+    1654100n 0
+    1654149n 0
+    1654150n 1.8
+    1654199n 1.8
+    1654200n 0
+    1654249n 0
+    1654250n 1.8
+    1654299n 1.8
+    1654300n 0
+    1654349n 0
+    1654350n 1.8
+    1654399n 1.8
+    1654400n 0
+    1654449n 0
+    1654450n 1.8
+    1654499n 1.8
+    1654500n 0
+    1654549n 0
+    1654550n 1.8
+    1654599n 1.8
+    1654600n 0
+    1654649n 0
+    1654650n 1.8
+    1654699n 1.8
+    1654700n 0
+    1654749n 0
+    1654750n 1.8
+    1654799n 1.8
+    1654800n 0
+    1654849n 0
+    1654850n 1.8
+    1654899n 1.8
+    1654900n 0
+    1654949n 0
+    1654950n 1.8
+    1654999n 1.8
+    1655000n 0
+    1655049n 0
+    1655050n 1.8
+    1655099n 1.8
+    1655100n 0
+    1655149n 0
+    1655150n 1.8
+    1655199n 1.8
+    1655200n 0
+    1655249n 0
+    1655250n 1.8
+    1655299n 1.8
+    1655300n 0
+    1655349n 0
+    1655350n 1.8
+    1655399n 1.8
+    1655400n 0
+    1655449n 0
+    1655450n 1.8
+    1655499n 1.8
+    1655500n 0
+    1655549n 0
+    1655550n 1.8
+    1655599n 1.8
+    1655600n 0
+    1655649n 0
+    1655650n 1.8
+    1655699n 1.8
+    1655700n 0
+    1655749n 0
+    1655750n 1.8
+    1655799n 1.8
+    1655800n 0
+    1655849n 0
+    1655850n 1.8
+    1655899n 1.8
+    1655900n 0
+    1655949n 0
+    1655950n 1.8
+    1655999n 1.8
+    1656000n 0
+    1656049n 0
+    1656050n 1.8
+    1656099n 1.8
+    1656100n 0
+    1656149n 0
+    1656150n 1.8
+    1656199n 1.8
+    1656200n 0
+    1656249n 0
+    1656250n 1.8
+    1656299n 1.8
+    1656300n 0
+    1656349n 0
+    1656350n 1.8
+    1656399n 1.8
+    1656400n 0
+    1656449n 0
+    1656450n 1.8
+    1656499n 1.8
+    1656500n 0
+    1656549n 0
+    1656550n 1.8
+    1656599n 1.8
+    1656600n 0
+    1656649n 0
+    1656650n 1.8
+    1656699n 1.8
+    1656700n 0
+    1656749n 0
+    1656750n 1.8
+    1656799n 1.8
+    1656800n 0
+    1656849n 0
+    1656850n 1.8
+    1656899n 1.8
+    1656900n 0
+    1656949n 0
+    1656950n 1.8
+    1656999n 1.8
+    1657000n 0
+    1657049n 0
+    1657050n 1.8
+    1657099n 1.8
+    1657100n 0
+    1657149n 0
+    1657150n 1.8
+    1657199n 1.8
+    1657200n 0
+    1657249n 0
+    1657250n 1.8
+    1657299n 1.8
+    1657300n 0
+    1657349n 0
+    1657350n 1.8
+    1657399n 1.8
+    1657400n 0
+    1657449n 0
+    1657450n 1.8
+    1657499n 1.8
+    1657500n 0
+    1657549n 0
+    1657550n 1.8
+    1657599n 1.8
+    1657600n 0
+    1657649n 0
+    1657650n 1.8
+    1657699n 1.8
+    1657700n 0
+    1657749n 0
+    1657750n 1.8
+    1657799n 1.8
+    1657800n 0
+    1657849n 0
+    1657850n 1.8
+    1657899n 1.8
+    1657900n 0
+    1657949n 0
+    1657950n 1.8
+    1657999n 1.8
+    1658000n 0
+    1658049n 0
+    1658050n 1.8
+    1658099n 1.8
+    1658100n 0
+    1658149n 0
+    1658150n 1.8
+    1658199n 1.8
+    1658200n 0
+    1658249n 0
+    1658250n 1.8
+    1658299n 1.8
+    1658300n 0
+    1658349n 0
+    1658350n 1.8
+    1658399n 1.8
+    1658400n 0
+    1658449n 0
+    1658450n 1.8
+    1658499n 1.8
+    1658500n 0
+    1658549n 0
+    1658550n 1.8
+    1658599n 1.8
+    1658600n 0
+    1658649n 0
+    1658650n 1.8
+    1658699n 1.8
+    1658700n 0
+    1658749n 0
+    1658750n 1.8
+    1658799n 1.8
+    1658800n 0
+    1658849n 0
+    1658850n 1.8
+    1658899n 1.8
+    1658900n 0
+    1658949n 0
+    1658950n 1.8
+    1658999n 1.8
+    1659000n 0
+    1659049n 0
+    1659050n 1.8
+    1659099n 1.8
+    1659100n 0
+    1659149n 0
+    1659150n 1.8
+    1659199n 1.8
+    1659200n 0
+    1659249n 0
+    1659250n 1.8
+    1659299n 1.8
+    1659300n 0
+    1659349n 0
+    1659350n 1.8
+    1659399n 1.8
+    1659400n 0
+    1659449n 0
+    1659450n 1.8
+    1659499n 1.8
+    1659500n 0
+    1659549n 0
+    1659550n 1.8
+    1659599n 1.8
+    1659600n 0
+    1659649n 0
+    1659650n 1.8
+    1659699n 1.8
+    1659700n 0
+    1659749n 0
+    1659750n 1.8
+    1659799n 1.8
+    1659800n 0
+    1659849n 0
+    1659850n 1.8
+    1659899n 1.8
+    1659900n 0
+    1659949n 0
+    1659950n 1.8
+    1659999n 1.8
+    1660000n 0
+    1660049n 0
+    1660050n 1.8
+    1660099n 1.8
+    1660100n 0
+    1660149n 0
+    1660150n 1.8
+    1660199n 1.8
+    1660200n 0
+    1660249n 0
+    1660250n 1.8
+    1660299n 1.8
+    1660300n 0
+    1660349n 0
+    1660350n 1.8
+    1660399n 1.8
+    1660400n 0
+    1660449n 0
+    1660450n 1.8
+    1660499n 1.8
+    1660500n 0
+    1660549n 0
+    1660550n 1.8
+    1660599n 1.8
+    1660600n 0
+    1660649n 0
+    1660650n 1.8
+    1660699n 1.8
+    1660700n 0
+    1660749n 0
+    1660750n 1.8
+    1660799n 1.8
+    1660800n 0
+    1660849n 0
+    1660850n 1.8
+    1660899n 1.8
+    1660900n 0
+    1660949n 0
+    1660950n 1.8
+    1660999n 1.8
+    1661000n 0
+    1661049n 0
+    1661050n 1.8
+    1661099n 1.8
+    1661100n 0
+    1661149n 0
+    1661150n 1.8
+    1661199n 1.8
+    1661200n 0
+    1661249n 0
+    1661250n 1.8
+    1661299n 1.8
+    1661300n 0
+    1661349n 0
+    1661350n 1.8
+    1661399n 1.8
+    1661400n 0
+    1661449n 0
+    1661450n 1.8
+    1661499n 1.8
+    1661500n 0
+    1661549n 0
+    1661550n 1.8
+    1661599n 1.8
+    1661600n 0
+    1661649n 0
+    1661650n 1.8
+    1661699n 1.8
+    1661700n 0
+    1661749n 0
+    1661750n 1.8
+    1661799n 1.8
+    1661800n 0
+    1661849n 0
+    1661850n 1.8
+    1661899n 1.8
+    1661900n 0
+    1661949n 0
+    1661950n 1.8
+    1661999n 1.8
+    1662000n 0
+    1662049n 0
+    1662050n 1.8
+    1662099n 1.8
+    1662100n 0
+    1662149n 0
+    1662150n 1.8
+    1662199n 1.8
+    1662200n 0
+    1662249n 0
+    1662250n 1.8
+    1662299n 1.8
+    1662300n 0
+    1662349n 0
+    1662350n 1.8
+    1662399n 1.8
+    1662400n 0
+    1662449n 0
+    1662450n 1.8
+    1662499n 1.8
+    1662500n 0
+    1662549n 0
+    1662550n 1.8
+    1662599n 1.8
+    1662600n 0
+    1662649n 0
+    1662650n 1.8
+    1662699n 1.8
+    1662700n 0
+    1662749n 0
+    1662750n 1.8
+    1662799n 1.8
+    1662800n 0
+    1662849n 0
+    1662850n 1.8
+    1662899n 1.8
+    1662900n 0
+    1662949n 0
+    1662950n 1.8
+    1662999n 1.8
+    1663000n 0
+    1663049n 0
+    1663050n 1.8
+    1663099n 1.8
+    1663100n 0
+    1663149n 0
+    1663150n 1.8
+    1663199n 1.8
+    1663200n 0
+    1663249n 0
+    1663250n 1.8
+    1663299n 1.8
+    1663300n 0
+    1663349n 0
+    1663350n 1.8
+    1663399n 1.8
+    1663400n 0
+    1663449n 0
+    1663450n 1.8
+    1663499n 1.8
+    1663500n 0
+    1663549n 0
+    1663550n 1.8
+    1663599n 1.8
+    1663600n 0
+    1663649n 0
+    1663650n 1.8
+    1663699n 1.8
+    1663700n 0
+    1663749n 0
+    1663750n 1.8
+    1663799n 1.8
+    1663800n 0
+    1663849n 0
+    1663850n 1.8
+    1663899n 1.8
+    1663900n 0
+    1663949n 0
+    1663950n 1.8
+    1663999n 1.8
+    1664000n 0
+    1664049n 0
+    1664050n 1.8
+    1664099n 1.8
+    1664100n 0
+    1664149n 0
+    1664150n 1.8
+    1664199n 1.8
+    1664200n 0
+    1664249n 0
+    1664250n 1.8
+    1664299n 1.8
+    1664300n 0
+    1664349n 0
+    1664350n 1.8
+    1664399n 1.8
+    1664400n 0
+    1664449n 0
+    1664450n 1.8
+    1664499n 1.8
+    1664500n 0
+    1664549n 0
+    1664550n 1.8
+    1664599n 1.8
+    1664600n 0
+    1664649n 0
+    1664650n 1.8
+    1664699n 1.8
+    1664700n 0
+    1664749n 0
+    1664750n 1.8
+    1664799n 1.8
+    1664800n 0
+    1664849n 0
+    1664850n 1.8
+    1664899n 1.8
+    1664900n 0
+    1664949n 0
+    1664950n 1.8
+    1664999n 1.8
+    1665000n 0
+    1665049n 0
+    1665050n 1.8
+    1665099n 1.8
+    1665100n 0
+    1665149n 0
+    1665150n 1.8
+    1665199n 1.8
+    1665200n 0
+    1665249n 0
+    1665250n 1.8
+    1665299n 1.8
+    1665300n 0
+    1665349n 0
+    1665350n 1.8
+    1665399n 1.8
+    1665400n 0
+    1665449n 0
+    1665450n 1.8
+    1665499n 1.8
+    1665500n 0
+    1665549n 0
+    1665550n 1.8
+    1665599n 1.8
+    1665600n 0
+    1665649n 0
+    1665650n 1.8
+    1665699n 1.8
+    1665700n 0
+    1665749n 0
+    1665750n 1.8
+    1665799n 1.8
+    1665800n 0
+    1665849n 0
+    1665850n 1.8
+    1665899n 1.8
+    1665900n 0
+    1665949n 0
+    1665950n 1.8
+    1665999n 1.8
+    1666000n 0
+    1666049n 0
+    1666050n 1.8
+    1666099n 1.8
+    1666100n 0
+    1666149n 0
+    1666150n 1.8
+    1666199n 1.8
+    1666200n 0
+    1666249n 0
+    1666250n 1.8
+    1666299n 1.8
+    1666300n 0
+    1666349n 0
+    1666350n 1.8
+    1666399n 1.8
+    1666400n 0
+    1666449n 0
+    1666450n 1.8
+    1666499n 1.8
+    1666500n 0
+    1666549n 0
+    1666550n 1.8
+    1666599n 1.8
+    1666600n 0
+    1666649n 0
+    1666650n 1.8
+    1666699n 1.8
+    1666700n 0
+    1666749n 0
+    1666750n 1.8
+    1666799n 1.8
+    1666800n 0
+    1666849n 0
+    1666850n 1.8
+    1666899n 1.8
+    1666900n 0
+    1666949n 0
+    1666950n 1.8
+    1666999n 1.8
+    1667000n 0
+    1667049n 0
+    1667050n 1.8
+    1667099n 1.8
+    1667100n 0
+    1667149n 0
+    1667150n 1.8
+    1667199n 1.8
+    1667200n 0
+    1667249n 0
+    1667250n 1.8
+    1667299n 1.8
+    1667300n 0
+    1667349n 0
+    1667350n 1.8
+    1667399n 1.8
+    1667400n 0
+    1667449n 0
+    1667450n 1.8
+    1667499n 1.8
+    1667500n 0
+    1667549n 0
+    1667550n 1.8
+    1667599n 1.8
+    1667600n 0
+    1667649n 0
+    1667650n 1.8
+    1667699n 1.8
+    1667700n 0
+    1667749n 0
+    1667750n 1.8
+    1667799n 1.8
+    1667800n 0
+    1667849n 0
+    1667850n 1.8
+    1667899n 1.8
+    1667900n 0
+    1667949n 0
+    1667950n 1.8
+    1667999n 1.8
+    1668000n 0
+    1668049n 0
+    1668050n 1.8
+    1668099n 1.8
+    1668100n 0
+    1668149n 0
+    1668150n 1.8
+    1668199n 1.8
+    1668200n 0
+    1668249n 0
+    1668250n 1.8
+    1668299n 1.8
+    1668300n 0
+    1668349n 0
+    1668350n 1.8
+    1668399n 1.8
+    1668400n 0
+    1668449n 0
+    1668450n 1.8
+    1668499n 1.8
+    1668500n 0
+    1668549n 0
+    1668550n 1.8
+    1668599n 1.8
+    1668600n 0
+    1668649n 0
+    1668650n 1.8
+    1668699n 1.8
+    1668700n 0
+    1668749n 0
+    1668750n 1.8
+    1668799n 1.8
+    1668800n 0
+    1668849n 0
+    1668850n 1.8
+    1668899n 1.8
+    1668900n 0
+    1668949n 0
+    1668950n 1.8
+    1668999n 1.8
+    1669000n 0
+    1669049n 0
+    1669050n 1.8
+    1669099n 1.8
+    1669100n 0
+    1669149n 0
+    1669150n 1.8
+    1669199n 1.8
+    1669200n 0
+    1669249n 0
+    1669250n 1.8
+    1669299n 1.8
+    1669300n 0
+    1669349n 0
+    1669350n 1.8
+    1669399n 1.8
+    1669400n 0
+    1669449n 0
+    1669450n 1.8
+    1669499n 1.8
+    1669500n 0
+    1669549n 0
+    1669550n 1.8
+    1669599n 1.8
+    1669600n 0
+    1669649n 0
+    1669650n 1.8
+    1669699n 1.8
+    1669700n 0
+    1669749n 0
+    1669750n 1.8
+    1669799n 1.8
+    1669800n 0
+    1669849n 0
+    1669850n 1.8
+    1669899n 1.8
+    1669900n 0
+    1669949n 0
+    1669950n 1.8
+    1669999n 1.8
+    1670000n 0
+    1670049n 0
+    1670050n 1.8
+    1670099n 1.8
+    1670100n 0
+    1670149n 0
+    1670150n 1.8
+    1670199n 1.8
+    1670200n 0
+    1670249n 0
+    1670250n 1.8
+    1670299n 1.8
+    1670300n 0
+    1670349n 0
+    1670350n 1.8
+    1670399n 1.8
+    1670400n 0
+    1670449n 0
+    1670450n 1.8
+    1670499n 1.8
+    1670500n 0
+    1670549n 0
+    1670550n 1.8
+    1670599n 1.8
+    1670600n 0
+    1670649n 0
+    1670650n 1.8
+    1670699n 1.8
+    1670700n 0
+    1670749n 0
+    1670750n 1.8
+    1670799n 1.8
+    1670800n 0
+    1670849n 0
+    1670850n 1.8
+    1670899n 1.8
+    1670900n 0
+    1670949n 0
+    1670950n 1.8
+    1670999n 1.8
+    1671000n 0
+    1671049n 0
+    1671050n 1.8
+    1671099n 1.8
+    1671100n 0
+    1671149n 0
+    1671150n 1.8
+    1671199n 1.8
+    1671200n 0
+    1671249n 0
+    1671250n 1.8
+    1671299n 1.8
+    1671300n 0
+    1671349n 0
+    1671350n 1.8
+    1671399n 1.8
+    1671400n 0
+    1671449n 0
+    1671450n 1.8
+    1671499n 1.8
+    1671500n 0
+    1671549n 0
+    1671550n 1.8
+    1671599n 1.8
+    1671600n 0
+    1671649n 0
+    1671650n 1.8
+    1671699n 1.8
+    1671700n 0
+    1671749n 0
+    1671750n 1.8
+    1671799n 1.8
+    1671800n 0
+    1671849n 0
+    1671850n 1.8
+    1671899n 1.8
+    1671900n 0
+    1671949n 0
+    1671950n 1.8
+    1671999n 1.8
+    1672000n 0
+    1672049n 0
+    1672050n 1.8
+    1672099n 1.8
+    1672100n 0
+    1672149n 0
+    1672150n 1.8
+    1672199n 1.8
+    1672200n 0
+    1672249n 0
+    1672250n 1.8
+    1672299n 1.8
+    1672300n 0
+    1672349n 0
+    1672350n 1.8
+    1672399n 1.8
+    1672400n 0
+    1672449n 0
+    1672450n 1.8
+    1672499n 1.8
+    1672500n 0
+    1672549n 0
+    1672550n 1.8
+    1672599n 1.8
+    1672600n 0
+    1672649n 0
+    1672650n 1.8
+    1672699n 1.8
+    1672700n 0
+    1672749n 0
+    1672750n 1.8
+    1672799n 1.8
+    1672800n 0
+    1672849n 0
+    1672850n 1.8
+    1672899n 1.8
+    1672900n 0
+    1672949n 0
+    1672950n 1.8
+    1672999n 1.8
+    1673000n 0
+    1673049n 0
+    1673050n 1.8
+    1673099n 1.8
+    1673100n 0
+    1673149n 0
+    1673150n 1.8
+    1673199n 1.8
+    1673200n 0
+    1673249n 0
+    1673250n 1.8
+    1673299n 1.8
+    1673300n 0
+    1673349n 0
+    1673350n 1.8
+    1673399n 1.8
+    1673400n 0
+    1673449n 0
+    1673450n 1.8
+    1673499n 1.8
+    1673500n 0
+    1673549n 0
+    1673550n 1.8
+    1673599n 1.8
+    1673600n 0
+    1673649n 0
+    1673650n 1.8
+    1673699n 1.8
+    1673700n 0
+    1673749n 0
+    1673750n 1.8
+    1673799n 1.8
+    1673800n 0
+    1673849n 0
+    1673850n 1.8
+    1673899n 1.8
+    1673900n 0
+    1673949n 0
+    1673950n 1.8
+    1673999n 1.8
+    1674000n 0
+    1674049n 0
+    1674050n 1.8
+    1674099n 1.8
+    1674100n 0
+    1674149n 0
+    1674150n 1.8
+    1674199n 1.8
+    1674200n 0
+    1674249n 0
+    1674250n 1.8
+    1674299n 1.8
+    1674300n 0
+    1674349n 0
+    1674350n 1.8
+    1674399n 1.8
+    1674400n 0
+    1674449n 0
+    1674450n 1.8
+    1674499n 1.8
+    1674500n 0
+    1674549n 0
+    1674550n 1.8
+    1674599n 1.8
+    1674600n 0
+    1674649n 0
+    1674650n 1.8
+    1674699n 1.8
+    1674700n 0
+    1674749n 0
+    1674750n 1.8
+    1674799n 1.8
+    1674800n 0
+    1674849n 0
+    1674850n 1.8
+    1674899n 1.8
+    1674900n 0
+    1674949n 0
+    1674950n 1.8
+    1674999n 1.8
+    1675000n 0
+    1675049n 0
+    1675050n 1.8
+    1675099n 1.8
+    1675100n 0
+    1675149n 0
+    1675150n 1.8
+    1675199n 1.8
+    1675200n 0
+    1675249n 0
+    1675250n 1.8
+    1675299n 1.8
+    1675300n 0
+    1675349n 0
+    1675350n 1.8
+    1675399n 1.8
+    1675400n 0
+    1675449n 0
+    1675450n 1.8
+    1675499n 1.8
+    1675500n 0
+    1675549n 0
+    1675550n 1.8
+    1675599n 1.8
+    1675600n 0
+    1675649n 0
+    1675650n 1.8
+    1675699n 1.8
+    1675700n 0
+    1675749n 0
+    1675750n 1.8
+    1675799n 1.8
+    1675800n 0
+    1675849n 0
+    1675850n 1.8
+    1675899n 1.8
+    1675900n 0
+    1675949n 0
+    1675950n 1.8
+    1675999n 1.8
+    1676000n 0
+    1676049n 0
+    1676050n 1.8
+    1676099n 1.8
+    1676100n 0
+    1676149n 0
+    1676150n 1.8
+    1676199n 1.8
+    1676200n 0
+    1676249n 0
+    1676250n 1.8
+    1676299n 1.8
+    1676300n 0
+    1676349n 0
+    1676350n 1.8
+    1676399n 1.8
+    1676400n 0
+    1676449n 0
+    1676450n 1.8
+    1676499n 1.8
+    1676500n 0
+    1676549n 0
+    1676550n 1.8
+    1676599n 1.8
+    1676600n 0
+    1676649n 0
+    1676650n 1.8
+    1676699n 1.8
+    1676700n 0
+    1676749n 0
+    1676750n 1.8
+    1676799n 1.8
+    1676800n 0
+    1676849n 0
+    1676850n 1.8
+    1676899n 1.8
+    1676900n 0
+    1676949n 0
+    1676950n 1.8
+    1676999n 1.8
+    1677000n 0
+    1677049n 0
+    1677050n 1.8
+    1677099n 1.8
+    1677100n 0
+    1677149n 0
+    1677150n 1.8
+    1677199n 1.8
+    1677200n 0
+    1677249n 0
+    1677250n 1.8
+    1677299n 1.8
+    1677300n 0
+    1677349n 0
+    1677350n 1.8
+    1677399n 1.8
+    1677400n 0
+    1677449n 0
+    1677450n 1.8
+    1677499n 1.8
+    1677500n 0
+    1677549n 0
+    1677550n 1.8
+    1677599n 1.8
+    1677600n 0
+    1677649n 0
+    1677650n 1.8
+    1677699n 1.8
+    1677700n 0
+    1677749n 0
+    1677750n 1.8
+    1677799n 1.8
+    1677800n 0
+    1677849n 0
+    1677850n 1.8
+    1677899n 1.8
+    1677900n 0
+    1677949n 0
+    1677950n 1.8
+    1677999n 1.8
+    1678000n 0
+    1678049n 0
+    1678050n 1.8
+    1678099n 1.8
+    1678100n 0
+    1678149n 0
+    1678150n 1.8
+    1678199n 1.8
+    1678200n 0
+    1678249n 0
+    1678250n 1.8
+    1678299n 1.8
+    1678300n 0
+    1678349n 0
+    1678350n 1.8
+    1678399n 1.8
+    1678400n 0
+    1678449n 0
+    1678450n 1.8
+    1678499n 1.8
+    1678500n 0
+    1678549n 0
+    1678550n 1.8
+    1678599n 1.8
+    1678600n 0
+    1678649n 0
+    1678650n 1.8
+    1678699n 1.8
+    1678700n 0
+    1678749n 0
+    1678750n 1.8
+    1678799n 1.8
+    1678800n 0
+    1678849n 0
+    1678850n 1.8
+    1678899n 1.8
+    1678900n 0
+    1678949n 0
+    1678950n 1.8
+    1678999n 1.8
+    1679000n 0
+    1679049n 0
+    1679050n 1.8
+    1679099n 1.8
+    1679100n 0
+    1679149n 0
+    1679150n 1.8
+    1679199n 1.8
+    1679200n 0
+    1679249n 0
+    1679250n 1.8
+    1679299n 1.8
+    1679300n 0
+    1679349n 0
+    1679350n 1.8
+    1679399n 1.8
+    1679400n 0
+    1679449n 0
+    1679450n 1.8
+    1679499n 1.8
+    1679500n 0
+    1679549n 0
+    1679550n 1.8
+    1679599n 1.8
+    1679600n 0
+    1679649n 0
+    1679650n 1.8
+    1679699n 1.8
+    1679700n 0
+    1679749n 0
+    1679750n 1.8
+    1679799n 1.8
+    1679800n 0
+    1679849n 0
+    1679850n 1.8
+    1679899n 1.8
+    1679900n 0
+    1679949n 0
+    1679950n 1.8
+    1679999n 1.8
+    1680000n 0
+    1680049n 0
+    1680050n 1.8
+    1680099n 1.8
+    1680100n 0
+    1680149n 0
+    1680150n 1.8
+    1680199n 1.8
+    1680200n 0
+    1680249n 0
+    1680250n 1.8
+    1680299n 1.8
+    1680300n 0
+    1680349n 0
+    1680350n 1.8
+    1680399n 1.8
+    1680400n 0
+    1680449n 0
+    1680450n 1.8
+    1680499n 1.8
+    1680500n 0
+    1680549n 0
+    1680550n 1.8
+    1680599n 1.8
+    1680600n 0
+    1680649n 0
+    1680650n 1.8
+    1680699n 1.8
+    1680700n 0
+    1680749n 0
+    1680750n 1.8
+    1680799n 1.8
+    1680800n 0
+    1680849n 0
+    1680850n 1.8
+    1680899n 1.8
+    1680900n 0
+    1680949n 0
+    1680950n 1.8
+    1680999n 1.8
+    1681000n 0
+    1681049n 0
+    1681050n 1.8
+    1681099n 1.8
+    1681100n 0
+    1681149n 0
+    1681150n 1.8
+    1681199n 1.8
+    1681200n 0
+    1681249n 0
+    1681250n 1.8
+    1681299n 1.8
+    1681300n 0
+    1681349n 0
+    1681350n 1.8
+    1681399n 1.8
+    1681400n 0
+    1681449n 0
+    1681450n 1.8
+    1681499n 1.8
+    1681500n 0
+    1681549n 0
+    1681550n 1.8
+    1681599n 1.8
+    1681600n 0
+    1681649n 0
+    1681650n 1.8
+    1681699n 1.8
+    1681700n 0
+    1681749n 0
+    1681750n 1.8
+    1681799n 1.8
+    1681800n 0
+    1681849n 0
+    1681850n 1.8
+    1681899n 1.8
+    1681900n 0
+    1681949n 0
+    1681950n 1.8
+    1681999n 1.8
+    1682000n 0
+    1682049n 0
+    1682050n 1.8
+    1682099n 1.8
+    1682100n 0
+    1682149n 0
+    1682150n 1.8
+    1682199n 1.8
+    1682200n 0
+    1682249n 0
+    1682250n 1.8
+    1682299n 1.8
+    1682300n 0
+    1682349n 0
+    1682350n 1.8
+    1682399n 1.8
+    1682400n 0
+    1682449n 0
+    1682450n 1.8
+    1682499n 1.8
+    1682500n 0
+    1682549n 0
+    1682550n 1.8
+    1682599n 1.8
+    1682600n 0
+    1682649n 0
+    1682650n 1.8
+    1682699n 1.8
+    1682700n 0
+    1682749n 0
+    1682750n 1.8
+    1682799n 1.8
+    1682800n 0
+    1682849n 0
+    1682850n 1.8
+    1682899n 1.8
+    1682900n 0
+    1682949n 0
+    1682950n 1.8
+    1682999n 1.8
+    1683000n 0
+    1683049n 0
+    1683050n 1.8
+    1683099n 1.8
+    1683100n 0
+    1683149n 0
+    1683150n 1.8
+    1683199n 1.8
+    1683200n 0
+    1683249n 0
+    1683250n 1.8
+    1683299n 1.8
+    1683300n 0
+    1683349n 0
+    1683350n 1.8
+    1683399n 1.8
+    1683400n 0
+    1683449n 0
+    1683450n 1.8
+    1683499n 1.8
+    1683500n 0
+    1683549n 0
+    1683550n 1.8
+    1683599n 1.8
+    1683600n 0
+    1683649n 0
+    1683650n 1.8
+    1683699n 1.8
+    1683700n 0
+    1683749n 0
+    1683750n 1.8
+    1683799n 1.8
+    1683800n 0
+    1683849n 0
+    1683850n 1.8
+    1683899n 1.8
+    1683900n 0
+    1683949n 0
+    1683950n 1.8
+    1683999n 1.8
+    1684000n 0
+    1684049n 0
+    1684050n 1.8
+    1684099n 1.8
+    1684100n 0
+    1684149n 0
+    1684150n 1.8
+    1684199n 1.8
+    1684200n 0
+    1684249n 0
+    1684250n 1.8
+    1684299n 1.8
+    1684300n 0
+    1684349n 0
+    1684350n 1.8
+    1684399n 1.8
+    1684400n 0
+    1684449n 0
+    1684450n 1.8
+    1684499n 1.8
+    1684500n 0
+    1684549n 0
+    1684550n 1.8
+    1684599n 1.8
+    1684600n 0
+    1684649n 0
+    1684650n 1.8
+    1684699n 1.8
+    1684700n 0
+    1684749n 0
+    1684750n 1.8
+    1684799n 1.8
+    1684800n 0
+    1684849n 0
+    1684850n 1.8
+    1684899n 1.8
+    1684900n 0
+    1684949n 0
+    1684950n 1.8
+    1684999n 1.8
+    1685000n 0
+    1685049n 0
+    1685050n 1.8
+    1685099n 1.8
+    1685100n 0
+    1685149n 0
+    1685150n 1.8
+    1685199n 1.8
+    1685200n 0
+    1685249n 0
+    1685250n 1.8
+    1685299n 1.8
+    1685300n 0
+    1685349n 0
+    1685350n 1.8
+    1685399n 1.8
+    1685400n 0
+    1685449n 0
+    1685450n 1.8
+    1685499n 1.8
+    1685500n 0
+    1685549n 0
+    1685550n 1.8
+    1685599n 1.8
+    1685600n 0
+    1685649n 0
+    1685650n 1.8
+    1685699n 1.8
+    1685700n 0
+    1685749n 0
+    1685750n 1.8
+    1685799n 1.8
+    1685800n 0
+    1685849n 0
+    1685850n 1.8
+    1685899n 1.8
+    1685900n 0
+    1685949n 0
+    1685950n 1.8
+    1685999n 1.8
+    1686000n 0
+    1686049n 0
+    1686050n 1.8
+    1686099n 1.8
+    1686100n 0
+    1686149n 0
+    1686150n 1.8
+    1686199n 1.8
+    1686200n 0
+    1686249n 0
+    1686250n 1.8
+    1686299n 1.8
+    1686300n 0
+    1686349n 0
+    1686350n 1.8
+    1686399n 1.8
+    1686400n 0
+    1686449n 0
+    1686450n 1.8
+    1686499n 1.8
+    1686500n 0
+    1686549n 0
+    1686550n 1.8
+    1686599n 1.8
+    1686600n 0
+    1686649n 0
+    1686650n 1.8
+    1686699n 1.8
+    1686700n 0
+    1686749n 0
+    1686750n 1.8
+    1686799n 1.8
+    1686800n 0
+    1686849n 0
+    1686850n 1.8
+    1686899n 1.8
+    1686900n 0
+    1686949n 0
+    1686950n 1.8
+    1686999n 1.8
+    1687000n 0
+    1687049n 0
+    1687050n 1.8
+    1687099n 1.8
+    1687100n 0
+    1687149n 0
+    1687150n 1.8
+    1687199n 1.8
+    1687200n 0
+    1687249n 0
+    1687250n 1.8
+    1687299n 1.8
+    1687300n 0
+    1687349n 0
+    1687350n 1.8
+    1687399n 1.8
+    1687400n 0
+    1687449n 0
+    1687450n 1.8
+    1687499n 1.8
+    1687500n 0
+    1687549n 0
+    1687550n 1.8
+    1687599n 1.8
+    1687600n 0
+    1687649n 0
+    1687650n 1.8
+    1687699n 1.8
+    1687700n 0
+    1687749n 0
+    1687750n 1.8
+    1687799n 1.8
+    1687800n 0
+    1687849n 0
+    1687850n 1.8
+    1687899n 1.8
+    1687900n 0
+    1687949n 0
+    1687950n 1.8
+    1687999n 1.8
+    1688000n 0
+    1688049n 0
+    1688050n 1.8
+    1688099n 1.8
+    1688100n 0
+    1688149n 0
+    1688150n 1.8
+    1688199n 1.8
+    1688200n 0
+    1688249n 0
+    1688250n 1.8
+    1688299n 1.8
+    1688300n 0
+    1688349n 0
+    1688350n 1.8
+    1688399n 1.8
+    1688400n 0
+    1688449n 0
+    1688450n 1.8
+    1688499n 1.8
+    1688500n 0
+    1688549n 0
+    1688550n 1.8
+    1688599n 1.8
+    1688600n 0
+    1688649n 0
+    1688650n 1.8
+    1688699n 1.8
+    1688700n 0
+    1688749n 0
+    1688750n 1.8
+    1688799n 1.8
+    1688800n 0
+    1688849n 0
+    1688850n 1.8
+    1688899n 1.8
+    1688900n 0
+    1688949n 0
+    1688950n 1.8
+    1688999n 1.8
+    1689000n 0
+    1689049n 0
+    1689050n 1.8
+    1689099n 1.8
+    1689100n 0
+    1689149n 0
+    1689150n 1.8
+    1689199n 1.8
+    1689200n 0
+    1689249n 0
+    1689250n 1.8
+    1689299n 1.8
+    1689300n 0
+    1689349n 0
+    1689350n 1.8
+    1689399n 1.8
+    1689400n 0
+    1689449n 0
+    1689450n 1.8
+    1689499n 1.8
+    1689500n 0
+    1689549n 0
+    1689550n 1.8
+    1689599n 1.8
+    1689600n 0
+    1689649n 0
+    1689650n 1.8
+    1689699n 1.8
+    1689700n 0
+    1689749n 0
+    1689750n 1.8
+    1689799n 1.8
+    1689800n 0
+    1689849n 0
+    1689850n 1.8
+    1689899n 1.8
+    1689900n 0
+    1689949n 0
+    1689950n 1.8
+    1689999n 1.8
+    1690000n 0
+    1690049n 0
+    1690050n 1.8
+    1690099n 1.8
+    1690100n 0
+    1690149n 0
+    1690150n 1.8
+    1690199n 1.8
+    1690200n 0
+    1690249n 0
+    1690250n 1.8
+    1690299n 1.8
+    1690300n 0
+    1690349n 0
+    1690350n 1.8
+    1690399n 1.8
+    1690400n 0
+    1690449n 0
+    1690450n 1.8
+    1690499n 1.8
+    1690500n 0
+    1690549n 0
+    1690550n 1.8
+    1690599n 1.8
+    1690600n 0
+    1690649n 0
+    1690650n 1.8
+    1690699n 1.8
+    1690700n 0
+    1690749n 0
+    1690750n 1.8
+    1690799n 1.8
+    1690800n 0
+    1690849n 0
+    1690850n 1.8
+    1690899n 1.8
+    1690900n 0
+    1690949n 0
+    1690950n 1.8
+    1690999n 1.8
+    1691000n 0
+    1691049n 0
+    1691050n 1.8
+    1691099n 1.8
+    1691100n 0
+    1691149n 0
+    1691150n 1.8
+    1691199n 1.8
+    1691200n 0
+    1691249n 0
+    1691250n 1.8
+    1691299n 1.8
+    1691300n 0
+    1691349n 0
+    1691350n 1.8
+    1691399n 1.8
+    1691400n 0
+    1691449n 0
+    1691450n 1.8
+    1691499n 1.8
+    1691500n 0
+    1691549n 0
+    1691550n 1.8
+    1691599n 1.8
+    1691600n 0
+    1691649n 0
+    1691650n 1.8
+    1691699n 1.8
+    1691700n 0
+    1691749n 0
+    1691750n 1.8
+    1691799n 1.8
+    1691800n 0
+    1691849n 0
+    1691850n 1.8
+    1691899n 1.8
+    1691900n 0
+    1691949n 0
+    1691950n 1.8
+    1691999n 1.8
+    1692000n 0
+    1692049n 0
+    1692050n 1.8
+    1692099n 1.8
+    1692100n 0
+    1692149n 0
+    1692150n 1.8
+    1692199n 1.8
+    1692200n 0
+    1692249n 0
+    1692250n 1.8
+    1692299n 1.8
+    1692300n 0
+    1692349n 0
+    1692350n 1.8
+    1692399n 1.8
+    1692400n 0
+    1692449n 0
+    1692450n 1.8
+    1692499n 1.8
+    1692500n 0
+    1692549n 0
+    1692550n 1.8
+    1692599n 1.8
+    1692600n 0
+    1692649n 0
+    1692650n 1.8
+    1692699n 1.8
+    1692700n 0
+    1692749n 0
+    1692750n 1.8
+    1692799n 1.8
+    1692800n 0
+    1692849n 0
+    1692850n 1.8
+    1692899n 1.8
+    1692900n 0
+    1692949n 0
+    1692950n 1.8
+    1692999n 1.8
+    1693000n 0
+    1693049n 0
+    1693050n 1.8
+    1693099n 1.8
+    1693100n 0
+    1693149n 0
+    1693150n 1.8
+    1693199n 1.8
+    1693200n 0
+    1693249n 0
+    1693250n 1.8
+    1693299n 1.8
+    1693300n 0
+    1693349n 0
+    1693350n 1.8
+    1693399n 1.8
+    1693400n 0
+    1693449n 0
+    1693450n 1.8
+    1693499n 1.8
+    1693500n 0
+    1693549n 0
+    1693550n 1.8
+    1693599n 1.8
+    1693600n 0
+    1693649n 0
+    1693650n 1.8
+    1693699n 1.8
+    1693700n 0
+    1693749n 0
+    1693750n 1.8
+    1693799n 1.8
+    1693800n 0
+    1693849n 0
+    1693850n 1.8
+    1693899n 1.8
+    1693900n 0
+    1693949n 0
+    1693950n 1.8
+    1693999n 1.8
+    1694000n 0
+    1694049n 0
+    1694050n 1.8
+    1694099n 1.8
+    1694100n 0
+    1694149n 0
+    1694150n 1.8
+    1694199n 1.8
+    1694200n 0
+    1694249n 0
+    1694250n 1.8
+    1694299n 1.8
+    1694300n 0
+    1694349n 0
+    1694350n 1.8
+    1694399n 1.8
+    1694400n 0
+    1694449n 0
+    1694450n 1.8
+    1694499n 1.8
+    1694500n 0
+    1694549n 0
+    1694550n 1.8
+    1694599n 1.8
+    1694600n 0
+    1694649n 0
+    1694650n 1.8
+    1694699n 1.8
+    1694700n 0
+    1694749n 0
+    1694750n 1.8
+    1694799n 1.8
+    1694800n 0
+    1694849n 0
+    1694850n 1.8
+    1694899n 1.8
+    1694900n 0
+    1694949n 0
+    1694950n 1.8
+    1694999n 1.8
+    1695000n 0
+    1695049n 0
+    1695050n 1.8
+    1695099n 1.8
+    1695100n 0
+    1695149n 0
+    1695150n 1.8
+    1695199n 1.8
+    1695200n 0
+    1695249n 0
+    1695250n 1.8
+    1695299n 1.8
+    1695300n 0
+    1695349n 0
+    1695350n 1.8
+    1695399n 1.8
+    1695400n 0
+    1695449n 0
+    1695450n 1.8
+    1695499n 1.8
+    1695500n 0
+    1695549n 0
+    1695550n 1.8
+    1695599n 1.8
+    1695600n 0
+    1695649n 0
+    1695650n 1.8
+    1695699n 1.8
+    1695700n 0
+    1695749n 0
+    1695750n 1.8
+    1695799n 1.8
+    1695800n 0
+    1695849n 0
+    1695850n 1.8
+    1695899n 1.8
+    1695900n 0
+    1695949n 0
+    1695950n 1.8
+    1695999n 1.8
+    1696000n 0
+    1696049n 0
+    1696050n 1.8
+    1696099n 1.8
+    1696100n 0
+    1696149n 0
+    1696150n 1.8
+    1696199n 1.8
+    1696200n 0
+    1696249n 0
+    1696250n 1.8
+    1696299n 1.8
+    1696300n 0
+    1696349n 0
+    1696350n 1.8
+    1696399n 1.8
+    1696400n 0
+    1696449n 0
+    1696450n 1.8
+    1696499n 1.8
+    1696500n 0
+    1696549n 0
+    1696550n 1.8
+    1696599n 1.8
+    1696600n 0
+    1696649n 0
+    1696650n 1.8
+    1696699n 1.8
+    1696700n 0
+    1696749n 0
+    1696750n 1.8
+    1696799n 1.8
+    1696800n 0
+    1696849n 0
+    1696850n 1.8
+    1696899n 1.8
+    1696900n 0
+    1696949n 0
+    1696950n 1.8
+    1696999n 1.8
+    1697000n 0
+    1697049n 0
+    1697050n 1.8
+    1697099n 1.8
+    1697100n 0
+    1697149n 0
+    1697150n 1.8
+    1697199n 1.8
+    1697200n 0
+    1697249n 0
+    1697250n 1.8
+    1697299n 1.8
+    1697300n 0
+    1697349n 0
+    1697350n 1.8
+    1697399n 1.8
+    1697400n 0
+    1697449n 0
+    1697450n 1.8
+    1697499n 1.8
+    1697500n 0
+    1697549n 0
+    1697550n 1.8
+    1697599n 1.8
+    1697600n 0
+    1697649n 0
+    1697650n 1.8
+    1697699n 1.8
+    1697700n 0
+    1697749n 0
+    1697750n 1.8
+    1697799n 1.8
+    1697800n 0
+    1697849n 0
+    1697850n 1.8
+    1697899n 1.8
+    1697900n 0
+    1697949n 0
+    1697950n 1.8
+    1697999n 1.8
+    1698000n 0
+    1698049n 0
+    1698050n 1.8
+    1698099n 1.8
+    1698100n 0
+    1698149n 0
+    1698150n 1.8
+    1698199n 1.8
+    1698200n 0
+    1698249n 0
+    1698250n 1.8
+    1698299n 1.8
+    1698300n 0
+    1698349n 0
+    1698350n 1.8
+    1698399n 1.8
+    1698400n 0
+    1698449n 0
+    1698450n 1.8
+    1698499n 1.8
+    1698500n 0
+    1698549n 0
+    1698550n 1.8
+    1698599n 1.8
+    1698600n 0
+    1698649n 0
+    1698650n 1.8
+    1698699n 1.8
+    1698700n 0
+    1698749n 0
+    1698750n 1.8
+    1698799n 1.8
+    1698800n 0
+    1698849n 0
+    1698850n 1.8
+    1698899n 1.8
+    1698900n 0
+    1698949n 0
+    1698950n 1.8
+    1698999n 1.8
+    1699000n 0
+    1699049n 0
+    1699050n 1.8
+    1699099n 1.8
+    1699100n 0
+    1699149n 0
+    1699150n 1.8
+    1699199n 1.8
+    1699200n 0
+    1699249n 0
+    1699250n 1.8
+    1699299n 1.8
+    1699300n 0
+    1699349n 0
+    1699350n 1.8
+    1699399n 1.8
+    1699400n 0
+    1699449n 0
+    1699450n 1.8
+    1699499n 1.8
+    1699500n 0
+    1699549n 0
+    1699550n 1.8
+    1699599n 1.8
+    1699600n 0
+    1699649n 0
+    1699650n 1.8
+    1699699n 1.8
+    1699700n 0
+    1699749n 0
+    1699750n 1.8
+    1699799n 1.8
+    1699800n 0
+    1699849n 0
+    1699850n 1.8
+    1699899n 1.8
+    1699900n 0
+    1699949n 0
+    1699950n 1.8
+    1699999n 1.8
+    1700000n 0
+    1700049n 0
+    1700050n 1.8
+    1700099n 1.8
+    1700100n 0
+    1700149n 0
+    1700150n 1.8
+    1700199n 1.8
+    1700200n 0
+    1700249n 0
+    1700250n 1.8
+    1700299n 1.8
+    1700300n 0
+    1700349n 0
+    1700350n 1.8
+    1700399n 1.8
+    1700400n 0
+    1700449n 0
+    1700450n 1.8
+    1700499n 1.8
+    1700500n 0
+    1700549n 0
+    1700550n 1.8
+    1700599n 1.8
+    1700600n 0
+    1700649n 0
+    1700650n 1.8
+    1700699n 1.8
+    1700700n 0
+    1700749n 0
+    1700750n 1.8
+    1700799n 1.8
+    1700800n 0
+    1700849n 0
+    1700850n 1.8
+    1700899n 1.8
+    1700900n 0
+    1700949n 0
+    1700950n 1.8
+    1700999n 1.8
+    1701000n 0
+    1701049n 0
+    1701050n 1.8
+    1701099n 1.8
+    1701100n 0
+    1701149n 0
+    1701150n 1.8
+    1701199n 1.8
+    1701200n 0
+    1701249n 0
+    1701250n 1.8
+    1701299n 1.8
+    1701300n 0
+    1701349n 0
+    1701350n 1.8
+    1701399n 1.8
+    1701400n 0
+    1701449n 0
+    1701450n 1.8
+    1701499n 1.8
+    1701500n 0
+    1701549n 0
+    1701550n 1.8
+    1701599n 1.8
+    1701600n 0
+    1701649n 0
+    1701650n 1.8
+    1701699n 1.8
+    1701700n 0
+    1701749n 0
+    1701750n 1.8
+    1701799n 1.8
+    1701800n 0
+    1701849n 0
+    1701850n 1.8
+    1701899n 1.8
+    1701900n 0
+    1701949n 0
+    1701950n 1.8
+    1701999n 1.8
+    1702000n 0
+    1702049n 0
+    1702050n 1.8
+    1702099n 1.8
+    1702100n 0
+    1702149n 0
+    1702150n 1.8
+    1702199n 1.8
+    1702200n 0
+    1702249n 0
+    1702250n 1.8
+    1702299n 1.8
+    1702300n 0
+    1702349n 0
+    1702350n 1.8
+    1702399n 1.8
+    1702400n 0
+    1702449n 0
+    1702450n 1.8
+    1702499n 1.8
+    1702500n 0
+    1702549n 0
+    1702550n 1.8
+    1702599n 1.8
+    1702600n 0
+    1702649n 0
+    1702650n 1.8
+    1702699n 1.8
+    1702700n 0
+    1702749n 0
+    1702750n 1.8
+    1702799n 1.8
+    1702800n 0
+    1702849n 0
+    1702850n 1.8
+    1702899n 1.8
+    1702900n 0
+    1702949n 0
+    1702950n 1.8
+    1702999n 1.8
+    1703000n 0
+    1703049n 0
+    1703050n 1.8
+    1703099n 1.8
+    1703100n 0
+    1703149n 0
+    1703150n 1.8
+    1703199n 1.8
+    1703200n 0
+    1703249n 0
+    1703250n 1.8
+    1703299n 1.8
+    1703300n 0
+    1703349n 0
+    1703350n 1.8
+    1703399n 1.8
+    1703400n 0
+    1703449n 0
+    1703450n 1.8
+    1703499n 1.8
+    1703500n 0
+    1703549n 0
+    1703550n 1.8
+    1703599n 1.8
+    1703600n 0
+    1703649n 0
+    1703650n 1.8
+    1703699n 1.8
+    1703700n 0
+    1703749n 0
+    1703750n 1.8
+    1703799n 1.8
+    1703800n 0
+    1703849n 0
+    1703850n 1.8
+    1703899n 1.8
+    1703900n 0
+    1703949n 0
+    1703950n 1.8
+    1703999n 1.8
+    1704000n 0
+    1704049n 0
+    1704050n 1.8
+    1704099n 1.8
+    1704100n 0
+    1704149n 0
+    1704150n 1.8
+    1704199n 1.8
+    1704200n 0
+    1704249n 0
+    1704250n 1.8
+    1704299n 1.8
+    1704300n 0
+    1704349n 0
+    1704350n 1.8
+    1704399n 1.8
+    1704400n 0
+    1704449n 0
+    1704450n 1.8
+    1704499n 1.8
+    1704500n 0
+    1704549n 0
+    1704550n 1.8
+    1704599n 1.8
+    1704600n 0
+    1704649n 0
+    1704650n 1.8
+    1704699n 1.8
+    1704700n 0
+    1704749n 0
+    1704750n 1.8
+    1704799n 1.8
+    1704800n 0
+    1704849n 0
+    1704850n 1.8
+    1704899n 1.8
+    1704900n 0
+    1704949n 0
+    1704950n 1.8
+    1704999n 1.8
+    1705000n 0
+    1705049n 0
+    1705050n 1.8
+    1705099n 1.8
+    1705100n 0
+    1705149n 0
+    1705150n 1.8
+    1705199n 1.8
+    1705200n 0
+    1705249n 0
+    1705250n 1.8
+    1705299n 1.8
+    1705300n 0
+    1705349n 0
+    1705350n 1.8
+    1705399n 1.8
+    1705400n 0
+    1705449n 0
+    1705450n 1.8
+    1705499n 1.8
+    1705500n 0
+    1705549n 0
+    1705550n 1.8
+    1705599n 1.8
+    1705600n 0
+    1705649n 0
+    1705650n 1.8
+    1705699n 1.8
+    1705700n 0
+    1705749n 0
+    1705750n 1.8
+    1705799n 1.8
+    1705800n 0
+    1705849n 0
+    1705850n 1.8
+    1705899n 1.8
+    1705900n 0
+    1705949n 0
+    1705950n 1.8
+    1705999n 1.8
+    1706000n 0
+    1706049n 0
+    1706050n 1.8
+    1706099n 1.8
+    1706100n 0
+    1706149n 0
+    1706150n 1.8
+    1706199n 1.8
+    1706200n 0
+    1706249n 0
+    1706250n 1.8
+    1706299n 1.8
+    1706300n 0
+    1706349n 0
+    1706350n 1.8
+    1706399n 1.8
+    1706400n 0
+    1706449n 0
+    1706450n 1.8
+    1706499n 1.8
+    1706500n 0
+    1706549n 0
+    1706550n 1.8
+    1706599n 1.8
+    1706600n 0
+    1706649n 0
+    1706650n 1.8
+    1706699n 1.8
+    1706700n 0
+    1706749n 0
+    1706750n 1.8
+    1706799n 1.8
+    1706800n 0
+    1706849n 0
+    1706850n 1.8
+    1706899n 1.8
+    1706900n 0
+    1706949n 0
+    1706950n 1.8
+    1706999n 1.8
+    1707000n 0
+    1707049n 0
+    1707050n 1.8
+    1707099n 1.8
+    1707100n 0
+    1707149n 0
+    1707150n 1.8
+    1707199n 1.8
+    1707200n 0
+    1707249n 0
+    1707250n 1.8
+    1707299n 1.8
+    1707300n 0
+    1707349n 0
+    1707350n 1.8
+    1707399n 1.8
+    1707400n 0
+    1707449n 0
+    1707450n 1.8
+    1707499n 1.8
+    1707500n 0
+    1707549n 0
+    1707550n 1.8
+    1707599n 1.8
+    1707600n 0
+    1707649n 0
+    1707650n 1.8
+    1707699n 1.8
+    1707700n 0
+    1707749n 0
+    1707750n 1.8
+    1707799n 1.8
+    1707800n 0
+    1707849n 0
+    1707850n 1.8
+    1707899n 1.8
+    1707900n 0
+    1707949n 0
+    1707950n 1.8
+    1707999n 1.8
+    1708000n 0
+    1708049n 0
+    1708050n 1.8
+    1708099n 1.8
+    1708100n 0
+    1708149n 0
+    1708150n 1.8
+    1708199n 1.8
+    1708200n 0
+    1708249n 0
+    1708250n 1.8
+    1708299n 1.8
+    1708300n 0
+    1708349n 0
+    1708350n 1.8
+    1708399n 1.8
+    1708400n 0
+    1708449n 0
+    1708450n 1.8
+    1708499n 1.8
+    1708500n 0
+    1708549n 0
+    1708550n 1.8
+    1708599n 1.8
+    1708600n 0
+    1708649n 0
+    1708650n 1.8
+    1708699n 1.8
+    1708700n 0
+    1708749n 0
+    1708750n 1.8
+    1708799n 1.8
+    1708800n 0
+    1708849n 0
+    1708850n 1.8
+    1708899n 1.8
+    1708900n 0
+    1708949n 0
+    1708950n 1.8
+    1708999n 1.8
+    1709000n 0
+    1709049n 0
+    1709050n 1.8
+    1709099n 1.8
+    1709100n 0
+    1709149n 0
+    1709150n 1.8
+    1709199n 1.8
+    1709200n 0
+    1709249n 0
+    1709250n 1.8
+    1709299n 1.8
+    1709300n 0
+    1709349n 0
+    1709350n 1.8
+    1709399n 1.8
+    1709400n 0
+    1709449n 0
+    1709450n 1.8
+    1709499n 1.8
+    1709500n 0
+    1709549n 0
+    1709550n 1.8
+    1709599n 1.8
+    1709600n 0
+    1709649n 0
+    1709650n 1.8
+    1709699n 1.8
+    1709700n 0
+    1709749n 0
+    1709750n 1.8
+    1709799n 1.8
+    1709800n 0
+    1709849n 0
+    1709850n 1.8
+    1709899n 1.8
+    1709900n 0
+    1709949n 0
+    1709950n 1.8
+    1709999n 1.8
+    1710000n 0
+    1710049n 0
+    1710050n 1.8
+    1710099n 1.8
+    1710100n 0
+    1710149n 0
+    1710150n 1.8
+    1710199n 1.8
+    1710200n 0
+    1710249n 0
+    1710250n 1.8
+    1710299n 1.8
+    1710300n 0
+    1710349n 0
+    1710350n 1.8
+    1710399n 1.8
+    1710400n 0
+    1710449n 0
+    1710450n 1.8
+    1710499n 1.8
+    1710500n 0
+    1710549n 0
+    1710550n 1.8
+    1710599n 1.8
+    1710600n 0
+    1710649n 0
+    1710650n 1.8
+    1710699n 1.8
+    1710700n 0
+    1710749n 0
+    1710750n 1.8
+    1710799n 1.8
+    1710800n 0
+    1710849n 0
+    1710850n 1.8
+    1710899n 1.8
+    1710900n 0
+    1710949n 0
+    1710950n 1.8
+    1710999n 1.8
+    1711000n 0
+    1711049n 0
+    1711050n 1.8
+    1711099n 1.8
+    1711100n 0
+    1711149n 0
+    1711150n 1.8
+    1711199n 1.8
+    1711200n 0
+    1711249n 0
+    1711250n 1.8
+    1711299n 1.8
+    1711300n 0
+    1711349n 0
+    1711350n 1.8
+    1711399n 1.8
+    1711400n 0
+    1711449n 0
+    1711450n 1.8
+    1711499n 1.8
+    1711500n 0
+    1711549n 0
+    1711550n 1.8
+    1711599n 1.8
+    1711600n 0
+    1711649n 0
+    1711650n 1.8
+    1711699n 1.8
+    1711700n 0
+    1711749n 0
+    1711750n 1.8
+    1711799n 1.8
+    1711800n 0
+    1711849n 0
+    1711850n 1.8
+    1711899n 1.8
+    1711900n 0
+    1711949n 0
+    1711950n 1.8
+    1711999n 1.8
+    1712000n 0
+    1712049n 0
+    1712050n 1.8
+    1712099n 1.8
+    1712100n 0
+    1712149n 0
+    1712150n 1.8
+    1712199n 1.8
+    1712200n 0
+    1712249n 0
+    1712250n 1.8
+    1712299n 1.8
+    1712300n 0
+    1712349n 0
+    1712350n 1.8
+    1712399n 1.8
+    1712400n 0
+    1712449n 0
+    1712450n 1.8
+    1712499n 1.8
+    1712500n 0
+    1712549n 0
+    1712550n 1.8
+    1712599n 1.8
+    1712600n 0
+    1712649n 0
+    1712650n 1.8
+    1712699n 1.8
+    1712700n 0
+    1712749n 0
+    1712750n 1.8
+    1712799n 1.8
+    1712800n 0
+    1712849n 0
+    1712850n 1.8
+    1712899n 1.8
+    1712900n 0
+    1712949n 0
+    1712950n 1.8
+    1712999n 1.8
+    1713000n 0
+    1713049n 0
+    1713050n 1.8
+    1713099n 1.8
+    1713100n 0
+    1713149n 0
+    1713150n 1.8
+    1713199n 1.8
+    1713200n 0
+    1713249n 0
+    1713250n 1.8
+    1713299n 1.8
+    1713300n 0
+    1713349n 0
+    1713350n 1.8
+    1713399n 1.8
+    1713400n 0
+    1713449n 0
+    1713450n 1.8
+    1713499n 1.8
+    1713500n 0
+    1713549n 0
+    1713550n 1.8
+    1713599n 1.8
+    1713600n 0
+    1713649n 0
+    1713650n 1.8
+    1713699n 1.8
+    1713700n 0
+    1713749n 0
+    1713750n 1.8
+    1713799n 1.8
+    1713800n 0
+    1713849n 0
+    1713850n 1.8
+    1713899n 1.8
+    1713900n 0
+    1713949n 0
+    1713950n 1.8
+    1713999n 1.8
+    1714000n 0
+    1714049n 0
+    1714050n 1.8
+    1714099n 1.8
+    1714100n 0
+    1714149n 0
+    1714150n 1.8
+    1714199n 1.8
+    1714200n 0
+    1714249n 0
+    1714250n 1.8
+    1714299n 1.8
+    1714300n 0
+    1714349n 0
+    1714350n 1.8
+    1714399n 1.8
+    1714400n 0
+    1714449n 0
+    1714450n 1.8
+    1714499n 1.8
+    1714500n 0
+    1714549n 0
+    1714550n 1.8
+    1714599n 1.8
+    1714600n 0
+    1714649n 0
+    1714650n 1.8
+    1714699n 1.8
+    1714700n 0
+    1714749n 0
+    1714750n 1.8
+    1714799n 1.8
+    1714800n 0
+    1714849n 0
+    1714850n 1.8
+    1714899n 1.8
+    1714900n 0
+    1714949n 0
+    1714950n 1.8
+    1714999n 1.8
+    1715000n 0
+    1715049n 0
+    1715050n 1.8
+    1715099n 1.8
+    1715100n 0
+    1715149n 0
+    1715150n 1.8
+    1715199n 1.8
+    1715200n 0
+    1715249n 0
+    1715250n 1.8
+    1715299n 1.8
+    1715300n 0
+    1715349n 0
+    1715350n 1.8
+    1715399n 1.8
+    1715400n 0
+    1715449n 0
+    1715450n 1.8
+    1715499n 1.8
+    1715500n 0
+    1715549n 0
+    1715550n 1.8
+    1715599n 1.8
+    1715600n 0
+    1715649n 0
+    1715650n 1.8
+    1715699n 1.8
+    1715700n 0
+    1715749n 0
+    1715750n 1.8
+    1715799n 1.8
+    1715800n 0
+    1715849n 0
+    1715850n 1.8
+    1715899n 1.8
+    1715900n 0
+    1715949n 0
+    1715950n 1.8
+    1715999n 1.8
+    1716000n 0
+    1716049n 0
+    1716050n 1.8
+    1716099n 1.8
+    1716100n 0
+    1716149n 0
+    1716150n 1.8
+    1716199n 1.8
+    1716200n 0
+    1716249n 0
+    1716250n 1.8
+    1716299n 1.8
+    1716300n 0
+    1716349n 0
+    1716350n 1.8
+    1716399n 1.8
+    1716400n 0
+    1716449n 0
+    1716450n 1.8
+    1716499n 1.8
+    1716500n 0
+    1716549n 0
+    1716550n 1.8
+    1716599n 1.8
+    1716600n 0
+    1716649n 0
+    1716650n 1.8
+    1716699n 1.8
+    1716700n 0
+    1716749n 0
+    1716750n 1.8
+    1716799n 1.8
+    1716800n 0
+    1716849n 0
+    1716850n 1.8
+    1716899n 1.8
+    1716900n 0
+    1716949n 0
+    1716950n 1.8
+    1716999n 1.8
+    1717000n 0
+    1717049n 0
+    1717050n 1.8
+    1717099n 1.8
+    1717100n 0
+    1717149n 0
+    1717150n 1.8
+    1717199n 1.8
+    1717200n 0
+    1717249n 0
+    1717250n 1.8
+    1717299n 1.8
+    1717300n 0
+    1717349n 0
+    1717350n 1.8
+    1717399n 1.8
+    1717400n 0
+    1717449n 0
+    1717450n 1.8
+    1717499n 1.8
+    1717500n 0
+    1717549n 0
+    1717550n 1.8
+    1717599n 1.8
+    1717600n 0
+    1717649n 0
+    1717650n 1.8
+    1717699n 1.8
+    1717700n 0
+    1717749n 0
+    1717750n 1.8
+    1717799n 1.8
+    1717800n 0
+    1717849n 0
+    1717850n 1.8
+    1717899n 1.8
+    1717900n 0
+    1717949n 0
+    1717950n 1.8
+    1717999n 1.8
+    1718000n 0
+    1718049n 0
+    1718050n 1.8
+    1718099n 1.8
+    1718100n 0
+    1718149n 0
+    1718150n 1.8
+    1718199n 1.8
+    1718200n 0
+    1718249n 0
+    1718250n 1.8
+    1718299n 1.8
+    1718300n 0
+    1718349n 0
+    1718350n 1.8
+    1718399n 1.8
+    1718400n 0
+    1718449n 0
+    1718450n 1.8
+    1718499n 1.8
+    1718500n 0
+    1718549n 0
+    1718550n 1.8
+    1718599n 1.8
+    1718600n 0
+    1718649n 0
+    1718650n 1.8
+    1718699n 1.8
+    1718700n 0
+    1718749n 0
+    1718750n 1.8
+    1718799n 1.8
+    1718800n 0
+    1718849n 0
+    1718850n 1.8
+    1718899n 1.8
+    1718900n 0
+    1718949n 0
+    1718950n 1.8
+    1718999n 1.8
+    1719000n 0
+    1719049n 0
+    1719050n 1.8
+    1719099n 1.8
+    1719100n 0
+    1719149n 0
+    1719150n 1.8
+    1719199n 1.8
+    1719200n 0
+    1719249n 0
+    1719250n 1.8
+    1719299n 1.8
+    1719300n 0
+    1719349n 0
+    1719350n 1.8
+    1719399n 1.8
+    1719400n 0
+    1719449n 0
+    1719450n 1.8
+    1719499n 1.8
+    1719500n 0
+    1719549n 0
+    1719550n 1.8
+    1719599n 1.8
+    1719600n 0
+    1719649n 0
+    1719650n 1.8
+    1719699n 1.8
+    1719700n 0
+    1719749n 0
+    1719750n 1.8
+    1719799n 1.8
+    1719800n 0
+    1719849n 0
+    1719850n 1.8
+    1719899n 1.8
+    1719900n 0
+    1719949n 0
+    1719950n 1.8
+    1719999n 1.8
+    1720000n 0
+    1720049n 0
+    1720050n 1.8
+    1720099n 1.8
+    1720100n 0
+    1720149n 0
+    1720150n 1.8
+    1720199n 1.8
+    1720200n 0
+    1720249n 0
+    1720250n 1.8
+    1720299n 1.8
+    1720300n 0
+    1720349n 0
+    1720350n 1.8
+    1720399n 1.8
+    1720400n 0
+    1720449n 0
+    1720450n 1.8
+    1720499n 1.8
+    1720500n 0
+    1720549n 0
+    1720550n 1.8
+    1720599n 1.8
+    1720600n 0
+    1720649n 0
+    1720650n 1.8
+    1720699n 1.8
+    1720700n 0
+    1720749n 0
+    1720750n 1.8
+    1720799n 1.8
+    1720800n 0
+    1720849n 0
+    1720850n 1.8
+    1720899n 1.8
+    1720900n 0
+    1720949n 0
+    1720950n 1.8
+    1720999n 1.8
+    1721000n 0
+    1721049n 0
+    1721050n 1.8
+    1721099n 1.8
+    1721100n 0
+    1721149n 0
+    1721150n 1.8
+    1721199n 1.8
+    1721200n 0
+    1721249n 0
+    1721250n 1.8
+    1721299n 1.8
+    1721300n 0
+    1721349n 0
+    1721350n 1.8
+    1721399n 1.8
+    1721400n 0
+    1721449n 0
+    1721450n 1.8
+    1721499n 1.8
+    1721500n 0
+    1721549n 0
+    1721550n 1.8
+    1721599n 1.8
+    1721600n 0
+    1721649n 0
+    1721650n 1.8
+    1721699n 1.8
+    1721700n 0
+    1721749n 0
+    1721750n 1.8
+    1721799n 1.8
+    1721800n 0
+    1721849n 0
+    1721850n 1.8
+    1721899n 1.8
+    1721900n 0
+    1721949n 0
+    1721950n 1.8
+    1721999n 1.8
+    1722000n 0
+    1722049n 0
+    1722050n 1.8
+    1722099n 1.8
+    1722100n 0
+    1722149n 0
+    1722150n 1.8
+    1722199n 1.8
+    1722200n 0
+    1722249n 0
+    1722250n 1.8
+    1722299n 1.8
+    1722300n 0
+    1722349n 0
+    1722350n 1.8
+    1722399n 1.8
+    1722400n 0
+    1722449n 0
+    1722450n 1.8
+    1722499n 1.8
+    1722500n 0
+    1722549n 0
+    1722550n 1.8
+    1722599n 1.8
+    1722600n 0
+    1722649n 0
+    1722650n 1.8
+    1722699n 1.8
+    1722700n 0
+    1722749n 0
+    1722750n 1.8
+    1722799n 1.8
+    1722800n 0
+    1722849n 0
+    1722850n 1.8
+    1722899n 1.8
+    1722900n 0
+    1722949n 0
+    1722950n 1.8
+    1722999n 1.8
+    1723000n 0
+    1723049n 0
+    1723050n 1.8
+    1723099n 1.8
+    1723100n 0
+    1723149n 0
+    1723150n 1.8
+    1723199n 1.8
+    1723200n 0
+    1723249n 0
+    1723250n 1.8
+    1723299n 1.8
+    1723300n 0
+    1723349n 0
+    1723350n 1.8
+    1723399n 1.8
+    1723400n 0
+    1723449n 0
+    1723450n 1.8
+    1723499n 1.8
+    1723500n 0
+    1723549n 0
+    1723550n 1.8
+    1723599n 1.8
+    1723600n 0
+    1723649n 0
+    1723650n 1.8
+    1723699n 1.8
+    1723700n 0
+    1723749n 0
+    1723750n 1.8
+    1723799n 1.8
+    1723800n 0
+    1723849n 0
+    1723850n 1.8
+    1723899n 1.8
+    1723900n 0
+    1723949n 0
+    1723950n 1.8
+    1723999n 1.8
+    1724000n 0
+    1724049n 0
+    1724050n 1.8
+    1724099n 1.8
+    1724100n 0
+    1724149n 0
+    1724150n 1.8
+    1724199n 1.8
+    1724200n 0
+    1724249n 0
+    1724250n 1.8
+    1724299n 1.8
+    1724300n 0
+    1724349n 0
+    1724350n 1.8
+    1724399n 1.8
+    1724400n 0
+    1724449n 0
+    1724450n 1.8
+    1724499n 1.8
+    1724500n 0
+    1724549n 0
+    1724550n 1.8
+    1724599n 1.8
+    1724600n 0
+    1724649n 0
+    1724650n 1.8
+    1724699n 1.8
+    1724700n 0
+    1724749n 0
+    1724750n 1.8
+    1724799n 1.8
+    1724800n 0
+    1724849n 0
+    1724850n 1.8
+    1724899n 1.8
+    1724900n 0
+    1724949n 0
+    1724950n 1.8
+    1724999n 1.8
+    1725000n 0
+    1725049n 0
+    1725050n 1.8
+    1725099n 1.8
+    1725100n 0
+    1725149n 0
+    1725150n 1.8
+    1725199n 1.8
+    1725200n 0
+    1725249n 0
+    1725250n 1.8
+    1725299n 1.8
+    1725300n 0
+    1725349n 0
+    1725350n 1.8
+    1725399n 1.8
+    1725400n 0
+    1725449n 0
+    1725450n 1.8
+    1725499n 1.8
+    1725500n 0
+    1725549n 0
+    1725550n 1.8
+    1725599n 1.8
+    1725600n 0
+    1725649n 0
+    1725650n 1.8
+    1725699n 1.8
+    1725700n 0
+    1725749n 0
+    1725750n 1.8
+    1725799n 1.8
+    1725800n 0
+    1725849n 0
+    1725850n 1.8
+    1725899n 1.8
+    1725900n 0
+    1725949n 0
+    1725950n 1.8
+    1725999n 1.8
+    1726000n 0
+    1726049n 0
+    1726050n 1.8
+    1726099n 1.8
+    1726100n 0
+    1726149n 0
+    1726150n 1.8
+    1726199n 1.8
+    1726200n 0
+    1726249n 0
+    1726250n 1.8
+    1726299n 1.8
+    1726300n 0
+    1726349n 0
+    1726350n 1.8
+    1726399n 1.8
+    1726400n 0
+    1726449n 0
+    1726450n 1.8
+    1726499n 1.8
+    1726500n 0
+    1726549n 0
+    1726550n 1.8
+    1726599n 1.8
+    1726600n 0
+    1726649n 0
+    1726650n 1.8
+    1726699n 1.8
+    1726700n 0
+    1726749n 0
+    1726750n 1.8
+    1726799n 1.8
+    1726800n 0
+    1726849n 0
+    1726850n 1.8
+    1726899n 1.8
+    1726900n 0
+    1726949n 0
+    1726950n 1.8
+    1726999n 1.8
+    1727000n 0
+    1727049n 0
+    1727050n 1.8
+    1727099n 1.8
+    1727100n 0
+    1727149n 0
+    1727150n 1.8
+    1727199n 1.8
+    1727200n 0
+    1727249n 0
+    1727250n 1.8
+    1727299n 1.8
+    1727300n 0
+    1727349n 0
+    1727350n 1.8
+    1727399n 1.8
+    1727400n 0
+    1727449n 0
+    1727450n 1.8
+    1727499n 1.8
+    1727500n 0
+    1727549n 0
+    1727550n 1.8
+    1727599n 1.8
+    1727600n 0
+    1727649n 0
+    1727650n 1.8
+    1727699n 1.8
+    1727700n 0
+    1727749n 0
+    1727750n 1.8
+    1727799n 1.8
+    1727800n 0
+    1727849n 0
+    1727850n 1.8
+    1727899n 1.8
+    1727900n 0
+    1727949n 0
+    1727950n 1.8
+    1727999n 1.8
+    1728000n 0
+    1728049n 0
+    1728050n 1.8
+    1728099n 1.8
+    1728100n 0
+    1728149n 0
+    1728150n 1.8
+    1728199n 1.8
+    1728200n 0
+    1728249n 0
+    1728250n 1.8
+    1728299n 1.8
+    1728300n 0
+    1728349n 0
+    1728350n 1.8
+    1728399n 1.8
+    1728400n 0
+    1728449n 0
+    1728450n 1.8
+    1728499n 1.8
+    1728500n 0
+    1728549n 0
+    1728550n 1.8
+    1728599n 1.8
+    1728600n 0
+    1728649n 0
+    1728650n 1.8
+    1728699n 1.8
+    1728700n 0
+    1728749n 0
+    1728750n 1.8
+    1728799n 1.8
+    1728800n 0
+    1728849n 0
+    1728850n 1.8
+    1728899n 1.8
+    1728900n 0
+    1728949n 0
+    1728950n 1.8
+    1728999n 1.8
+    1729000n 0
+    1729049n 0
+    1729050n 1.8
+    1729099n 1.8
+    1729100n 0
+    1729149n 0
+    1729150n 1.8
+    1729199n 1.8
+    1729200n 0
+    1729249n 0
+    1729250n 1.8
+    1729299n 1.8
+    1729300n 0
+    1729349n 0
+    1729350n 1.8
+    1729399n 1.8
+    1729400n 0
+    1729449n 0
+    1729450n 1.8
+    1729499n 1.8
+    1729500n 0
+    1729549n 0
+    1729550n 1.8
+    1729599n 1.8
+    1729600n 0
+    1729649n 0
+    1729650n 1.8
+    1729699n 1.8
+    1729700n 0
+    1729749n 0
+    1729750n 1.8
+    1729799n 1.8
+    1729800n 0
+    1729849n 0
+    1729850n 1.8
+    1729899n 1.8
+    1729900n 0
+    1729949n 0
+    1729950n 1.8
+    1729999n 1.8
+    1730000n 0
+    1730049n 0
+    1730050n 1.8
+    1730099n 1.8
+    1730100n 0
+    1730149n 0
+    1730150n 1.8
+    1730199n 1.8
+    1730200n 0
+    1730249n 0
+    1730250n 1.8
+    1730299n 1.8
+    1730300n 0
+    1730349n 0
+    1730350n 1.8
+    1730399n 1.8
+    1730400n 0
+    1730449n 0
+    1730450n 1.8
+    1730499n 1.8
+    1730500n 0
+    1730549n 0
+    1730550n 1.8
+    1730599n 1.8
+    1730600n 0
+    1730649n 0
+    1730650n 1.8
+    1730699n 1.8
+    1730700n 0
+    1730749n 0
+    1730750n 1.8
+    1730799n 1.8
+    1730800n 0
+    1730849n 0
+    1730850n 1.8
+    1730899n 1.8
+    1730900n 0
+    1730949n 0
+    1730950n 1.8
+    1730999n 1.8
+    1731000n 0
+    1731049n 0
+    1731050n 1.8
+    1731099n 1.8
+    1731100n 0
+    1731149n 0
+    1731150n 1.8
+    1731199n 1.8
+    1731200n 0
+    1731249n 0
+    1731250n 1.8
+    1731299n 1.8
+    1731300n 0
+    1731349n 0
+    1731350n 1.8
+    1731399n 1.8
+    1731400n 0
+    1731449n 0
+    1731450n 1.8
+    1731499n 1.8
+    1731500n 0
+    1731549n 0
+    1731550n 1.8
+    1731599n 1.8
+    1731600n 0
+    1731649n 0
+    1731650n 1.8
+    1731699n 1.8
+    1731700n 0
+    1731749n 0
+    1731750n 1.8
+    1731799n 1.8
+    1731800n 0
+    1731849n 0
+    1731850n 1.8
+    1731899n 1.8
+    1731900n 0
+    1731949n 0
+    1731950n 1.8
+    1731999n 1.8
+    1732000n 0
+    1732049n 0
+    1732050n 1.8
+    1732099n 1.8
+    1732100n 0
+    1732149n 0
+    1732150n 1.8
+    1732199n 1.8
+    1732200n 0
+    1732249n 0
+    1732250n 1.8
+    1732299n 1.8
+    1732300n 0
+    1732349n 0
+    1732350n 1.8
+    1732399n 1.8
+    1732400n 0
+    1732449n 0
+    1732450n 1.8
+    1732499n 1.8
+    1732500n 0
+    1732549n 0
+    1732550n 1.8
+    1732599n 1.8
+    1732600n 0
+    1732649n 0
+    1732650n 1.8
+    1732699n 1.8
+    1732700n 0
+    1732749n 0
+    1732750n 1.8
+    1732799n 1.8
+    1732800n 0
+    1732849n 0
+    1732850n 1.8
+    1732899n 1.8
+    1732900n 0
+    1732949n 0
+    1732950n 1.8
+    1732999n 1.8
+    1733000n 0
+    1733049n 0
+    1733050n 1.8
+    1733099n 1.8
+    1733100n 0
+    1733149n 0
+    1733150n 1.8
+    1733199n 1.8
+    1733200n 0
+    1733249n 0
+    1733250n 1.8
+    1733299n 1.8
+    1733300n 0
+    1733349n 0
+    1733350n 1.8
+    1733399n 1.8
+    1733400n 0
+    1733449n 0
+    1733450n 1.8
+    1733499n 1.8
+    1733500n 0
+    1733549n 0
+    1733550n 1.8
+    1733599n 1.8
+    1733600n 0
+    1733649n 0
+    1733650n 1.8
+    1733699n 1.8
+    1733700n 0
+    1733749n 0
+    1733750n 1.8
+    1733799n 1.8
+    1733800n 0
+    1733849n 0
+    1733850n 1.8
+    1733899n 1.8
+    1733900n 0
+    1733949n 0
+    1733950n 1.8
+    1733999n 1.8
+    1734000n 0
+    1734049n 0
+    1734050n 1.8
+    1734099n 1.8
+    1734100n 0
+    1734149n 0
+    1734150n 1.8
+    1734199n 1.8
+    1734200n 0
+    1734249n 0
+    1734250n 1.8
+    1734299n 1.8
+    1734300n 0
+    1734349n 0
+    1734350n 1.8
+    1734399n 1.8
+    1734400n 0
+    1734449n 0
+    1734450n 1.8
+    1734499n 1.8
+    1734500n 0
+    1734549n 0
+    1734550n 1.8
+    1734599n 1.8
+    1734600n 0
+    1734649n 0
+    1734650n 1.8
+    1734699n 1.8
+    1734700n 0
+    1734749n 0
+    1734750n 1.8
+    1734799n 1.8
+    1734800n 0
+    1734849n 0
+    1734850n 1.8
+    1734899n 1.8
+    1734900n 0
+    1734949n 0
+    1734950n 1.8
+    1734999n 1.8
+    1735000n 0
+    1735049n 0
+    1735050n 1.8
+    1735099n 1.8
+    1735100n 0
+    1735149n 0
+    1735150n 1.8
+    1735199n 1.8
+    1735200n 0
+    1735249n 0
+    1735250n 1.8
+    1735299n 1.8
+    1735300n 0
+    1735349n 0
+    1735350n 1.8
+    1735399n 1.8
+    1735400n 0
+    1735449n 0
+    1735450n 1.8
+    1735499n 1.8
+    1735500n 0
+    1735549n 0
+    1735550n 1.8
+    1735599n 1.8
+    1735600n 0
+    1735649n 0
+    1735650n 1.8
+    1735699n 1.8
+    1735700n 0
+    1735749n 0
+    1735750n 1.8
+    1735799n 1.8
+    1735800n 0
+    1735849n 0
+    1735850n 1.8
+    1735899n 1.8
+    1735900n 0
+    1735949n 0
+    1735950n 1.8
+    1735999n 1.8
+    1736000n 0
+    1736049n 0
+    1736050n 1.8
+    1736099n 1.8
+    1736100n 0
+    1736149n 0
+    1736150n 1.8
+    1736199n 1.8
+    1736200n 0
+    1736249n 0
+    1736250n 1.8
+    1736299n 1.8
+    1736300n 0
+    1736349n 0
+    1736350n 1.8
+    1736399n 1.8
+    1736400n 0
+    1736449n 0
+    1736450n 1.8
+    1736499n 1.8
+    1736500n 0
+    1736549n 0
+    1736550n 1.8
+    1736599n 1.8
+    1736600n 0
+    1736649n 0
+    1736650n 1.8
+    1736699n 1.8
+    1736700n 0
+    1736749n 0
+    1736750n 1.8
+    1736799n 1.8
+    1736800n 0
+    1736849n 0
+    1736850n 1.8
+    1736899n 1.8
+    1736900n 0
+    1736949n 0
+    1736950n 1.8
+    1736999n 1.8
+    1737000n 0
+    1737049n 0
+    1737050n 1.8
+    1737099n 1.8
+    1737100n 0
+    1737149n 0
+    1737150n 1.8
+    1737199n 1.8
+    1737200n 0
+    1737249n 0
+    1737250n 1.8
+    1737299n 1.8
+    1737300n 0
+    1737349n 0
+    1737350n 1.8
+    1737399n 1.8
+    1737400n 0
+    1737449n 0
+    1737450n 1.8
+    1737499n 1.8
+    1737500n 0
+    1737549n 0
+    1737550n 1.8
+    1737599n 1.8
+    1737600n 0
+    1737649n 0
+    1737650n 1.8
+    1737699n 1.8
+    1737700n 0
+    1737749n 0
+    1737750n 1.8
+    1737799n 1.8
+    1737800n 0
+    1737849n 0
+    1737850n 1.8
+    1737899n 1.8
+    1737900n 0
+    1737949n 0
+    1737950n 1.8
+    1737999n 1.8
+    1738000n 0
+    1738049n 0
+    1738050n 1.8
+    1738099n 1.8
+    1738100n 0
+    1738149n 0
+    1738150n 1.8
+    1738199n 1.8
+    1738200n 0
+    1738249n 0
+    1738250n 1.8
+    1738299n 1.8
+    1738300n 0
+    1738349n 0
+    1738350n 1.8
+    1738399n 1.8
+    1738400n 0
+    1738449n 0
+    1738450n 1.8
+    1738499n 1.8
+    1738500n 0
+    1738549n 0
+    1738550n 1.8
+    1738599n 1.8
+    1738600n 0
+    1738649n 0
+    1738650n 1.8
+    1738699n 1.8
+    1738700n 0
+    1738749n 0
+    1738750n 1.8
+    1738799n 1.8
+    1738800n 0
+    1738849n 0
+    1738850n 1.8
+    1738899n 1.8
+    1738900n 0
+    1738949n 0
+    1738950n 1.8
+    1738999n 1.8
+    1739000n 0
+    1739049n 0
+    1739050n 1.8
+    1739099n 1.8
+    1739100n 0
+    1739149n 0
+    1739150n 1.8
+    1739199n 1.8
+    1739200n 0
+    1739249n 0
+    1739250n 1.8
+    1739299n 1.8
+    1739300n 0
+    1739349n 0
+    1739350n 1.8
+    1739399n 1.8
+    1739400n 0
+    1739449n 0
+    1739450n 1.8
+    1739499n 1.8
+    1739500n 0
+    1739549n 0
+    1739550n 1.8
+    1739599n 1.8
+    1739600n 0
+    1739649n 0
+    1739650n 1.8
+    1739699n 1.8
+    1739700n 0
+    1739749n 0
+    1739750n 1.8
+    1739799n 1.8
+    1739800n 0
+    1739849n 0
+    1739850n 1.8
+    1739899n 1.8
+    1739900n 0
+    1739949n 0
+    1739950n 1.8
+    1739999n 1.8
+    1740000n 0
+    1740049n 0
+    1740050n 1.8
+    1740099n 1.8
+    1740100n 0
+    1740149n 0
+    1740150n 1.8
+    1740199n 1.8
+    1740200n 0
+    1740249n 0
+    1740250n 1.8
+    1740299n 1.8
+    1740300n 0
+    1740349n 0
+    1740350n 1.8
+    1740399n 1.8
+    1740400n 0
+    1740449n 0
+    1740450n 1.8
+    1740499n 1.8
+    1740500n 0
+    1740549n 0
+    1740550n 1.8
+    1740599n 1.8
+    1740600n 0
+    1740649n 0
+    1740650n 1.8
+    1740699n 1.8
+    1740700n 0
+    1740749n 0
+    1740750n 1.8
+    1740799n 1.8
+    1740800n 0
+    1740849n 0
+    1740850n 1.8
+    1740899n 1.8
+    1740900n 0
+    1740949n 0
+    1740950n 1.8
+    1740999n 1.8
+    1741000n 0
+    1741049n 0
+    1741050n 1.8
+    1741099n 1.8
+    1741100n 0
+    1741149n 0
+    1741150n 1.8
+    1741199n 1.8
+    1741200n 0
+    1741249n 0
+    1741250n 1.8
+    1741299n 1.8
+    1741300n 0
+    1741349n 0
+    1741350n 1.8
+    1741399n 1.8
+    1741400n 0
+    1741449n 0
+    1741450n 1.8
+    1741499n 1.8
+    1741500n 0
+    1741549n 0
+    1741550n 1.8
+    1741599n 1.8
+    1741600n 0
+    1741649n 0
+    1741650n 1.8
+    1741699n 1.8
+    1741700n 0
+    1741749n 0
+    1741750n 1.8
+    1741799n 1.8
+    1741800n 0
+    1741849n 0
+    1741850n 1.8
+    1741899n 1.8
+    1741900n 0
+    1741949n 0
+    1741950n 1.8
+    1741999n 1.8
+    1742000n 0
+    1742049n 0
+    1742050n 1.8
+    1742099n 1.8
+    1742100n 0
+    1742149n 0
+    1742150n 1.8
+    1742199n 1.8
+    1742200n 0
+    1742249n 0
+    1742250n 1.8
+    1742299n 1.8
+    1742300n 0
+    1742349n 0
+    1742350n 1.8
+    1742399n 1.8
+    1742400n 0
+    1742449n 0
+    1742450n 1.8
+    1742499n 1.8
+    1742500n 0
+    1742549n 0
+    1742550n 1.8
+    1742599n 1.8
+    1742600n 0
+    1742649n 0
+    1742650n 1.8
+    1742699n 1.8
+    1742700n 0
+    1742749n 0
+    1742750n 1.8
+    1742799n 1.8
+    1742800n 0
+    1742849n 0
+    1742850n 1.8
+    1742899n 1.8
+    1742900n 0
+    1742949n 0
+    1742950n 1.8
+    1742999n 1.8
+    1743000n 0
+    1743049n 0
+    1743050n 1.8
+    1743099n 1.8
+    1743100n 0
+    1743149n 0
+    1743150n 1.8
+    1743199n 1.8
+    1743200n 0
+    1743249n 0
+    1743250n 1.8
+    1743299n 1.8
+    1743300n 0
+    1743349n 0
+    1743350n 1.8
+    1743399n 1.8
+    1743400n 0
+    1743449n 0
+    1743450n 1.8
+    1743499n 1.8
+    1743500n 0
+    1743549n 0
+    1743550n 1.8
+    1743599n 1.8
+    1743600n 0
+    1743649n 0
+    1743650n 1.8
+    1743699n 1.8
+    1743700n 0
+    1743749n 0
+    1743750n 1.8
+    1743799n 1.8
+    1743800n 0
+    1743849n 0
+    1743850n 1.8
+    1743899n 1.8
+    1743900n 0
+    1743949n 0
+    1743950n 1.8
+    1743999n 1.8
+    1744000n 0
+    1744049n 0
+    1744050n 1.8
+    1744099n 1.8
+    1744100n 0
+    1744149n 0
+    1744150n 1.8
+    1744199n 1.8
+    1744200n 0
+    1744249n 0
+    1744250n 1.8
+    1744299n 1.8
+    1744300n 0
+    1744349n 0
+    1744350n 1.8
+    1744399n 1.8
+    1744400n 0
+    1744449n 0
+    1744450n 1.8
+    1744499n 1.8
+    1744500n 0
+    1744549n 0
+    1744550n 1.8
+    1744599n 1.8
+    1744600n 0
+    1744649n 0
+    1744650n 1.8
+    1744699n 1.8
+    1744700n 0
+    1744749n 0
+    1744750n 1.8
+    1744799n 1.8
+    1744800n 0
+    1744849n 0
+    1744850n 1.8
+    1744899n 1.8
+    1744900n 0
+    1744949n 0
+    1744950n 1.8
+    1744999n 1.8
+    1745000n 0
+    1745049n 0
+    1745050n 1.8
+    1745099n 1.8
+    1745100n 0
+    1745149n 0
+    1745150n 1.8
+    1745199n 1.8
+    1745200n 0
+    1745249n 0
+    1745250n 1.8
+    1745299n 1.8
+    1745300n 0
+    1745349n 0
+    1745350n 1.8
+    1745399n 1.8
+    1745400n 0
+    1745449n 0
+    1745450n 1.8
+    1745499n 1.8
+    1745500n 0
+    1745549n 0
+    1745550n 1.8
+    1745599n 1.8
+    1745600n 0
+    1745649n 0
+    1745650n 1.8
+    1745699n 1.8
+    1745700n 0
+    1745749n 0
+    1745750n 1.8
+    1745799n 1.8
+    1745800n 0
+    1745849n 0
+    1745850n 1.8
+    1745899n 1.8
+    1745900n 0
+    1745949n 0
+    1745950n 1.8
+    1745999n 1.8
+    1746000n 0
+    1746049n 0
+    1746050n 1.8
+    1746099n 1.8
+    1746100n 0
+    1746149n 0
+    1746150n 1.8
+    1746199n 1.8
+    1746200n 0
+    1746249n 0
+    1746250n 1.8
+    1746299n 1.8
+    1746300n 0
+    1746349n 0
+    1746350n 1.8
+    1746399n 1.8
+    1746400n 0
+    1746449n 0
+    1746450n 1.8
+    1746499n 1.8
+    1746500n 0
+    1746549n 0
+    1746550n 1.8
+    1746599n 1.8
+    1746600n 0
+    1746649n 0
+    1746650n 1.8
+    1746699n 1.8
+    1746700n 0
+    1746749n 0
+    1746750n 1.8
+    1746799n 1.8
+    1746800n 0
+    1746849n 0
+    1746850n 1.8
+    1746899n 1.8
+    1746900n 0
+    1746949n 0
+    1746950n 1.8
+    1746999n 1.8
+    1747000n 0
+    1747049n 0
+    1747050n 1.8
+    1747099n 1.8
+    1747100n 0
+    1747149n 0
+    1747150n 1.8
+    1747199n 1.8
+    1747200n 0
+    1747249n 0
+    1747250n 1.8
+    1747299n 1.8
+    1747300n 0
+    1747349n 0
+    1747350n 1.8
+    1747399n 1.8
+    1747400n 0
+    1747449n 0
+    1747450n 1.8
+    1747499n 1.8
+    1747500n 0
+    1747549n 0
+    1747550n 1.8
+    1747599n 1.8
+    1747600n 0
+    1747649n 0
+    1747650n 1.8
+    1747699n 1.8
+    1747700n 0
+    1747749n 0
+    1747750n 1.8
+    1747799n 1.8
+    1747800n 0
+    1747849n 0
+    1747850n 1.8
+    1747899n 1.8
+    1747900n 0
+    1747949n 0
+    1747950n 1.8
+    1747999n 1.8
+    1748000n 0
+    1748049n 0
+    1748050n 1.8
+    1748099n 1.8
+    1748100n 0
+    1748149n 0
+    1748150n 1.8
+    1748199n 1.8
+    1748200n 0
+    1748249n 0
+    1748250n 1.8
+    1748299n 1.8
+    1748300n 0
+    1748349n 0
+    1748350n 1.8
+    1748399n 1.8
+    1748400n 0
+    1748449n 0
+    1748450n 1.8
+    1748499n 1.8
+    1748500n 0
+    1748549n 0
+    1748550n 1.8
+    1748599n 1.8
+    1748600n 0
+    1748649n 0
+    1748650n 1.8
+    1748699n 1.8
+    1748700n 0
+    1748749n 0
+    1748750n 1.8
+    1748799n 1.8
+    1748800n 0
+    1748849n 0
+    1748850n 1.8
+    1748899n 1.8
+    1748900n 0
+    1748949n 0
+    1748950n 1.8
+    1748999n 1.8
+    1749000n 0
+    1749049n 0
+    1749050n 1.8
+    1749099n 1.8
+    1749100n 0
+    1749149n 0
+    1749150n 1.8
+    1749199n 1.8
+    1749200n 0
+    1749249n 0
+    1749250n 1.8
+    1749299n 1.8
+    1749300n 0
+    1749349n 0
+    1749350n 1.8
+    1749399n 1.8
+    1749400n 0
+    1749449n 0
+    1749450n 1.8
+    1749499n 1.8
+    1749500n 0
+    1749549n 0
+    1749550n 1.8
+    1749599n 1.8
+    1749600n 0
+    1749649n 0
+    1749650n 1.8
+    1749699n 1.8
+    1749700n 0
+    1749749n 0
+    1749750n 1.8
+    1749799n 1.8
+    1749800n 0
+    1749849n 0
+    1749850n 1.8
+    1749899n 1.8
+    1749900n 0
+    1749949n 0
+    1749950n 1.8
+    1749999n 1.8
+    1750000n 0
+    1750049n 0
+    1750050n 1.8
+    1750099n 1.8
+    1750100n 0
+    1750149n 0
+    1750150n 1.8
+    1750199n 1.8
+    1750200n 0
+    1750249n 0
+    1750250n 1.8
+    1750299n 1.8
+    1750300n 0
+    1750349n 0
+    1750350n 1.8
+    1750399n 1.8
+    1750400n 0
+    1750449n 0
+    1750450n 1.8
+    1750499n 1.8
+    1750500n 0
+    1750549n 0
+    1750550n 1.8
+    1750599n 1.8
+    1750600n 0
+    1750649n 0
+    1750650n 1.8
+    1750699n 1.8
+    1750700n 0
+    1750749n 0
+    1750750n 1.8
+    1750799n 1.8
+    1750800n 0
+    1750849n 0
+    1750850n 1.8
+    1750899n 1.8
+    1750900n 0
+    1750949n 0
+    1750950n 1.8
+    1750999n 1.8
+    1751000n 0
+    1751049n 0
+    1751050n 1.8
+    1751099n 1.8
+    1751100n 0
+    1751149n 0
+    1751150n 1.8
+    1751199n 1.8
+    1751200n 0
+    1751249n 0
+    1751250n 1.8
+    1751299n 1.8
+    1751300n 0
+    1751349n 0
+    1751350n 1.8
+    1751399n 1.8
+    1751400n 0
+    1751449n 0
+    1751450n 1.8
+    1751499n 1.8
+    1751500n 0
+    1751549n 0
+    1751550n 1.8
+    1751599n 1.8
+    1751600n 0
+    1751649n 0
+    1751650n 1.8
+    1751699n 1.8
+    1751700n 0
+    1751749n 0
+    1751750n 1.8
+    1751799n 1.8
+    1751800n 0
+    1751849n 0
+    1751850n 1.8
+    1751899n 1.8
+    1751900n 0
+    1751949n 0
+    1751950n 1.8
+    1751999n 1.8
+    1752000n 0
+    1752049n 0
+    1752050n 1.8
+    1752099n 1.8
+    1752100n 0
+    1752149n 0
+    1752150n 1.8
+    1752199n 1.8
+    1752200n 0
+    1752249n 0
+    1752250n 1.8
+    1752299n 1.8
+    1752300n 0
+    1752349n 0
+    1752350n 1.8
+    1752399n 1.8
+    1752400n 0
+    1752449n 0
+    1752450n 1.8
+    1752499n 1.8
+    1752500n 0
+    1752549n 0
+    1752550n 1.8
+    1752599n 1.8
+    1752600n 0
+    1752649n 0
+    1752650n 1.8
+    1752699n 1.8
+    1752700n 0
+    1752749n 0
+    1752750n 1.8
+    1752799n 1.8
+    1752800n 0
+    1752849n 0
+    1752850n 1.8
+    1752899n 1.8
+    1752900n 0
+    1752949n 0
+    1752950n 1.8
+    1752999n 1.8
+    1753000n 0
+    1753049n 0
+    1753050n 1.8
+    1753099n 1.8
+    1753100n 0
+    1753149n 0
+    1753150n 1.8
+    1753199n 1.8
+    1753200n 0
+    1753249n 0
+    1753250n 1.8
+    1753299n 1.8
+    1753300n 0
+    1753349n 0
+    1753350n 1.8
+    1753399n 1.8
+    1753400n 0
+    1753449n 0
+    1753450n 1.8
+    1753499n 1.8
+    1753500n 0
+    1753549n 0
+    1753550n 1.8
+    1753599n 1.8
+    1753600n 0
+    1753649n 0
+    1753650n 1.8
+    1753699n 1.8
+    1753700n 0
+    1753749n 0
+    1753750n 1.8
+    1753799n 1.8
+    1753800n 0
+    1753849n 0
+    1753850n 1.8
+    1753899n 1.8
+    1753900n 0
+    1753949n 0
+    1753950n 1.8
+    1753999n 1.8
+    1754000n 0
+    1754049n 0
+    1754050n 1.8
+    1754099n 1.8
+    1754100n 0
+    1754149n 0
+    1754150n 1.8
+    1754199n 1.8
+    1754200n 0
+    1754249n 0
+    1754250n 1.8
+    1754299n 1.8
+    1754300n 0
+    1754349n 0
+    1754350n 1.8
+    1754399n 1.8
+    1754400n 0
+    1754449n 0
+    1754450n 1.8
+    1754499n 1.8
+    1754500n 0
+    1754549n 0
+    1754550n 1.8
+    1754599n 1.8
+    1754600n 0
+    1754649n 0
+    1754650n 1.8
+    1754699n 1.8
+    1754700n 0
+    1754749n 0
+    1754750n 1.8
+    1754799n 1.8
+    1754800n 0
+    1754849n 0
+    1754850n 1.8
+    1754899n 1.8
+    1754900n 0
+    1754949n 0
+    1754950n 1.8
+    1754999n 1.8
+    1755000n 0
+    1755049n 0
+    1755050n 1.8
+    1755099n 1.8
+    1755100n 0
+    1755149n 0
+    1755150n 1.8
+    1755199n 1.8
+    1755200n 0
+    1755249n 0
+    1755250n 1.8
+    1755299n 1.8
+    1755300n 0
+    1755349n 0
+    1755350n 1.8
+    1755399n 1.8
+    1755400n 0
+    1755449n 0
+    1755450n 1.8
+    1755499n 1.8
+    1755500n 0
+    1755549n 0
+    1755550n 1.8
+    1755599n 1.8
+    1755600n 0
+    1755649n 0
+    1755650n 1.8
+    1755699n 1.8
+    1755700n 0
+    1755749n 0
+    1755750n 1.8
+    1755799n 1.8
+    1755800n 0
+    1755849n 0
+    1755850n 1.8
+    1755899n 1.8
+    1755900n 0
+    1755949n 0
+    1755950n 1.8
+    1755999n 1.8
+    1756000n 0
+    1756049n 0
+    1756050n 1.8
+    1756099n 1.8
+    1756100n 0
+    1756149n 0
+    1756150n 1.8
+    1756199n 1.8
+    1756200n 0
+    1756249n 0
+    1756250n 1.8
+    1756299n 1.8
+    1756300n 0
+    1756349n 0
+    1756350n 1.8
+    1756399n 1.8
+    1756400n 0
+    1756449n 0
+    1756450n 1.8
+    1756499n 1.8
+    1756500n 0
+    1756549n 0
+    1756550n 1.8
+    1756599n 1.8
+    1756600n 0
+    1756649n 0
+    1756650n 1.8
+    1756699n 1.8
+    1756700n 0
+    1756749n 0
+    1756750n 1.8
+    1756799n 1.8
+    1756800n 0
+    1756849n 0
+    1756850n 1.8
+    1756899n 1.8
+    1756900n 0
+    1756949n 0
+    1756950n 1.8
+    1756999n 1.8
+    1757000n 0
+    1757049n 0
+    1757050n 1.8
+    1757099n 1.8
+    1757100n 0
+    1757149n 0
+    1757150n 1.8
+    1757199n 1.8
+    1757200n 0
+    1757249n 0
+    1757250n 1.8
+    1757299n 1.8
+    1757300n 0
+    1757349n 0
+    1757350n 1.8
+    1757399n 1.8
+    1757400n 0
+    1757449n 0
+    1757450n 1.8
+    1757499n 1.8
+    1757500n 0
+    1757549n 0
+    1757550n 1.8
+    1757599n 1.8
+    1757600n 0
+    1757649n 0
+    1757650n 1.8
+    1757699n 1.8
+    1757700n 0
+    1757749n 0
+    1757750n 1.8
+    1757799n 1.8
+    1757800n 0
+    1757849n 0
+    1757850n 1.8
+    1757899n 1.8
+    1757900n 0
+    1757949n 0
+    1757950n 1.8
+    1757999n 1.8
+    1758000n 0
+    1758049n 0
+    1758050n 1.8
+    1758099n 1.8
+    1758100n 0
+    1758149n 0
+    1758150n 1.8
+    1758199n 1.8
+    1758200n 0
+    1758249n 0
+    1758250n 1.8
+    1758299n 1.8
+    1758300n 0
+    1758349n 0
+    1758350n 1.8
+    1758399n 1.8
+    1758400n 0
+    1758449n 0
+    1758450n 1.8
+    1758499n 1.8
+    1758500n 0
+    1758549n 0
+    1758550n 1.8
+    1758599n 1.8
+    1758600n 0
+    1758649n 0
+    1758650n 1.8
+    1758699n 1.8
+    1758700n 0
+    1758749n 0
+    1758750n 1.8
+    1758799n 1.8
+    1758800n 0
+    1758849n 0
+    1758850n 1.8
+    1758899n 1.8
+    1758900n 0
+    1758949n 0
+    1758950n 1.8
+    1758999n 1.8
+    1759000n 0
+    1759049n 0
+    1759050n 1.8
+    1759099n 1.8
+    1759100n 0
+    1759149n 0
+    1759150n 1.8
+    1759199n 1.8
+    1759200n 0
+    1759249n 0
+    1759250n 1.8
+    1759299n 1.8
+    1759300n 0
+    1759349n 0
+    1759350n 1.8
+    1759399n 1.8
+    1759400n 0
+    1759449n 0
+    1759450n 1.8
+    1759499n 1.8
+    1759500n 0
+    1759549n 0
+    1759550n 1.8
+    1759599n 1.8
+    1759600n 0
+    1759649n 0
+    1759650n 1.8
+    1759699n 1.8
+    1759700n 0
+    1759749n 0
+    1759750n 1.8
+    1759799n 1.8
+    1759800n 0
+    1759849n 0
+    1759850n 1.8
+    1759899n 1.8
+    1759900n 0
+    1759949n 0
+    1759950n 1.8
+    1759999n 1.8
+    1760000n 0
+    1760049n 0
+    1760050n 1.8
+    1760099n 1.8
+    1760100n 0
+    1760149n 0
+    1760150n 1.8
+    1760199n 1.8
+    1760200n 0
+    1760249n 0
+    1760250n 1.8
+    1760299n 1.8
+    1760300n 0
+    1760349n 0
+    1760350n 1.8
+    1760399n 1.8
+    1760400n 0
+    1760449n 0
+    1760450n 1.8
+    1760499n 1.8
+    1760500n 0
+    1760549n 0
+    1760550n 1.8
+    1760599n 1.8
+    1760600n 0
+    1760649n 0
+    1760650n 1.8
+    1760699n 1.8
+    1760700n 0
+    1760749n 0
+    1760750n 1.8
+    1760799n 1.8
+    1760800n 0
+    1760849n 0
+    1760850n 1.8
+    1760899n 1.8
+    1760900n 0
+    1760949n 0
+    1760950n 1.8
+    1760999n 1.8
+    1761000n 0
+    1761049n 0
+    1761050n 1.8
+    1761099n 1.8
+    1761100n 0
+    1761149n 0
+    1761150n 1.8
+    1761199n 1.8
+    1761200n 0
+    1761249n 0
+    1761250n 1.8
+    1761299n 1.8
+    1761300n 0
+    1761349n 0
+    1761350n 1.8
+    1761399n 1.8
+    1761400n 0
+    1761449n 0
+    1761450n 1.8
+    1761499n 1.8
+    1761500n 0
+    1761549n 0
+    1761550n 1.8
+    1761599n 1.8
+    1761600n 0
+    1761649n 0
+    1761650n 1.8
+    1761699n 1.8
+    1761700n 0
+    1761749n 0
+    1761750n 1.8
+    1761799n 1.8
+    1761800n 0
+    1761849n 0
+    1761850n 1.8
+    1761899n 1.8
+    1761900n 0
+    1761949n 0
+    1761950n 1.8
+    1761999n 1.8
+    1762000n 0
+    1762049n 0
+    1762050n 1.8
+    1762099n 1.8
+    1762100n 0
+    1762149n 0
+    1762150n 1.8
+    1762199n 1.8
+    1762200n 0
+    1762249n 0
+    1762250n 1.8
+    1762299n 1.8
+    1762300n 0
+    1762349n 0
+    1762350n 1.8
+    1762399n 1.8
+    1762400n 0
+    1762449n 0
+    1762450n 1.8
+    1762499n 1.8
+    1762500n 0
+    1762549n 0
+    1762550n 1.8
+    1762599n 1.8
+    1762600n 0
+    1762649n 0
+    1762650n 1.8
+    1762699n 1.8
+    1762700n 0
+    1762749n 0
+    1762750n 1.8
+    1762799n 1.8
+    1762800n 0
+    1762849n 0
+    1762850n 1.8
+    1762899n 1.8
+    1762900n 0
+    1762949n 0
+    1762950n 1.8
+    1762999n 1.8
+    1763000n 0
+    1763049n 0
+    1763050n 1.8
+    1763099n 1.8
+    1763100n 0
+    1763149n 0
+    1763150n 1.8
+    1763199n 1.8
+    1763200n 0
+    1763249n 0
+    1763250n 1.8
+    1763299n 1.8
+    1763300n 0
+    1763349n 0
+    1763350n 1.8
+    1763399n 1.8
+    1763400n 0
+    1763449n 0
+    1763450n 1.8
+    1763499n 1.8
+    1763500n 0
+    1763549n 0
+    1763550n 1.8
+    1763599n 1.8
+    1763600n 0
+    1763649n 0
+    1763650n 1.8
+    1763699n 1.8
+    1763700n 0
+    1763749n 0
+    1763750n 1.8
+    1763799n 1.8
+    1763800n 0
+    1763849n 0
+    1763850n 1.8
+    1763899n 1.8
+    1763900n 0
+    1763949n 0
+    1763950n 1.8
+    1763999n 1.8
+    1764000n 0
+    1764049n 0
+    1764050n 1.8
+    1764099n 1.8
+    1764100n 0
+    1764149n 0
+    1764150n 1.8
+    1764199n 1.8
+    1764200n 0
+    1764249n 0
+    1764250n 1.8
+    1764299n 1.8
+    1764300n 0
+    1764349n 0
+    1764350n 1.8
+    1764399n 1.8
+    1764400n 0
+    1764449n 0
+    1764450n 1.8
+    1764499n 1.8
+    1764500n 0
+    1764549n 0
+    1764550n 1.8
+    1764599n 1.8
+    1764600n 0
+    1764649n 0
+    1764650n 1.8
+    1764699n 1.8
+    1764700n 0
+    1764749n 0
+    1764750n 1.8
+    1764799n 1.8
+    1764800n 0
+    1764849n 0
+    1764850n 1.8
+    1764899n 1.8
+    1764900n 0
+    1764949n 0
+    1764950n 1.8
+    1764999n 1.8
+    1765000n 0
+    1765049n 0
+    1765050n 1.8
+    1765099n 1.8
+    1765100n 0
+    1765149n 0
+    1765150n 1.8
+    1765199n 1.8
+    1765200n 0
+    1765249n 0
+    1765250n 1.8
+    1765299n 1.8
+    1765300n 0
+    1765349n 0
+    1765350n 1.8
+    1765399n 1.8
+    1765400n 0
+    1765449n 0
+    1765450n 1.8
+    1765499n 1.8
+    1765500n 0
+    1765549n 0
+    1765550n 1.8
+    1765599n 1.8
+    1765600n 0
+    1765649n 0
+    1765650n 1.8
+    1765699n 1.8
+    1765700n 0
+    1765749n 0
+    1765750n 1.8
+    1765799n 1.8
+    1765800n 0
+    1765849n 0
+    1765850n 1.8
+    1765899n 1.8
+    1765900n 0
+    1765949n 0
+    1765950n 1.8
+    1765999n 1.8
+    1766000n 0
+    1766049n 0
+    1766050n 1.8
+    1766099n 1.8
+    1766100n 0
+    1766149n 0
+    1766150n 1.8
+    1766199n 1.8
+    1766200n 0
+    1766249n 0
+    1766250n 1.8
+    1766299n 1.8
+    1766300n 0
+    1766349n 0
+    1766350n 1.8
+    1766399n 1.8
+    1766400n 0
+    1766449n 0
+    1766450n 1.8
+    1766499n 1.8
+    1766500n 0
+    1766549n 0
+    1766550n 1.8
+    1766599n 1.8
+    1766600n 0
+    1766649n 0
+    1766650n 1.8
+    1766699n 1.8
+    1766700n 0
+    1766749n 0
+    1766750n 1.8
+    1766799n 1.8
+    1766800n 0
+    1766849n 0
+    1766850n 1.8
+    1766899n 1.8
+    1766900n 0
+    1766949n 0
+    1766950n 1.8
+    1766999n 1.8
+    1767000n 0
+    1767049n 0
+    1767050n 1.8
+    1767099n 1.8
+    1767100n 0
+    1767149n 0
+    1767150n 1.8
+    1767199n 1.8
+    1767200n 0
+    1767249n 0
+    1767250n 1.8
+    1767299n 1.8
+    1767300n 0
+    1767349n 0
+    1767350n 1.8
+    1767399n 1.8
+    1767400n 0
+    1767449n 0
+    1767450n 1.8
+    1767499n 1.8
+    1767500n 0
+    1767549n 0
+    1767550n 1.8
+    1767599n 1.8
+    1767600n 0
+    1767649n 0
+    1767650n 1.8
+    1767699n 1.8
+    1767700n 0
+    1767749n 0
+    1767750n 1.8
+    1767799n 1.8
+    1767800n 0
+    1767849n 0
+    1767850n 1.8
+    1767899n 1.8
+    1767900n 0
+    1767949n 0
+    1767950n 1.8
+    1767999n 1.8
+    1768000n 0
+    1768049n 0
+    1768050n 1.8
+    1768099n 1.8
+    1768100n 0
+    1768149n 0
+    1768150n 1.8
+    1768199n 1.8
+    1768200n 0
+    1768249n 0
+    1768250n 1.8
+    1768299n 1.8
+    1768300n 0
+    1768349n 0
+    1768350n 1.8
+    1768399n 1.8
+    1768400n 0
+    1768449n 0
+    1768450n 1.8
+    1768499n 1.8
+    1768500n 0
+    1768549n 0
+    1768550n 1.8
+    1768599n 1.8
+    1768600n 0
+    1768649n 0
+    1768650n 1.8
+    1768699n 1.8
+    1768700n 0
+    1768749n 0
+    1768750n 1.8
+    1768799n 1.8
+    1768800n 0
+    1768849n 0
+    1768850n 1.8
+    1768899n 1.8
+    1768900n 0
+    1768949n 0
+    1768950n 1.8
+    1768999n 1.8
+    1769000n 0
+    1769049n 0
+    1769050n 1.8
+    1769099n 1.8
+    1769100n 0
+    1769149n 0
+    1769150n 1.8
+    1769199n 1.8
+    1769200n 0
+    1769249n 0
+    1769250n 1.8
+    1769299n 1.8
+    1769300n 0
+    1769349n 0
+    1769350n 1.8
+    1769399n 1.8
+    1769400n 0
+    1769449n 0
+    1769450n 1.8
+    1769499n 1.8
+    1769500n 0
+    1769549n 0
+    1769550n 1.8
+    1769599n 1.8
+    1769600n 0
+    1769649n 0
+    1769650n 1.8
+    1769699n 1.8
+    1769700n 0
+    1769749n 0
+    1769750n 1.8
+    1769799n 1.8
+    1769800n 0
+    1769849n 0
+    1769850n 1.8
+    1769899n 1.8
+    1769900n 0
+    1769949n 0
+    1769950n 1.8
+    1769999n 1.8
+    1770000n 0
+    1770049n 0
+    1770050n 1.8
+    1770099n 1.8
+    1770100n 0
+    1770149n 0
+    1770150n 1.8
+    1770199n 1.8
+    1770200n 0
+    1770249n 0
+    1770250n 1.8
+    1770299n 1.8
+    1770300n 0
+    1770349n 0
+    1770350n 1.8
+    1770399n 1.8
+    1770400n 0
+    1770449n 0
+    1770450n 1.8
+    1770499n 1.8
+    1770500n 0
+    1770549n 0
+    1770550n 1.8
+    1770599n 1.8
+    1770600n 0
+    1770649n 0
+    1770650n 1.8
+    1770699n 1.8
+    1770700n 0
+    1770749n 0
+    1770750n 1.8
+    1770799n 1.8
+    1770800n 0
+    1770849n 0
+    1770850n 1.8
+    1770899n 1.8
+    1770900n 0
+    1770949n 0
+    1770950n 1.8
+    1770999n 1.8
+    1771000n 0
+    1771049n 0
+    1771050n 1.8
+    1771099n 1.8
+    1771100n 0
+    1771149n 0
+    1771150n 1.8
+    1771199n 1.8
+    1771200n 0
+    1771249n 0
+    1771250n 1.8
+    1771299n 1.8
+    1771300n 0
+    1771349n 0
+    1771350n 1.8
+    1771399n 1.8
+    1771400n 0
+    1771449n 0
+    1771450n 1.8
+    1771499n 1.8
+    1771500n 0
+    1771549n 0
+    1771550n 1.8
+    1771599n 1.8
+    1771600n 0
+    1771649n 0
+    1771650n 1.8
+    1771699n 1.8
+    1771700n 0
+    1771749n 0
+    1771750n 1.8
+    1771799n 1.8
+    1771800n 0
+    1771849n 0
+    1771850n 1.8
+    1771899n 1.8
+    1771900n 0
+    1771949n 0
+    1771950n 1.8
+    1771999n 1.8
+    1772000n 0
+    1772049n 0
+    1772050n 1.8
+    1772099n 1.8
+    1772100n 0
+    1772149n 0
+    1772150n 1.8
+    1772199n 1.8
+    1772200n 0
+    1772249n 0
+    1772250n 1.8
+    1772299n 1.8
+    1772300n 0
+    1772349n 0
+    1772350n 1.8
+    1772399n 1.8
+    1772400n 0
+    1772449n 0
+    1772450n 1.8
+    1772499n 1.8
+    1772500n 0
+    1772549n 0
+    1772550n 1.8
+    1772599n 1.8
+    1772600n 0
+    1772649n 0
+    1772650n 1.8
+    1772699n 1.8
+    1772700n 0
+    1772749n 0
+    1772750n 1.8
+    1772799n 1.8
+    1772800n 0
+    1772849n 0
+    1772850n 1.8
+    1772899n 1.8
+    1772900n 0
+    1772949n 0
+    1772950n 1.8
+    1772999n 1.8
+    1773000n 0
+    1773049n 0
+    1773050n 1.8
+    1773099n 1.8
+    1773100n 0
+    1773149n 0
+    1773150n 1.8
+    1773199n 1.8
+    1773200n 0
+    1773249n 0
+    1773250n 1.8
+    1773299n 1.8
+    1773300n 0
+    1773349n 0
+    1773350n 1.8
+    1773399n 1.8
+    1773400n 0
+    1773449n 0
+    1773450n 1.8
+    1773499n 1.8
+    1773500n 0
+    1773549n 0
+    1773550n 1.8
+    1773599n 1.8
+    1773600n 0
+    1773649n 0
+    1773650n 1.8
+    1773699n 1.8
+    1773700n 0
+    1773749n 0
+    1773750n 1.8
+    1773799n 1.8
+    1773800n 0
+    1773849n 0
+    1773850n 1.8
+    1773899n 1.8
+    1773900n 0
+    1773949n 0
+    1773950n 1.8
+    1773999n 1.8
+    1774000n 0
+    1774049n 0
+    1774050n 1.8
+    1774099n 1.8
+    1774100n 0
+    1774149n 0
+    1774150n 1.8
+    1774199n 1.8
+    1774200n 0
+    1774249n 0
+    1774250n 1.8
+    1774299n 1.8
+    1774300n 0
+    1774349n 0
+    1774350n 1.8
+    1774399n 1.8
+    1774400n 0
+    1774449n 0
+    1774450n 1.8
+    1774499n 1.8
+    1774500n 0
+    1774549n 0
+    1774550n 1.8
+    1774599n 1.8
+    1774600n 0
+    1774649n 0
+    1774650n 1.8
+    1774699n 1.8
+    1774700n 0
+    1774749n 0
+    1774750n 1.8
+    1774799n 1.8
+    1774800n 0
+    1774849n 0
+    1774850n 1.8
+    1774899n 1.8
+    1774900n 0
+    1774949n 0
+    1774950n 1.8
+    1774999n 1.8
+    1775000n 0
+    1775049n 0
+    1775050n 1.8
+    1775099n 1.8
+    1775100n 0
+    1775149n 0
+    1775150n 1.8
+    1775199n 1.8
+    1775200n 0
+    1775249n 0
+    1775250n 1.8
+    1775299n 1.8
+    1775300n 0
+    1775349n 0
+    1775350n 1.8
+    1775399n 1.8
+    1775400n 0
+    1775449n 0
+    1775450n 1.8
+    1775499n 1.8
+    1775500n 0
+    1775549n 0
+    1775550n 1.8
+    1775599n 1.8
+    1775600n 0
+    1775649n 0
+    1775650n 1.8
+    1775699n 1.8
+    1775700n 0
+    1775749n 0
+    1775750n 1.8
+    1775799n 1.8
+    1775800n 0
+    1775849n 0
+    1775850n 1.8
+    1775899n 1.8
+    1775900n 0
+    1775949n 0
+    1775950n 1.8
+    1775999n 1.8
+    1776000n 0
+    1776049n 0
+    1776050n 1.8
+    1776099n 1.8
+    1776100n 0
+    1776149n 0
+    1776150n 1.8
+    1776199n 1.8
+    1776200n 0
+    1776249n 0
+    1776250n 1.8
+    1776299n 1.8
+    1776300n 0
+    1776349n 0
+    1776350n 1.8
+    1776399n 1.8
+    1776400n 0
+    1776449n 0
+    1776450n 1.8
+    1776499n 1.8
+    1776500n 0
+    1776549n 0
+    1776550n 1.8
+    1776599n 1.8
+    1776600n 0
+    1776649n 0
+    1776650n 1.8
+    1776699n 1.8
+    1776700n 0
+    1776749n 0
+    1776750n 1.8
+    1776799n 1.8
+    1776800n 0
+    1776849n 0
+    1776850n 1.8
+    1776899n 1.8
+    1776900n 0
+    1776949n 0
+    1776950n 1.8
+    1776999n 1.8
+    1777000n 0
+    1777049n 0
+    1777050n 1.8
+    1777099n 1.8
+    1777100n 0
+    1777149n 0
+    1777150n 1.8
+    1777199n 1.8
+    1777200n 0
+    1777249n 0
+    1777250n 1.8
+    1777299n 1.8
+    1777300n 0
+    1777349n 0
+    1777350n 1.8
+    1777399n 1.8
+    1777400n 0
+    1777449n 0
+    1777450n 1.8
+    1777499n 1.8
+    1777500n 0
+    1777549n 0
+    1777550n 1.8
+    1777599n 1.8
+    1777600n 0
+    1777649n 0
+    1777650n 1.8
+    1777699n 1.8
+    1777700n 0
+    1777749n 0
+    1777750n 1.8
+    1777799n 1.8
+    1777800n 0
+    1777849n 0
+    1777850n 1.8
+    1777899n 1.8
+    1777900n 0
+    1777949n 0
+    1777950n 1.8
+    1777999n 1.8
+    1778000n 0
+    1778049n 0
+    1778050n 1.8
+    1778099n 1.8
+    1778100n 0
+    1778149n 0
+    1778150n 1.8
+    1778199n 1.8
+    1778200n 0
+    1778249n 0
+    1778250n 1.8
+    1778299n 1.8
+    1778300n 0
+    1778349n 0
+    1778350n 1.8
+    1778399n 1.8
+    1778400n 0
+    1778449n 0
+    1778450n 1.8
+    1778499n 1.8
+    1778500n 0
+    1778549n 0
+    1778550n 1.8
+    1778599n 1.8
+    1778600n 0
+    1778649n 0
+    1778650n 1.8
+    1778699n 1.8
+    1778700n 0
+    1778749n 0
+    1778750n 1.8
+    1778799n 1.8
+    1778800n 0
+    1778849n 0
+    1778850n 1.8
+    1778899n 1.8
+    1778900n 0
+    1778949n 0
+    1778950n 1.8
+    1778999n 1.8
+    1779000n 0
+    1779049n 0
+    1779050n 1.8
+    1779099n 1.8
+    1779100n 0
+    1779149n 0
+    1779150n 1.8
+    1779199n 1.8
+    1779200n 0
+    1779249n 0
+    1779250n 1.8
+    1779299n 1.8
+    1779300n 0
+    1779349n 0
+    1779350n 1.8
+    1779399n 1.8
+    1779400n 0
+    1779449n 0
+    1779450n 1.8
+    1779499n 1.8
+    1779500n 0
+    1779549n 0
+    1779550n 1.8
+    1779599n 1.8
+    1779600n 0
+    1779649n 0
+    1779650n 1.8
+    1779699n 1.8
+    1779700n 0
+    1779749n 0
+    1779750n 1.8
+    1779799n 1.8
+    1779800n 0
+    1779849n 0
+    1779850n 1.8
+    1779899n 1.8
+    1779900n 0
+    1779949n 0
+    1779950n 1.8
+    1779999n 1.8
+    1780000n 0
+    1780049n 0
+    1780050n 1.8
+    1780099n 1.8
+    1780100n 0
+    1780149n 0
+    1780150n 1.8
+    1780199n 1.8
+    1780200n 0
+    1780249n 0
+    1780250n 1.8
+    1780299n 1.8
+    1780300n 0
+    1780349n 0
+    1780350n 1.8
+    1780399n 1.8
+    1780400n 0
+    1780449n 0
+    1780450n 1.8
+    1780499n 1.8
+    1780500n 0
+    1780549n 0
+    1780550n 1.8
+    1780599n 1.8
+    1780600n 0
+    1780649n 0
+    1780650n 1.8
+    1780699n 1.8
+    1780700n 0
+    1780749n 0
+    1780750n 1.8
+    1780799n 1.8
+    1780800n 0
+    1780849n 0
+    1780850n 1.8
+    1780899n 1.8
+    1780900n 0
+    1780949n 0
+    1780950n 1.8
+    1780999n 1.8
+    1781000n 0
+    1781049n 0
+    1781050n 1.8
+    1781099n 1.8
+    1781100n 0
+    1781149n 0
+    1781150n 1.8
+    1781199n 1.8
+    1781200n 0
+    1781249n 0
+    1781250n 1.8
+    1781299n 1.8
+    1781300n 0
+    1781349n 0
+    1781350n 1.8
+    1781399n 1.8
+    1781400n 0
+    1781449n 0
+    1781450n 1.8
+    1781499n 1.8
+    1781500n 0
+    1781549n 0
+    1781550n 1.8
+    1781599n 1.8
+    1781600n 0
+    1781649n 0
+    1781650n 1.8
+    1781699n 1.8
+    1781700n 0
+    1781749n 0
+    1781750n 1.8
+    1781799n 1.8
+    1781800n 0
+    1781849n 0
+    1781850n 1.8
+    1781899n 1.8
+    1781900n 0
+    1781949n 0
+    1781950n 1.8
+    1781999n 1.8
+    1782000n 0
+    1782049n 0
+    1782050n 1.8
+    1782099n 1.8
+    1782100n 0
+    1782149n 0
+    1782150n 1.8
+    1782199n 1.8
+    1782200n 0
+    1782249n 0
+    1782250n 1.8
+    1782299n 1.8
+    1782300n 0
+    1782349n 0
+    1782350n 1.8
+    1782399n 1.8
+    1782400n 0
+    1782449n 0
+    1782450n 1.8
+    1782499n 1.8
+    1782500n 0
+    1782549n 0
+    1782550n 1.8
+    1782599n 1.8
+    1782600n 0
+    1782649n 0
+    1782650n 1.8
+    1782699n 1.8
+    1782700n 0
+    1782749n 0
+    1782750n 1.8
+    1782799n 1.8
+    1782800n 0
+    1782849n 0
+    1782850n 1.8
+    1782899n 1.8
+    1782900n 0
+    1782949n 0
+    1782950n 1.8
+    1782999n 1.8
+    1783000n 0
+    1783049n 0
+    1783050n 1.8
+    1783099n 1.8
+    1783100n 0
+    1783149n 0
+    1783150n 1.8
+    1783199n 1.8
+    1783200n 0
+    1783249n 0
+    1783250n 1.8
+    1783299n 1.8
+    1783300n 0
+    1783349n 0
+    1783350n 1.8
+    1783399n 1.8
+    1783400n 0
+    1783449n 0
+    1783450n 1.8
+    1783499n 1.8
+    1783500n 0
+    1783549n 0
+    1783550n 1.8
+    1783599n 1.8
+    1783600n 0
+    1783649n 0
+    1783650n 1.8
+    1783699n 1.8
+    1783700n 0
+    1783749n 0
+    1783750n 1.8
+    1783799n 1.8
+    1783800n 0
+    1783849n 0
+    1783850n 1.8
+    1783899n 1.8
+    1783900n 0
+    1783949n 0
+    1783950n 1.8
+    1783999n 1.8
+    1784000n 0
+    1784049n 0
+    1784050n 1.8
+    1784099n 1.8
+    1784100n 0
+    1784149n 0
+    1784150n 1.8
+    1784199n 1.8
+    1784200n 0
+    1784249n 0
+    1784250n 1.8
+    1784299n 1.8
+    1784300n 0
+    1784349n 0
+    1784350n 1.8
+    1784399n 1.8
+    1784400n 0
+    1784449n 0
+    1784450n 1.8
+    1784499n 1.8
+    1784500n 0
+    1784549n 0
+    1784550n 1.8
+    1784599n 1.8
+    1784600n 0
+    1784649n 0
+    1784650n 1.8
+    1784699n 1.8
+    1784700n 0
+    1784749n 0
+    1784750n 1.8
+    1784799n 1.8
+    1784800n 0
+    1784849n 0
+    1784850n 1.8
+    1784899n 1.8
+    1784900n 0
+    1784949n 0
+    1784950n 1.8
+    1784999n 1.8
+    1785000n 0
+    1785049n 0
+    1785050n 1.8
+    1785099n 1.8
+    1785100n 0
+    1785149n 0
+    1785150n 1.8
+    1785199n 1.8
+    1785200n 0
+    1785249n 0
+    1785250n 1.8
+    1785299n 1.8
+    1785300n 0
+    1785349n 0
+    1785350n 1.8
+    1785399n 1.8
+    1785400n 0
+    1785449n 0
+    1785450n 1.8
+    1785499n 1.8
+    1785500n 0
+    1785549n 0
+    1785550n 1.8
+    1785599n 1.8
+    1785600n 0
+    1785649n 0
+    1785650n 1.8
+    1785699n 1.8
+    1785700n 0
+    1785749n 0
+    1785750n 1.8
+    1785799n 1.8
+    1785800n 0
+    1785849n 0
+    1785850n 1.8
+    1785899n 1.8
+    1785900n 0
+    1785949n 0
+    1785950n 1.8
+    1785999n 1.8
+    1786000n 0
+    1786049n 0
+    1786050n 1.8
+    1786099n 1.8
+    1786100n 0
+    1786149n 0
+    1786150n 1.8
+    1786199n 1.8
+    1786200n 0
+    1786249n 0
+    1786250n 1.8
+    1786299n 1.8
+    1786300n 0
+    1786349n 0
+    1786350n 1.8
+    1786399n 1.8
+    1786400n 0
+    1786449n 0
+    1786450n 1.8
+    1786499n 1.8
+    1786500n 0
+    1786549n 0
+    1786550n 1.8
+    1786599n 1.8
+    1786600n 0
+    1786649n 0
+    1786650n 1.8
+    1786699n 1.8
+    1786700n 0
+    1786749n 0
+    1786750n 1.8
+    1786799n 1.8
+    1786800n 0
+    1786849n 0
+    1786850n 1.8
+    1786899n 1.8
+    1786900n 0
+    1786949n 0
+    1786950n 1.8
+    1786999n 1.8
+    1787000n 0
+    1787049n 0
+    1787050n 1.8
+    1787099n 1.8
+    1787100n 0
+    1787149n 0
+    1787150n 1.8
+    1787199n 1.8
+    1787200n 0
+    1787249n 0
+    1787250n 1.8
+    1787299n 1.8
+    1787300n 0
+    1787349n 0
+    1787350n 1.8
+    1787399n 1.8
+    1787400n 0
+    1787449n 0
+    1787450n 1.8
+    1787499n 1.8
+    1787500n 0
+    1787549n 0
+    1787550n 1.8
+    1787599n 1.8
+    1787600n 0
+    1787649n 0
+    1787650n 1.8
+    1787699n 1.8
+    1787700n 0
+    1787749n 0
+    1787750n 1.8
+    1787799n 1.8
+    1787800n 0
+    1787849n 0
+    1787850n 1.8
+    1787899n 1.8
+    1787900n 0
+    1787949n 0
+    1787950n 1.8
+    1787999n 1.8
+    1788000n 0
+    1788049n 0
+    1788050n 1.8
+    1788099n 1.8
+    1788100n 0
+    1788149n 0
+    1788150n 1.8
+    1788199n 1.8
+    1788200n 0
+    1788249n 0
+    1788250n 1.8
+    1788299n 1.8
+    1788300n 0
+    1788349n 0
+    1788350n 1.8
+    1788399n 1.8
+    1788400n 0
+    1788449n 0
+    1788450n 1.8
+    1788499n 1.8
+    1788500n 0
+    1788549n 0
+    1788550n 1.8
+    1788599n 1.8
+    1788600n 0
+    1788649n 0
+    1788650n 1.8
+    1788699n 1.8
+    1788700n 0
+    1788749n 0
+    1788750n 1.8
+    1788799n 1.8
+    1788800n 0
+    1788849n 0
+    1788850n 1.8
+    1788899n 1.8
+    1788900n 0
+    1788949n 0
+    1788950n 1.8
+    1788999n 1.8
+    1789000n 0
+    1789049n 0
+    1789050n 1.8
+    1789099n 1.8
+    1789100n 0
+    1789149n 0
+    1789150n 1.8
+    1789199n 1.8
+    1789200n 0
+    1789249n 0
+    1789250n 1.8
+    1789299n 1.8
+    1789300n 0
+    1789349n 0
+    1789350n 1.8
+    1789399n 1.8
+    1789400n 0
+    1789449n 0
+    1789450n 1.8
+    1789499n 1.8
+    1789500n 0
+    1789549n 0
+    1789550n 1.8
+    1789599n 1.8
+    1789600n 0
+    1789649n 0
+    1789650n 1.8
+    1789699n 1.8
+    1789700n 0
+    1789749n 0
+    1789750n 1.8
+    1789799n 1.8
+    1789800n 0
+    1789849n 0
+    1789850n 1.8
+    1789899n 1.8
+    1789900n 0
+    1789949n 0
+    1789950n 1.8
+    1789999n 1.8
+    1790000n 0
+    1790049n 0
+    1790050n 1.8
+    1790099n 1.8
+    1790100n 0
+    1790149n 0
+    1790150n 1.8
+    1790199n 1.8
+    1790200n 0
+    1790249n 0
+    1790250n 1.8
+    1790299n 1.8
+    1790300n 0
+    1790349n 0
+    1790350n 1.8
+    1790399n 1.8
+    1790400n 0
+    1790449n 0
+    1790450n 1.8
+    1790499n 1.8
+    1790500n 0
+    1790549n 0
+    1790550n 1.8
+    1790599n 1.8
+    1790600n 0
+    1790649n 0
+    1790650n 1.8
+    1790699n 1.8
+    1790700n 0
+    1790749n 0
+    1790750n 1.8
+    1790799n 1.8
+    1790800n 0
+    1790849n 0
+    1790850n 1.8
+    1790899n 1.8
+    1790900n 0
+    1790949n 0
+    1790950n 1.8
+    1790999n 1.8
+    1791000n 0
+    1791049n 0
+    1791050n 1.8
+    1791099n 1.8
+    1791100n 0
+    1791149n 0
+    1791150n 1.8
+    1791199n 1.8
+    1791200n 0
+    1791249n 0
+    1791250n 1.8
+    1791299n 1.8
+    1791300n 0
+    1791349n 0
+    1791350n 1.8
+    1791399n 1.8
+    1791400n 0
+    1791449n 0
+    1791450n 1.8
+    1791499n 1.8
+    1791500n 0
+    1791549n 0
+    1791550n 1.8
+    1791599n 1.8
+    1791600n 0
+    1791649n 0
+    1791650n 1.8
+    1791699n 1.8
+    1791700n 0
+    1791749n 0
+    1791750n 1.8
+    1791799n 1.8
+    1791800n 0
+    1791849n 0
+    1791850n 1.8
+    1791899n 1.8
+    1791900n 0
+    1791949n 0
+    1791950n 1.8
+    1791999n 1.8
+    1792000n 0
+    1792049n 0
+    1792050n 1.8
+    1792099n 1.8
+    1792100n 0
+    1792149n 0
+    1792150n 1.8
+    1792199n 1.8
+    1792200n 0
+    1792249n 0
+    1792250n 1.8
+    1792299n 1.8
+    1792300n 0
+    1792349n 0
+    1792350n 1.8
+    1792399n 1.8
+    1792400n 0
+    1792449n 0
+    1792450n 1.8
+    1792499n 1.8
+    1792500n 0
+    1792549n 0
+    1792550n 1.8
+    1792599n 1.8
+    1792600n 0
+    1792649n 0
+    1792650n 1.8
+    1792699n 1.8
+    1792700n 0
+    1792749n 0
+    1792750n 1.8
+    1792799n 1.8
+    1792800n 0
+    1792849n 0
+    1792850n 1.8
+    1792899n 1.8
+    1792900n 0
+    1792949n 0
+    1792950n 1.8
+    1792999n 1.8
+    1793000n 0
+    1793049n 0
+    1793050n 1.8
+    1793099n 1.8
+    1793100n 0
+    1793149n 0
+    1793150n 1.8
+    1793199n 1.8
+    1793200n 0
+    1793249n 0
+    1793250n 1.8
+    1793299n 1.8
+    1793300n 0
+    1793349n 0
+    1793350n 1.8
+    1793399n 1.8
+    1793400n 0
+    1793449n 0
+    1793450n 1.8
+    1793499n 1.8
+    1793500n 0
+    1793549n 0
+    1793550n 1.8
+    1793599n 1.8
+    1793600n 0
+    1793649n 0
+    1793650n 1.8
+    1793699n 1.8
+    1793700n 0
+    1793749n 0
+    1793750n 1.8
+    1793799n 1.8
+    1793800n 0
+    1793849n 0
+    1793850n 1.8
+    1793899n 1.8
+    1793900n 0
+    1793949n 0
+    1793950n 1.8
+    1793999n 1.8
+    1794000n 0
+    1794049n 0
+    1794050n 1.8
+    1794099n 1.8
+    1794100n 0
+    1794149n 0
+    1794150n 1.8
+    1794199n 1.8
+    1794200n 0
+    1794249n 0
+    1794250n 1.8
+    1794299n 1.8
+    1794300n 0
+    1794349n 0
+    1794350n 1.8
+    1794399n 1.8
+    1794400n 0
+    1794449n 0
+    1794450n 1.8
+    1794499n 1.8
+    1794500n 0
+    1794549n 0
+    1794550n 1.8
+    1794599n 1.8
+    1794600n 0
+    1794649n 0
+    1794650n 1.8
+    1794699n 1.8
+    1794700n 0
+    1794749n 0
+    1794750n 1.8
+    1794799n 1.8
+    1794800n 0
+    1794849n 0
+    1794850n 1.8
+    1794899n 1.8
+    1794900n 0
+    1794949n 0
+    1794950n 1.8
+    1794999n 1.8
+    1795000n 0
+    1795049n 0
+    1795050n 1.8
+    1795099n 1.8
+    1795100n 0
+    1795149n 0
+    1795150n 1.8
+    1795199n 1.8
+    1795200n 0
+    1795249n 0
+    1795250n 1.8
+    1795299n 1.8
+    1795300n 0
+    1795349n 0
+    1795350n 1.8
+    1795399n 1.8
+    1795400n 0
+    1795449n 0
+    1795450n 1.8
+    1795499n 1.8
+    1795500n 0
+    1795549n 0
+    1795550n 1.8
+    1795599n 1.8
+    1795600n 0
+    1795649n 0
+    1795650n 1.8
+    1795699n 1.8
+    1795700n 0
+    1795749n 0
+    1795750n 1.8
+    1795799n 1.8
+    1795800n 0
+    1795849n 0
+    1795850n 1.8
+    1795899n 1.8
+    1795900n 0
+    1795949n 0
+    1795950n 1.8
+    1795999n 1.8
+    1796000n 0
+    1796049n 0
+    1796050n 1.8
+    1796099n 1.8
+    1796100n 0
+    1796149n 0
+    1796150n 1.8
+    1796199n 1.8
+    1796200n 0
+    1796249n 0
+    1796250n 1.8
+    1796299n 1.8
+    1796300n 0
+    1796349n 0
+    1796350n 1.8
+    1796399n 1.8
+    1796400n 0
+    1796449n 0
+    1796450n 1.8
+    1796499n 1.8
+    1796500n 0
+    1796549n 0
+    1796550n 1.8
+    1796599n 1.8
+    1796600n 0
+    1796649n 0
+    1796650n 1.8
+    1796699n 1.8
+    1796700n 0
+    1796749n 0
+    1796750n 1.8
+    1796799n 1.8
+    1796800n 0
+    1796849n 0
+    1796850n 1.8
+    1796899n 1.8
+    1796900n 0
+    1796949n 0
+    1796950n 1.8
+    1796999n 1.8
+    1797000n 0
+    1797049n 0
+    1797050n 1.8
+    1797099n 1.8
+    1797100n 0
+    1797149n 0
+    1797150n 1.8
+    1797199n 1.8
+    1797200n 0
+    1797249n 0
+    1797250n 1.8
+    1797299n 1.8
+    1797300n 0
+    1797349n 0
+    1797350n 1.8
+    1797399n 1.8
+    1797400n 0
+    1797449n 0
+    1797450n 1.8
+    1797499n 1.8
+    1797500n 0
+    1797549n 0
+    1797550n 1.8
+    1797599n 1.8
+    1797600n 0
+    1797649n 0
+    1797650n 1.8
+    1797699n 1.8
+    1797700n 0
+    1797749n 0
+    1797750n 1.8
+    1797799n 1.8
+    1797800n 0
+    1797849n 0
+    1797850n 1.8
+    1797899n 1.8
+    1797900n 0
+    1797949n 0
+    1797950n 1.8
+    1797999n 1.8
+    1798000n 0
+    1798049n 0
+    1798050n 1.8
+    1798099n 1.8
+    1798100n 0
+    1798149n 0
+    1798150n 1.8
+    1798199n 1.8
+    1798200n 0
+    1798249n 0
+    1798250n 1.8
+    1798299n 1.8
+    1798300n 0
+    1798349n 0
+    1798350n 1.8
+    1798399n 1.8
+    1798400n 0
+    1798449n 0
+    1798450n 1.8
+    1798499n 1.8
+    1798500n 0
+    1798549n 0
+    1798550n 1.8
+    1798599n 1.8
+    1798600n 0
+    1798649n 0
+    1798650n 1.8
+    1798699n 1.8
+    1798700n 0
+    1798749n 0
+    1798750n 1.8
+    1798799n 1.8
+    1798800n 0
+    1798849n 0
+    1798850n 1.8
+    1798899n 1.8
+    1798900n 0
+    1798949n 0
+    1798950n 1.8
+    1798999n 1.8
+    1799000n 0
+    1799049n 0
+    1799050n 1.8
+    1799099n 1.8
+    1799100n 0
+    1799149n 0
+    1799150n 1.8
+    1799199n 1.8
+    1799200n 0
+    1799249n 0
+    1799250n 1.8
+    1799299n 1.8
+    1799300n 0
+    1799349n 0
+    1799350n 1.8
+    1799399n 1.8
+    1799400n 0
+    1799449n 0
+    1799450n 1.8
+    1799499n 1.8
+    1799500n 0
+    1799549n 0
+    1799550n 1.8
+    1799599n 1.8
+    1799600n 0
+    1799649n 0
+    1799650n 1.8
+    1799699n 1.8
+    1799700n 0
+    1799749n 0
+    1799750n 1.8
+    1799799n 1.8
+    1799800n 0
+    1799849n 0
+    1799850n 1.8
+    1799899n 1.8
+    1799900n 0
+    1799949n 0
+    1799950n 1.8
+    1799999n 1.8
+    1800000n 0
+    1800049n 0
+    1800050n 1.8
+    1800099n 1.8
+    1800100n 0
+    1800149n 0
+    1800150n 1.8
+    1800199n 1.8
+    1800200n 0
+    1800249n 0
+    1800250n 1.8
+    1800299n 1.8
+    1800300n 0
+    1800349n 0
+    1800350n 1.8
+    1800399n 1.8
+    1800400n 0
+    1800449n 0
+    1800450n 1.8
+    1800499n 1.8
+    1800500n 0
+    1800549n 0
+    1800550n 1.8
+    1800599n 1.8
+    1800600n 0
+    1800649n 0
+    1800650n 1.8
+    1800699n 1.8
+    1800700n 0
+    1800749n 0
+    1800750n 1.8
+    1800799n 1.8
+    1800800n 0
+    1800849n 0
+    1800850n 1.8
+    1800899n 1.8
+    1800900n 0
+    1800949n 0
+    1800950n 1.8
+    1800999n 1.8
+    1801000n 0
+    1801049n 0
+    1801050n 1.8
+    1801099n 1.8
+    1801100n 0
+    1801149n 0
+    1801150n 1.8
+    1801199n 1.8
+    1801200n 0
+    1801249n 0
+    1801250n 1.8
+    1801299n 1.8
+    1801300n 0
+    1801349n 0
+    1801350n 1.8
+    1801399n 1.8
+    1801400n 0
+    1801449n 0
+    1801450n 1.8
+    1801499n 1.8
+    1801500n 0
+    1801549n 0
+    1801550n 1.8
+    1801599n 1.8
+    1801600n 0
+    1801649n 0
+    1801650n 1.8
+    1801699n 1.8
+    1801700n 0
+    1801749n 0
+    1801750n 1.8
+    1801799n 1.8
+    1801800n 0
+    1801849n 0
+    1801850n 1.8
+    1801899n 1.8
+    1801900n 0
+    1801949n 0
+    1801950n 1.8
+    1801999n 1.8
+    1802000n 0
+    1802049n 0
+    1802050n 1.8
+    1802099n 1.8
+    1802100n 0
+    1802149n 0
+    1802150n 1.8
+    1802199n 1.8
+    1802200n 0
+    1802249n 0
+    1802250n 1.8
+    1802299n 1.8
+    1802300n 0
+    1802349n 0
+    1802350n 1.8
+    1802399n 1.8
+    1802400n 0
+    1802449n 0
+    1802450n 1.8
+    1802499n 1.8
+    1802500n 0
+    1802549n 0
+    1802550n 1.8
+    1802599n 1.8
+    1802600n 0
+    1802649n 0
+    1802650n 1.8
+    1802699n 1.8
+    1802700n 0
+    1802749n 0
+    1802750n 1.8
+    1802799n 1.8
+    1802800n 0
+    1802849n 0
+    1802850n 1.8
+    1802899n 1.8
+    1802900n 0
+    1802949n 0
+    1802950n 1.8
+    1802999n 1.8
+    1803000n 0
+    1803049n 0
+    1803050n 1.8
+    1803099n 1.8
+    1803100n 0
+    1803149n 0
+    1803150n 1.8
+    1803199n 1.8
+    1803200n 0
+    1803249n 0
+    1803250n 1.8
+    1803299n 1.8
+    1803300n 0
+    1803349n 0
+    1803350n 1.8
+    1803399n 1.8
+    1803400n 0
+    1803449n 0
+    1803450n 1.8
+    1803499n 1.8
+    1803500n 0
+    1803549n 0
+    1803550n 1.8
+    1803599n 1.8
+    1803600n 0
+    1803649n 0
+    1803650n 1.8
+    1803699n 1.8
+    1803700n 0
+    1803749n 0
+    1803750n 1.8
+    1803799n 1.8
+    1803800n 0
+    1803849n 0
+    1803850n 1.8
+    1803899n 1.8
+    1803900n 0
+    1803949n 0
+    1803950n 1.8
+    1803999n 1.8
+    1804000n 0
+    1804049n 0
+    1804050n 1.8
+    1804099n 1.8
+    1804100n 0
+    1804149n 0
+    1804150n 1.8
+    1804199n 1.8
+    1804200n 0
+    1804249n 0
+    1804250n 1.8
+    1804299n 1.8
+    1804300n 0
+    1804349n 0
+    1804350n 1.8
+    1804399n 1.8
+    1804400n 0
+    1804449n 0
+    1804450n 1.8
+    1804499n 1.8
+    1804500n 0
+    1804549n 0
+    1804550n 1.8
+    1804599n 1.8
+    1804600n 0
+    1804649n 0
+    1804650n 1.8
+    1804699n 1.8
+    1804700n 0
+    1804749n 0
+    1804750n 1.8
+    1804799n 1.8
+    1804800n 0
+    1804849n 0
+    1804850n 1.8
+    1804899n 1.8
+    1804900n 0
+    1804949n 0
+    1804950n 1.8
+    1804999n 1.8
+    1805000n 0
+    1805049n 0
+    1805050n 1.8
+    1805099n 1.8
+    1805100n 0
+    1805149n 0
+    1805150n 1.8
+    1805199n 1.8
+    1805200n 0
+    1805249n 0
+    1805250n 1.8
+    1805299n 1.8
+    1805300n 0
+    1805349n 0
+    1805350n 1.8
+    1805399n 1.8
+    1805400n 0
+    1805449n 0
+    1805450n 1.8
+    1805499n 1.8
+    1805500n 0
+    1805549n 0
+    1805550n 1.8
+    1805599n 1.8
+    1805600n 0
+    1805649n 0
+    1805650n 1.8
+    1805699n 1.8
+    1805700n 0
+    1805749n 0
+    1805750n 1.8
+    1805799n 1.8
+    1805800n 0
+    1805849n 0
+    1805850n 1.8
+    1805899n 1.8
+    1805900n 0
+    1805949n 0
+    1805950n 1.8
+    1805999n 1.8
+    1806000n 0
+    1806049n 0
+    1806050n 1.8
+    1806099n 1.8
+    1806100n 0
+    1806149n 0
+    1806150n 1.8
+    1806199n 1.8
+    1806200n 0
+    1806249n 0
+    1806250n 1.8
+    1806299n 1.8
+    1806300n 0
+    1806349n 0
+    1806350n 1.8
+    1806399n 1.8
+    1806400n 0
+    1806449n 0
+    1806450n 1.8
+    1806499n 1.8
+    1806500n 0
+    1806549n 0
+    1806550n 1.8
+    1806599n 1.8
+    1806600n 0
+    1806649n 0
+    1806650n 1.8
+    1806699n 1.8
+    1806700n 0
+    1806749n 0
+    1806750n 1.8
+    1806799n 1.8
+    1806800n 0
+    1806849n 0
+    1806850n 1.8
+    1806899n 1.8
+    1806900n 0
+    1806949n 0
+    1806950n 1.8
+    1806999n 1.8
+    1807000n 0
+    1807049n 0
+    1807050n 1.8
+    1807099n 1.8
+    1807100n 0
+    1807149n 0
+    1807150n 1.8
+    1807199n 1.8
+    1807200n 0
+    1807249n 0
+    1807250n 1.8
+    1807299n 1.8
+    1807300n 0
+    1807349n 0
+    1807350n 1.8
+    1807399n 1.8
+    1807400n 0
+    1807449n 0
+    1807450n 1.8
+    1807499n 1.8
+    1807500n 0
+    1807549n 0
+    1807550n 1.8
+    1807599n 1.8
+    1807600n 0
+    1807649n 0
+    1807650n 1.8
+    1807699n 1.8
+    1807700n 0
+    1807749n 0
+    1807750n 1.8
+    1807799n 1.8
+    1807800n 0
+    1807849n 0
+    1807850n 1.8
+    1807899n 1.8
+    1807900n 0
+    1807949n 0
+    1807950n 1.8
+    1807999n 1.8
+    1808000n 0
+    1808049n 0
+    1808050n 1.8
+    1808099n 1.8
+    1808100n 0
+    1808149n 0
+    1808150n 1.8
+    1808199n 1.8
+    1808200n 0
+    1808249n 0
+    1808250n 1.8
+    1808299n 1.8
+    1808300n 0
+    1808349n 0
+    1808350n 1.8
+    1808399n 1.8
+    1808400n 0
+    1808449n 0
+    1808450n 1.8
+    1808499n 1.8
+    1808500n 0
+    1808549n 0
+    1808550n 1.8
+    1808599n 1.8
+    1808600n 0
+    1808649n 0
+    1808650n 1.8
+    1808699n 1.8
+    1808700n 0
+    1808749n 0
+    1808750n 1.8
+    1808799n 1.8
+    1808800n 0
+    1808849n 0
+    1808850n 1.8
+    1808899n 1.8
+    1808900n 0
+    1808949n 0
+    1808950n 1.8
+    1808999n 1.8
+    1809000n 0
+    1809049n 0
+    1809050n 1.8
+    1809099n 1.8
+    1809100n 0
+    1809149n 0
+    1809150n 1.8
+    1809199n 1.8
+    1809200n 0
+    1809249n 0
+    1809250n 1.8
+    1809299n 1.8
+    1809300n 0
+    1809349n 0
+    1809350n 1.8
+    1809399n 1.8
+    1809400n 0
+    1809449n 0
+    1809450n 1.8
+    1809499n 1.8
+    1809500n 0
+    1809549n 0
+    1809550n 1.8
+    1809599n 1.8
+    1809600n 0
+    1809649n 0
+    1809650n 1.8
+    1809699n 1.8
+    1809700n 0
+    1809749n 0
+    1809750n 1.8
+    1809799n 1.8
+    1809800n 0
+    1809849n 0
+    1809850n 1.8
+    1809899n 1.8
+    1809900n 0
+    1809949n 0
+    1809950n 1.8
+    1809999n 1.8
+    1810000n 0
+    1810049n 0
+    1810050n 1.8
+    1810099n 1.8
+    1810100n 0
+    1810149n 0
+    1810150n 1.8
+    1810199n 1.8
+    1810200n 0
+    1810249n 0
+    1810250n 1.8
+    1810299n 1.8
+    1810300n 0
+    1810349n 0
+    1810350n 1.8
+    1810399n 1.8
+    1810400n 0
+    1810449n 0
+    1810450n 1.8
+    1810499n 1.8
+    1810500n 0
+    1810549n 0
+    1810550n 1.8
+    1810599n 1.8
+    1810600n 0
+    1810649n 0
+    1810650n 1.8
+    1810699n 1.8
+    1810700n 0
+    1810749n 0
+    1810750n 1.8
+    1810799n 1.8
+    1810800n 0
+    1810849n 0
+    1810850n 1.8
+    1810899n 1.8
+    1810900n 0
+    1810949n 0
+    1810950n 1.8
+    1810999n 1.8
+    1811000n 0
+    1811049n 0
+    1811050n 1.8
+    1811099n 1.8
+    1811100n 0
+    1811149n 0
+    1811150n 1.8
+    1811199n 1.8
+    1811200n 0
+    1811249n 0
+    1811250n 1.8
+    1811299n 1.8
+    1811300n 0
+    1811349n 0
+    1811350n 1.8
+    1811399n 1.8
+    1811400n 0
+    1811449n 0
+    1811450n 1.8
+    1811499n 1.8
+    1811500n 0
+    1811549n 0
+    1811550n 1.8
+    1811599n 1.8
+    1811600n 0
+    1811649n 0
+    1811650n 1.8
+    1811699n 1.8
+    1811700n 0
+    1811749n 0
+    1811750n 1.8
+    1811799n 1.8
+    1811800n 0
+    1811849n 0
+    1811850n 1.8
+    1811899n 1.8
+    1811900n 0
+    1811949n 0
+    1811950n 1.8
+    1811999n 1.8
+    1812000n 0
+    1812049n 0
+    1812050n 1.8
+    1812099n 1.8
+    1812100n 0
+    1812149n 0
+    1812150n 1.8
+    1812199n 1.8
+    1812200n 0
+    1812249n 0
+    1812250n 1.8
+    1812299n 1.8
+    1812300n 0
+    1812349n 0
+    1812350n 1.8
+    1812399n 1.8
+    1812400n 0
+    1812449n 0
+    1812450n 1.8
+    1812499n 1.8
+    1812500n 0
+    1812549n 0
+    1812550n 1.8
+    1812599n 1.8
+    1812600n 0
+    1812649n 0
+    1812650n 1.8
+    1812699n 1.8
+    1812700n 0
+    1812749n 0
+    1812750n 1.8
+    1812799n 1.8
+    1812800n 0
+    1812849n 0
+    1812850n 1.8
+    1812899n 1.8
+    1812900n 0
+    1812949n 0
+    1812950n 1.8
+    1812999n 1.8
+    1813000n 0
+    1813049n 0
+    1813050n 1.8
+    1813099n 1.8
+    1813100n 0
+    1813149n 0
+    1813150n 1.8
+    1813199n 1.8
+    1813200n 0
+    1813249n 0
+    1813250n 1.8
+    1813299n 1.8
+    1813300n 0
+    1813349n 0
+    1813350n 1.8
+    1813399n 1.8
+    1813400n 0
+    1813449n 0
+    1813450n 1.8
+    1813499n 1.8
+    1813500n 0
+    1813549n 0
+    1813550n 1.8
+    1813599n 1.8
+    1813600n 0
+    1813649n 0
+    1813650n 1.8
+    1813699n 1.8
+    1813700n 0
+    1813749n 0
+    1813750n 1.8
+    1813799n 1.8
+    1813800n 0
+    1813849n 0
+    1813850n 1.8
+    1813899n 1.8
+    1813900n 0
+    1813949n 0
+    1813950n 1.8
+    1813999n 1.8
+    1814000n 0
+    1814049n 0
+    1814050n 1.8
+    1814099n 1.8
+    1814100n 0
+    1814149n 0
+    1814150n 1.8
+    1814199n 1.8
+    1814200n 0
+    1814249n 0
+    1814250n 1.8
+    1814299n 1.8
+    1814300n 0
+    1814349n 0
+    1814350n 1.8
+    1814399n 1.8
+    1814400n 0
+    1814449n 0
+    1814450n 1.8
+    1814499n 1.8
+    1814500n 0
+    1814549n 0
+    1814550n 1.8
+    1814599n 1.8
+    1814600n 0
+    1814649n 0
+    1814650n 1.8
+    1814699n 1.8
+    1814700n 0
+    1814749n 0
+    1814750n 1.8
+    1814799n 1.8
+    1814800n 0
+    1814849n 0
+    1814850n 1.8
+    1814899n 1.8
+    1814900n 0
+    1814949n 0
+    1814950n 1.8
+    1814999n 1.8
+    1815000n 0
+    1815049n 0
+    1815050n 1.8
+    1815099n 1.8
+    1815100n 0
+    1815149n 0
+    1815150n 1.8
+    1815199n 1.8
+    1815200n 0
+    1815249n 0
+    1815250n 1.8
+    1815299n 1.8
+    1815300n 0
+    1815349n 0
+    1815350n 1.8
+    1815399n 1.8
+    1815400n 0
+    1815449n 0
+    1815450n 1.8
+    1815499n 1.8
+    1815500n 0
+    1815549n 0
+    1815550n 1.8
+    1815599n 1.8
+    1815600n 0
+    1815649n 0
+    1815650n 1.8
+    1815699n 1.8
+    1815700n 0
+    1815749n 0
+    1815750n 1.8
+    1815799n 1.8
+    1815800n 0
+    1815849n 0
+    1815850n 1.8
+    1815899n 1.8
+    1815900n 0
+    1815949n 0
+    1815950n 1.8
+    1815999n 1.8
+    1816000n 0
+    1816049n 0
+    1816050n 1.8
+    1816099n 1.8
+    1816100n 0
+    1816149n 0
+    1816150n 1.8
+    1816199n 1.8
+    1816200n 0
+    1816249n 0
+    1816250n 1.8
+    1816299n 1.8
+    1816300n 0
+    1816349n 0
+    1816350n 1.8
+    1816399n 1.8
+    1816400n 0
+    1816449n 0
+    1816450n 1.8
+    1816499n 1.8
+    1816500n 0
+    1816549n 0
+    1816550n 1.8
+    1816599n 1.8
+    1816600n 0
+    1816649n 0
+    1816650n 1.8
+    1816699n 1.8
+    1816700n 0
+    1816749n 0
+    1816750n 1.8
+    1816799n 1.8
+    1816800n 0
+    1816849n 0
+    1816850n 1.8
+    1816899n 1.8
+    1816900n 0
+    1816949n 0
+    1816950n 1.8
+    1816999n 1.8
+    1817000n 0
+    1817049n 0
+    1817050n 1.8
+    1817099n 1.8
+    1817100n 0
+    1817149n 0
+    1817150n 1.8
+    1817199n 1.8
+    1817200n 0
+    1817249n 0
+    1817250n 1.8
+    1817299n 1.8
+    1817300n 0
+    1817349n 0
+    1817350n 1.8
+    1817399n 1.8
+    1817400n 0
+    1817449n 0
+    1817450n 1.8
+    1817499n 1.8
+    1817500n 0
+    1817549n 0
+    1817550n 1.8
+    1817599n 1.8
+    1817600n 0
+    1817649n 0
+    1817650n 1.8
+    1817699n 1.8
+    1817700n 0
+    1817749n 0
+    1817750n 1.8
+    1817799n 1.8
+    1817800n 0
+    1817849n 0
+    1817850n 1.8
+    1817899n 1.8
+    1817900n 0
+    1817949n 0
+    1817950n 1.8
+    1817999n 1.8
+    1818000n 0
+    1818049n 0
+    1818050n 1.8
+    1818099n 1.8
+    1818100n 0
+    1818149n 0
+    1818150n 1.8
+    1818199n 1.8
+    1818200n 0
+    1818249n 0
+    1818250n 1.8
+    1818299n 1.8
+    1818300n 0
+    1818349n 0
+    1818350n 1.8
+    1818399n 1.8
+    1818400n 0
+    1818449n 0
+    1818450n 1.8
+    1818499n 1.8
+    1818500n 0
+    1818549n 0
+    1818550n 1.8
+    1818599n 1.8
+    1818600n 0
+    1818649n 0
+    1818650n 1.8
+    1818699n 1.8
+    1818700n 0
+    1818749n 0
+    1818750n 1.8
+    1818799n 1.8
+    1818800n 0
+    1818849n 0
+    1818850n 1.8
+    1818899n 1.8
+    1818900n 0
+    1818949n 0
+    1818950n 1.8
+    1818999n 1.8
+    1819000n 0
+    1819049n 0
+    1819050n 1.8
+    1819099n 1.8
+    1819100n 0
+    1819149n 0
+    1819150n 1.8
+    1819199n 1.8
+    1819200n 0
+    1819249n 0
+    1819250n 1.8
+    1819299n 1.8
+    1819300n 0
+    1819349n 0
+    1819350n 1.8
+    1819399n 1.8
+    1819400n 0
+    1819449n 0
+    1819450n 1.8
+    1819499n 1.8
+    1819500n 0
+    1819549n 0
+    1819550n 1.8
+    1819599n 1.8
+    1819600n 0
+    1819649n 0
+    1819650n 1.8
+    1819699n 1.8
+    1819700n 0
+    1819749n 0
+    1819750n 1.8
+    1819799n 1.8
+    1819800n 0
+    1819849n 0
+    1819850n 1.8
+    1819899n 1.8
+    1819900n 0
+    1819949n 0
+    1819950n 1.8
+    1819999n 1.8
+    1820000n 0
+    1820049n 0
+    1820050n 1.8
+    1820099n 1.8
+    1820100n 0
+    1820149n 0
+    1820150n 1.8
+    1820199n 1.8
+    1820200n 0
+    1820249n 0
+    1820250n 1.8
+    1820299n 1.8
+    1820300n 0
+    1820349n 0
+    1820350n 1.8
+    1820399n 1.8
+    1820400n 0
+    1820449n 0
+    1820450n 1.8
+    1820499n 1.8
+    1820500n 0
+    1820549n 0
+    1820550n 1.8
+    1820599n 1.8
+    1820600n 0
+    1820649n 0
+    1820650n 1.8
+    1820699n 1.8
+    1820700n 0
+    1820749n 0
+    1820750n 1.8
+    1820799n 1.8
+    1820800n 0
+    1820849n 0
+    1820850n 1.8
+    1820899n 1.8
+    1820900n 0
+    1820949n 0
+    1820950n 1.8
+    1820999n 1.8
+    1821000n 0
+    1821049n 0
+    1821050n 1.8
+    1821099n 1.8
+    1821100n 0
+    1821149n 0
+    1821150n 1.8
+    1821199n 1.8
+    1821200n 0
+    1821249n 0
+    1821250n 1.8
+    1821299n 1.8
+    1821300n 0
+    1821349n 0
+    1821350n 1.8
+    1821399n 1.8
+    1821400n 0
+    1821449n 0
+    1821450n 1.8
+    1821499n 1.8
+    1821500n 0
+    1821549n 0
+    1821550n 1.8
+    1821599n 1.8
+    1821600n 0
+    1821649n 0
+    1821650n 1.8
+    1821699n 1.8
+    1821700n 0
+    1821749n 0
+    1821750n 1.8
+    1821799n 1.8
+    1821800n 0
+    1821849n 0
+    1821850n 1.8
+    1821899n 1.8
+    1821900n 0
+    1821949n 0
+    1821950n 1.8
+    1821999n 1.8
+    1822000n 0
+    1822049n 0
+    1822050n 1.8
+    1822099n 1.8
+    1822100n 0
+    1822149n 0
+    1822150n 1.8
+    1822199n 1.8
+    1822200n 0
+    1822249n 0
+    1822250n 1.8
+    1822299n 1.8
+    1822300n 0
+    1822349n 0
+    1822350n 1.8
+    1822399n 1.8
+    1822400n 0
+    1822449n 0
+    1822450n 1.8
+    1822499n 1.8
+    1822500n 0
+    1822549n 0
+    1822550n 1.8
+    1822599n 1.8
+    1822600n 0
+    1822649n 0
+    1822650n 1.8
+    1822699n 1.8
+    1822700n 0
+    1822749n 0
+    1822750n 1.8
+    1822799n 1.8
+    1822800n 0
+    1822849n 0
+    1822850n 1.8
+    1822899n 1.8
+    1822900n 0
+    1822949n 0
+    1822950n 1.8
+    1822999n 1.8
+    1823000n 0
+    1823049n 0
+    1823050n 1.8
+    1823099n 1.8
+    1823100n 0
+    1823149n 0
+    1823150n 1.8
+    1823199n 1.8
+    1823200n 0
+    1823249n 0
+    1823250n 1.8
+    1823299n 1.8
+    1823300n 0
+    1823349n 0
+    1823350n 1.8
+    1823399n 1.8
+    1823400n 0
+    1823449n 0
+    1823450n 1.8
+    1823499n 1.8
+    1823500n 0
+    1823549n 0
+    1823550n 1.8
+    1823599n 1.8
+    1823600n 0
+    1823649n 0
+    1823650n 1.8
+    1823699n 1.8
+    1823700n 0
+    1823749n 0
+    1823750n 1.8
+    1823799n 1.8
+    1823800n 0
+    1823849n 0
+    1823850n 1.8
+    1823899n 1.8
+    1823900n 0
+    1823949n 0
+    1823950n 1.8
+    1823999n 1.8
+    1824000n 0
+    1824049n 0
+    1824050n 1.8
+    1824099n 1.8
+    1824100n 0
+    1824149n 0
+    1824150n 1.8
+    1824199n 1.8
+    1824200n 0
+    1824249n 0
+    1824250n 1.8
+    1824299n 1.8
+    1824300n 0
+    1824349n 0
+    1824350n 1.8
+    1824399n 1.8
+    1824400n 0
+    1824449n 0
+    1824450n 1.8
+    1824499n 1.8
+    1824500n 0
+    1824549n 0
+    1824550n 1.8
+    1824599n 1.8
+    1824600n 0
+    1824649n 0
+    1824650n 1.8
+    1824699n 1.8
+    1824700n 0
+    1824749n 0
+    1824750n 1.8
+    1824799n 1.8
+    1824800n 0
+    1824849n 0
+    1824850n 1.8
+    1824899n 1.8
+    1824900n 0
+    1824949n 0
+    1824950n 1.8
+    1824999n 1.8
+    1825000n 0
+    1825049n 0
+    1825050n 1.8
+    1825099n 1.8
+    1825100n 0
+    1825149n 0
+    1825150n 1.8
+    1825199n 1.8
+    1825200n 0
+    1825249n 0
+    1825250n 1.8
+    1825299n 1.8
+    1825300n 0
+    1825349n 0
+    1825350n 1.8
+    1825399n 1.8
+    1825400n 0
+    1825449n 0
+    1825450n 1.8
+    1825499n 1.8
+    1825500n 0
+    1825549n 0
+    1825550n 1.8
+    1825599n 1.8
+    1825600n 0
+    1825649n 0
+    1825650n 1.8
+    1825699n 1.8
+    1825700n 0
+    1825749n 0
+    1825750n 1.8
+    1825799n 1.8
+    1825800n 0
+    1825849n 0
+    1825850n 1.8
+    1825899n 1.8
+    1825900n 0
+    1825949n 0
+    1825950n 1.8
+    1825999n 1.8
+    1826000n 0
+    1826049n 0
+    1826050n 1.8
+    1826099n 1.8
+    1826100n 0
+    1826149n 0
+    1826150n 1.8
+    1826199n 1.8
+    1826200n 0
+    1826249n 0
+    1826250n 1.8
+    1826299n 1.8
+    1826300n 0
+    1826349n 0
+    1826350n 1.8
+    1826399n 1.8
+    1826400n 0
+    1826449n 0
+    1826450n 1.8
+    1826499n 1.8
+    1826500n 0
+    1826549n 0
+    1826550n 1.8
+    1826599n 1.8
+    1826600n 0
+    1826649n 0
+    1826650n 1.8
+    1826699n 1.8
+    1826700n 0
+    1826749n 0
+    1826750n 1.8
+    1826799n 1.8
+    1826800n 0
+    1826849n 0
+    1826850n 1.8
+    1826899n 1.8
+    1826900n 0
+    1826949n 0
+    1826950n 1.8
+    1826999n 1.8
+    1827000n 0
+    1827049n 0
+    1827050n 1.8
+    1827099n 1.8
+    1827100n 0
+    1827149n 0
+    1827150n 1.8
+    1827199n 1.8
+    1827200n 0
+    1827249n 0
+    1827250n 1.8
+    1827299n 1.8
+    1827300n 0
+    1827349n 0
+    1827350n 1.8
+    1827399n 1.8
+    1827400n 0
+    1827449n 0
+    1827450n 1.8
+    1827499n 1.8
+    1827500n 0
+    1827549n 0
+    1827550n 1.8
+    1827599n 1.8
+    1827600n 0
+    1827649n 0
+    1827650n 1.8
+    1827699n 1.8
+    1827700n 0
+    1827749n 0
+    1827750n 1.8
+    1827799n 1.8
+    1827800n 0
+    1827849n 0
+    1827850n 1.8
+    1827899n 1.8
+    1827900n 0
+    1827949n 0
+    1827950n 1.8
+    1827999n 1.8
+    1828000n 0
+    1828049n 0
+    1828050n 1.8
+    1828099n 1.8
+    1828100n 0
+    1828149n 0
+    1828150n 1.8
+    1828199n 1.8
+    1828200n 0
+    1828249n 0
+    1828250n 1.8
+    1828299n 1.8
+    1828300n 0
+    1828349n 0
+    1828350n 1.8
+    1828399n 1.8
+    1828400n 0
+    1828449n 0
+    1828450n 1.8
+    1828499n 1.8
+    1828500n 0
+    1828549n 0
+    1828550n 1.8
+    1828599n 1.8
+    1828600n 0
+    1828649n 0
+    1828650n 1.8
+    1828699n 1.8
+    1828700n 0
+    1828749n 0
+    1828750n 1.8
+    1828799n 1.8
+    1828800n 0
+    1828849n 0
+    1828850n 1.8
+    1828899n 1.8
+    1828900n 0
+    1828949n 0
+    1828950n 1.8
+    1828999n 1.8
+    1829000n 0
+    1829049n 0
+    1829050n 1.8
+    1829099n 1.8
+    1829100n 0
+    1829149n 0
+    1829150n 1.8
+    1829199n 1.8
+    1829200n 0
+    1829249n 0
+    1829250n 1.8
+    1829299n 1.8
+    1829300n 0
+    1829349n 0
+    1829350n 1.8
+    1829399n 1.8
+    1829400n 0
+    1829449n 0
+    1829450n 1.8
+    1829499n 1.8
+    1829500n 0
+    1829549n 0
+    1829550n 1.8
+    1829599n 1.8
+    1829600n 0
+    1829649n 0
+    1829650n 1.8
+    1829699n 1.8
+    1829700n 0
+    1829749n 0
+    1829750n 1.8
+    1829799n 1.8
+    1829800n 0
+    1829849n 0
+    1829850n 1.8
+    1829899n 1.8
+    1829900n 0
+    1829949n 0
+    1829950n 1.8
+    1829999n 1.8
+    1830000n 0
+    1830049n 0
+    1830050n 1.8
+    1830099n 1.8
+    1830100n 0
+    1830149n 0
+    1830150n 1.8
+    1830199n 1.8
+    1830200n 0
+    1830249n 0
+    1830250n 1.8
+    1830299n 1.8
+    1830300n 0
+    1830349n 0
+    1830350n 1.8
+    1830399n 1.8
+    1830400n 0
+    1830449n 0
+    1830450n 1.8
+    1830499n 1.8
+    1830500n 0
+    1830549n 0
+    1830550n 1.8
+    1830599n 1.8
+    1830600n 0
+    1830649n 0
+    1830650n 1.8
+    1830699n 1.8
+    1830700n 0
+    1830749n 0
+    1830750n 1.8
+    1830799n 1.8
+    1830800n 0
+    1830849n 0
+    1830850n 1.8
+    1830899n 1.8
+    1830900n 0
+    1830949n 0
+    1830950n 1.8
+    1830999n 1.8
+    1831000n 0
+    1831049n 0
+    1831050n 1.8
+    1831099n 1.8
+    1831100n 0
+    1831149n 0
+    1831150n 1.8
+    1831199n 1.8
+    1831200n 0
+    1831249n 0
+    1831250n 1.8
+    1831299n 1.8
+    1831300n 0
+    1831349n 0
+    1831350n 1.8
+    1831399n 1.8
+    1831400n 0
+    1831449n 0
+    1831450n 1.8
+    1831499n 1.8
+    1831500n 0
+    1831549n 0
+    1831550n 1.8
+    1831599n 1.8
+    1831600n 0
+    1831649n 0
+    1831650n 1.8
+    1831699n 1.8
+    1831700n 0
+    1831749n 0
+    1831750n 1.8
+    1831799n 1.8
+    1831800n 0
+    1831849n 0
+    1831850n 1.8
+    1831899n 1.8
+    1831900n 0
+    1831949n 0
+    1831950n 1.8
+    1831999n 1.8
+    1832000n 0
+    1832049n 0
+    1832050n 1.8
+    1832099n 1.8
+    1832100n 0
+    1832149n 0
+    1832150n 1.8
+    1832199n 1.8
+    1832200n 0
+    1832249n 0
+    1832250n 1.8
+    1832299n 1.8
+    1832300n 0
+    1832349n 0
+    1832350n 1.8
+    1832399n 1.8
+    1832400n 0
+    1832449n 0
+    1832450n 1.8
+    1832499n 1.8
+    1832500n 0
+    1832549n 0
+    1832550n 1.8
+    1832599n 1.8
+    1832600n 0
+    1832649n 0
+    1832650n 1.8
+    1832699n 1.8
+    1832700n 0
+    1832749n 0
+    1832750n 1.8
+    1832799n 1.8
+    1832800n 0
+    1832849n 0
+    1832850n 1.8
+    1832899n 1.8
+    1832900n 0
+    1832949n 0
+    1832950n 1.8
+    1832999n 1.8
+    1833000n 0
+    1833049n 0
+    1833050n 1.8
+    1833099n 1.8
+    1833100n 0
+    1833149n 0
+    1833150n 1.8
+    1833199n 1.8
+    1833200n 0
+    1833249n 0
+    1833250n 1.8
+    1833299n 1.8
+    1833300n 0
+    1833349n 0
+    1833350n 1.8
+    1833399n 1.8
+    1833400n 0
+    1833449n 0
+    1833450n 1.8
+    1833499n 1.8
+    1833500n 0
+    1833549n 0
+    1833550n 1.8
+    1833599n 1.8
+    1833600n 0
+    1833649n 0
+    1833650n 1.8
+    1833699n 1.8
+    1833700n 0
+    1833749n 0
+    1833750n 1.8
+    1833799n 1.8
+    1833800n 0
+    1833849n 0
+    1833850n 1.8
+    1833899n 1.8
+    1833900n 0
+    1833949n 0
+    1833950n 1.8
+    1833999n 1.8
+    1834000n 0
+    1834049n 0
+    1834050n 1.8
+    1834099n 1.8
+    1834100n 0
+    1834149n 0
+    1834150n 1.8
+    1834199n 1.8
+    1834200n 0
+    1834249n 0
+    1834250n 1.8
+    1834299n 1.8
+    1834300n 0
+    1834349n 0
+    1834350n 1.8
+    1834399n 1.8
+    1834400n 0
+    1834449n 0
+    1834450n 1.8
+    1834499n 1.8
+    1834500n 0
+    1834549n 0
+    1834550n 1.8
+    1834599n 1.8
+    1834600n 0
+    1834649n 0
+    1834650n 1.8
+    1834699n 1.8
+    1834700n 0
+    1834749n 0
+    1834750n 1.8
+    1834799n 1.8
+    1834800n 0
+    1834849n 0
+    1834850n 1.8
+    1834899n 1.8
+    1834900n 0
+    1834949n 0
+    1834950n 1.8
+    1834999n 1.8
+    1835000n 0
+    1835049n 0
+    1835050n 1.8
+    1835099n 1.8
+    1835100n 0
+    1835149n 0
+    1835150n 1.8
+    1835199n 1.8
+    1835200n 0
+    1835249n 0
+    1835250n 1.8
+    1835299n 1.8
+    1835300n 0
+    1835349n 0
+    1835350n 1.8
+    1835399n 1.8
+    1835400n 0
+    1835449n 0
+    1835450n 1.8
+    1835499n 1.8
+    1835500n 0
+    1835549n 0
+    1835550n 1.8
+    1835599n 1.8
+    1835600n 0
+    1835649n 0
+    1835650n 1.8
+    1835699n 1.8
+    1835700n 0
+    1835749n 0
+    1835750n 1.8
+    1835799n 1.8
+    1835800n 0
+    1835849n 0
+    1835850n 1.8
+    1835899n 1.8
+    1835900n 0
+    1835949n 0
+    1835950n 1.8
+    1835999n 1.8
+    1836000n 0
+    1836049n 0
+    1836050n 1.8
+    1836099n 1.8
+    1836100n 0
+    1836149n 0
+    1836150n 1.8
+    1836199n 1.8
+    1836200n 0
+    1836249n 0
+    1836250n 1.8
+    1836299n 1.8
+    1836300n 0
+    1836349n 0
+    1836350n 1.8
+    1836399n 1.8
+    1836400n 0
+    1836449n 0
+    1836450n 1.8
+    1836499n 1.8
+    1836500n 0
+    1836549n 0
+    1836550n 1.8
+    1836599n 1.8
+    1836600n 0
+    1836649n 0
+    1836650n 1.8
+    1836699n 1.8
+    1836700n 0
+    1836749n 0
+    1836750n 1.8
+    1836799n 1.8
+    1836800n 0
+    1836849n 0
+    1836850n 1.8
+    1836899n 1.8
+    1836900n 0
+    1836949n 0
+    1836950n 1.8
+    1836999n 1.8
+    1837000n 0
+    1837049n 0
+    1837050n 1.8
+    1837099n 1.8
+    1837100n 0
+    1837149n 0
+    1837150n 1.8
+    1837199n 1.8
+    1837200n 0
+    1837249n 0
+    1837250n 1.8
+    1837299n 1.8
+    1837300n 0
+    1837349n 0
+    1837350n 1.8
+    1837399n 1.8
+    1837400n 0
+    1837449n 0
+    1837450n 1.8
+    1837499n 1.8
+    1837500n 0
+    1837549n 0
+    1837550n 1.8
+    1837599n 1.8
+    1837600n 0
+    1837649n 0
+    1837650n 1.8
+    1837699n 1.8
+    1837700n 0
+    1837749n 0
+    1837750n 1.8
+    1837799n 1.8
+    1837800n 0
+    1837849n 0
+    1837850n 1.8
+    1837899n 1.8
+    1837900n 0
+    1837949n 0
+    1837950n 1.8
+    1837999n 1.8
+    1838000n 0
+    1838049n 0
+    1838050n 1.8
+    1838099n 1.8
+    1838100n 0
+    1838149n 0
+    1838150n 1.8
+    1838199n 1.8
+    1838200n 0
+    1838249n 0
+    1838250n 1.8
+    1838299n 1.8
+    1838300n 0
+    1838349n 0
+    1838350n 1.8
+    1838399n 1.8
+    1838400n 0
+    1838449n 0
+    1838450n 1.8
+    1838499n 1.8
+    1838500n 0
+    1838549n 0
+    1838550n 1.8
+    1838599n 1.8
+    1838600n 0
+    1838649n 0
+    1838650n 1.8
+    1838699n 1.8
+    1838700n 0
+    1838749n 0
+    1838750n 1.8
+    1838799n 1.8
+    1838800n 0
+    1838849n 0
+    1838850n 1.8
+    1838899n 1.8
+    1838900n 0
+    1838949n 0
+    1838950n 1.8
+    1838999n 1.8
+    1839000n 0
+    1839049n 0
+    1839050n 1.8
+    1839099n 1.8
+    1839100n 0
+    1839149n 0
+    1839150n 1.8
+    1839199n 1.8
+    1839200n 0
+    1839249n 0
+    1839250n 1.8
+    1839299n 1.8
+    1839300n 0
+    1839349n 0
+    1839350n 1.8
+    1839399n 1.8
+    1839400n 0
+    1839449n 0
+    1839450n 1.8
+    1839499n 1.8
+    1839500n 0
+    1839549n 0
+    1839550n 1.8
+    1839599n 1.8
+    1839600n 0
+    1839649n 0
+    1839650n 1.8
+    1839699n 1.8
+    1839700n 0
+    1839749n 0
+    1839750n 1.8
+    1839799n 1.8
+    1839800n 0
+    1839849n 0
+    1839850n 1.8
+    1839899n 1.8
+    1839900n 0
+    1839949n 0
+    1839950n 1.8
+    1839999n 1.8
+    1840000n 0
+    1840049n 0
+    1840050n 1.8
+    1840099n 1.8
+    1840100n 0
+    1840149n 0
+    1840150n 1.8
+    1840199n 1.8
+    1840200n 0
+    1840249n 0
+    1840250n 1.8
+    1840299n 1.8
+    1840300n 0
+    1840349n 0
+    1840350n 1.8
+    1840399n 1.8
+    1840400n 0
+    1840449n 0
+    1840450n 1.8
+    1840499n 1.8
+    1840500n 0
+    1840549n 0
+    1840550n 1.8
+    1840599n 1.8
+    1840600n 0
+    1840649n 0
+    1840650n 1.8
+    1840699n 1.8
+    1840700n 0
+    1840749n 0
+    1840750n 1.8
+    1840799n 1.8
+    1840800n 0
+    1840849n 0
+    1840850n 1.8
+    1840899n 1.8
+    1840900n 0
+    1840949n 0
+    1840950n 1.8
+    1840999n 1.8
+    1841000n 0
+    1841049n 0
+    1841050n 1.8
+    1841099n 1.8
+    1841100n 0
+    1841149n 0
+    1841150n 1.8
+    1841199n 1.8
+    1841200n 0
+    1841249n 0
+    1841250n 1.8
+    1841299n 1.8
+    1841300n 0
+    1841349n 0
+    1841350n 1.8
+    1841399n 1.8
+    1841400n 0
+    1841449n 0
+    1841450n 1.8
+    1841499n 1.8
+    1841500n 0
+    1841549n 0
+    1841550n 1.8
+    1841599n 1.8
+    1841600n 0
+    1841649n 0
+    1841650n 1.8
+    1841699n 1.8
+    1841700n 0
+    1841749n 0
+    1841750n 1.8
+    1841799n 1.8
+    1841800n 0
+    1841849n 0
+    1841850n 1.8
+    1841899n 1.8
+    1841900n 0
+    1841949n 0
+    1841950n 1.8
+    1841999n 1.8
+    1842000n 0
+    1842049n 0
+    1842050n 1.8
+    1842099n 1.8
+    1842100n 0
+    1842149n 0
+    1842150n 1.8
+    1842199n 1.8
+    1842200n 0
+    1842249n 0
+    1842250n 1.8
+    1842299n 1.8
+    1842300n 0
+    1842349n 0
+    1842350n 1.8
+    1842399n 1.8
+    1842400n 0
+    1842449n 0
+    1842450n 1.8
+    1842499n 1.8
+    1842500n 0
+    1842549n 0
+    1842550n 1.8
+    1842599n 1.8
+    1842600n 0
+    1842649n 0
+    1842650n 1.8
+    1842699n 1.8
+    1842700n 0
+    1842749n 0
+    1842750n 1.8
+    1842799n 1.8
+    1842800n 0
+    1842849n 0
+    1842850n 1.8
+    1842899n 1.8
+    1842900n 0
+    1842949n 0
+    1842950n 1.8
+    1842999n 1.8
+    1843000n 0
+    1843049n 0
+    1843050n 1.8
+    1843099n 1.8
+    1843100n 0
+    1843149n 0
+    1843150n 1.8
+    1843199n 1.8
+    1843200n 0
+    1843249n 0
+    1843250n 1.8
+    1843299n 1.8
+    1843300n 0
+    1843349n 0
+    1843350n 1.8
+    1843399n 1.8
+    1843400n 0
+    1843449n 0
+    1843450n 1.8
+    1843499n 1.8
+    1843500n 0
+    1843549n 0
+    1843550n 1.8
+    1843599n 1.8
+    1843600n 0
+    1843649n 0
+    1843650n 1.8
+    1843699n 1.8
+    1843700n 0
+    1843749n 0
+    1843750n 1.8
+    1843799n 1.8
+    1843800n 0
+    1843849n 0
+    1843850n 1.8
+    1843899n 1.8
+    1843900n 0
+    1843949n 0
+    1843950n 1.8
+    1843999n 1.8
+    1844000n 0
+    1844049n 0
+    1844050n 1.8
+    1844099n 1.8
+    1844100n 0
+    1844149n 0
+    1844150n 1.8
+    1844199n 1.8
+    1844200n 0
+    1844249n 0
+    1844250n 1.8
+    1844299n 1.8
+    1844300n 0
+    1844349n 0
+    1844350n 1.8
+    1844399n 1.8
+    1844400n 0
+    1844449n 0
+    1844450n 1.8
+    1844499n 1.8
+    1844500n 0
+    1844549n 0
+    1844550n 1.8
+    1844599n 1.8
+    1844600n 0
+    1844649n 0
+    1844650n 1.8
+    1844699n 1.8
+    1844700n 0
+    1844749n 0
+    1844750n 1.8
+    1844799n 1.8
+    1844800n 0
+    1844849n 0
+    1844850n 1.8
+    1844899n 1.8
+    1844900n 0
+    1844949n 0
+    1844950n 1.8
+    1844999n 1.8
+    1845000n 0
+    1845049n 0
+    1845050n 1.8
+    1845099n 1.8
+    1845100n 0
+    1845149n 0
+    1845150n 1.8
+    1845199n 1.8
+    1845200n 0
+    1845249n 0
+    1845250n 1.8
+    1845299n 1.8
+    1845300n 0
+    1845349n 0
+    1845350n 1.8
+    1845399n 1.8
+    1845400n 0
+    1845449n 0
+    1845450n 1.8
+    1845499n 1.8
+    1845500n 0
+    1845549n 0
+    1845550n 1.8
+    1845599n 1.8
+    1845600n 0
+    1845649n 0
+    1845650n 1.8
+    1845699n 1.8
+    1845700n 0
+    1845749n 0
+    1845750n 1.8
+    1845799n 1.8
+    1845800n 0
+    1845849n 0
+    1845850n 1.8
+    1845899n 1.8
+    1845900n 0
+    1845949n 0
+    1845950n 1.8
+    1845999n 1.8
+    1846000n 0
+    1846049n 0
+    1846050n 1.8
+    1846099n 1.8
+    1846100n 0
+    1846149n 0
+    1846150n 1.8
+    1846199n 1.8
+    1846200n 0
+    1846249n 0
+    1846250n 1.8
+    1846299n 1.8
+    1846300n 0
+    1846349n 0
+    1846350n 1.8
+    1846399n 1.8
+    1846400n 0
+    1846449n 0
+    1846450n 1.8
+    1846499n 1.8
+    1846500n 0
+    1846549n 0
+    1846550n 1.8
+    1846599n 1.8
+    1846600n 0
+    1846649n 0
+    1846650n 1.8
+    1846699n 1.8
+    1846700n 0
+    1846749n 0
+    1846750n 1.8
+    1846799n 1.8
+    1846800n 0
+    1846849n 0
+    1846850n 1.8
+    1846899n 1.8
+    1846900n 0
+    1846949n 0
+    1846950n 1.8
+    1846999n 1.8
+    1847000n 0
+    1847049n 0
+    1847050n 1.8
+    1847099n 1.8
+    1847100n 0
+    1847149n 0
+    1847150n 1.8
+    1847199n 1.8
+    1847200n 0
+    1847249n 0
+    1847250n 1.8
+    1847299n 1.8
+    1847300n 0
+    1847349n 0
+    1847350n 1.8
+    1847399n 1.8
+    1847400n 0
+    1847449n 0
+    1847450n 1.8
+    1847499n 1.8
+    1847500n 0
+    1847549n 0
+    1847550n 1.8
+    1847599n 1.8
+    1847600n 0
+    1847649n 0
+    1847650n 1.8
+    1847699n 1.8
+    1847700n 0
+    1847749n 0
+    1847750n 1.8
+    1847799n 1.8
+    1847800n 0
+    1847849n 0
+    1847850n 1.8
+    1847899n 1.8
+    1847900n 0
+    1847949n 0
+    1847950n 1.8
+    1847999n 1.8
+    1848000n 0
+    1848049n 0
+    1848050n 1.8
+    1848099n 1.8
+    1848100n 0
+    1848149n 0
+    1848150n 1.8
+    1848199n 1.8
+    1848200n 0
+    1848249n 0
+    1848250n 1.8
+    1848299n 1.8
+    1848300n 0
+    1848349n 0
+    1848350n 1.8
+    1848399n 1.8
+    1848400n 0
+    1848449n 0
+    1848450n 1.8
+    1848499n 1.8
+    1848500n 0
+    1848549n 0
+    1848550n 1.8
+    1848599n 1.8
+    1848600n 0
+    1848649n 0
+    1848650n 1.8
+    1848699n 1.8
+    1848700n 0
+    1848749n 0
+    1848750n 1.8
+    1848799n 1.8
+    1848800n 0
+    1848849n 0
+    1848850n 1.8
+    1848899n 1.8
+    1848900n 0
+    1848949n 0
+    1848950n 1.8
+    1848999n 1.8
+    1849000n 0
+    1849049n 0
+    1849050n 1.8
+    1849099n 1.8
+    1849100n 0
+    1849149n 0
+    1849150n 1.8
+    1849199n 1.8
+    1849200n 0
+    1849249n 0
+    1849250n 1.8
+    1849299n 1.8
+    1849300n 0
+    1849349n 0
+    1849350n 1.8
+    1849399n 1.8
+    1849400n 0
+    1849449n 0
+    1849450n 1.8
+    1849499n 1.8
+    1849500n 0
+    1849549n 0
+    1849550n 1.8
+    1849599n 1.8
+    1849600n 0
+    1849649n 0
+    1849650n 1.8
+    1849699n 1.8
+    1849700n 0
+    1849749n 0
+    1849750n 1.8
+    1849799n 1.8
+    1849800n 0
+    1849849n 0
+    1849850n 1.8
+    1849899n 1.8
+    1849900n 0
+    1849949n 0
+    1849950n 1.8
+    1849999n 1.8
+    1850000n 0
+    1850049n 0
+    1850050n 1.8
+    1850099n 1.8
+    1850100n 0
+    1850149n 0
+    1850150n 1.8
+    1850199n 1.8
+    1850200n 0
+    1850249n 0
+    1850250n 1.8
+    1850299n 1.8
+    1850300n 0
+    1850349n 0
+    1850350n 1.8
+    1850399n 1.8
+    1850400n 0
+    1850449n 0
+    1850450n 1.8
+    1850499n 1.8
+    1850500n 0
+    1850549n 0
+    1850550n 1.8
+    1850599n 1.8
+    1850600n 0
+    1850649n 0
+    1850650n 1.8
+    1850699n 1.8
+    1850700n 0
+    1850749n 0
+    1850750n 1.8
+    1850799n 1.8
+    1850800n 0
+    1850849n 0
+    1850850n 1.8
+    1850899n 1.8
+    1850900n 0
+    1850949n 0
+    1850950n 1.8
+    1850999n 1.8
+    1851000n 0
+    1851049n 0
+    1851050n 1.8
+    1851099n 1.8
+    1851100n 0
+    1851149n 0
+    1851150n 1.8
+    1851199n 1.8
+    1851200n 0
+    1851249n 0
+    1851250n 1.8
+    1851299n 1.8
+    1851300n 0
+    1851349n 0
+    1851350n 1.8
+    1851399n 1.8
+    1851400n 0
+    1851449n 0
+    1851450n 1.8
+    1851499n 1.8
+    1851500n 0
+    1851549n 0
+    1851550n 1.8
+    1851599n 1.8
+    1851600n 0
+    1851649n 0
+    1851650n 1.8
+    1851699n 1.8
+    1851700n 0
+    1851749n 0
+    1851750n 1.8
+    1851799n 1.8
+    1851800n 0
+    1851849n 0
+    1851850n 1.8
+    1851899n 1.8
+    1851900n 0
+    1851949n 0
+    1851950n 1.8
+    1851999n 1.8
+    1852000n 0
+    1852049n 0
+    1852050n 1.8
+    1852099n 1.8
+    1852100n 0
+    1852149n 0
+    1852150n 1.8
+    1852199n 1.8
+    1852200n 0
+    1852249n 0
+    1852250n 1.8
+    1852299n 1.8
+    1852300n 0
+    1852349n 0
+    1852350n 1.8
+    1852399n 1.8
+    1852400n 0
+    1852449n 0
+    1852450n 1.8
+    1852499n 1.8
+    1852500n 0
+    1852549n 0
+    1852550n 1.8
+    1852599n 1.8
+    1852600n 0
+    1852649n 0
+    1852650n 1.8
+    1852699n 1.8
+    1852700n 0
+    1852749n 0
+    1852750n 1.8
+    1852799n 1.8
+    1852800n 0
+    1852849n 0
+    1852850n 1.8
+    1852899n 1.8
+    1852900n 0
+    1852949n 0
+    1852950n 1.8
+    1852999n 1.8
+    1853000n 0
+    1853049n 0
+    1853050n 1.8
+    1853099n 1.8
+    1853100n 0
+    1853149n 0
+    1853150n 1.8
+    1853199n 1.8
+    1853200n 0
+    1853249n 0
+    1853250n 1.8
+    1853299n 1.8
+    1853300n 0
+    1853349n 0
+    1853350n 1.8
+    1853399n 1.8
+    1853400n 0
+    1853449n 0
+    1853450n 1.8
+    1853499n 1.8
+    1853500n 0
+    1853549n 0
+    1853550n 1.8
+    1853599n 1.8
+    1853600n 0
+    1853649n 0
+    1853650n 1.8
+    1853699n 1.8
+    1853700n 0
+    1853749n 0
+    1853750n 1.8
+    1853799n 1.8
+    1853800n 0
+    1853849n 0
+    1853850n 1.8
+    1853899n 1.8
+    1853900n 0
+    1853949n 0
+    1853950n 1.8
+    1853999n 1.8
+    1854000n 0
+    1854049n 0
+    1854050n 1.8
+    1854099n 1.8
+    1854100n 0
+    1854149n 0
+    1854150n 1.8
+    1854199n 1.8
+    1854200n 0
+    1854249n 0
+    1854250n 1.8
+    1854299n 1.8
+    1854300n 0
+    1854349n 0
+    1854350n 1.8
+    1854399n 1.8
+    1854400n 0
+    1854449n 0
+    1854450n 1.8
+    1854499n 1.8
+    1854500n 0
+    1854549n 0
+    1854550n 1.8
+    1854599n 1.8
+    1854600n 0
+    1854649n 0
+    1854650n 1.8
+    1854699n 1.8
+    1854700n 0
+    1854749n 0
+    1854750n 1.8
+    1854799n 1.8
+    1854800n 0
+    1854849n 0
+    1854850n 1.8
+    1854899n 1.8
+    1854900n 0
+    1854949n 0
+    1854950n 1.8
+    1854999n 1.8
+    1855000n 0
+    1855049n 0
+    1855050n 1.8
+    1855099n 1.8
+    1855100n 0
+    1855149n 0
+    1855150n 1.8
+    1855199n 1.8
+    1855200n 0
+    1855249n 0
+    1855250n 1.8
+    1855299n 1.8
+    1855300n 0
+    1855349n 0
+    1855350n 1.8
+    1855399n 1.8
+    1855400n 0
+    1855449n 0
+    1855450n 1.8
+    1855499n 1.8
+    1855500n 0
+    1855549n 0
+    1855550n 1.8
+    1855599n 1.8
+    1855600n 0
+    1855649n 0
+    1855650n 1.8
+    1855699n 1.8
+    1855700n 0
+    1855749n 0
+    1855750n 1.8
+    1855799n 1.8
+    1855800n 0
+    1855849n 0
+    1855850n 1.8
+    1855899n 1.8
+    1855900n 0
+    1855949n 0
+    1855950n 1.8
+    1855999n 1.8
+    1856000n 0
+    1856049n 0
+    1856050n 1.8
+    1856099n 1.8
+    1856100n 0
+    1856149n 0
+    1856150n 1.8
+    1856199n 1.8
+    1856200n 0
+    1856249n 0
+    1856250n 1.8
+    1856299n 1.8
+    1856300n 0
+    1856349n 0
+    1856350n 1.8
+    1856399n 1.8
+    1856400n 0
+    1856449n 0
+    1856450n 1.8
+    1856499n 1.8
+    1856500n 0
+    1856549n 0
+    1856550n 1.8
+    1856599n 1.8
+    1856600n 0
+    1856649n 0
+    1856650n 1.8
+    1856699n 1.8
+    1856700n 0
+    1856749n 0
+    1856750n 1.8
+    1856799n 1.8
+    1856800n 0
+    1856849n 0
+    1856850n 1.8
+    1856899n 1.8
+    1856900n 0
+    1856949n 0
+    1856950n 1.8
+    1856999n 1.8
+    1857000n 0
+    1857049n 0
+    1857050n 1.8
+    1857099n 1.8
+    1857100n 0
+    1857149n 0
+    1857150n 1.8
+    1857199n 1.8
+    1857200n 0
+    1857249n 0
+    1857250n 1.8
+    1857299n 1.8
+    1857300n 0
+    1857349n 0
+    1857350n 1.8
+    1857399n 1.8
+    1857400n 0
+    1857449n 0
+    1857450n 1.8
+    1857499n 1.8
+    1857500n 0
+    1857549n 0
+    1857550n 1.8
+    1857599n 1.8
+    1857600n 0
+    1857649n 0
+    1857650n 1.8
+    1857699n 1.8
+    1857700n 0
+    1857749n 0
+    1857750n 1.8
+    1857799n 1.8
+    1857800n 0
+    1857849n 0
+    1857850n 1.8
+    1857899n 1.8
+    1857900n 0
+    1857949n 0
+    1857950n 1.8
+    1857999n 1.8
+    1858000n 0
+    1858049n 0
+    1858050n 1.8
+    1858099n 1.8
+    1858100n 0
+    1858149n 0
+    1858150n 1.8
+    1858199n 1.8
+    1858200n 0
+    1858249n 0
+    1858250n 1.8
+    1858299n 1.8
+    1858300n 0
+    1858349n 0
+    1858350n 1.8
+    1858399n 1.8
+    1858400n 0
+    1858449n 0
+    1858450n 1.8
+    1858499n 1.8
+    1858500n 0
+    1858549n 0
+    1858550n 1.8
+    1858599n 1.8
+    1858600n 0
+    1858649n 0
+    1858650n 1.8
+    1858699n 1.8
+    1858700n 0
+    1858749n 0
+    1858750n 1.8
+    1858799n 1.8
+    1858800n 0
+    1858849n 0
+    1858850n 1.8
+    1858899n 1.8
+    1858900n 0
+    1858949n 0
+    1858950n 1.8
+    1858999n 1.8
+    1859000n 0
+    1859049n 0
+    1859050n 1.8
+    1859099n 1.8
+    1859100n 0
+    1859149n 0
+    1859150n 1.8
+    1859199n 1.8
+    1859200n 0
+    1859249n 0
+    1859250n 1.8
+    1859299n 1.8
+    1859300n 0
+    1859349n 0
+    1859350n 1.8
+    1859399n 1.8
+    1859400n 0
+    1859449n 0
+    1859450n 1.8
+    1859499n 1.8
+    1859500n 0
+    1859549n 0
+    1859550n 1.8
+    1859599n 1.8
+    1859600n 0
+    1859649n 0
+    1859650n 1.8
+    1859699n 1.8
+    1859700n 0
+    1859749n 0
+    1859750n 1.8
+    1859799n 1.8
+    1859800n 0
+    1859849n 0
+    1859850n 1.8
+    1859899n 1.8
+    1859900n 0
+    1859949n 0
+    1859950n 1.8
+    1859999n 1.8
+    1860000n 0
+    1860049n 0
+    1860050n 1.8
+    1860099n 1.8
+    1860100n 0
+    1860149n 0
+    1860150n 1.8
+    1860199n 1.8
+    1860200n 0
+    1860249n 0
+    1860250n 1.8
+    1860299n 1.8
+    1860300n 0
+    1860349n 0
+    1860350n 1.8
+    1860399n 1.8
+    1860400n 0
+    1860449n 0
+    1860450n 1.8
+    1860499n 1.8
+    1860500n 0
+    1860549n 0
+    1860550n 1.8
+    1860599n 1.8
+    1860600n 0
+    1860649n 0
+    1860650n 1.8
+    1860699n 1.8
+    1860700n 0
+    1860749n 0
+    1860750n 1.8
+    1860799n 1.8
+    1860800n 0
+    1860849n 0
+    1860850n 1.8
+    1860899n 1.8
+    1860900n 0
+    1860949n 0
+    1860950n 1.8
+    1860999n 1.8
+    1861000n 0
+    1861049n 0
+    1861050n 1.8
+    1861099n 1.8
+    1861100n 0
+    1861149n 0
+    1861150n 1.8
+    1861199n 1.8
+    1861200n 0
+    1861249n 0
+    1861250n 1.8
+    1861299n 1.8
+    1861300n 0
+    1861349n 0
+    1861350n 1.8
+    1861399n 1.8
+    1861400n 0
+    1861449n 0
+    1861450n 1.8
+    1861499n 1.8
+    1861500n 0
+    1861549n 0
+    1861550n 1.8
+    1861599n 1.8
+    1861600n 0
+    1861649n 0
+    1861650n 1.8
+    1861699n 1.8
+    1861700n 0
+    1861749n 0
+    1861750n 1.8
+    1861799n 1.8
+    1861800n 0
+    1861849n 0
+    1861850n 1.8
+    1861899n 1.8
+    1861900n 0
+    1861949n 0
+    1861950n 1.8
+    1861999n 1.8
+    1862000n 0
+    1862049n 0
+    1862050n 1.8
+    1862099n 1.8
+    1862100n 0
+    1862149n 0
+    1862150n 1.8
+    1862199n 1.8
+    1862200n 0
+    1862249n 0
+    1862250n 1.8
+    1862299n 1.8
+    1862300n 0
+    1862349n 0
+    1862350n 1.8
+    1862399n 1.8
+    1862400n 0
+    1862449n 0
+    1862450n 1.8
+    1862499n 1.8
+    1862500n 0
+    1862549n 0
+    1862550n 1.8
+    1862599n 1.8
+    1862600n 0
+    1862649n 0
+    1862650n 1.8
+    1862699n 1.8
+    1862700n 0
+    1862749n 0
+    1862750n 1.8
+    1862799n 1.8
+    1862800n 0
+    1862849n 0
+    1862850n 1.8
+    1862899n 1.8
+    1862900n 0
+    1862949n 0
+    1862950n 1.8
+    1862999n 1.8
+    1863000n 0
+    1863049n 0
+    1863050n 1.8
+    1863099n 1.8
+    1863100n 0
+    1863149n 0
+    1863150n 1.8
+    1863199n 1.8
+    1863200n 0
+    1863249n 0
+    1863250n 1.8
+    1863299n 1.8
+    1863300n 0
+    1863349n 0
+    1863350n 1.8
+    1863399n 1.8
+    1863400n 0
+    1863449n 0
+    1863450n 1.8
+    1863499n 1.8
+    1863500n 0
+    1863549n 0
+    1863550n 1.8
+    1863599n 1.8
+    1863600n 0
+    1863649n 0
+    1863650n 1.8
+    1863699n 1.8
+    1863700n 0
+    1863749n 0
+    1863750n 1.8
+    1863799n 1.8
+    1863800n 0
+    1863849n 0
+    1863850n 1.8
+    1863899n 1.8
+    1863900n 0
+    1863949n 0
+    1863950n 1.8
+    1863999n 1.8
+    1864000n 0
+    1864049n 0
+    1864050n 1.8
+    1864099n 1.8
+    1864100n 0
+    1864149n 0
+    1864150n 1.8
+    1864199n 1.8
+    1864200n 0
+    1864249n 0
+    1864250n 1.8
+    1864299n 1.8
+    1864300n 0
+    1864349n 0
+    1864350n 1.8
+    1864399n 1.8
+    1864400n 0
+    1864449n 0
+    1864450n 1.8
+    1864499n 1.8
+    1864500n 0
+    1864549n 0
+    1864550n 1.8
+    1864599n 1.8
+    1864600n 0
+    1864649n 0
+    1864650n 1.8
+    1864699n 1.8
+    1864700n 0
+    1864749n 0
+    1864750n 1.8
+    1864799n 1.8
+    1864800n 0
+    1864849n 0
+    1864850n 1.8
+    1864899n 1.8
+    1864900n 0
+    1864949n 0
+    1864950n 1.8
+    1864999n 1.8
+    1865000n 0
+    1865049n 0
+    1865050n 1.8
+    1865099n 1.8
+    1865100n 0
+    1865149n 0
+    1865150n 1.8
+    1865199n 1.8
+    1865200n 0
+    1865249n 0
+    1865250n 1.8
+    1865299n 1.8
+    1865300n 0
+    1865349n 0
+    1865350n 1.8
+    1865399n 1.8
+    1865400n 0
+    1865449n 0
+    1865450n 1.8
+    1865499n 1.8
+    1865500n 0
+    1865549n 0
+    1865550n 1.8
+    1865599n 1.8
+    1865600n 0
+    1865649n 0
+    1865650n 1.8
+    1865699n 1.8
+    1865700n 0
+    1865749n 0
+    1865750n 1.8
+    1865799n 1.8
+    1865800n 0
+    1865849n 0
+    1865850n 1.8
+    1865899n 1.8
+    1865900n 0
+    1865949n 0
+    1865950n 1.8
+    1865999n 1.8
+    1866000n 0
+    1866049n 0
+    1866050n 1.8
+    1866099n 1.8
+    1866100n 0
+    1866149n 0
+    1866150n 1.8
+    1866199n 1.8
+    1866200n 0
+    1866249n 0
+    1866250n 1.8
+    1866299n 1.8
+    1866300n 0
+    1866349n 0
+    1866350n 1.8
+    1866399n 1.8
+    1866400n 0
+    1866449n 0
+    1866450n 1.8
+    1866499n 1.8
+    1866500n 0
+    1866549n 0
+    1866550n 1.8
+    1866599n 1.8
+    1866600n 0
+    1866649n 0
+    1866650n 1.8
+    1866699n 1.8
+    1866700n 0
+    1866749n 0
+    1866750n 1.8
+    1866799n 1.8
+    1866800n 0
+    1866849n 0
+    1866850n 1.8
+    1866899n 1.8
+    1866900n 0
+    1866949n 0
+    1866950n 1.8
+    1866999n 1.8
+    1867000n 0
+    1867049n 0
+    1867050n 1.8
+    1867099n 1.8
+    1867100n 0
+    1867149n 0
+    1867150n 1.8
+    1867199n 1.8
+    1867200n 0
+    1867249n 0
+    1867250n 1.8
+    1867299n 1.8
+    1867300n 0
+    1867349n 0
+    1867350n 1.8
+    1867399n 1.8
+    1867400n 0
+    1867449n 0
+    1867450n 1.8
+    1867499n 1.8
+    1867500n 0
+    1867549n 0
+    1867550n 1.8
+    1867599n 1.8
+    1867600n 0
+    1867649n 0
+    1867650n 1.8
+    1867699n 1.8
+    1867700n 0
+    1867749n 0
+    1867750n 1.8
+    1867799n 1.8
+    1867800n 0
+    1867849n 0
+    1867850n 1.8
+    1867899n 1.8
+    1867900n 0
+    1867949n 0
+    1867950n 1.8
+    1867999n 1.8
+    1868000n 0
+    1868049n 0
+    1868050n 1.8
+    1868099n 1.8
+    1868100n 0
+    1868149n 0
+    1868150n 1.8
+    1868199n 1.8
+    1868200n 0
+    1868249n 0
+    1868250n 1.8
+    1868299n 1.8
+    1868300n 0
+    1868349n 0
+    1868350n 1.8
+    1868399n 1.8
+    1868400n 0
+    1868449n 0
+    1868450n 1.8
+    1868499n 1.8
+    1868500n 0
+    1868549n 0
+    1868550n 1.8
+    1868599n 1.8
+    1868600n 0
+    1868649n 0
+    1868650n 1.8
+    1868699n 1.8
+    1868700n 0
+    1868749n 0
+    1868750n 1.8
+    1868799n 1.8
+    1868800n 0
+    1868849n 0
+    1868850n 1.8
+    1868899n 1.8
+    1868900n 0
+    1868949n 0
+    1868950n 1.8
+    1868999n 1.8
+    1869000n 0
+    1869049n 0
+    1869050n 1.8
+    1869099n 1.8
+    1869100n 0
+    1869149n 0
+    1869150n 1.8
+    1869199n 1.8
+    1869200n 0
+    1869249n 0
+    1869250n 1.8
+    1869299n 1.8
+    1869300n 0
+    1869349n 0
+    1869350n 1.8
+    1869399n 1.8
+    1869400n 0
+    1869449n 0
+    1869450n 1.8
+    1869499n 1.8
+    1869500n 0
+    1869549n 0
+    1869550n 1.8
+    1869599n 1.8
+    1869600n 0
+    1869649n 0
+    1869650n 1.8
+    1869699n 1.8
+    1869700n 0
+    1869749n 0
+    1869750n 1.8
+    1869799n 1.8
+    1869800n 0
+    1869849n 0
+    1869850n 1.8
+    1869899n 1.8
+    1869900n 0
+    1869949n 0
+    1869950n 1.8
+    1869999n 1.8
+    1870000n 0
+    1870049n 0
+    1870050n 1.8
+    1870099n 1.8
+    1870100n 0
+    1870149n 0
+    1870150n 1.8
+    1870199n 1.8
+    1870200n 0
+    1870249n 0
+    1870250n 1.8
+    1870299n 1.8
+    1870300n 0
+    1870349n 0
+    1870350n 1.8
+    1870399n 1.8
+    1870400n 0
+    1870449n 0
+    1870450n 1.8
+    1870499n 1.8
+    1870500n 0
+    1870549n 0
+    1870550n 1.8
+    1870599n 1.8
+    1870600n 0
+    1870649n 0
+    1870650n 1.8
+    1870699n 1.8
+    1870700n 0
+    1870749n 0
+    1870750n 1.8
+    1870799n 1.8
+    1870800n 0
+    1870849n 0
+    1870850n 1.8
+    1870899n 1.8
+    1870900n 0
+    1870949n 0
+    1870950n 1.8
+    1870999n 1.8
+    1871000n 0
+    1871049n 0
+    1871050n 1.8
+    1871099n 1.8
+    1871100n 0
+    1871149n 0
+    1871150n 1.8
+    1871199n 1.8
+    1871200n 0
+    1871249n 0
+    1871250n 1.8
+    1871299n 1.8
+    1871300n 0
+    1871349n 0
+    1871350n 1.8
+    1871399n 1.8
+    1871400n 0
+    1871449n 0
+    1871450n 1.8
+    1871499n 1.8
+    1871500n 0
+    1871549n 0
+    1871550n 1.8
+    1871599n 1.8
+    1871600n 0
+    1871649n 0
+    1871650n 1.8
+    1871699n 1.8
+    1871700n 0
+    1871749n 0
+    1871750n 1.8
+    1871799n 1.8
+    1871800n 0
+    1871849n 0
+    1871850n 1.8
+    1871899n 1.8
+    1871900n 0
+    1871949n 0
+    1871950n 1.8
+    1871999n 1.8
+    1872000n 0
+    1872049n 0
+    1872050n 1.8
+    1872099n 1.8
+    1872100n 0
+    1872149n 0
+    1872150n 1.8
+    1872199n 1.8
+    1872200n 0
+    1872249n 0
+    1872250n 1.8
+    1872299n 1.8
+    1872300n 0
+    1872349n 0
+    1872350n 1.8
+    1872399n 1.8
+    1872400n 0
+    1872449n 0
+    1872450n 1.8
+    1872499n 1.8
+    1872500n 0
+    1872549n 0
+    1872550n 1.8
+    1872599n 1.8
+    1872600n 0
+    1872649n 0
+    1872650n 1.8
+    1872699n 1.8
+    1872700n 0
+    1872749n 0
+    1872750n 1.8
+    1872799n 1.8
+    1872800n 0
+    1872849n 0
+    1872850n 1.8
+    1872899n 1.8
+    1872900n 0
+    1872949n 0
+    1872950n 1.8
+    1872999n 1.8
+    1873000n 0
+    1873049n 0
+    1873050n 1.8
+    1873099n 1.8
+    1873100n 0
+    1873149n 0
+    1873150n 1.8
+    1873199n 1.8
+    1873200n 0
+    1873249n 0
+    1873250n 1.8
+    1873299n 1.8
+    1873300n 0
+    1873349n 0
+    1873350n 1.8
+    1873399n 1.8
+    1873400n 0
+    1873449n 0
+    1873450n 1.8
+    1873499n 1.8
+    1873500n 0
+    1873549n 0
+    1873550n 1.8
+    1873599n 1.8
+    1873600n 0
+    1873649n 0
+    1873650n 1.8
+    1873699n 1.8
+    1873700n 0
+    1873749n 0
+    1873750n 1.8
+    1873799n 1.8
+    1873800n 0
+    1873849n 0
+    1873850n 1.8
+    1873899n 1.8
+    1873900n 0
+    1873949n 0
+    1873950n 1.8
+    1873999n 1.8
+    1874000n 0
+    1874049n 0
+    1874050n 1.8
+    1874099n 1.8
+    1874100n 0
+    1874149n 0
+    1874150n 1.8
+    1874199n 1.8
+    1874200n 0
+    1874249n 0
+    1874250n 1.8
+    1874299n 1.8
+    1874300n 0
+    1874349n 0
+    1874350n 1.8
+    1874399n 1.8
+    1874400n 0
+    1874449n 0
+    1874450n 1.8
+    1874499n 1.8
+    1874500n 0
+    1874549n 0
+    1874550n 1.8
+    1874599n 1.8
+    1874600n 0
+    1874649n 0
+    1874650n 1.8
+    1874699n 1.8
+    1874700n 0
+    1874749n 0
+    1874750n 1.8
+    1874799n 1.8
+    1874800n 0
+    1874849n 0
+    1874850n 1.8
+    1874899n 1.8
+    1874900n 0
+    1874949n 0
+    1874950n 1.8
+    1874999n 1.8
+    1875000n 0
+    1875049n 0
+    1875050n 1.8
+    1875099n 1.8
+    1875100n 0
+    1875149n 0
+    1875150n 1.8
+    1875199n 1.8
+    1875200n 0
+    1875249n 0
+    1875250n 1.8
+    1875299n 1.8
+    1875300n 0
+    1875349n 0
+    1875350n 1.8
+    1875399n 1.8
+    1875400n 0
+    1875449n 0
+    1875450n 1.8
+    1875499n 1.8
+    1875500n 0
+    1875549n 0
+    1875550n 1.8
+    1875599n 1.8
+    1875600n 0
+    1875649n 0
+    1875650n 1.8
+    1875699n 1.8
+    1875700n 0
+    1875749n 0
+    1875750n 1.8
+    1875799n 1.8
+    1875800n 0
+    1875849n 0
+    1875850n 1.8
+    1875899n 1.8
+    1875900n 0
+    1875949n 0
+    1875950n 1.8
+    1875999n 1.8
+    1876000n 0
+    1876049n 0
+    1876050n 1.8
+    1876099n 1.8
+    1876100n 0
+    1876149n 0
+    1876150n 1.8
+    1876199n 1.8
+    1876200n 0
+    1876249n 0
+    1876250n 1.8
+    1876299n 1.8
+    1876300n 0
+    1876349n 0
+    1876350n 1.8
+    1876399n 1.8
+    1876400n 0
+    1876449n 0
+    1876450n 1.8
+    1876499n 1.8
+    1876500n 0
+    1876549n 0
+    1876550n 1.8
+    1876599n 1.8
+    1876600n 0
+    1876649n 0
+    1876650n 1.8
+    1876699n 1.8
+    1876700n 0
+    1876749n 0
+    1876750n 1.8
+    1876799n 1.8
+    1876800n 0
+    1876849n 0
+    1876850n 1.8
+    1876899n 1.8
+    1876900n 0
+    1876949n 0
+    1876950n 1.8
+    1876999n 1.8
+    1877000n 0
+    1877049n 0
+    1877050n 1.8
+    1877099n 1.8
+    1877100n 0
+    1877149n 0
+    1877150n 1.8
+    1877199n 1.8
+    1877200n 0
+    1877249n 0
+    1877250n 1.8
+    1877299n 1.8
+    1877300n 0
+    1877349n 0
+    1877350n 1.8
+    1877399n 1.8
+    1877400n 0
+    1877449n 0
+    1877450n 1.8
+    1877499n 1.8
+    1877500n 0
+    1877549n 0
+    1877550n 1.8
+    1877599n 1.8
+    1877600n 0
+    1877649n 0
+    1877650n 1.8
+    1877699n 1.8
+    1877700n 0
+    1877749n 0
+    1877750n 1.8
+    1877799n 1.8
+    1877800n 0
+    1877849n 0
+    1877850n 1.8
+    1877899n 1.8
+    1877900n 0
+    1877949n 0
+    1877950n 1.8
+    1877999n 1.8
+    1878000n 0
+    1878049n 0
+    1878050n 1.8
+    1878099n 1.8
+    1878100n 0
+    1878149n 0
+    1878150n 1.8
+    1878199n 1.8
+    1878200n 0
+    1878249n 0
+    1878250n 1.8
+    1878299n 1.8
+    1878300n 0
+    1878349n 0
+    1878350n 1.8
+    1878399n 1.8
+    1878400n 0
+    1878449n 0
+    1878450n 1.8
+    1878499n 1.8
+    1878500n 0
+    1878549n 0
+    1878550n 1.8
+    1878599n 1.8
+    1878600n 0
+    1878649n 0
+    1878650n 1.8
+    1878699n 1.8
+    1878700n 0
+    1878749n 0
+    1878750n 1.8
+    1878799n 1.8
+    1878800n 0
+    1878849n 0
+    1878850n 1.8
+    1878899n 1.8
+    1878900n 0
+    1878949n 0
+    1878950n 1.8
+    1878999n 1.8
+    1879000n 0
+    1879049n 0
+    1879050n 1.8
+    1879099n 1.8
+    1879100n 0
+    1879149n 0
+    1879150n 1.8
+    1879199n 1.8
+    1879200n 0
+    1879249n 0
+    1879250n 1.8
+    1879299n 1.8
+    1879300n 0
+    1879349n 0
+    1879350n 1.8
+    1879399n 1.8
+    1879400n 0
+    1879449n 0
+    1879450n 1.8
+    1879499n 1.8
+    1879500n 0
+    1879549n 0
+    1879550n 1.8
+    1879599n 1.8
+    1879600n 0
+    1879649n 0
+    1879650n 1.8
+    1879699n 1.8
+    1879700n 0
+    1879749n 0
+    1879750n 1.8
+    1879799n 1.8
+    1879800n 0
+    1879849n 0
+    1879850n 1.8
+    1879899n 1.8
+    1879900n 0
+    1879949n 0
+    1879950n 1.8
+    1879999n 1.8
+    1880000n 0
+    1880049n 0
+    1880050n 1.8
+    1880099n 1.8
+    1880100n 0
+    1880149n 0
+    1880150n 1.8
+    1880199n 1.8
+    1880200n 0
+    1880249n 0
+    1880250n 1.8
+    1880299n 1.8
+    1880300n 0
+    1880349n 0
+    1880350n 1.8
+    1880399n 1.8
+    1880400n 0
+    1880449n 0
+    1880450n 1.8
+    1880499n 1.8
+    1880500n 0
+    1880549n 0
+    1880550n 1.8
+    1880599n 1.8
+    1880600n 0
+    1880649n 0
+    1880650n 1.8
+    1880699n 1.8
+    1880700n 0
+    1880749n 0
+    1880750n 1.8
+    1880799n 1.8
+    1880800n 0
+    1880849n 0
+    1880850n 1.8
+    1880899n 1.8
+    1880900n 0
+    1880949n 0
+    1880950n 1.8
+    1880999n 1.8
+    1881000n 0
+    1881049n 0
+    1881050n 1.8
+    1881099n 1.8
+    1881100n 0
+    1881149n 0
+    1881150n 1.8
+    1881199n 1.8
+    1881200n 0
+    1881249n 0
+    1881250n 1.8
+    1881299n 1.8
+    1881300n 0
+    1881349n 0
+    1881350n 1.8
+    1881399n 1.8
+    1881400n 0
+    1881449n 0
+    1881450n 1.8
+    1881499n 1.8
+    1881500n 0
+    1881549n 0
+    1881550n 1.8
+    1881599n 1.8
+    1881600n 0
+    1881649n 0
+    1881650n 1.8
+    1881699n 1.8
+    1881700n 0
+    1881749n 0
+    1881750n 1.8
+    1881799n 1.8
+    1881800n 0
+    1881849n 0
+    1881850n 1.8
+    1881899n 1.8
+    1881900n 0
+    1881949n 0
+    1881950n 1.8
+    1881999n 1.8
+    1882000n 0
+    1882049n 0
+    1882050n 1.8
+    1882099n 1.8
+    1882100n 0
+    1882149n 0
+    1882150n 1.8
+    1882199n 1.8
+    1882200n 0
+    1882249n 0
+    1882250n 1.8
+    1882299n 1.8
+    1882300n 0
+    1882349n 0
+    1882350n 1.8
+    1882399n 1.8
+    1882400n 0
+    1882449n 0
+    1882450n 1.8
+    1882499n 1.8
+    1882500n 0
+    1882549n 0
+    1882550n 1.8
+    1882599n 1.8
+    1882600n 0
+    1882649n 0
+    1882650n 1.8
+    1882699n 1.8
+    1882700n 0
+    1882749n 0
+    1882750n 1.8
+    1882799n 1.8
+    1882800n 0
+    1882849n 0
+    1882850n 1.8
+    1882899n 1.8
+    1882900n 0
+    1882949n 0
+    1882950n 1.8
+    1882999n 1.8
+    1883000n 0
+    1883049n 0
+    1883050n 1.8
+    1883099n 1.8
+    1883100n 0
+    1883149n 0
+    1883150n 1.8
+    1883199n 1.8
+    1883200n 0
+    1883249n 0
+    1883250n 1.8
+    1883299n 1.8
+    1883300n 0
+    1883349n 0
+    1883350n 1.8
+    1883399n 1.8
+    1883400n 0
+    1883449n 0
+    1883450n 1.8
+    1883499n 1.8
+    1883500n 0
+    1883549n 0
+    1883550n 1.8
+    1883599n 1.8
+    1883600n 0
+    1883649n 0
+    1883650n 1.8
+    1883699n 1.8
+    1883700n 0
+    1883749n 0
+    1883750n 1.8
+    1883799n 1.8
+    1883800n 0
+    1883849n 0
+    1883850n 1.8
+    1883899n 1.8
+    1883900n 0
+    1883949n 0
+    1883950n 1.8
+    1883999n 1.8
+    1884000n 0
+    1884049n 0
+    1884050n 1.8
+    1884099n 1.8
+    1884100n 0
+    1884149n 0
+    1884150n 1.8
+    1884199n 1.8
+    1884200n 0
+    1884249n 0
+    1884250n 1.8
+    1884299n 1.8
+    1884300n 0
+    1884349n 0
+    1884350n 1.8
+    1884399n 1.8
+    1884400n 0
+    1884449n 0
+    1884450n 1.8
+    1884499n 1.8
+    1884500n 0
+    1884549n 0
+    1884550n 1.8
+    1884599n 1.8
+    1884600n 0
+    1884649n 0
+    1884650n 1.8
+    1884699n 1.8
+    1884700n 0
+    1884749n 0
+    1884750n 1.8
+    1884799n 1.8
+    1884800n 0
+    1884849n 0
+    1884850n 1.8
+    1884899n 1.8
+    1884900n 0
+    1884949n 0
+    1884950n 1.8
+    1884999n 1.8
+    1885000n 0
+    1885049n 0
+    1885050n 1.8
+    1885099n 1.8
+    1885100n 0
+    1885149n 0
+    1885150n 1.8
+    1885199n 1.8
+    1885200n 0
+    1885249n 0
+    1885250n 1.8
+    1885299n 1.8
+    1885300n 0
+    1885349n 0
+    1885350n 1.8
+    1885399n 1.8
+    1885400n 0
+    1885449n 0
+    1885450n 1.8
+    1885499n 1.8
+    1885500n 0
+    1885549n 0
+    1885550n 1.8
+    1885599n 1.8
+    1885600n 0
+    1885649n 0
+    1885650n 1.8
+    1885699n 1.8
+    1885700n 0
+    1885749n 0
+    1885750n 1.8
+    1885799n 1.8
+    1885800n 0
+    1885849n 0
+    1885850n 1.8
+    1885899n 1.8
+    1885900n 0
+    1885949n 0
+    1885950n 1.8
+    1885999n 1.8
+    1886000n 0
+    1886049n 0
+    1886050n 1.8
+    1886099n 1.8
+    1886100n 0
+    1886149n 0
+    1886150n 1.8
+    1886199n 1.8
+    1886200n 0
+    1886249n 0
+    1886250n 1.8
+    1886299n 1.8
+    1886300n 0
+    1886349n 0
+    1886350n 1.8
+    1886399n 1.8
+    1886400n 0
+    1886449n 0
+    1886450n 1.8
+    1886499n 1.8
+    1886500n 0
+    1886549n 0
+    1886550n 1.8
+    1886599n 1.8
+    1886600n 0
+    1886649n 0
+    1886650n 1.8
+    1886699n 1.8
+    1886700n 0
+    1886749n 0
+    1886750n 1.8
+    1886799n 1.8
+    1886800n 0
+    1886849n 0
+    1886850n 1.8
+    1886899n 1.8
+    1886900n 0
+    1886949n 0
+    1886950n 1.8
+    1886999n 1.8
+    1887000n 0
+    1887049n 0
+    1887050n 1.8
+    1887099n 1.8
+    1887100n 0
+    1887149n 0
+    1887150n 1.8
+    1887199n 1.8
+    1887200n 0
+    1887249n 0
+    1887250n 1.8
+    1887299n 1.8
+    1887300n 0
+    1887349n 0
+    1887350n 1.8
+    1887399n 1.8
+    1887400n 0
+    1887449n 0
+    1887450n 1.8
+    1887499n 1.8
+    1887500n 0
+    1887549n 0
+    1887550n 1.8
+    1887599n 1.8
+    1887600n 0
+    1887649n 0
+    1887650n 1.8
+    1887699n 1.8
+    1887700n 0
+    1887749n 0
+    1887750n 1.8
+    1887799n 1.8
+    1887800n 0
+    1887849n 0
+    1887850n 1.8
+    1887899n 1.8
+    1887900n 0
+    1887949n 0
+    1887950n 1.8
+    1887999n 1.8
+    1888000n 0
+    1888049n 0
+    1888050n 1.8
+    1888099n 1.8
+    1888100n 0
+    1888149n 0
+    1888150n 1.8
+    1888199n 1.8
+    1888200n 0
+    1888249n 0
+    1888250n 1.8
+    1888299n 1.8
+    1888300n 0
+    1888349n 0
+    1888350n 1.8
+    1888399n 1.8
+    1888400n 0
+    1888449n 0
+    1888450n 1.8
+    1888499n 1.8
+    1888500n 0
+    1888549n 0
+    1888550n 1.8
+    1888599n 1.8
+    1888600n 0
+    1888649n 0
+    1888650n 1.8
+    1888699n 1.8
+    1888700n 0
+    1888749n 0
+    1888750n 1.8
+    1888799n 1.8
+    1888800n 0
+    1888849n 0
+    1888850n 1.8
+    1888899n 1.8
+    1888900n 0
+    1888949n 0
+    1888950n 1.8
+    1888999n 1.8
+    1889000n 0
+    1889049n 0
+    1889050n 1.8
+    1889099n 1.8
+    1889100n 0
+    1889149n 0
+    1889150n 1.8
+    1889199n 1.8
+    1889200n 0
+    1889249n 0
+    1889250n 1.8
+    1889299n 1.8
+    1889300n 0
+    1889349n 0
+    1889350n 1.8
+    1889399n 1.8
+    1889400n 0
+    1889449n 0
+    1889450n 1.8
+    1889499n 1.8
+    1889500n 0
+    1889549n 0
+    1889550n 1.8
+    1889599n 1.8
+    1889600n 0
+    1889649n 0
+    1889650n 1.8
+    1889699n 1.8
+    1889700n 0
+    1889749n 0
+    1889750n 1.8
+    1889799n 1.8
+    1889800n 0
+    1889849n 0
+    1889850n 1.8
+    1889899n 1.8
+    1889900n 0
+    1889949n 0
+    1889950n 1.8
+    1889999n 1.8
+    1890000n 0
+    1890049n 0
+    1890050n 1.8
+    1890099n 1.8
+    1890100n 0
+    1890149n 0
+    1890150n 1.8
+    1890199n 1.8
+    1890200n 0
+    1890249n 0
+    1890250n 1.8
+    1890299n 1.8
+    1890300n 0
+    1890349n 0
+    1890350n 1.8
+    1890399n 1.8
+    1890400n 0
+    1890449n 0
+    1890450n 1.8
+    1890499n 1.8
+    1890500n 0
+    1890549n 0
+    1890550n 1.8
+    1890599n 1.8
+    1890600n 0
+    1890649n 0
+    1890650n 1.8
+    1890699n 1.8
+    1890700n 0
+    1890749n 0
+    1890750n 1.8
+    1890799n 1.8
+    1890800n 0
+    1890849n 0
+    1890850n 1.8
+    1890899n 1.8
+    1890900n 0
+    1890949n 0
+    1890950n 1.8
+    1890999n 1.8
+    1891000n 0
+    1891049n 0
+    1891050n 1.8
+    1891099n 1.8
+    1891100n 0
+    1891149n 0
+    1891150n 1.8
+    1891199n 1.8
+    1891200n 0
+    1891249n 0
+    1891250n 1.8
+    1891299n 1.8
+    1891300n 0
+    1891349n 0
+    1891350n 1.8
+    1891399n 1.8
+    1891400n 0
+    1891449n 0
+    1891450n 1.8
+    1891499n 1.8
+    1891500n 0
+    1891549n 0
+    1891550n 1.8
+    1891599n 1.8
+    1891600n 0
+    1891649n 0
+    1891650n 1.8
+    1891699n 1.8
+    1891700n 0
+    1891749n 0
+    1891750n 1.8
+    1891799n 1.8
+    1891800n 0
+    1891849n 0
+    1891850n 1.8
+    1891899n 1.8
+    1891900n 0
+    1891949n 0
+    1891950n 1.8
+    1891999n 1.8
+    1892000n 0
+    1892049n 0
+    1892050n 1.8
+    1892099n 1.8
+    1892100n 0
+    1892149n 0
+    1892150n 1.8
+    1892199n 1.8
+    1892200n 0
+    1892249n 0
+    1892250n 1.8
+    1892299n 1.8
+    1892300n 0
+    1892349n 0
+    1892350n 1.8
+    1892399n 1.8
+    1892400n 0
+    1892449n 0
+    1892450n 1.8
+    1892499n 1.8
+    1892500n 0
+    1892549n 0
+    1892550n 1.8
+    1892599n 1.8
+    1892600n 0
+    1892649n 0
+    1892650n 1.8
+    1892699n 1.8
+    1892700n 0
+    1892749n 0
+    1892750n 1.8
+    1892799n 1.8
+    1892800n 0
+    1892849n 0
+    1892850n 1.8
+    1892899n 1.8
+    1892900n 0
+    1892949n 0
+    1892950n 1.8
+    1892999n 1.8
+    1893000n 0
+    1893049n 0
+    1893050n 1.8
+    1893099n 1.8
+    1893100n 0
+    1893149n 0
+    1893150n 1.8
+    1893199n 1.8
+    1893200n 0
+    1893249n 0
+    1893250n 1.8
+    1893299n 1.8
+    1893300n 0
+    1893349n 0
+    1893350n 1.8
+    1893399n 1.8
+    1893400n 0
+    1893449n 0
+    1893450n 1.8
+    1893499n 1.8
+    1893500n 0
+    1893549n 0
+    1893550n 1.8
+    1893599n 1.8
+    1893600n 0
+    1893649n 0
+    1893650n 1.8
+    1893699n 1.8
+    1893700n 0
+    1893749n 0
+    1893750n 1.8
+    1893799n 1.8
+    1893800n 0
+    1893849n 0
+    1893850n 1.8
+    1893899n 1.8
+    1893900n 0
+    1893949n 0
+    1893950n 1.8
+    1893999n 1.8
+    1894000n 0
+    1894049n 0
+    1894050n 1.8
+    1894099n 1.8
+    1894100n 0
+    1894149n 0
+    1894150n 1.8
+    1894199n 1.8
+    1894200n 0
+    1894249n 0
+    1894250n 1.8
+    1894299n 1.8
+    1894300n 0
+    1894349n 0
+    1894350n 1.8
+    1894399n 1.8
+    1894400n 0
+    1894449n 0
+    1894450n 1.8
+    1894499n 1.8
+    1894500n 0
+    1894549n 0
+    1894550n 1.8
+    1894599n 1.8
+    1894600n 0
+    1894649n 0
+    1894650n 1.8
+    1894699n 1.8
+    1894700n 0
+    1894749n 0
+    1894750n 1.8
+    1894799n 1.8
+    1894800n 0
+    1894849n 0
+    1894850n 1.8
+    1894899n 1.8
+    1894900n 0
+    1894949n 0
+    1894950n 1.8
+    1894999n 1.8
+    1895000n 0
+    1895049n 0
+    1895050n 1.8
+    1895099n 1.8
+    1895100n 0
+    1895149n 0
+    1895150n 1.8
+    1895199n 1.8
+    1895200n 0
+    1895249n 0
+    1895250n 1.8
+    1895299n 1.8
+    1895300n 0
+    1895349n 0
+    1895350n 1.8
+    1895399n 1.8
+    1895400n 0
+    1895449n 0
+    1895450n 1.8
+    1895499n 1.8
+    1895500n 0
+    1895549n 0
+    1895550n 1.8
+    1895599n 1.8
+    1895600n 0
+    1895649n 0
+    1895650n 1.8
+    1895699n 1.8
+    1895700n 0
+    1895749n 0
+    1895750n 1.8
+    1895799n 1.8
+    1895800n 0
+    1895849n 0
+    1895850n 1.8
+    1895899n 1.8
+    1895900n 0
+    1895949n 0
+    1895950n 1.8
+    1895999n 1.8
+    1896000n 0
+    1896049n 0
+    1896050n 1.8
+    1896099n 1.8
+    1896100n 0
+    1896149n 0
+    1896150n 1.8
+    1896199n 1.8
+    1896200n 0
+    1896249n 0
+    1896250n 1.8
+    1896299n 1.8
+    1896300n 0
+    1896349n 0
+    1896350n 1.8
+    1896399n 1.8
+    1896400n 0
+    1896449n 0
+    1896450n 1.8
+    1896499n 1.8
+    1896500n 0
+    1896549n 0
+    1896550n 1.8
+    1896599n 1.8
+    1896600n 0
+    1896649n 0
+    1896650n 1.8
+    1896699n 1.8
+    1896700n 0
+    1896749n 0
+    1896750n 1.8
+    1896799n 1.8
+    1896800n 0
+    1896849n 0
+    1896850n 1.8
+    1896899n 1.8
+    1896900n 0
+    1896949n 0
+    1896950n 1.8
+    1896999n 1.8
+    1897000n 0
+    1897049n 0
+    1897050n 1.8
+    1897099n 1.8
+    1897100n 0
+    1897149n 0
+    1897150n 1.8
+    1897199n 1.8
+    1897200n 0
+    1897249n 0
+    1897250n 1.8
+    1897299n 1.8
+    1897300n 0
+    1897349n 0
+    1897350n 1.8
+    1897399n 1.8
+    1897400n 0
+    1897449n 0
+    1897450n 1.8
+    1897499n 1.8
+    1897500n 0
+    1897549n 0
+    1897550n 1.8
+    1897599n 1.8
+    1897600n 0
+    1897649n 0
+    1897650n 1.8
+    1897699n 1.8
+    1897700n 0
+    1897749n 0
+    1897750n 1.8
+    1897799n 1.8
+    1897800n 0
+    1897849n 0
+    1897850n 1.8
+    1897899n 1.8
+    1897900n 0
+    1897949n 0
+    1897950n 1.8
+    1897999n 1.8
+    1898000n 0
+    1898049n 0
+    1898050n 1.8
+    1898099n 1.8
+    1898100n 0
+    1898149n 0
+    1898150n 1.8
+    1898199n 1.8
+    1898200n 0
+    1898249n 0
+    1898250n 1.8
+    1898299n 1.8
+    1898300n 0
+    1898349n 0
+    1898350n 1.8
+    1898399n 1.8
+    1898400n 0
+    1898449n 0
+    1898450n 1.8
+    1898499n 1.8
+    1898500n 0
+    1898549n 0
+    1898550n 1.8
+    1898599n 1.8
+    1898600n 0
+    1898649n 0
+    1898650n 1.8
+    1898699n 1.8
+    1898700n 0
+    1898749n 0
+    1898750n 1.8
+    1898799n 1.8
+    1898800n 0
+    1898849n 0
+    1898850n 1.8
+    1898899n 1.8
+    1898900n 0
+    1898949n 0
+    1898950n 1.8
+    1898999n 1.8
+    1899000n 0
+    1899049n 0
+    1899050n 1.8
+    1899099n 1.8
+    1899100n 0
+    1899149n 0
+    1899150n 1.8
+    1899199n 1.8
+    1899200n 0
+    1899249n 0
+    1899250n 1.8
+    1899299n 1.8
+    1899300n 0
+    1899349n 0
+    1899350n 1.8
+    1899399n 1.8
+    1899400n 0
+    1899449n 0
+    1899450n 1.8
+    1899499n 1.8
+    1899500n 0
+    1899549n 0
+    1899550n 1.8
+    1899599n 1.8
+    1899600n 0
+    1899649n 0
+    1899650n 1.8
+    1899699n 1.8
+    1899700n 0
+    1899749n 0
+    1899750n 1.8
+    1899799n 1.8
+    1899800n 0
+    1899849n 0
+    1899850n 1.8
+    1899899n 1.8
+    1899900n 0
+    1899949n 0
+    1899950n 1.8
+    1899999n 1.8
+    1900000n 0
+    1900049n 0
+    1900050n 1.8
+    1900099n 1.8
+    1900100n 0
+    1900149n 0
+    1900150n 1.8
+    1900199n 1.8
+    1900200n 0
+    1900249n 0
+    1900250n 1.8
+    1900299n 1.8
+    1900300n 0
+    1900349n 0
+    1900350n 1.8
+    1900399n 1.8
+    1900400n 0
+    1900449n 0
+    1900450n 1.8
+    1900499n 1.8
+    1900500n 0
+    1900549n 0
+    1900550n 1.8
+    1900599n 1.8
+    1900600n 0
+    1900649n 0
+    1900650n 1.8
+    1900699n 1.8
+    1900700n 0
+    1900749n 0
+    1900750n 1.8
+    1900799n 1.8
+    1900800n 0
+    1900849n 0
+    1900850n 1.8
+    1900899n 1.8
+    1900900n 0
+    1900949n 0
+    1900950n 1.8
+    1900999n 1.8
+    1901000n 0
+    1901049n 0
+    1901050n 1.8
+    1901099n 1.8
+    1901100n 0
+    1901149n 0
+    1901150n 1.8
+    1901199n 1.8
+    1901200n 0
+    1901249n 0
+    1901250n 1.8
+    1901299n 1.8
+    1901300n 0
+    1901349n 0
+    1901350n 1.8
+    1901399n 1.8
+    1901400n 0
+    1901449n 0
+    1901450n 1.8
+    1901499n 1.8
+    1901500n 0
+    1901549n 0
+    1901550n 1.8
+    1901599n 1.8
+    1901600n 0
+    1901649n 0
+    1901650n 1.8
+    1901699n 1.8
+    1901700n 0
+    1901749n 0
+    1901750n 1.8
+    1901799n 1.8
+    1901800n 0
+    1901849n 0
+    1901850n 1.8
+    1901899n 1.8
+    1901900n 0
+    1901949n 0
+    1901950n 1.8
+    1901999n 1.8
+    1902000n 0
+    1902049n 0
+    1902050n 1.8
+    1902099n 1.8
+    1902100n 0
+    1902149n 0
+    1902150n 1.8
+    1902199n 1.8
+    1902200n 0
+    1902249n 0
+    1902250n 1.8
+    1902299n 1.8
+    1902300n 0
+    1902349n 0
+    1902350n 1.8
+    1902399n 1.8
+    1902400n 0
+    1902449n 0
+    1902450n 1.8
+    1902499n 1.8
+    1902500n 0
+    1902549n 0
+    1902550n 1.8
+    1902599n 1.8
+    1902600n 0
+    1902649n 0
+    1902650n 1.8
+    1902699n 1.8
+    1902700n 0
+    1902749n 0
+    1902750n 1.8
+    1902799n 1.8
+    1902800n 0
+    1902849n 0
+    1902850n 1.8
+    1902899n 1.8
+    1902900n 0
+    1902949n 0
+    1902950n 1.8
+    1902999n 1.8
+    1903000n 0
+    1903049n 0
+    1903050n 1.8
+    1903099n 1.8
+    1903100n 0
+    1903149n 0
+    1903150n 1.8
+    1903199n 1.8
+    1903200n 0
+    1903249n 0
+    1903250n 1.8
+    1903299n 1.8
+    1903300n 0
+    1903349n 0
+    1903350n 1.8
+    1903399n 1.8
+    1903400n 0
+    1903449n 0
+    1903450n 1.8
+    1903499n 1.8
+    1903500n 0
+    1903549n 0
+    1903550n 1.8
+    1903599n 1.8
+    1903600n 0
+    1903649n 0
+    1903650n 1.8
+    1903699n 1.8
+    1903700n 0
+    1903749n 0
+    1903750n 1.8
+    1903799n 1.8
+    1903800n 0
+    1903849n 0
+    1903850n 1.8
+    1903899n 1.8
+    1903900n 0
+    1903949n 0
+    1903950n 1.8
+    1903999n 1.8
+    1904000n 0
+    1904049n 0
+    1904050n 1.8
+    1904099n 1.8
+    1904100n 0
+    1904149n 0
+    1904150n 1.8
+    1904199n 1.8
+    1904200n 0
+    1904249n 0
+    1904250n 1.8
+    1904299n 1.8
+    1904300n 0
+    1904349n 0
+    1904350n 1.8
+    1904399n 1.8
+    1904400n 0
+    1904449n 0
+    1904450n 1.8
+    1904499n 1.8
+    1904500n 0
+    1904549n 0
+    1904550n 1.8
+    1904599n 1.8
+    1904600n 0
+    1904649n 0
+    1904650n 1.8
+    1904699n 1.8
+    1904700n 0
+    1904749n 0
+    1904750n 1.8
+    1904799n 1.8
+    1904800n 0
+    1904849n 0
+    1904850n 1.8
+    1904899n 1.8
+    1904900n 0
+    1904949n 0
+    1904950n 1.8
+    1904999n 1.8
+    1905000n 0
+    1905049n 0
+    1905050n 1.8
+    1905099n 1.8
+    1905100n 0
+    1905149n 0
+    1905150n 1.8
+    1905199n 1.8
+    1905200n 0
+    1905249n 0
+    1905250n 1.8
+    1905299n 1.8
+    1905300n 0
+    1905349n 0
+    1905350n 1.8
+    1905399n 1.8
+    1905400n 0
+    1905449n 0
+    1905450n 1.8
+    1905499n 1.8
+    1905500n 0
+    1905549n 0
+    1905550n 1.8
+    1905599n 1.8
+    1905600n 0
+    1905649n 0
+    1905650n 1.8
+    1905699n 1.8
+    1905700n 0
+    1905749n 0
+    1905750n 1.8
+    1905799n 1.8
+    1905800n 0
+    1905849n 0
+    1905850n 1.8
+    1905899n 1.8
+    1905900n 0
+    1905949n 0
+    1905950n 1.8
+    1905999n 1.8
+    1906000n 0
+    1906049n 0
+    1906050n 1.8
+    1906099n 1.8
+    1906100n 0
+    1906149n 0
+    1906150n 1.8
+    1906199n 1.8
+    1906200n 0
+    1906249n 0
+    1906250n 1.8
+    1906299n 1.8
+    1906300n 0
+    1906349n 0
+    1906350n 1.8
+    1906399n 1.8
+    1906400n 0
+    1906449n 0
+    1906450n 1.8
+    1906499n 1.8
+    1906500n 0
+    1906549n 0
+    1906550n 1.8
+    1906599n 1.8
+    1906600n 0
+    1906649n 0
+    1906650n 1.8
+    1906699n 1.8
+    1906700n 0
+    1906749n 0
+    1906750n 1.8
+    1906799n 1.8
+    1906800n 0
+    1906849n 0
+    1906850n 1.8
+    1906899n 1.8
+    1906900n 0
+    1906949n 0
+    1906950n 1.8
+    1906999n 1.8
+    1907000n 0
+    1907049n 0
+    1907050n 1.8
+    1907099n 1.8
+    1907100n 0
+    1907149n 0
+    1907150n 1.8
+    1907199n 1.8
+    1907200n 0
+    1907249n 0
+    1907250n 1.8
+    1907299n 1.8
+    1907300n 0
+    1907349n 0
+    1907350n 1.8
+    1907399n 1.8
+    1907400n 0
+    1907449n 0
+    1907450n 1.8
+    1907499n 1.8
+    1907500n 0
+    1907549n 0
+    1907550n 1.8
+    1907599n 1.8
+    1907600n 0
+    1907649n 0
+    1907650n 1.8
+    1907699n 1.8
+    1907700n 0
+    1907749n 0
+    1907750n 1.8
+    1907799n 1.8
+    1907800n 0
+    1907849n 0
+    1907850n 1.8
+    1907899n 1.8
+    1907900n 0
+    1907949n 0
+    1907950n 1.8
+    1907999n 1.8
+    1908000n 0
+    1908049n 0
+    1908050n 1.8
+    1908099n 1.8
+    1908100n 0
+    1908149n 0
+    1908150n 1.8
+    1908199n 1.8
+    1908200n 0
+    1908249n 0
+    1908250n 1.8
+    1908299n 1.8
+    1908300n 0
+    1908349n 0
+    1908350n 1.8
+    1908399n 1.8
+    1908400n 0
+    1908449n 0
+    1908450n 1.8
+    1908499n 1.8
+    1908500n 0
+    1908549n 0
+    1908550n 1.8
+    1908599n 1.8
+    1908600n 0
+    1908649n 0
+    1908650n 1.8
+    1908699n 1.8
+    1908700n 0
+    1908749n 0
+    1908750n 1.8
+    1908799n 1.8
+    1908800n 0
+    1908849n 0
+    1908850n 1.8
+    1908899n 1.8
+    1908900n 0
+    1908949n 0
+    1908950n 1.8
+    1908999n 1.8
+    1909000n 0
+    1909049n 0
+    1909050n 1.8
+    1909099n 1.8
+    1909100n 0
+    1909149n 0
+    1909150n 1.8
+    1909199n 1.8
+    1909200n 0
+    1909249n 0
+    1909250n 1.8
+    1909299n 1.8
+    1909300n 0
+    1909349n 0
+    1909350n 1.8
+    1909399n 1.8
+    1909400n 0
+    1909449n 0
+    1909450n 1.8
+    1909499n 1.8
+    1909500n 0
+    1909549n 0
+    1909550n 1.8
+    1909599n 1.8
+    1909600n 0
+    1909649n 0
+    1909650n 1.8
+    1909699n 1.8
+    1909700n 0
+    1909749n 0
+    1909750n 1.8
+    1909799n 1.8
+    1909800n 0
+    1909849n 0
+    1909850n 1.8
+    1909899n 1.8
+    1909900n 0
+    1909949n 0
+    1909950n 1.8
+    1909999n 1.8
+    1910000n 0
+    1910049n 0
+    1910050n 1.8
+    1910099n 1.8
+    1910100n 0
+    1910149n 0
+    1910150n 1.8
+    1910199n 1.8
+    1910200n 0
+    1910249n 0
+    1910250n 1.8
+    1910299n 1.8
+    1910300n 0
+    1910349n 0
+    1910350n 1.8
+    1910399n 1.8
+    1910400n 0
+    1910449n 0
+    1910450n 1.8
+    1910499n 1.8
+    1910500n 0
+    1910549n 0
+    1910550n 1.8
+    1910599n 1.8
+    1910600n 0
+    1910649n 0
+    1910650n 1.8
+    1910699n 1.8
+    1910700n 0
+    1910749n 0
+    1910750n 1.8
+    1910799n 1.8
+    1910800n 0
+    1910849n 0
+    1910850n 1.8
+    1910899n 1.8
+    1910900n 0
+    1910949n 0
+    1910950n 1.8
+    1910999n 1.8
+    1911000n 0
+    1911049n 0
+    1911050n 1.8
+    1911099n 1.8
+    1911100n 0
+    1911149n 0
+    1911150n 1.8
+    1911199n 1.8
+    1911200n 0
+    1911249n 0
+    1911250n 1.8
+    1911299n 1.8
+    1911300n 0
+    1911349n 0
+    1911350n 1.8
+    1911399n 1.8
+    1911400n 0
+    1911449n 0
+    1911450n 1.8
+    1911499n 1.8
+    1911500n 0
+    1911549n 0
+    1911550n 1.8
+    1911599n 1.8
+    1911600n 0
+    1911649n 0
+    1911650n 1.8
+    1911699n 1.8
+    1911700n 0
+    1911749n 0
+    1911750n 1.8
+    1911799n 1.8
+    1911800n 0
+    1911849n 0
+    1911850n 1.8
+    1911899n 1.8
+    1911900n 0
+    1911949n 0
+    1911950n 1.8
+    1911999n 1.8
+    1912000n 0
+    1912049n 0
+    1912050n 1.8
+    1912099n 1.8
+    1912100n 0
+    1912149n 0
+    1912150n 1.8
+    1912199n 1.8
+    1912200n 0
+    1912249n 0
+    1912250n 1.8
+    1912299n 1.8
+    1912300n 0
+    1912349n 0
+    1912350n 1.8
+    1912399n 1.8
+    1912400n 0
+    1912449n 0
+    1912450n 1.8
+    1912499n 1.8
+    1912500n 0
+    1912549n 0
+    1912550n 1.8
+    1912599n 1.8
+    1912600n 0
+    1912649n 0
+    1912650n 1.8
+    1912699n 1.8
+    1912700n 0
+    1912749n 0
+    1912750n 1.8
+    1912799n 1.8
+    1912800n 0
+    1912849n 0
+    1912850n 1.8
+    1912899n 1.8
+    1912900n 0
+    1912949n 0
+    1912950n 1.8
+    1912999n 1.8
+    1913000n 0
+    1913049n 0
+    1913050n 1.8
+    1913099n 1.8
+    1913100n 0
+    1913149n 0
+    1913150n 1.8
+    1913199n 1.8
+    1913200n 0
+    1913249n 0
+    1913250n 1.8
+    1913299n 1.8
+    1913300n 0
+    1913349n 0
+    1913350n 1.8
+    1913399n 1.8
+    1913400n 0
+    1913449n 0
+    1913450n 1.8
+    1913499n 1.8
+    1913500n 0
+    1913549n 0
+    1913550n 1.8
+    1913599n 1.8
+    1913600n 0
+    1913649n 0
+    1913650n 1.8
+    1913699n 1.8
+    1913700n 0
+    1913749n 0
+    1913750n 1.8
+    1913799n 1.8
+    1913800n 0
+    1913849n 0
+    1913850n 1.8
+    1913899n 1.8
+    1913900n 0
+    1913949n 0
+    1913950n 1.8
+    1913999n 1.8
+    1914000n 0
+    1914049n 0
+    1914050n 1.8
+    1914099n 1.8
+    1914100n 0
+    1914149n 0
+    1914150n 1.8
+    1914199n 1.8
+    1914200n 0
+    1914249n 0
+    1914250n 1.8
+    1914299n 1.8
+    1914300n 0
+    1914349n 0
+    1914350n 1.8
+    1914399n 1.8
+    1914400n 0
+    1914449n 0
+    1914450n 1.8
+    1914499n 1.8
+    1914500n 0
+    1914549n 0
+    1914550n 1.8
+    1914599n 1.8
+    1914600n 0
+    1914649n 0
+    1914650n 1.8
+    1914699n 1.8
+    1914700n 0
+    1914749n 0
+    1914750n 1.8
+    1914799n 1.8
+    1914800n 0
+    1914849n 0
+    1914850n 1.8
+    1914899n 1.8
+    1914900n 0
+    1914949n 0
+    1914950n 1.8
+    1914999n 1.8
+    1915000n 0
+    1915049n 0
+    1915050n 1.8
+    1915099n 1.8
+    1915100n 0
+    1915149n 0
+    1915150n 1.8
+    1915199n 1.8
+    1915200n 0
+    1915249n 0
+    1915250n 1.8
+    1915299n 1.8
+    1915300n 0
+    1915349n 0
+    1915350n 1.8
+    1915399n 1.8
+    1915400n 0
+    1915449n 0
+    1915450n 1.8
+    1915499n 1.8
+    1915500n 0
+    1915549n 0
+    1915550n 1.8
+    1915599n 1.8
+    1915600n 0
+    1915649n 0
+    1915650n 1.8
+    1915699n 1.8
+    1915700n 0
+    1915749n 0
+    1915750n 1.8
+    1915799n 1.8
+    1915800n 0
+    1915849n 0
+    1915850n 1.8
+    1915899n 1.8
+    1915900n 0
+    1915949n 0
+    1915950n 1.8
+    1915999n 1.8
+    1916000n 0
+    1916049n 0
+    1916050n 1.8
+    1916099n 1.8
+    1916100n 0
+    1916149n 0
+    1916150n 1.8
+    1916199n 1.8
+    1916200n 0
+    1916249n 0
+    1916250n 1.8
+    1916299n 1.8
+    1916300n 0
+    1916349n 0
+    1916350n 1.8
+    1916399n 1.8
+    1916400n 0
+    1916449n 0
+    1916450n 1.8
+    1916499n 1.8
+    1916500n 0
+    1916549n 0
+    1916550n 1.8
+    1916599n 1.8
+    1916600n 0
+    1916649n 0
+    1916650n 1.8
+    1916699n 1.8
+    1916700n 0
+    1916749n 0
+    1916750n 1.8
+    1916799n 1.8
+    1916800n 0
+    1916849n 0
+    1916850n 1.8
+    1916899n 1.8
+    1916900n 0
+    1916949n 0
+    1916950n 1.8
+    1916999n 1.8
+    1917000n 0
+    1917049n 0
+    1917050n 1.8
+    1917099n 1.8
+    1917100n 0
+    1917149n 0
+    1917150n 1.8
+    1917199n 1.8
+    1917200n 0
+    1917249n 0
+    1917250n 1.8
+    1917299n 1.8
+    1917300n 0
+    1917349n 0
+    1917350n 1.8
+    1917399n 1.8
+    1917400n 0
+    1917449n 0
+    1917450n 1.8
+    1917499n 1.8
+    1917500n 0
+    1917549n 0
+    1917550n 1.8
+    1917599n 1.8
+    1917600n 0
+    1917649n 0
+    1917650n 1.8
+    1917699n 1.8
+    1917700n 0
+    1917749n 0
+    1917750n 1.8
+    1917799n 1.8
+    1917800n 0
+    1917849n 0
+    1917850n 1.8
+    1917899n 1.8
+    1917900n 0
+    1917949n 0
+    1917950n 1.8
+    1917999n 1.8
+    1918000n 0
+    1918049n 0
+    1918050n 1.8
+    1918099n 1.8
+    1918100n 0
+    1918149n 0
+    1918150n 1.8
+    1918199n 1.8
+    1918200n 0
+    1918249n 0
+    1918250n 1.8
+    1918299n 1.8
+    1918300n 0
+    1918349n 0
+    1918350n 1.8
+    1918399n 1.8
+    1918400n 0
+    1918449n 0
+    1918450n 1.8
+    1918499n 1.8
+    1918500n 0
+    1918549n 0
+    1918550n 1.8
+    1918599n 1.8
+    1918600n 0
+    1918649n 0
+    1918650n 1.8
+    1918699n 1.8
+    1918700n 0
+    1918749n 0
+    1918750n 1.8
+    1918799n 1.8
+    1918800n 0
+    1918849n 0
+    1918850n 1.8
+    1918899n 1.8
+    1918900n 0
+    1918949n 0
+    1918950n 1.8
+    1918999n 1.8
+    1919000n 0
+    1919049n 0
+    1919050n 1.8
+    1919099n 1.8
+    1919100n 0
+    1919149n 0
+    1919150n 1.8
+    1919199n 1.8
+    1919200n 0
+    1919249n 0
+    1919250n 1.8
+    1919299n 1.8
+    1919300n 0
+    1919349n 0
+    1919350n 1.8
+    1919399n 1.8
+    1919400n 0
+    1919449n 0
+    1919450n 1.8
+    1919499n 1.8
+    1919500n 0
+    1919549n 0
+    1919550n 1.8
+    1919599n 1.8
+    1919600n 0
+    1919649n 0
+    1919650n 1.8
+    1919699n 1.8
+    1919700n 0
+    1919749n 0
+    1919750n 1.8
+    1919799n 1.8
+    1919800n 0
+    1919849n 0
+    1919850n 1.8
+    1919899n 1.8
+    1919900n 0
+    1919949n 0
+    1919950n 1.8
+    1919999n 1.8
+    1920000n 0
+    1920049n 0
+    1920050n 1.8
+    1920099n 1.8
+    1920100n 0
+    1920149n 0
+    1920150n 1.8
+    1920199n 1.8
+    1920200n 0
+    1920249n 0
+    1920250n 1.8
+    1920299n 1.8
+    1920300n 0
+    1920349n 0
+    1920350n 1.8
+    1920399n 1.8
+    1920400n 0
+    1920449n 0
+    1920450n 1.8
+    1920499n 1.8
+    1920500n 0
+    1920549n 0
+    1920550n 1.8
+    1920599n 1.8
+    1920600n 0
+    1920649n 0
+    1920650n 1.8
+    1920699n 1.8
+    1920700n 0
+    1920749n 0
+    1920750n 1.8
+    1920799n 1.8
+    1920800n 0
+    1920849n 0
+    1920850n 1.8
+    1920899n 1.8
+    1920900n 0
+    1920949n 0
+    1920950n 1.8
+    1920999n 1.8
+    1921000n 0
+    1921049n 0
+    1921050n 1.8
+    1921099n 1.8
+    1921100n 0
+    1921149n 0
+    1921150n 1.8
+    1921199n 1.8
+    1921200n 0
+    1921249n 0
+    1921250n 1.8
+    1921299n 1.8
+    1921300n 0
+    1921349n 0
+    1921350n 1.8
+    1921399n 1.8
+    1921400n 0
+    1921449n 0
+    1921450n 1.8
+    1921499n 1.8
+    1921500n 0
+    1921549n 0
+    1921550n 1.8
+    1921599n 1.8
+    1921600n 0
+    1921649n 0
+    1921650n 1.8
+    1921699n 1.8
+    1921700n 0
+    1921749n 0
+    1921750n 1.8
+    1921799n 1.8
+    1921800n 0
+    1921849n 0
+    1921850n 1.8
+    1921899n 1.8
+    1921900n 0
+    1921949n 0
+    1921950n 1.8
+    1921999n 1.8
+    1922000n 0
+    1922049n 0
+    1922050n 1.8
+    1922099n 1.8
+    1922100n 0
+    1922149n 0
+    1922150n 1.8
+    1922199n 1.8
+    1922200n 0
+    1922249n 0
+    1922250n 1.8
+    1922299n 1.8
+    1922300n 0
+    1922349n 0
+    1922350n 1.8
+    1922399n 1.8
+    1922400n 0
+    1922449n 0
+    1922450n 1.8
+    1922499n 1.8
+    1922500n 0
+    1922549n 0
+    1922550n 1.8
+    1922599n 1.8
+    1922600n 0
+    1922649n 0
+    1922650n 1.8
+    1922699n 1.8
+    1922700n 0
+    1922749n 0
+    1922750n 1.8
+    1922799n 1.8
+    1922800n 0
+    1922849n 0
+    1922850n 1.8
+    1922899n 1.8
+    1922900n 0
+    1922949n 0
+    1922950n 1.8
+    1922999n 1.8
+    1923000n 0
+    1923049n 0
+    1923050n 1.8
+    1923099n 1.8
+    1923100n 0
+    1923149n 0
+    1923150n 1.8
+    1923199n 1.8
+    1923200n 0
+    1923249n 0
+    1923250n 1.8
+    1923299n 1.8
+    1923300n 0
+    1923349n 0
+    1923350n 1.8
+    1923399n 1.8
+    1923400n 0
+    1923449n 0
+    1923450n 1.8
+    1923499n 1.8
+    1923500n 0
+    1923549n 0
+    1923550n 1.8
+    1923599n 1.8
+    1923600n 0
+    1923649n 0
+    1923650n 1.8
+    1923699n 1.8
+    1923700n 0
+    1923749n 0
+    1923750n 1.8
+    1923799n 1.8
+    1923800n 0
+    1923849n 0
+    1923850n 1.8
+    1923899n 1.8
+    1923900n 0
+    1923949n 0
+    1923950n 1.8
+    1923999n 1.8
+    1924000n 0
+    1924049n 0
+    1924050n 1.8
+    1924099n 1.8
+    1924100n 0
+    1924149n 0
+    1924150n 1.8
+    1924199n 1.8
+    1924200n 0
+    1924249n 0
+    1924250n 1.8
+    1924299n 1.8
+    1924300n 0
+    1924349n 0
+    1924350n 1.8
+    1924399n 1.8
+    1924400n 0
+    1924449n 0
+    1924450n 1.8
+    1924499n 1.8
+    1924500n 0
+    1924549n 0
+    1924550n 1.8
+    1924599n 1.8
+    1924600n 0
+    1924649n 0
+    1924650n 1.8
+    1924699n 1.8
+    1924700n 0
+    1924749n 0
+    1924750n 1.8
+    1924799n 1.8
+    1924800n 0
+    1924849n 0
+    1924850n 1.8
+    1924899n 1.8
+    1924900n 0
+    1924949n 0
+    1924950n 1.8
+    1924999n 1.8
+    1925000n 0
+    1925049n 0
+    1925050n 1.8
+    1925099n 1.8
+    1925100n 0
+    1925149n 0
+    1925150n 1.8
+    1925199n 1.8
+    1925200n 0
+    1925249n 0
+    1925250n 1.8
+    1925299n 1.8
+    1925300n 0
+    1925349n 0
+    1925350n 1.8
+    1925399n 1.8
+    1925400n 0
+    1925449n 0
+    1925450n 1.8
+    1925499n 1.8
+    1925500n 0
+    1925549n 0
+    1925550n 1.8
+    1925599n 1.8
+    1925600n 0
+    1925649n 0
+    1925650n 1.8
+    1925699n 1.8
+    1925700n 0
+    1925749n 0
+    1925750n 1.8
+    1925799n 1.8
+    1925800n 0
+    1925849n 0
+    1925850n 1.8
+    1925899n 1.8
+    1925900n 0
+    1925949n 0
+    1925950n 1.8
+    1925999n 1.8
+    1926000n 0
+    1926049n 0
+    1926050n 1.8
+    1926099n 1.8
+    1926100n 0
+    1926149n 0
+    1926150n 1.8
+    1926199n 1.8
+    1926200n 0
+    1926249n 0
+    1926250n 1.8
+    1926299n 1.8
+    1926300n 0
+    1926349n 0
+    1926350n 1.8
+    1926399n 1.8
+    1926400n 0
+    1926449n 0
+    1926450n 1.8
+    1926499n 1.8
+    1926500n 0
+    1926549n 0
+    1926550n 1.8
+    1926599n 1.8
+    1926600n 0
+    1926649n 0
+    1926650n 1.8
+    1926699n 1.8
+    1926700n 0
+    1926749n 0
+    1926750n 1.8
+    1926799n 1.8
+    1926800n 0
+    1926849n 0
+    1926850n 1.8
+    1926899n 1.8
+    1926900n 0
+    1926949n 0
+    1926950n 1.8
+    1926999n 1.8
+    1927000n 0
+    1927049n 0
+    1927050n 1.8
+    1927099n 1.8
+    1927100n 0
+    1927149n 0
+    1927150n 1.8
+    1927199n 1.8
+    1927200n 0
+    1927249n 0
+    1927250n 1.8
+    1927299n 1.8
+    1927300n 0
+    1927349n 0
+    1927350n 1.8
+    1927399n 1.8
+    1927400n 0
+    1927449n 0
+    1927450n 1.8
+    1927499n 1.8
+    1927500n 0
+    1927549n 0
+    1927550n 1.8
+    1927599n 1.8
+    1927600n 0
+    1927649n 0
+    1927650n 1.8
+    1927699n 1.8
+    1927700n 0
+    1927749n 0
+    1927750n 1.8
+    1927799n 1.8
+    1927800n 0
+    1927849n 0
+    1927850n 1.8
+    1927899n 1.8
+    1927900n 0
+    1927949n 0
+    1927950n 1.8
+    1927999n 1.8
+    1928000n 0
+    1928049n 0
+    1928050n 1.8
+    1928099n 1.8
+    1928100n 0
+    1928149n 0
+    1928150n 1.8
+    1928199n 1.8
+    1928200n 0
+    1928249n 0
+    1928250n 1.8
+    1928299n 1.8
+    1928300n 0
+    1928349n 0
+    1928350n 1.8
+    1928399n 1.8
+    1928400n 0
+    1928449n 0
+    1928450n 1.8
+    1928499n 1.8
+    1928500n 0
+    1928549n 0
+    1928550n 1.8
+    1928599n 1.8
+    1928600n 0
+    1928649n 0
+    1928650n 1.8
+    1928699n 1.8
+    1928700n 0
+    1928749n 0
+    1928750n 1.8
+    1928799n 1.8
+    1928800n 0
+    1928849n 0
+    1928850n 1.8
+    1928899n 1.8
+    1928900n 0
+    1928949n 0
+    1928950n 1.8
+    1928999n 1.8
+    1929000n 0
+    1929049n 0
+    1929050n 1.8
+    1929099n 1.8
+    1929100n 0
+    1929149n 0
+    1929150n 1.8
+    1929199n 1.8
+    1929200n 0
+    1929249n 0
+    1929250n 1.8
+    1929299n 1.8
+    1929300n 0
+    1929349n 0
+    1929350n 1.8
+    1929399n 1.8
+    1929400n 0
+    1929449n 0
+    1929450n 1.8
+    1929499n 1.8
+    1929500n 0
+    1929549n 0
+    1929550n 1.8
+    1929599n 1.8
+    1929600n 0
+    1929649n 0
+    1929650n 1.8
+    1929699n 1.8
+    1929700n 0
+    1929749n 0
+    1929750n 1.8
+    1929799n 1.8
+    1929800n 0
+    1929849n 0
+    1929850n 1.8
+    1929899n 1.8
+    1929900n 0
+    1929949n 0
+    1929950n 1.8
+    1929999n 1.8
+    1930000n 0
+    1930049n 0
+    1930050n 1.8
+    1930099n 1.8
+    1930100n 0
+    1930149n 0
+    1930150n 1.8
+    1930199n 1.8
+    1930200n 0
+    1930249n 0
+    1930250n 1.8
+    1930299n 1.8
+    1930300n 0
+    1930349n 0
+    1930350n 1.8
+    1930399n 1.8
+    1930400n 0
+    1930449n 0
+    1930450n 1.8
+    1930499n 1.8
+    1930500n 0
+    1930549n 0
+    1930550n 1.8
+    1930599n 1.8
+    1930600n 0
+    1930649n 0
+    1930650n 1.8
+    1930699n 1.8
+    1930700n 0
+    1930749n 0
+    1930750n 1.8
+    1930799n 1.8
+    1930800n 0
+    1930849n 0
+    1930850n 1.8
+    1930899n 1.8
+    1930900n 0
+    1930949n 0
+    1930950n 1.8
+    1930999n 1.8
+    1931000n 0
+    1931049n 0
+    1931050n 1.8
+    1931099n 1.8
+    1931100n 0
+    1931149n 0
+    1931150n 1.8
+    1931199n 1.8
+    1931200n 0
+    1931249n 0
+    1931250n 1.8
+    1931299n 1.8
+    1931300n 0
+    1931349n 0
+    1931350n 1.8
+    1931399n 1.8
+    1931400n 0
+    1931449n 0
+    1931450n 1.8
+    1931499n 1.8
+    1931500n 0
+    1931549n 0
+    1931550n 1.8
+    1931599n 1.8
+    1931600n 0
+    1931649n 0
+    1931650n 1.8
+    1931699n 1.8
+    1931700n 0
+    1931749n 0
+    1931750n 1.8
+    1931799n 1.8
+    1931800n 0
+    1931849n 0
+    1931850n 1.8
+    1931899n 1.8
+    1931900n 0
+    1931949n 0
+    1931950n 1.8
+    1931999n 1.8
+    1932000n 0
+    1932049n 0
+    1932050n 1.8
+    1932099n 1.8
+    1932100n 0
+    1932149n 0
+    1932150n 1.8
+    1932199n 1.8
+    1932200n 0
+    1932249n 0
+    1932250n 1.8
+    1932299n 1.8
+    1932300n 0
+    1932349n 0
+    1932350n 1.8
+    1932399n 1.8
+    1932400n 0
+    1932449n 0
+    1932450n 1.8
+    1932499n 1.8
+    1932500n 0
+    1932549n 0
+    1932550n 1.8
+    1932599n 1.8
+    1932600n 0
+    1932649n 0
+    1932650n 1.8
+    1932699n 1.8
+    1932700n 0
+    1932749n 0
+    1932750n 1.8
+    1932799n 1.8
+    1932800n 0
+    1932849n 0
+    1932850n 1.8
+    1932899n 1.8
+    1932900n 0
+    1932949n 0
+    1932950n 1.8
+    1932999n 1.8
+    1933000n 0
+    1933049n 0
+    1933050n 1.8
+    1933099n 1.8
+    1933100n 0
+    1933149n 0
+    1933150n 1.8
+    1933199n 1.8
+    1933200n 0
+    1933249n 0
+    1933250n 1.8
+    1933299n 1.8
+    1933300n 0
+    1933349n 0
+    1933350n 1.8
+    1933399n 1.8
+    1933400n 0
+    1933449n 0
+    1933450n 1.8
+    1933499n 1.8
+    1933500n 0
+    1933549n 0
+    1933550n 1.8
+    1933599n 1.8
+    1933600n 0
+    1933649n 0
+    1933650n 1.8
+    1933699n 1.8
+    1933700n 0
+    1933749n 0
+    1933750n 1.8
+    1933799n 1.8
+    1933800n 0
+    1933849n 0
+    1933850n 1.8
+    1933899n 1.8
+    1933900n 0
+    1933949n 0
+    1933950n 1.8
+    1933999n 1.8
+    1934000n 0
+    1934049n 0
+    1934050n 1.8
+    1934099n 1.8
+    1934100n 0
+    1934149n 0
+    1934150n 1.8
+    1934199n 1.8
+    1934200n 0
+    1934249n 0
+    1934250n 1.8
+    1934299n 1.8
+    1934300n 0
+    1934349n 0
+    1934350n 1.8
+    1934399n 1.8
+    1934400n 0
+    1934449n 0
+    1934450n 1.8
+    1934499n 1.8
+    1934500n 0
+    1934549n 0
+    1934550n 1.8
+    1934599n 1.8
+    1934600n 0
+    1934649n 0
+    1934650n 1.8
+    1934699n 1.8
+    1934700n 0
+    1934749n 0
+    1934750n 1.8
+    1934799n 1.8
+    1934800n 0
+    1934849n 0
+    1934850n 1.8
+    1934899n 1.8
+    1934900n 0
+    1934949n 0
+    1934950n 1.8
+    1934999n 1.8
+    1935000n 0
+    1935049n 0
+    1935050n 1.8
+    1935099n 1.8
+    1935100n 0
+    1935149n 0
+    1935150n 1.8
+    1935199n 1.8
+    1935200n 0
+    1935249n 0
+    1935250n 1.8
+    1935299n 1.8
+    1935300n 0
+    1935349n 0
+    1935350n 1.8
+    1935399n 1.8
+    1935400n 0
+    1935449n 0
+    1935450n 1.8
+    1935499n 1.8
+    1935500n 0
+    1935549n 0
+    1935550n 1.8
+    1935599n 1.8
+    1935600n 0
+    1935649n 0
+    1935650n 1.8
+    1935699n 1.8
+    1935700n 0
+    1935749n 0
+    1935750n 1.8
+    1935799n 1.8
+    1935800n 0
+    1935849n 0
+    1935850n 1.8
+    1935899n 1.8
+    1935900n 0
+    1935949n 0
+    1935950n 1.8
+    1935999n 1.8
+    1936000n 0
+    1936049n 0
+    1936050n 1.8
+    1936099n 1.8
+    1936100n 0
+    1936149n 0
+    1936150n 1.8
+    1936199n 1.8
+    1936200n 0
+    1936249n 0
+    1936250n 1.8
+    1936299n 1.8
+    1936300n 0
+    1936349n 0
+    1936350n 1.8
+    1936399n 1.8
+    1936400n 0
+    1936449n 0
+    1936450n 1.8
+    1936499n 1.8
+    1936500n 0
+    1936549n 0
+    1936550n 1.8
+    1936599n 1.8
+    1936600n 0
+    1936649n 0
+    1936650n 1.8
+    1936699n 1.8
+    1936700n 0
+    1936749n 0
+    1936750n 1.8
+    1936799n 1.8
+    1936800n 0
+    1936849n 0
+    1936850n 1.8
+    1936899n 1.8
+    1936900n 0
+    1936949n 0
+    1936950n 1.8
+    1936999n 1.8
+    1937000n 0
+    1937049n 0
+    1937050n 1.8
+    1937099n 1.8
+    1937100n 0
+    1937149n 0
+    1937150n 1.8
+    1937199n 1.8
+    1937200n 0
+    1937249n 0
+    1937250n 1.8
+    1937299n 1.8
+    1937300n 0
+    1937349n 0
+    1937350n 1.8
+    1937399n 1.8
+    1937400n 0
+    1937449n 0
+    1937450n 1.8
+    1937499n 1.8
+    1937500n 0
+    1937549n 0
+    1937550n 1.8
+    1937599n 1.8
+    1937600n 0
+    1937649n 0
+    1937650n 1.8
+    1937699n 1.8
+    1937700n 0
+    1937749n 0
+    1937750n 1.8
+    1937799n 1.8
+    1937800n 0
+    1937849n 0
+    1937850n 1.8
+    1937899n 1.8
+    1937900n 0
+    1937949n 0
+    1937950n 1.8
+    1937999n 1.8
+    1938000n 0
+    1938049n 0
+    1938050n 1.8
+    1938099n 1.8
+    1938100n 0
+    1938149n 0
+    1938150n 1.8
+    1938199n 1.8
+    1938200n 0
+    1938249n 0
+    1938250n 1.8
+    1938299n 1.8
+    1938300n 0
+    1938349n 0
+    1938350n 1.8
+    1938399n 1.8
+    1938400n 0
+    1938449n 0
+    1938450n 1.8
+    1938499n 1.8
+    1938500n 0
+    1938549n 0
+    1938550n 1.8
+    1938599n 1.8
+    1938600n 0
+    1938649n 0
+    1938650n 1.8
+    1938699n 1.8
+    1938700n 0
+    1938749n 0
+    1938750n 1.8
+    1938799n 1.8
+    1938800n 0
+    1938849n 0
+    1938850n 1.8
+    1938899n 1.8
+    1938900n 0
+    1938949n 0
+    1938950n 1.8
+    1938999n 1.8
+    1939000n 0
+    1939049n 0
+    1939050n 1.8
+    1939099n 1.8
+    1939100n 0
+    1939149n 0
+    1939150n 1.8
+    1939199n 1.8
+    1939200n 0
+    1939249n 0
+    1939250n 1.8
+    1939299n 1.8
+    1939300n 0
+    1939349n 0
+    1939350n 1.8
+    1939399n 1.8
+    1939400n 0
+    1939449n 0
+    1939450n 1.8
+    1939499n 1.8
+    1939500n 0
+    1939549n 0
+    1939550n 1.8
+    1939599n 1.8
+    1939600n 0
+    1939649n 0
+    1939650n 1.8
+    1939699n 1.8
+    1939700n 0
+    1939749n 0
+    1939750n 1.8
+    1939799n 1.8
+    1939800n 0
+    1939849n 0
+    1939850n 1.8
+    1939899n 1.8
+    1939900n 0
+    1939949n 0
+    1939950n 1.8
+    1939999n 1.8
+    1940000n 0
+    1940049n 0
+    1940050n 1.8
+    1940099n 1.8
+    1940100n 0
+    1940149n 0
+    1940150n 1.8
+    1940199n 1.8
+    1940200n 0
+    1940249n 0
+    1940250n 1.8
+    1940299n 1.8
+    1940300n 0
+    1940349n 0
+    1940350n 1.8
+    1940399n 1.8
+    1940400n 0
+    1940449n 0
+    1940450n 1.8
+    1940499n 1.8
+    1940500n 0
+    1940549n 0
+    1940550n 1.8
+    1940599n 1.8
+    1940600n 0
+    1940649n 0
+    1940650n 1.8
+    1940699n 1.8
+    1940700n 0
+    1940749n 0
+    1940750n 1.8
+    1940799n 1.8
+    1940800n 0
+    1940849n 0
+    1940850n 1.8
+    1940899n 1.8
+    1940900n 0
+    1940949n 0
+    1940950n 1.8
+    1940999n 1.8
+    1941000n 0
+    1941049n 0
+    1941050n 1.8
+    1941099n 1.8
+    1941100n 0
+    1941149n 0
+    1941150n 1.8
+    1941199n 1.8
+    1941200n 0
+    1941249n 0
+    1941250n 1.8
+    1941299n 1.8
+    1941300n 0
+    1941349n 0
+    1941350n 1.8
+    1941399n 1.8
+    1941400n 0
+    1941449n 0
+    1941450n 1.8
+    1941499n 1.8
+    1941500n 0
+    1941549n 0
+    1941550n 1.8
+    1941599n 1.8
+    1941600n 0
+    1941649n 0
+    1941650n 1.8
+    1941699n 1.8
+    1941700n 0
+    1941749n 0
+    1941750n 1.8
+    1941799n 1.8
+    1941800n 0
+    1941849n 0
+    1941850n 1.8
+    1941899n 1.8
+    1941900n 0
+    1941949n 0
+    1941950n 1.8
+    1941999n 1.8
+    1942000n 0
+    1942049n 0
+    1942050n 1.8
+    1942099n 1.8
+    1942100n 0
+    1942149n 0
+    1942150n 1.8
+    1942199n 1.8
+    1942200n 0
+    1942249n 0
+    1942250n 1.8
+    1942299n 1.8
+    1942300n 0
+    1942349n 0
+    1942350n 1.8
+    1942399n 1.8
+    1942400n 0
+    1942449n 0
+    1942450n 1.8
+    1942499n 1.8
+    1942500n 0
+    1942549n 0
+    1942550n 1.8
+    1942599n 1.8
+    1942600n 0
+    1942649n 0
+    1942650n 1.8
+    1942699n 1.8
+    1942700n 0
+    1942749n 0
+    1942750n 1.8
+    1942799n 1.8
+    1942800n 0
+    1942849n 0
+    1942850n 1.8
+    1942899n 1.8
+    1942900n 0
+    1942949n 0
+    1942950n 1.8
+    1942999n 1.8
+    1943000n 0
+    1943049n 0
+    1943050n 1.8
+    1943099n 1.8
+    1943100n 0
+    1943149n 0
+    1943150n 1.8
+    1943199n 1.8
+    1943200n 0
+    1943249n 0
+    1943250n 1.8
+    1943299n 1.8
+    1943300n 0
+    1943349n 0
+    1943350n 1.8
+    1943399n 1.8
+    1943400n 0
+    1943449n 0
+    1943450n 1.8
+    1943499n 1.8
+    1943500n 0
+    1943549n 0
+    1943550n 1.8
+    1943599n 1.8
+    1943600n 0
+    1943649n 0
+    1943650n 1.8
+    1943699n 1.8
+    1943700n 0
+    1943749n 0
+    1943750n 1.8
+    1943799n 1.8
+    1943800n 0
+    1943849n 0
+    1943850n 1.8
+    1943899n 1.8
+    1943900n 0
+    1943949n 0
+    1943950n 1.8
+    1943999n 1.8
+    1944000n 0
+    1944049n 0
+    1944050n 1.8
+    1944099n 1.8
+    1944100n 0
+    1944149n 0
+    1944150n 1.8
+    1944199n 1.8
+    1944200n 0
+    1944249n 0
+    1944250n 1.8
+    1944299n 1.8
+    1944300n 0
+    1944349n 0
+    1944350n 1.8
+    1944399n 1.8
+    1944400n 0
+    1944449n 0
+    1944450n 1.8
+    1944499n 1.8
+    1944500n 0
+    1944549n 0
+    1944550n 1.8
+    1944599n 1.8
+    1944600n 0
+    1944649n 0
+    1944650n 1.8
+    1944699n 1.8
+    1944700n 0
+    1944749n 0
+    1944750n 1.8
+    1944799n 1.8
+    1944800n 0
+    1944849n 0
+    1944850n 1.8
+    1944899n 1.8
+    1944900n 0
+    1944949n 0
+    1944950n 1.8
+    1944999n 1.8
+    1945000n 0
+    1945049n 0
+    1945050n 1.8
+    1945099n 1.8
+    1945100n 0
+    1945149n 0
+    1945150n 1.8
+    1945199n 1.8
+    1945200n 0
+    1945249n 0
+    1945250n 1.8
+    1945299n 1.8
+    1945300n 0
+    1945349n 0
+    1945350n 1.8
+    1945399n 1.8
+    1945400n 0
+    1945449n 0
+    1945450n 1.8
+    1945499n 1.8
+    1945500n 0
+    1945549n 0
+    1945550n 1.8
+    1945599n 1.8
+    1945600n 0
+    1945649n 0
+    1945650n 1.8
+    1945699n 1.8
+    1945700n 0
+    1945749n 0
+    1945750n 1.8
+    1945799n 1.8
+    1945800n 0
+    1945849n 0
+    1945850n 1.8
+    1945899n 1.8
+    1945900n 0
+    1945949n 0
+    1945950n 1.8
+    1945999n 1.8
+    1946000n 0
+    1946049n 0
+    1946050n 1.8
+    1946099n 1.8
+    1946100n 0
+    1946149n 0
+    1946150n 1.8
+    1946199n 1.8
+    1946200n 0
+    1946249n 0
+    1946250n 1.8
+    1946299n 1.8
+    1946300n 0
+    1946349n 0
+    1946350n 1.8
+    1946399n 1.8
+    1946400n 0
+    1946449n 0
+    1946450n 1.8
+    1946499n 1.8
+    1946500n 0
+    1946549n 0
+    1946550n 1.8
+    1946599n 1.8
+    1946600n 0
+    1946649n 0
+    1946650n 1.8
+    1946699n 1.8
+    1946700n 0
+    1946749n 0
+    1946750n 1.8
+    1946799n 1.8
+    1946800n 0
+    1946849n 0
+    1946850n 1.8
+    1946899n 1.8
+    1946900n 0
+    1946949n 0
+    1946950n 1.8
+    1946999n 1.8
+    1947000n 0
+    1947049n 0
+    1947050n 1.8
+    1947099n 1.8
+    1947100n 0
+    1947149n 0
+    1947150n 1.8
+    1947199n 1.8
+    1947200n 0
+    1947249n 0
+    1947250n 1.8
+    1947299n 1.8
+    1947300n 0
+    1947349n 0
+    1947350n 1.8
+    1947399n 1.8
+    1947400n 0
+    1947449n 0
+    1947450n 1.8
+    1947499n 1.8
+    1947500n 0
+    1947549n 0
+    1947550n 1.8
+    1947599n 1.8
+    1947600n 0
+    1947649n 0
+    1947650n 1.8
+    1947699n 1.8
+    1947700n 0
+    1947749n 0
+    1947750n 1.8
+    1947799n 1.8
+    1947800n 0
+    1947849n 0
+    1947850n 1.8
+    1947899n 1.8
+    1947900n 0
+    1947949n 0
+    1947950n 1.8
+    1947999n 1.8
+    1948000n 0
+    1948049n 0
+    1948050n 1.8
+    1948099n 1.8
+    1948100n 0
+    1948149n 0
+    1948150n 1.8
+    1948199n 1.8
+    1948200n 0
+    1948249n 0
+    1948250n 1.8
+    1948299n 1.8
+    1948300n 0
+    1948349n 0
+    1948350n 1.8
+    1948399n 1.8
+    1948400n 0
+    1948449n 0
+    1948450n 1.8
+    1948499n 1.8
+    1948500n 0
+    1948549n 0
+    1948550n 1.8
+    1948599n 1.8
+    1948600n 0
+    1948649n 0
+    1948650n 1.8
+    1948699n 1.8
+    1948700n 0
+    1948749n 0
+    1948750n 1.8
+    1948799n 1.8
+    1948800n 0
+    1948849n 0
+    1948850n 1.8
+    1948899n 1.8
+    1948900n 0
+    1948949n 0
+    1948950n 1.8
+    1948999n 1.8
+    1949000n 0
+    1949049n 0
+    1949050n 1.8
+    1949099n 1.8
+    1949100n 0
+    1949149n 0
+    1949150n 1.8
+    1949199n 1.8
+    1949200n 0
+    1949249n 0
+    1949250n 1.8
+    1949299n 1.8
+    1949300n 0
+    1949349n 0
+    1949350n 1.8
+    1949399n 1.8
+    1949400n 0
+    1949449n 0
+    1949450n 1.8
+    1949499n 1.8
+    1949500n 0
+    1949549n 0
+    1949550n 1.8
+    1949599n 1.8
+    1949600n 0
+    1949649n 0
+    1949650n 1.8
+    1949699n 1.8
+    1949700n 0
+    1949749n 0
+    1949750n 1.8
+    1949799n 1.8
+    1949800n 0
+    1949849n 0
+    1949850n 1.8
+    1949899n 1.8
+    1949900n 0
+    1949949n 0
+    1949950n 1.8
+    1949999n 1.8
+    1950000n 0
+    1950049n 0
+    1950050n 1.8
+    1950099n 1.8
+    1950100n 0
+    1950149n 0
+    1950150n 1.8
+    1950199n 1.8
+    1950200n 0
+    1950249n 0
+    1950250n 1.8
+    1950299n 1.8
+    1950300n 0
+    1950349n 0
+    1950350n 1.8
+    1950399n 1.8
+    1950400n 0
+    1950449n 0
+    1950450n 1.8
+    1950499n 1.8
+    1950500n 0
+    1950549n 0
+    1950550n 1.8
+    1950599n 1.8
+    1950600n 0
+    1950649n 0
+    1950650n 1.8
+    1950699n 1.8
+    1950700n 0
+    1950749n 0
+    1950750n 1.8
+    1950799n 1.8
+    1950800n 0
+    1950849n 0
+    1950850n 1.8
+    1950899n 1.8
+    1950900n 0
+    1950949n 0
+    1950950n 1.8
+    1950999n 1.8
+    1951000n 0
+    1951049n 0
+    1951050n 1.8
+    1951099n 1.8
+    1951100n 0
+    1951149n 0
+    1951150n 1.8
+    1951199n 1.8
+    1951200n 0
+    1951249n 0
+    1951250n 1.8
+    1951299n 1.8
+    1951300n 0
+    1951349n 0
+    1951350n 1.8
+    1951399n 1.8
+    1951400n 0
+    1951449n 0
+    1951450n 1.8
+    1951499n 1.8
+    1951500n 0
+    1951549n 0
+    1951550n 1.8
+    1951599n 1.8
+    1951600n 0
+    1951649n 0
+    1951650n 1.8
+    1951699n 1.8
+    1951700n 0
+    1951749n 0
+    1951750n 1.8
+    1951799n 1.8
+    1951800n 0
+    1951849n 0
+    1951850n 1.8
+    1951899n 1.8
+    1951900n 0
+    1951949n 0
+    1951950n 1.8
+    1951999n 1.8
+    1952000n 0
+    1952049n 0
+    1952050n 1.8
+    1952099n 1.8
+    1952100n 0
+    1952149n 0
+    1952150n 1.8
+    1952199n 1.8
+    1952200n 0
+    1952249n 0
+    1952250n 1.8
+    1952299n 1.8
+    1952300n 0
+    1952349n 0
+    1952350n 1.8
+    1952399n 1.8
+    1952400n 0
+    1952449n 0
+    1952450n 1.8
+    1952499n 1.8
+    1952500n 0
+    1952549n 0
+    1952550n 1.8
+    1952599n 1.8
+    1952600n 0
+    1952649n 0
+    1952650n 1.8
+    1952699n 1.8
+    1952700n 0
+    1952749n 0
+    1952750n 1.8
+    1952799n 1.8
+    1952800n 0
+    1952849n 0
+    1952850n 1.8
+    1952899n 1.8
+    1952900n 0
+    1952949n 0
+    1952950n 1.8
+    1952999n 1.8
+    1953000n 0
+    1953049n 0
+    1953050n 1.8
+    1953099n 1.8
+    1953100n 0
+    1953149n 0
+    1953150n 1.8
+    1953199n 1.8
+    1953200n 0
+    1953249n 0
+    1953250n 1.8
+    1953299n 1.8
+    1953300n 0
+    1953349n 0
+    1953350n 1.8
+    1953399n 1.8
+    1953400n 0
+    1953449n 0
+    1953450n 1.8
+    1953499n 1.8
+    1953500n 0
+    1953549n 0
+    1953550n 1.8
+    1953599n 1.8
+    1953600n 0
+    1953649n 0
+    1953650n 1.8
+    1953699n 1.8
+    1953700n 0
+    1953749n 0
+    1953750n 1.8
+    1953799n 1.8
+    1953800n 0
+    1953849n 0
+    1953850n 1.8
+    1953899n 1.8
+    1953900n 0
+    1953949n 0
+    1953950n 1.8
+    1953999n 1.8
+    1954000n 0
+    1954049n 0
+    1954050n 1.8
+    1954099n 1.8
+    1954100n 0
+    1954149n 0
+    1954150n 1.8
+    1954199n 1.8
+    1954200n 0
+    1954249n 0
+    1954250n 1.8
+    1954299n 1.8
+    1954300n 0
+    1954349n 0
+    1954350n 1.8
+    1954399n 1.8
+    1954400n 0
+    1954449n 0
+    1954450n 1.8
+    1954499n 1.8
+    1954500n 0
+    1954549n 0
+    1954550n 1.8
+    1954599n 1.8
+    1954600n 0
+    1954649n 0
+    1954650n 1.8
+    1954699n 1.8
+    1954700n 0
+    1954749n 0
+    1954750n 1.8
+    1954799n 1.8
+    1954800n 0
+    1954849n 0
+    1954850n 1.8
+    1954899n 1.8
+    1954900n 0
+    1954949n 0
+    1954950n 1.8
+    1954999n 1.8
+    1955000n 0
+    1955049n 0
+    1955050n 1.8
+    1955099n 1.8
+    1955100n 0
+    1955149n 0
+    1955150n 1.8
+    1955199n 1.8
+    1955200n 0
+    1955249n 0
+    1955250n 1.8
+    1955299n 1.8
+    1955300n 0
+    1955349n 0
+    1955350n 1.8
+    1955399n 1.8
+    1955400n 0
+    1955449n 0
+    1955450n 1.8
+    1955499n 1.8
+    1955500n 0
+    1955549n 0
+    1955550n 1.8
+    1955599n 1.8
+    1955600n 0
+    1955649n 0
+    1955650n 1.8
+    1955699n 1.8
+    1955700n 0
+    1955749n 0
+    1955750n 1.8
+    1955799n 1.8
+    1955800n 0
+    1955849n 0
+    1955850n 1.8
+    1955899n 1.8
+    1955900n 0
+    1955949n 0
+    1955950n 1.8
+    1955999n 1.8
+    1956000n 0
+    1956049n 0
+    1956050n 1.8
+    1956099n 1.8
+    1956100n 0
+    1956149n 0
+    1956150n 1.8
+    1956199n 1.8
+    1956200n 0
+    1956249n 0
+    1956250n 1.8
+    1956299n 1.8
+    1956300n 0
+    1956349n 0
+    1956350n 1.8
+    1956399n 1.8
+    1956400n 0
+    1956449n 0
+    1956450n 1.8
+    1956499n 1.8
+    1956500n 0
+    1956549n 0
+    1956550n 1.8
+    1956599n 1.8
+    1956600n 0
+    1956649n 0
+    1956650n 1.8
+    1956699n 1.8
+    1956700n 0
+    1956749n 0
+    1956750n 1.8
+    1956799n 1.8
+    1956800n 0
+    1956849n 0
+    1956850n 1.8
+    1956899n 1.8
+    1956900n 0
+    1956949n 0
+    1956950n 1.8
+    1956999n 1.8
+    1957000n 0
+    1957049n 0
+    1957050n 1.8
+    1957099n 1.8
+    1957100n 0
+    1957149n 0
+    1957150n 1.8
+    1957199n 1.8
+    1957200n 0
+    1957249n 0
+    1957250n 1.8
+    1957299n 1.8
+    1957300n 0
+    1957349n 0
+    1957350n 1.8
+    1957399n 1.8
+    1957400n 0
+    1957449n 0
+    1957450n 1.8
+    1957499n 1.8
+    1957500n 0
+    1957549n 0
+    1957550n 1.8
+    1957599n 1.8
+    1957600n 0
+    1957649n 0
+    1957650n 1.8
+    1957699n 1.8
+    1957700n 0
+    1957749n 0
+    1957750n 1.8
+    1957799n 1.8
+    1957800n 0
+    1957849n 0
+    1957850n 1.8
+    1957899n 1.8
+    1957900n 0
+    1957949n 0
+    1957950n 1.8
+    1957999n 1.8
+    1958000n 0
+    1958049n 0
+    1958050n 1.8
+    1958099n 1.8
+    1958100n 0
+    1958149n 0
+    1958150n 1.8
+    1958199n 1.8
+    1958200n 0
+    1958249n 0
+    1958250n 1.8
+    1958299n 1.8
+    1958300n 0
+    1958349n 0
+    1958350n 1.8
+    1958399n 1.8
+    1958400n 0
+    1958449n 0
+    1958450n 1.8
+    1958499n 1.8
+    1958500n 0
+    1958549n 0
+    1958550n 1.8
+    1958599n 1.8
+    1958600n 0
+    1958649n 0
+    1958650n 1.8
+    1958699n 1.8
+    1958700n 0
+    1958749n 0
+    1958750n 1.8
+    1958799n 1.8
+    1958800n 0
+    1958849n 0
+    1958850n 1.8
+    1958899n 1.8
+    1958900n 0
+    1958949n 0
+    1958950n 1.8
+    1958999n 1.8
+    1959000n 0
+    1959049n 0
+    1959050n 1.8
+    1959099n 1.8
+    1959100n 0
+    1959149n 0
+    1959150n 1.8
+    1959199n 1.8
+    1959200n 0
+    1959249n 0
+    1959250n 1.8
+    1959299n 1.8
+    1959300n 0
+    1959349n 0
+    1959350n 1.8
+    1959399n 1.8
+    1959400n 0
+    1959449n 0
+    1959450n 1.8
+    1959499n 1.8
+    1959500n 0
+    1959549n 0
+    1959550n 1.8
+    1959599n 1.8
+    1959600n 0
+    1959649n 0
+    1959650n 1.8
+    1959699n 1.8
+    1959700n 0
+    1959749n 0
+    1959750n 1.8
+    1959799n 1.8
+    1959800n 0
+    1959849n 0
+    1959850n 1.8
+    1959899n 1.8
+    1959900n 0
+    1959949n 0
+    1959950n 1.8
+    1959999n 1.8
+    1960000n 0
+    1960049n 0
+    1960050n 1.8
+    1960099n 1.8
+    1960100n 0
+    1960149n 0
+    1960150n 1.8
+    1960199n 1.8
+    1960200n 0
+    1960249n 0
+    1960250n 1.8
+    1960299n 1.8
+    1960300n 0
+    1960349n 0
+    1960350n 1.8
+    1960399n 1.8
+    1960400n 0
+    1960449n 0
+    1960450n 1.8
+    1960499n 1.8
+    1960500n 0
+    1960549n 0
+    1960550n 1.8
+    1960599n 1.8
+    1960600n 0
+    1960649n 0
+    1960650n 1.8
+    1960699n 1.8
+    1960700n 0
+    1960749n 0
+    1960750n 1.8
+    1960799n 1.8
+    1960800n 0
+    1960849n 0
+    1960850n 1.8
+    1960899n 1.8
+    1960900n 0
+    1960949n 0
+    1960950n 1.8
+    1960999n 1.8
+    1961000n 0
+    1961049n 0
+    1961050n 1.8
+    1961099n 1.8
+    1961100n 0
+    1961149n 0
+    1961150n 1.8
+    1961199n 1.8
+    1961200n 0
+    1961249n 0
+    1961250n 1.8
+    1961299n 1.8
+    1961300n 0
+    1961349n 0
+    1961350n 1.8
+    1961399n 1.8
+    1961400n 0
+    1961449n 0
+    1961450n 1.8
+    1961499n 1.8
+    1961500n 0
+    1961549n 0
+    1961550n 1.8
+    1961599n 1.8
+    1961600n 0
+    1961649n 0
+    1961650n 1.8
+    1961699n 1.8
+    1961700n 0
+    1961749n 0
+    1961750n 1.8
+    1961799n 1.8
+    1961800n 0
+    1961849n 0
+    1961850n 1.8
+    1961899n 1.8
+    1961900n 0
+    1961949n 0
+    1961950n 1.8
+    1961999n 1.8
+    1962000n 0
+    1962049n 0
+    1962050n 1.8
+    1962099n 1.8
+    1962100n 0
+    1962149n 0
+    1962150n 1.8
+    1962199n 1.8
+    1962200n 0
+    1962249n 0
+    1962250n 1.8
+    1962299n 1.8
+    1962300n 0
+    1962349n 0
+    1962350n 1.8
+    1962399n 1.8
+    1962400n 0
+    1962449n 0
+    1962450n 1.8
+    1962499n 1.8
+    1962500n 0
+    1962549n 0
+    1962550n 1.8
+    1962599n 1.8
+    1962600n 0
+    1962649n 0
+    1962650n 1.8
+    1962699n 1.8
+    1962700n 0
+    1962749n 0
+    1962750n 1.8
+    1962799n 1.8
+    1962800n 0
+    1962849n 0
+    1962850n 1.8
+    1962899n 1.8
+    1962900n 0
+    1962949n 0
+    1962950n 1.8
+    1962999n 1.8
+    1963000n 0
+    1963049n 0
+    1963050n 1.8
+    1963099n 1.8
+    1963100n 0
+    1963149n 0
+    1963150n 1.8
+    1963199n 1.8
+    1963200n 0
+    1963249n 0
+    1963250n 1.8
+    1963299n 1.8
+    1963300n 0
+    1963349n 0
+    1963350n 1.8
+    1963399n 1.8
+    1963400n 0
+    1963449n 0
+    1963450n 1.8
+    1963499n 1.8
+    1963500n 0
+    1963549n 0
+    1963550n 1.8
+    1963599n 1.8
+    1963600n 0
+    1963649n 0
+    1963650n 1.8
+    1963699n 1.8
+    1963700n 0
+    1963749n 0
+    1963750n 1.8
+    1963799n 1.8
+    1963800n 0
+    1963849n 0
+    1963850n 1.8
+    1963899n 1.8
+    1963900n 0
+    1963949n 0
+    1963950n 1.8
+    1963999n 1.8
+    1964000n 0
+    1964049n 0
+    1964050n 1.8
+    1964099n 1.8
+    1964100n 0
+    1964149n 0
+    1964150n 1.8
+    1964199n 1.8
+    1964200n 0
+    1964249n 0
+    1964250n 1.8
+    1964299n 1.8
+    1964300n 0
+    1964349n 0
+    1964350n 1.8
+    1964399n 1.8
+    1964400n 0
+    1964449n 0
+    1964450n 1.8
+    1964499n 1.8
+    1964500n 0
+    1964549n 0
+    1964550n 1.8
+    1964599n 1.8
+    1964600n 0
+    1964649n 0
+    1964650n 1.8
+    1964699n 1.8
+    1964700n 0
+    1964749n 0
+    1964750n 1.8
+    1964799n 1.8
+    1964800n 0
+    1964849n 0
+    1964850n 1.8
+    1964899n 1.8
+    1964900n 0
+    1964949n 0
+    1964950n 1.8
+    1964999n 1.8
+    1965000n 0
+    1965049n 0
+    1965050n 1.8
+    1965099n 1.8
+    1965100n 0
+    1965149n 0
+    1965150n 1.8
+    1965199n 1.8
+    1965200n 0
+    1965249n 0
+    1965250n 1.8
+    1965299n 1.8
+    1965300n 0
+    1965349n 0
+    1965350n 1.8
+    1965399n 1.8
+    1965400n 0
+    1965449n 0
+    1965450n 1.8
+    1965499n 1.8
+    1965500n 0
+    1965549n 0
+    1965550n 1.8
+    1965599n 1.8
+    1965600n 0
+    1965649n 0
+    1965650n 1.8
+    1965699n 1.8
+    1965700n 0
+    1965749n 0
+    1965750n 1.8
+    1965799n 1.8
+    1965800n 0
+    1965849n 0
+    1965850n 1.8
+    1965899n 1.8
+    1965900n 0
+    1965949n 0
+    1965950n 1.8
+    1965999n 1.8
+    1966000n 0
+    1966049n 0
+    1966050n 1.8
+    1966099n 1.8
+    1966100n 0
+    1966149n 0
+    1966150n 1.8
+    1966199n 1.8
+    1966200n 0
+    1966249n 0
+    1966250n 1.8
+    1966299n 1.8
+    1966300n 0
+    1966349n 0
+    1966350n 1.8
+    1966399n 1.8
+    1966400n 0
+    1966449n 0
+    1966450n 1.8
+    1966499n 1.8
+    1966500n 0
+    1966549n 0
+    1966550n 1.8
+    1966599n 1.8
+    1966600n 0
+    1966649n 0
+    1966650n 1.8
+    1966699n 1.8
+    1966700n 0
+    1966749n 0
+    1966750n 1.8
+    1966799n 1.8
+    1966800n 0
+    1966849n 0
+    1966850n 1.8
+    1966899n 1.8
+    1966900n 0
+    1966949n 0
+    1966950n 1.8
+    1966999n 1.8
+    1967000n 0
+    1967049n 0
+    1967050n 1.8
+    1967099n 1.8
+    1967100n 0
+    1967149n 0
+    1967150n 1.8
+    1967199n 1.8
+    1967200n 0
+    1967249n 0
+    1967250n 1.8
+    1967299n 1.8
+    1967300n 0
+    1967349n 0
+    1967350n 1.8
+    1967399n 1.8
+    1967400n 0
+    1967449n 0
+    1967450n 1.8
+    1967499n 1.8
+    1967500n 0
+    1967549n 0
+    1967550n 1.8
+    1967599n 1.8
+    1967600n 0
+    1967649n 0
+    1967650n 1.8
+    1967699n 1.8
+    1967700n 0
+    1967749n 0
+    1967750n 1.8
+    1967799n 1.8
+    1967800n 0
+    1967849n 0
+    1967850n 1.8
+    1967899n 1.8
+    1967900n 0
+    1967949n 0
+    1967950n 1.8
+    1967999n 1.8
+    1968000n 0
+    1968049n 0
+    1968050n 1.8
+    1968099n 1.8
+    1968100n 0
+    1968149n 0
+    1968150n 1.8
+    1968199n 1.8
+    1968200n 0
+    1968249n 0
+    1968250n 1.8
+    1968299n 1.8
+    1968300n 0
+    1968349n 0
+    1968350n 1.8
+    1968399n 1.8
+    1968400n 0
+    1968449n 0
+    1968450n 1.8
+    1968499n 1.8
+    1968500n 0
+    1968549n 0
+    1968550n 1.8
+    1968599n 1.8
+    1968600n 0
+    1968649n 0
+    1968650n 1.8
+    1968699n 1.8
+    1968700n 0
+    1968749n 0
+    1968750n 1.8
+    1968799n 1.8
+    1968800n 0
+    1968849n 0
+    1968850n 1.8
+    1968899n 1.8
+    1968900n 0
+    1968949n 0
+    1968950n 1.8
+    1968999n 1.8
+    1969000n 0
+    1969049n 0
+    1969050n 1.8
+    1969099n 1.8
+    1969100n 0
+    1969149n 0
+    1969150n 1.8
+    1969199n 1.8
+    1969200n 0
+    1969249n 0
+    1969250n 1.8
+    1969299n 1.8
+    1969300n 0
+    1969349n 0
+    1969350n 1.8
+    1969399n 1.8
+    1969400n 0
+    1969449n 0
+    1969450n 1.8
+    1969499n 1.8
+    1969500n 0
+    1969549n 0
+    1969550n 1.8
+    1969599n 1.8
+    1969600n 0
+    1969649n 0
+    1969650n 1.8
+    1969699n 1.8
+    1969700n 0
+    1969749n 0
+    1969750n 1.8
+    1969799n 1.8
+    1969800n 0
+    1969849n 0
+    1969850n 1.8
+    1969899n 1.8
+    1969900n 0
+    1969949n 0
+    1969950n 1.8
+    1969999n 1.8
+    1970000n 0
+    1970049n 0
+    1970050n 1.8
+    1970099n 1.8
+    1970100n 0
+    1970149n 0
+    1970150n 1.8
+    1970199n 1.8
+    1970200n 0
+    1970249n 0
+    1970250n 1.8
+    1970299n 1.8
+    1970300n 0
+    1970349n 0
+    1970350n 1.8
+    1970399n 1.8
+    1970400n 0
+    1970449n 0
+    1970450n 1.8
+    1970499n 1.8
+    1970500n 0
+    1970549n 0
+    1970550n 1.8
+    1970599n 1.8
+    1970600n 0
+    1970649n 0
+    1970650n 1.8
+    1970699n 1.8
+    1970700n 0
+    1970749n 0
+    1970750n 1.8
+    1970799n 1.8
+    1970800n 0
+    1970849n 0
+    1970850n 1.8
+    1970899n 1.8
+    1970900n 0
+    1970949n 0
+    1970950n 1.8
+    1970999n 1.8
+    1971000n 0
+    1971049n 0
+    1971050n 1.8
+    1971099n 1.8
+    1971100n 0
+    1971149n 0
+    1971150n 1.8
+    1971199n 1.8
+    1971200n 0
+    1971249n 0
+    1971250n 1.8
+    1971299n 1.8
+    1971300n 0
+    1971349n 0
+    1971350n 1.8
+    1971399n 1.8
+    1971400n 0
+    1971449n 0
+    1971450n 1.8
+    1971499n 1.8
+    1971500n 0
+    1971549n 0
+    1971550n 1.8
+    1971599n 1.8
+    1971600n 0
+    1971649n 0
+    1971650n 1.8
+    1971699n 1.8
+    1971700n 0
+    1971749n 0
+    1971750n 1.8
+    1971799n 1.8
+    1971800n 0
+    1971849n 0
+    1971850n 1.8
+    1971899n 1.8
+    1971900n 0
+    1971949n 0
+    1971950n 1.8
+    1971999n 1.8
+    1972000n 0
+    1972049n 0
+    1972050n 1.8
+    1972099n 1.8
+    1972100n 0
+    1972149n 0
+    1972150n 1.8
+    1972199n 1.8
+    1972200n 0
+    1972249n 0
+    1972250n 1.8
+    1972299n 1.8
+    1972300n 0
+    1972349n 0
+    1972350n 1.8
+    1972399n 1.8
+    1972400n 0
+    1972449n 0
+    1972450n 1.8
+    1972499n 1.8
+    1972500n 0
+    1972549n 0
+    1972550n 1.8
+    1972599n 1.8
+    1972600n 0
+    1972649n 0
+    1972650n 1.8
+    1972699n 1.8
+    1972700n 0
+    1972749n 0
+    1972750n 1.8
+    1972799n 1.8
+    1972800n 0
+    1972849n 0
+    1972850n 1.8
+    1972899n 1.8
+    1972900n 0
+    1972949n 0
+    1972950n 1.8
+    1972999n 1.8
+    1973000n 0
+    1973049n 0
+    1973050n 1.8
+    1973099n 1.8
+    1973100n 0
+    1973149n 0
+    1973150n 1.8
+    1973199n 1.8
+    1973200n 0
+    1973249n 0
+    1973250n 1.8
+    1973299n 1.8
+    1973300n 0
+    1973349n 0
+    1973350n 1.8
+    1973399n 1.8
+    1973400n 0
+    1973449n 0
+    1973450n 1.8
+    1973499n 1.8
+    1973500n 0
+    1973549n 0
+    1973550n 1.8
+    1973599n 1.8
+    1973600n 0
+    1973649n 0
+    1973650n 1.8
+    1973699n 1.8
+    1973700n 0
+    1973749n 0
+    1973750n 1.8
+    1973799n 1.8
+    1973800n 0
+    1973849n 0
+    1973850n 1.8
+    1973899n 1.8
+    1973900n 0
+    1973949n 0
+    1973950n 1.8
+    1973999n 1.8
+    1974000n 0
+    1974049n 0
+    1974050n 1.8
+    1974099n 1.8
+    1974100n 0
+    1974149n 0
+    1974150n 1.8
+    1974199n 1.8
+    1974200n 0
+    1974249n 0
+    1974250n 1.8
+    1974299n 1.8
+    1974300n 0
+    1974349n 0
+    1974350n 1.8
+    1974399n 1.8
+    1974400n 0
+    1974449n 0
+    1974450n 1.8
+    1974499n 1.8
+    1974500n 0
+    1974549n 0
+    1974550n 1.8
+    1974599n 1.8
+    1974600n 0
+    1974649n 0
+    1974650n 1.8
+    1974699n 1.8
+    1974700n 0
+    1974749n 0
+    1974750n 1.8
+    1974799n 1.8
+    1974800n 0
+    1974849n 0
+    1974850n 1.8
+    1974899n 1.8
+    1974900n 0
+    1974949n 0
+    1974950n 1.8
+    1974999n 1.8
+    1975000n 0
+    1975049n 0
+    1975050n 1.8
+    1975099n 1.8
+    1975100n 0
+    1975149n 0
+    1975150n 1.8
+    1975199n 1.8
+    1975200n 0
+    1975249n 0
+    1975250n 1.8
+    1975299n 1.8
+    1975300n 0
+    1975349n 0
+    1975350n 1.8
+    1975399n 1.8
+    1975400n 0
+    1975449n 0
+    1975450n 1.8
+    1975499n 1.8
+    1975500n 0
+    1975549n 0
+    1975550n 1.8
+    1975599n 1.8
+    1975600n 0
+    1975649n 0
+    1975650n 1.8
+    1975699n 1.8
+    1975700n 0
+    1975749n 0
+    1975750n 1.8
+    1975799n 1.8
+    1975800n 0
+    1975849n 0
+    1975850n 1.8
+    1975899n 1.8
+    1975900n 0
+    1975949n 0
+    1975950n 1.8
+    1975999n 1.8
+    1976000n 0
+    1976049n 0
+    1976050n 1.8
+    1976099n 1.8
+    1976100n 0
+    1976149n 0
+    1976150n 1.8
+    1976199n 1.8
+    1976200n 0
+    1976249n 0
+    1976250n 1.8
+    1976299n 1.8
+    1976300n 0
+    1976349n 0
+    1976350n 1.8
+    1976399n 1.8
+    1976400n 0
+    1976449n 0
+    1976450n 1.8
+    1976499n 1.8
+    1976500n 0
+    1976549n 0
+    1976550n 1.8
+    1976599n 1.8
+    1976600n 0
+    1976649n 0
+    1976650n 1.8
+    1976699n 1.8
+    1976700n 0
+    1976749n 0
+    1976750n 1.8
+    1976799n 1.8
+    1976800n 0
+    1976849n 0
+    1976850n 1.8
+    1976899n 1.8
+    1976900n 0
+    1976949n 0
+    1976950n 1.8
+    1976999n 1.8
+    1977000n 0
+    1977049n 0
+    1977050n 1.8
+    1977099n 1.8
+    1977100n 0
+    1977149n 0
+    1977150n 1.8
+    1977199n 1.8
+    1977200n 0
+    1977249n 0
+    1977250n 1.8
+    1977299n 1.8
+    1977300n 0
+    1977349n 0
+    1977350n 1.8
+    1977399n 1.8
+    1977400n 0
+    1977449n 0
+    1977450n 1.8
+    1977499n 1.8
+    1977500n 0
+    1977549n 0
+    1977550n 1.8
+    1977599n 1.8
+    1977600n 0
+    1977649n 0
+    1977650n 1.8
+    1977699n 1.8
+    1977700n 0
+    1977749n 0
+    1977750n 1.8
+    1977799n 1.8
+    1977800n 0
+    1977849n 0
+    1977850n 1.8
+    1977899n 1.8
+    1977900n 0
+    1977949n 0
+    1977950n 1.8
+    1977999n 1.8
+    1978000n 0
+    1978049n 0
+    1978050n 1.8
+    1978099n 1.8
+    1978100n 0
+    1978149n 0
+    1978150n 1.8
+    1978199n 1.8
+    1978200n 0
+    1978249n 0
+    1978250n 1.8
+    1978299n 1.8
+    1978300n 0
+    1978349n 0
+    1978350n 1.8
+    1978399n 1.8
+    1978400n 0
+    1978449n 0
+    1978450n 1.8
+    1978499n 1.8
+    1978500n 0
+    1978549n 0
+    1978550n 1.8
+    1978599n 1.8
+    1978600n 0
+    1978649n 0
+    1978650n 1.8
+    1978699n 1.8
+    1978700n 0
+    1978749n 0
+    1978750n 1.8
+    1978799n 1.8
+    1978800n 0
+    1978849n 0
+    1978850n 1.8
+    1978899n 1.8
+    1978900n 0
+    1978949n 0
+    1978950n 1.8
+    1978999n 1.8
+    1979000n 0
+    1979049n 0
+    1979050n 1.8
+    1979099n 1.8
+    1979100n 0
+    1979149n 0
+    1979150n 1.8
+    1979199n 1.8
+    1979200n 0
+    1979249n 0
+    1979250n 1.8
+    1979299n 1.8
+    1979300n 0
+    1979349n 0
+    1979350n 1.8
+    1979399n 1.8
+    1979400n 0
+    1979449n 0
+    1979450n 1.8
+    1979499n 1.8
+    1979500n 0
+    1979549n 0
+    1979550n 1.8
+    1979599n 1.8
+    1979600n 0
+    1979649n 0
+    1979650n 1.8
+    1979699n 1.8
+    1979700n 0
+    1979749n 0
+    1979750n 1.8
+    1979799n 1.8
+    1979800n 0
+    1979849n 0
+    1979850n 1.8
+    1979899n 1.8
+    1979900n 0
+    1979949n 0
+    1979950n 1.8
+    1979999n 1.8
+    1980000n 0
+    1980049n 0
+    1980050n 1.8
+    1980099n 1.8
+    1980100n 0
+    1980149n 0
+    1980150n 1.8
+    1980199n 1.8
+    1980200n 0
+    1980249n 0
+    1980250n 1.8
+    1980299n 1.8
+    1980300n 0
+    1980349n 0
+    1980350n 1.8
+    1980399n 1.8
+    1980400n 0
+    1980449n 0
+    1980450n 1.8
+    1980499n 1.8
+    1980500n 0
+    1980549n 0
+    1980550n 1.8
+    1980599n 1.8
+    1980600n 0
+    1980649n 0
+    1980650n 1.8
+    1980699n 1.8
+    1980700n 0
+    1980749n 0
+    1980750n 1.8
+    1980799n 1.8
+    1980800n 0
+    1980849n 0
+    1980850n 1.8
+    1980899n 1.8
+    1980900n 0
+    1980949n 0
+    1980950n 1.8
+    1980999n 1.8
+    1981000n 0
+    1981049n 0
+    1981050n 1.8
+    1981099n 1.8
+    1981100n 0
+    1981149n 0
+    1981150n 1.8
+    1981199n 1.8
+    1981200n 0
+    1981249n 0
+    1981250n 1.8
+    1981299n 1.8
+    1981300n 0
+    1981349n 0
+    1981350n 1.8
+    1981399n 1.8
+    1981400n 0
+    1981449n 0
+    1981450n 1.8
+    1981499n 1.8
+    1981500n 0
+    1981549n 0
+    1981550n 1.8
+    1981599n 1.8
+    1981600n 0
+    1981649n 0
+    1981650n 1.8
+    1981699n 1.8
+    1981700n 0
+    1981749n 0
+    1981750n 1.8
+    1981799n 1.8
+    1981800n 0
+    1981849n 0
+    1981850n 1.8
+    1981899n 1.8
+    1981900n 0
+    1981949n 0
+    1981950n 1.8
+    1981999n 1.8
+    1982000n 0
+    1982049n 0
+    1982050n 1.8
+    1982099n 1.8
+    1982100n 0
+    1982149n 0
+    1982150n 1.8
+    1982199n 1.8
+    1982200n 0
+    1982249n 0
+    1982250n 1.8
+    1982299n 1.8
+    1982300n 0
+    1982349n 0
+    1982350n 1.8
+    1982399n 1.8
+    1982400n 0
+    1982449n 0
+    1982450n 1.8
+    1982499n 1.8
+    1982500n 0
+    1982549n 0
+    1982550n 1.8
+    1982599n 1.8
+    1982600n 0
+    1982649n 0
+    1982650n 1.8
+    1982699n 1.8
+    1982700n 0
+    1982749n 0
+    1982750n 1.8
+    1982799n 1.8
+    1982800n 0
+    1982849n 0
+    1982850n 1.8
+    1982899n 1.8
+    1982900n 0
+    1982949n 0
+    1982950n 1.8
+    1982999n 1.8
+    1983000n 0
+    1983049n 0
+    1983050n 1.8
+    1983099n 1.8
+    1983100n 0
+    1983149n 0
+    1983150n 1.8
+    1983199n 1.8
+    1983200n 0
+    1983249n 0
+    1983250n 1.8
+    1983299n 1.8
+    1983300n 0
+    1983349n 0
+    1983350n 1.8
+    1983399n 1.8
+    1983400n 0
+    1983449n 0
+    1983450n 1.8
+    1983499n 1.8
+    1983500n 0
+    1983549n 0
+    1983550n 1.8
+    1983599n 1.8
+    1983600n 0
+    1983649n 0
+    1983650n 1.8
+    1983699n 1.8
+    1983700n 0
+    1983749n 0
+    1983750n 1.8
+    1983799n 1.8
+    1983800n 0
+    1983849n 0
+    1983850n 1.8
+    1983899n 1.8
+    1983900n 0
+    1983949n 0
+    1983950n 1.8
+    1983999n 1.8
+    1984000n 0
+    1984049n 0
+    1984050n 1.8
+    1984099n 1.8
+    1984100n 0
+    1984149n 0
+    1984150n 1.8
+    1984199n 1.8
+    1984200n 0
+    1984249n 0
+    1984250n 1.8
+    1984299n 1.8
+    1984300n 0
+    1984349n 0
+    1984350n 1.8
+    1984399n 1.8
+    1984400n 0
+    1984449n 0
+    1984450n 1.8
+    1984499n 1.8
+    1984500n 0
+    1984549n 0
+    1984550n 1.8
+    1984599n 1.8
+    1984600n 0
+    1984649n 0
+    1984650n 1.8
+    1984699n 1.8
+    1984700n 0
+    1984749n 0
+    1984750n 1.8
+    1984799n 1.8
+    1984800n 0
+    1984849n 0
+    1984850n 1.8
+    1984899n 1.8
+    1984900n 0
+    1984949n 0
+    1984950n 1.8
+    1984999n 1.8
+    1985000n 0
+    1985049n 0
+    1985050n 1.8
+    1985099n 1.8
+    1985100n 0
+    1985149n 0
+    1985150n 1.8
+    1985199n 1.8
+    1985200n 0
+    1985249n 0
+    1985250n 1.8
+    1985299n 1.8
+    1985300n 0
+    1985349n 0
+    1985350n 1.8
+    1985399n 1.8
+    1985400n 0
+    1985449n 0
+    1985450n 1.8
+    1985499n 1.8
+    1985500n 0
+    1985549n 0
+    1985550n 1.8
+    1985599n 1.8
+    1985600n 0
+    1985649n 0
+    1985650n 1.8
+    1985699n 1.8
+    1985700n 0
+    1985749n 0
+    1985750n 1.8
+    1985799n 1.8
+    1985800n 0
+    1985849n 0
+    1985850n 1.8
+    1985899n 1.8
+    1985900n 0
+    1985949n 0
+    1985950n 1.8
+    1985999n 1.8
+    1986000n 0
+    1986049n 0
+    1986050n 1.8
+    1986099n 1.8
+    1986100n 0
+    1986149n 0
+    1986150n 1.8
+    1986199n 1.8
+    1986200n 0
+    1986249n 0
+    1986250n 1.8
+    1986299n 1.8
+    1986300n 0
+    1986349n 0
+    1986350n 1.8
+    1986399n 1.8
+    1986400n 0
+    1986449n 0
+    1986450n 1.8
+    1986499n 1.8
+    1986500n 0
+    1986549n 0
+    1986550n 1.8
+    1986599n 1.8
+    1986600n 0
+    1986649n 0
+    1986650n 1.8
+    1986699n 1.8
+    1986700n 0
+    1986749n 0
+    1986750n 1.8
+    1986799n 1.8
+    1986800n 0
+    1986849n 0
+    1986850n 1.8
+    1986899n 1.8
+    1986900n 0
+    1986949n 0
+    1986950n 1.8
+    1986999n 1.8
+    1987000n 0
+    1987049n 0
+    1987050n 1.8
+    1987099n 1.8
+    1987100n 0
+    1987149n 0
+    1987150n 1.8
+    1987199n 1.8
+    1987200n 0
+    1987249n 0
+    1987250n 1.8
+    1987299n 1.8
+    1987300n 0
+    1987349n 0
+    1987350n 1.8
+    1987399n 1.8
+    1987400n 0
+    1987449n 0
+    1987450n 1.8
+    1987499n 1.8
+    1987500n 0
+    1987549n 0
+    1987550n 1.8
+    1987599n 1.8
+    1987600n 0
+    1987649n 0
+    1987650n 1.8
+    1987699n 1.8
+    1987700n 0
+    1987749n 0
+    1987750n 1.8
+    1987799n 1.8
+    1987800n 0
+    1987849n 0
+    1987850n 1.8
+    1987899n 1.8
+    1987900n 0
+    1987949n 0
+    1987950n 1.8
+    1987999n 1.8
+    1988000n 0
+    1988049n 0
+    1988050n 1.8
+    1988099n 1.8
+    1988100n 0
+    1988149n 0
+    1988150n 1.8
+    1988199n 1.8
+    1988200n 0
+    1988249n 0
+    1988250n 1.8
+    1988299n 1.8
+    1988300n 0
+    1988349n 0
+    1988350n 1.8
+    1988399n 1.8
+    1988400n 0
+    1988449n 0
+    1988450n 1.8
+    1988499n 1.8
+    1988500n 0
+    1988549n 0
+    1988550n 1.8
+    1988599n 1.8
+    1988600n 0
+    1988649n 0
+    1988650n 1.8
+    1988699n 1.8
+    1988700n 0
+    1988749n 0
+    1988750n 1.8
+    1988799n 1.8
+    1988800n 0
+    1988849n 0
+    1988850n 1.8
+    1988899n 1.8
+    1988900n 0
+    1988949n 0
+    1988950n 1.8
+    1988999n 1.8
+    1989000n 0
+    1989049n 0
+    1989050n 1.8
+    1989099n 1.8
+    1989100n 0
+    1989149n 0
+    1989150n 1.8
+    1989199n 1.8
+    1989200n 0
+    1989249n 0
+    1989250n 1.8
+    1989299n 1.8
+    1989300n 0
+    1989349n 0
+    1989350n 1.8
+    1989399n 1.8
+    1989400n 0
+    1989449n 0
+    1989450n 1.8
+    1989499n 1.8
+    1989500n 0
+    1989549n 0
+    1989550n 1.8
+    1989599n 1.8
+    1989600n 0
+    1989649n 0
+    1989650n 1.8
+    1989699n 1.8
+    1989700n 0
+    1989749n 0
+    1989750n 1.8
+    1989799n 1.8
+    1989800n 0
+    1989849n 0
+    1989850n 1.8
+    1989899n 1.8
+    1989900n 0
+    1989949n 0
+    1989950n 1.8
+    1989999n 1.8
+    1990000n 0
+    1990049n 0
+    1990050n 1.8
+    1990099n 1.8
+    1990100n 0
+    1990149n 0
+    1990150n 1.8
+    1990199n 1.8
+    1990200n 0
+    1990249n 0
+    1990250n 1.8
+    1990299n 1.8
+    1990300n 0
+    1990349n 0
+    1990350n 1.8
+    1990399n 1.8
+    1990400n 0
+    1990449n 0
+    1990450n 1.8
+    1990499n 1.8
+    1990500n 0
+    1990549n 0
+    1990550n 1.8
+    1990599n 1.8
+    1990600n 0
+    1990649n 0
+    1990650n 1.8
+    1990699n 1.8
+    1990700n 0
+    1990749n 0
+    1990750n 1.8
+    1990799n 1.8
+    1990800n 0
+    1990849n 0
+    1990850n 1.8
+    1990899n 1.8
+    1990900n 0
+    1990949n 0
+    1990950n 1.8
+    1990999n 1.8
+    1991000n 0
+    1991049n 0
+    1991050n 1.8
+    1991099n 1.8
+    1991100n 0
+    1991149n 0
+    1991150n 1.8
+    1991199n 1.8
+    1991200n 0
+    1991249n 0
+    1991250n 1.8
+    1991299n 1.8
+    1991300n 0
+    1991349n 0
+    1991350n 1.8
+    1991399n 1.8
+    1991400n 0
+    1991449n 0
+    1991450n 1.8
+    1991499n 1.8
+    1991500n 0
+    1991549n 0
+    1991550n 1.8
+    1991599n 1.8
+    1991600n 0
+    1991649n 0
+    1991650n 1.8
+    1991699n 1.8
+    1991700n 0
+    1991749n 0
+    1991750n 1.8
+    1991799n 1.8
+    1991800n 0
+    1991849n 0
+    1991850n 1.8
+    1991899n 1.8
+    1991900n 0
+    1991949n 0
+    1991950n 1.8
+    1991999n 1.8
+    1992000n 0
+    1992049n 0
+    1992050n 1.8
+    1992099n 1.8
+    1992100n 0
+    1992149n 0
+    1992150n 1.8
+    1992199n 1.8
+    1992200n 0
+    1992249n 0
+    1992250n 1.8
+    1992299n 1.8
+    1992300n 0
+    1992349n 0
+    1992350n 1.8
+    1992399n 1.8
+    1992400n 0
+    1992449n 0
+    1992450n 1.8
+    1992499n 1.8
+    1992500n 0
+    1992549n 0
+    1992550n 1.8
+    1992599n 1.8
+    1992600n 0
+    1992649n 0
+    1992650n 1.8
+    1992699n 1.8
+    1992700n 0
+    1992749n 0
+    1992750n 1.8
+    1992799n 1.8
+    1992800n 0
+    1992849n 0
+    1992850n 1.8
+    1992899n 1.8
+    1992900n 0
+    1992949n 0
+    1992950n 1.8
+    1992999n 1.8
+    1993000n 0
+    1993049n 0
+    1993050n 1.8
+    1993099n 1.8
+    1993100n 0
+    1993149n 0
+    1993150n 1.8
+    1993199n 1.8
+    1993200n 0
+    1993249n 0
+    1993250n 1.8
+    1993299n 1.8
+    1993300n 0
+    1993349n 0
+    1993350n 1.8
+    1993399n 1.8
+    1993400n 0
+    1993449n 0
+    1993450n 1.8
+    1993499n 1.8
+    1993500n 0
+    1993549n 0
+    1993550n 1.8
+    1993599n 1.8
+    1993600n 0
+    1993649n 0
+    1993650n 1.8
+    1993699n 1.8
+    1993700n 0
+    1993749n 0
+    1993750n 1.8
+    1993799n 1.8
+    1993800n 0
+    1993849n 0
+    1993850n 1.8
+    1993899n 1.8
+    1993900n 0
+    1993949n 0
+    1993950n 1.8
+    1993999n 1.8
+    1994000n 0
+    1994049n 0
+    1994050n 1.8
+    1994099n 1.8
+    1994100n 0
+    1994149n 0
+    1994150n 1.8
+    1994199n 1.8
+    1994200n 0
+    1994249n 0
+    1994250n 1.8
+    1994299n 1.8
+    1994300n 0
+    1994349n 0
+    1994350n 1.8
+    1994399n 1.8
+    1994400n 0
+    1994449n 0
+    1994450n 1.8
+    1994499n 1.8
+    1994500n 0
+    1994549n 0
+    1994550n 1.8
+    1994599n 1.8
+    1994600n 0
+    1994649n 0
+    1994650n 1.8
+    1994699n 1.8
+    1994700n 0
+    1994749n 0
+    1994750n 1.8
+    1994799n 1.8
+    1994800n 0
+    1994849n 0
+    1994850n 1.8
+    1994899n 1.8
+    1994900n 0
+    1994949n 0
+    1994950n 1.8
+    1994999n 1.8
+    1995000n 0
+    1995049n 0
+    1995050n 1.8
+    1995099n 1.8
+    1995100n 0
+    1995149n 0
+    1995150n 1.8
+    1995199n 1.8
+    1995200n 0
+    1995249n 0
+    1995250n 1.8
+    1995299n 1.8
+    1995300n 0
+    1995349n 0
+    1995350n 1.8
+    1995399n 1.8
+    1995400n 0
+    1995449n 0
+    1995450n 1.8
+    1995499n 1.8
+    1995500n 0
+    1995549n 0
+    1995550n 1.8
+    1995599n 1.8
+    1995600n 0
+    1995649n 0
+    1995650n 1.8
+    1995699n 1.8
+    1995700n 0
+    1995749n 0
+    1995750n 1.8
+    1995799n 1.8
+    1995800n 0
+    1995849n 0
+    1995850n 1.8
+    1995899n 1.8
+    1995900n 0
+    1995949n 0
+    1995950n 1.8
+    1995999n 1.8
+    1996000n 0
+    1996049n 0
+    1996050n 1.8
+    1996099n 1.8
+    1996100n 0
+    1996149n 0
+    1996150n 1.8
+    1996199n 1.8
+    1996200n 0
+    1996249n 0
+    1996250n 1.8
+    1996299n 1.8
+    1996300n 0
+    1996349n 0
+    1996350n 1.8
+    1996399n 1.8
+    1996400n 0
+    1996449n 0
+    1996450n 1.8
+    1996499n 1.8
+    1996500n 0
+    1996549n 0
+    1996550n 1.8
+    1996599n 1.8
+    1996600n 0
+    1996649n 0
+    1996650n 1.8
+    1996699n 1.8
+    1996700n 0
+    1996749n 0
+    1996750n 1.8
+    1996799n 1.8
+    1996800n 0
+    1996849n 0
+    1996850n 1.8
+    1996899n 1.8
+    1996900n 0
+    1996949n 0
+    1996950n 1.8
+    1996999n 1.8
+    1997000n 0
+    1997049n 0
+    1997050n 1.8
+    1997099n 1.8
+    1997100n 0
+    1997149n 0
+    1997150n 1.8
+    1997199n 1.8
+    1997200n 0
+    1997249n 0
+    1997250n 1.8
+    1997299n 1.8
+    1997300n 0
+    1997349n 0
+    1997350n 1.8
+    1997399n 1.8
+    1997400n 0
+    1997449n 0
+    1997450n 1.8
+    1997499n 1.8
+    1997500n 0
+    1997549n 0
+    1997550n 1.8
+    1997599n 1.8
+    1997600n 0
+    1997649n 0
+    1997650n 1.8
+    1997699n 1.8
+    1997700n 0
+    1997749n 0
+    1997750n 1.8
+    1997799n 1.8
+    1997800n 0
+    1997849n 0
+    1997850n 1.8
+    1997899n 1.8
+    1997900n 0
+    1997949n 0
+    1997950n 1.8
+    1997999n 1.8
+    1998000n 0
+    1998049n 0
+    1998050n 1.8
+    1998099n 1.8
+    1998100n 0
+    1998149n 0
+    1998150n 1.8
+    1998199n 1.8
+    1998200n 0
+    1998249n 0
+    1998250n 1.8
+    1998299n 1.8
+    1998300n 0
+    1998349n 0
+    1998350n 1.8
+    1998399n 1.8
+    1998400n 0
+    1998449n 0
+    1998450n 1.8
+    1998499n 1.8
+    1998500n 0
+    1998549n 0
+    1998550n 1.8
+    1998599n 1.8
+    1998600n 0
+    1998649n 0
+    1998650n 1.8
+    1998699n 1.8
+    1998700n 0
+    1998749n 0
+    1998750n 1.8
+    1998799n 1.8
+    1998800n 0
+    1998849n 0
+    1998850n 1.8
+    1998899n 1.8
+    1998900n 0
+    1998949n 0
+    1998950n 1.8
+    1998999n 1.8
+    1999000n 0
+    1999049n 0
+    1999050n 1.8
+    1999099n 1.8
+    1999100n 0
+    1999149n 0
+    1999150n 1.8
+    1999199n 1.8
+    1999200n 0
+    1999249n 0
+    1999250n 1.8
+    1999299n 1.8
+    1999300n 0
+    1999349n 0
+    1999350n 1.8
+    1999399n 1.8
+    1999400n 0
+    1999449n 0
+    1999450n 1.8
+    1999499n 1.8
+    1999500n 0
+    1999549n 0
+    1999550n 1.8
+    1999599n 1.8
+    1999600n 0
+    1999649n 0
+    1999650n 1.8
+    1999699n 1.8
+    1999700n 0
+    1999749n 0
+    1999750n 1.8
+    1999799n 1.8
+    1999800n 0
+    1999849n 0
+    1999850n 1.8
+    1999899n 1.8
+    1999900n 0
+    1999949n 0
+    1999950n 1.8
+    1999999n 1.8
+    2000000n 0
+    )

* Pin: cen <- VCD: test.tb.cen
Vcen cen 0 pwl(
+    0n 1.8
+    99n 1.8
+    100n 0
+    399n 0
+    400n 1.8
+    499n 1.8
+    500n 0
+    799n 0
+    800n 1.8
+    899n 1.8
+    900n 0
+    1199n 0
+    1200n 1.8
+    1299n 1.8
+    1300n 0
+    1599n 0
+    1600n 1.8
+    1699n 1.8
+    1700n 0
+    1999n 0
+    2000n 1.8
+    2099n 1.8
+    2100n 0
+    2399n 0
+    2400n 1.8
+    2499n 1.8
+    2500n 0
+    2799n 0
+    2800n 1.8
+    2899n 1.8
+    2900n 0
+    3199n 0
+    3200n 1.8
+    3299n 1.8
+    3300n 0
+    3599n 0
+    3600n 1.8
+    3699n 1.8
+    3700n 0
+    3999n 0
+    4000n 1.8
+    4099n 1.8
+    4100n 0
+    4399n 0
+    4400n 1.8
+    4499n 1.8
+    4500n 0
+    4799n 0
+    4800n 1.8
+    4899n 1.8
+    4900n 0
+    5199n 0
+    5200n 1.8
+    5299n 1.8
+    5300n 0
+    5599n 0
+    5600n 1.8
+    5699n 1.8
+    5700n 0
+    5999n 0
+    6000n 1.8
+    6099n 1.8
+    6100n 0
+    6399n 0
+    6400n 1.8
+    6499n 1.8
+    6500n 0
+    6799n 0
+    6800n 1.8
+    6899n 1.8
+    6900n 0
+    7199n 0
+    7200n 1.8
+    7299n 1.8
+    7300n 0
+    7599n 0
+    7600n 1.8
+    7699n 1.8
+    7700n 0
+    7999n 0
+    8000n 1.8
+    8099n 1.8
+    8100n 0
+    8399n 0
+    8400n 1.8
+    8499n 1.8
+    8500n 0
+    8799n 0
+    8800n 1.8
+    8899n 1.8
+    8900n 0
+    9199n 0
+    9200n 1.8
+    9299n 1.8
+    9300n 0
+    9599n 0
+    9600n 1.8
+    9699n 1.8
+    9700n 0
+    9999n 0
+    10000n 1.8
+    10099n 1.8
+    10100n 0
+    10399n 0
+    10400n 1.8
+    10499n 1.8
+    10500n 0
+    10799n 0
+    10800n 1.8
+    10899n 1.8
+    10900n 0
+    11199n 0
+    11200n 1.8
+    11299n 1.8
+    11300n 0
+    11599n 0
+    11600n 1.8
+    11699n 1.8
+    11700n 0
+    11999n 0
+    12000n 1.8
+    12099n 1.8
+    12100n 0
+    12399n 0
+    12400n 1.8
+    12499n 1.8
+    12500n 0
+    12799n 0
+    12800n 1.8
+    12899n 1.8
+    12900n 0
+    13199n 0
+    13200n 1.8
+    13299n 1.8
+    13300n 0
+    13599n 0
+    13600n 1.8
+    13699n 1.8
+    13700n 0
+    13999n 0
+    14000n 1.8
+    14099n 1.8
+    14100n 0
+    14399n 0
+    14400n 1.8
+    14499n 1.8
+    14500n 0
+    14799n 0
+    14800n 1.8
+    14899n 1.8
+    14900n 0
+    15199n 0
+    15200n 1.8
+    15299n 1.8
+    15300n 0
+    15599n 0
+    15600n 1.8
+    15699n 1.8
+    15700n 0
+    15999n 0
+    16000n 1.8
+    16099n 1.8
+    16100n 0
+    16399n 0
+    16400n 1.8
+    16499n 1.8
+    16500n 0
+    16799n 0
+    16800n 1.8
+    16899n 1.8
+    16900n 0
+    17199n 0
+    17200n 1.8
+    17299n 1.8
+    17300n 0
+    17599n 0
+    17600n 1.8
+    17699n 1.8
+    17700n 0
+    17999n 0
+    18000n 1.8
+    18099n 1.8
+    18100n 0
+    18399n 0
+    18400n 1.8
+    18499n 1.8
+    18500n 0
+    18799n 0
+    18800n 1.8
+    18899n 1.8
+    18900n 0
+    19199n 0
+    19200n 1.8
+    19299n 1.8
+    19300n 0
+    19599n 0
+    19600n 1.8
+    19699n 1.8
+    19700n 0
+    19999n 0
+    20000n 1.8
+    20099n 1.8
+    20100n 0
+    20399n 0
+    20400n 1.8
+    20499n 1.8
+    20500n 0
+    20799n 0
+    20800n 1.8
+    20899n 1.8
+    20900n 0
+    21199n 0
+    21200n 1.8
+    21299n 1.8
+    21300n 0
+    21599n 0
+    21600n 1.8
+    21699n 1.8
+    21700n 0
+    21999n 0
+    22000n 1.8
+    22099n 1.8
+    22100n 0
+    22399n 0
+    22400n 1.8
+    22499n 1.8
+    22500n 0
+    22799n 0
+    22800n 1.8
+    22899n 1.8
+    22900n 0
+    23199n 0
+    23200n 1.8
+    23299n 1.8
+    23300n 0
+    23599n 0
+    23600n 1.8
+    23699n 1.8
+    23700n 0
+    23999n 0
+    24000n 1.8
+    24099n 1.8
+    24100n 0
+    24399n 0
+    24400n 1.8
+    24499n 1.8
+    24500n 0
+    24799n 0
+    24800n 1.8
+    24899n 1.8
+    24900n 0
+    25199n 0
+    25200n 1.8
+    25299n 1.8
+    25300n 0
+    25599n 0
+    25600n 1.8
+    25699n 1.8
+    25700n 0
+    25999n 0
+    26000n 1.8
+    26099n 1.8
+    26100n 0
+    26399n 0
+    26400n 1.8
+    26499n 1.8
+    26500n 0
+    26799n 0
+    26800n 1.8
+    26899n 1.8
+    26900n 0
+    27199n 0
+    27200n 1.8
+    27299n 1.8
+    27300n 0
+    27599n 0
+    27600n 1.8
+    27699n 1.8
+    27700n 0
+    27999n 0
+    28000n 1.8
+    28099n 1.8
+    28100n 0
+    28399n 0
+    28400n 1.8
+    28499n 1.8
+    28500n 0
+    28799n 0
+    28800n 1.8
+    28899n 1.8
+    28900n 0
+    29199n 0
+    29200n 1.8
+    29299n 1.8
+    29300n 0
+    29599n 0
+    29600n 1.8
+    29699n 1.8
+    29700n 0
+    29999n 0
+    30000n 1.8
+    30099n 1.8
+    30100n 0
+    30399n 0
+    30400n 1.8
+    30499n 1.8
+    30500n 0
+    30799n 0
+    30800n 1.8
+    30899n 1.8
+    30900n 0
+    31199n 0
+    31200n 1.8
+    31299n 1.8
+    31300n 0
+    31599n 0
+    31600n 1.8
+    31699n 1.8
+    31700n 0
+    31999n 0
+    32000n 1.8
+    32099n 1.8
+    32100n 0
+    32399n 0
+    32400n 1.8
+    32499n 1.8
+    32500n 0
+    32799n 0
+    32800n 1.8
+    32899n 1.8
+    32900n 0
+    33199n 0
+    33200n 1.8
+    33299n 1.8
+    33300n 0
+    33599n 0
+    33600n 1.8
+    33699n 1.8
+    33700n 0
+    33999n 0
+    34000n 1.8
+    34099n 1.8
+    34100n 0
+    34399n 0
+    34400n 1.8
+    34499n 1.8
+    34500n 0
+    34799n 0
+    34800n 1.8
+    34899n 1.8
+    34900n 0
+    35199n 0
+    35200n 1.8
+    35299n 1.8
+    35300n 0
+    35599n 0
+    35600n 1.8
+    35699n 1.8
+    35700n 0
+    35999n 0
+    36000n 1.8
+    36099n 1.8
+    36100n 0
+    36399n 0
+    36400n 1.8
+    36499n 1.8
+    36500n 0
+    36799n 0
+    36800n 1.8
+    36899n 1.8
+    36900n 0
+    37199n 0
+    37200n 1.8
+    37299n 1.8
+    37300n 0
+    37599n 0
+    37600n 1.8
+    37699n 1.8
+    37700n 0
+    37999n 0
+    38000n 1.8
+    38099n 1.8
+    38100n 0
+    38399n 0
+    38400n 1.8
+    38499n 1.8
+    38500n 0
+    38799n 0
+    38800n 1.8
+    38899n 1.8
+    38900n 0
+    39199n 0
+    39200n 1.8
+    39299n 1.8
+    39300n 0
+    39599n 0
+    39600n 1.8
+    39699n 1.8
+    39700n 0
+    39999n 0
+    40000n 1.8
+    40099n 1.8
+    40100n 0
+    40399n 0
+    40400n 1.8
+    40499n 1.8
+    40500n 0
+    40799n 0
+    40800n 1.8
+    40899n 1.8
+    40900n 0
+    41199n 0
+    41200n 1.8
+    41299n 1.8
+    41300n 0
+    41599n 0
+    41600n 1.8
+    41699n 1.8
+    41700n 0
+    41999n 0
+    42000n 1.8
+    42099n 1.8
+    42100n 0
+    42399n 0
+    42400n 1.8
+    42499n 1.8
+    42500n 0
+    42799n 0
+    42800n 1.8
+    42899n 1.8
+    42900n 0
+    43199n 0
+    43200n 1.8
+    43299n 1.8
+    43300n 0
+    43599n 0
+    43600n 1.8
+    43699n 1.8
+    43700n 0
+    43999n 0
+    44000n 1.8
+    44099n 1.8
+    44100n 0
+    44399n 0
+    44400n 1.8
+    44499n 1.8
+    44500n 0
+    44799n 0
+    44800n 1.8
+    44899n 1.8
+    44900n 0
+    45199n 0
+    45200n 1.8
+    45299n 1.8
+    45300n 0
+    45599n 0
+    45600n 1.8
+    45699n 1.8
+    45700n 0
+    45999n 0
+    46000n 1.8
+    46099n 1.8
+    46100n 0
+    46399n 0
+    46400n 1.8
+    46499n 1.8
+    46500n 0
+    46799n 0
+    46800n 1.8
+    46899n 1.8
+    46900n 0
+    47199n 0
+    47200n 1.8
+    47299n 1.8
+    47300n 0
+    47599n 0
+    47600n 1.8
+    47699n 1.8
+    47700n 0
+    47999n 0
+    48000n 1.8
+    48099n 1.8
+    48100n 0
+    48399n 0
+    48400n 1.8
+    48499n 1.8
+    48500n 0
+    48799n 0
+    48800n 1.8
+    48899n 1.8
+    48900n 0
+    49199n 0
+    49200n 1.8
+    49299n 1.8
+    49300n 0
+    49599n 0
+    49600n 1.8
+    49699n 1.8
+    49700n 0
+    49999n 0
+    50000n 1.8
+    50099n 1.8
+    50100n 0
+    50399n 0
+    50400n 1.8
+    50499n 1.8
+    50500n 0
+    50799n 0
+    50800n 1.8
+    50899n 1.8
+    50900n 0
+    51199n 0
+    51200n 1.8
+    51299n 1.8
+    51300n 0
+    51599n 0
+    51600n 1.8
+    51699n 1.8
+    51700n 0
+    51999n 0
+    52000n 1.8
+    52099n 1.8
+    52100n 0
+    52399n 0
+    52400n 1.8
+    52499n 1.8
+    52500n 0
+    52799n 0
+    52800n 1.8
+    52899n 1.8
+    52900n 0
+    53199n 0
+    53200n 1.8
+    53299n 1.8
+    53300n 0
+    53599n 0
+    53600n 1.8
+    53699n 1.8
+    53700n 0
+    53999n 0
+    54000n 1.8
+    54099n 1.8
+    54100n 0
+    54399n 0
+    54400n 1.8
+    54499n 1.8
+    54500n 0
+    54799n 0
+    54800n 1.8
+    54899n 1.8
+    54900n 0
+    55199n 0
+    55200n 1.8
+    55299n 1.8
+    55300n 0
+    55599n 0
+    55600n 1.8
+    55699n 1.8
+    55700n 0
+    55999n 0
+    56000n 1.8
+    56099n 1.8
+    56100n 0
+    56399n 0
+    56400n 1.8
+    56499n 1.8
+    56500n 0
+    56799n 0
+    56800n 1.8
+    56899n 1.8
+    56900n 0
+    57199n 0
+    57200n 1.8
+    57299n 1.8
+    57300n 0
+    57599n 0
+    57600n 1.8
+    57699n 1.8
+    57700n 0
+    57999n 0
+    58000n 1.8
+    58099n 1.8
+    58100n 0
+    58399n 0
+    58400n 1.8
+    58499n 1.8
+    58500n 0
+    58799n 0
+    58800n 1.8
+    58899n 1.8
+    58900n 0
+    59199n 0
+    59200n 1.8
+    59299n 1.8
+    59300n 0
+    59599n 0
+    59600n 1.8
+    59699n 1.8
+    59700n 0
+    59999n 0
+    60000n 1.8
+    60099n 1.8
+    60100n 0
+    60399n 0
+    60400n 1.8
+    60499n 1.8
+    60500n 0
+    60799n 0
+    60800n 1.8
+    60899n 1.8
+    60900n 0
+    61199n 0
+    61200n 1.8
+    61299n 1.8
+    61300n 0
+    61599n 0
+    61600n 1.8
+    61699n 1.8
+    61700n 0
+    61999n 0
+    62000n 1.8
+    62099n 1.8
+    62100n 0
+    62399n 0
+    62400n 1.8
+    62499n 1.8
+    62500n 0
+    62799n 0
+    62800n 1.8
+    62899n 1.8
+    62900n 0
+    63199n 0
+    63200n 1.8
+    63299n 1.8
+    63300n 0
+    63599n 0
+    63600n 1.8
+    63699n 1.8
+    63700n 0
+    63999n 0
+    64000n 1.8
+    64099n 1.8
+    64100n 0
+    64399n 0
+    64400n 1.8
+    64499n 1.8
+    64500n 0
+    64799n 0
+    64800n 1.8
+    64899n 1.8
+    64900n 0
+    65199n 0
+    65200n 1.8
+    65299n 1.8
+    65300n 0
+    65599n 0
+    65600n 1.8
+    65699n 1.8
+    65700n 0
+    65999n 0
+    66000n 1.8
+    66099n 1.8
+    66100n 0
+    66399n 0
+    66400n 1.8
+    66499n 1.8
+    66500n 0
+    66799n 0
+    66800n 1.8
+    66899n 1.8
+    66900n 0
+    67199n 0
+    67200n 1.8
+    67299n 1.8
+    67300n 0
+    67599n 0
+    67600n 1.8
+    67699n 1.8
+    67700n 0
+    67999n 0
+    68000n 1.8
+    68099n 1.8
+    68100n 0
+    68399n 0
+    68400n 1.8
+    68499n 1.8
+    68500n 0
+    68799n 0
+    68800n 1.8
+    68899n 1.8
+    68900n 0
+    69199n 0
+    69200n 1.8
+    69299n 1.8
+    69300n 0
+    69599n 0
+    69600n 1.8
+    69699n 1.8
+    69700n 0
+    69999n 0
+    70000n 1.8
+    70099n 1.8
+    70100n 0
+    70399n 0
+    70400n 1.8
+    70499n 1.8
+    70500n 0
+    70799n 0
+    70800n 1.8
+    70899n 1.8
+    70900n 0
+    71199n 0
+    71200n 1.8
+    71299n 1.8
+    71300n 0
+    71599n 0
+    71600n 1.8
+    71699n 1.8
+    71700n 0
+    71999n 0
+    72000n 1.8
+    72099n 1.8
+    72100n 0
+    72399n 0
+    72400n 1.8
+    72499n 1.8
+    72500n 0
+    72799n 0
+    72800n 1.8
+    72899n 1.8
+    72900n 0
+    73199n 0
+    73200n 1.8
+    73299n 1.8
+    73300n 0
+    73599n 0
+    73600n 1.8
+    73699n 1.8
+    73700n 0
+    73999n 0
+    74000n 1.8
+    74099n 1.8
+    74100n 0
+    74399n 0
+    74400n 1.8
+    74499n 1.8
+    74500n 0
+    74799n 0
+    74800n 1.8
+    74899n 1.8
+    74900n 0
+    75199n 0
+    75200n 1.8
+    75299n 1.8
+    75300n 0
+    75599n 0
+    75600n 1.8
+    75699n 1.8
+    75700n 0
+    75999n 0
+    76000n 1.8
+    76099n 1.8
+    76100n 0
+    76399n 0
+    76400n 1.8
+    76499n 1.8
+    76500n 0
+    76799n 0
+    76800n 1.8
+    76899n 1.8
+    76900n 0
+    77199n 0
+    77200n 1.8
+    77299n 1.8
+    77300n 0
+    77599n 0
+    77600n 1.8
+    77699n 1.8
+    77700n 0
+    77999n 0
+    78000n 1.8
+    78099n 1.8
+    78100n 0
+    78399n 0
+    78400n 1.8
+    78499n 1.8
+    78500n 0
+    78799n 0
+    78800n 1.8
+    78899n 1.8
+    78900n 0
+    79199n 0
+    79200n 1.8
+    79299n 1.8
+    79300n 0
+    79599n 0
+    79600n 1.8
+    79699n 1.8
+    79700n 0
+    79999n 0
+    80000n 1.8
+    80099n 1.8
+    80100n 0
+    80399n 0
+    80400n 1.8
+    80499n 1.8
+    80500n 0
+    80799n 0
+    80800n 1.8
+    80899n 1.8
+    80900n 0
+    81199n 0
+    81200n 1.8
+    81299n 1.8
+    81300n 0
+    81599n 0
+    81600n 1.8
+    81699n 1.8
+    81700n 0
+    81999n 0
+    82000n 1.8
+    82099n 1.8
+    82100n 0
+    82399n 0
+    82400n 1.8
+    82499n 1.8
+    82500n 0
+    82799n 0
+    82800n 1.8
+    82899n 1.8
+    82900n 0
+    83199n 0
+    83200n 1.8
+    83299n 1.8
+    83300n 0
+    83599n 0
+    83600n 1.8
+    83699n 1.8
+    83700n 0
+    83999n 0
+    84000n 1.8
+    84099n 1.8
+    84100n 0
+    84399n 0
+    84400n 1.8
+    84499n 1.8
+    84500n 0
+    84799n 0
+    84800n 1.8
+    84899n 1.8
+    84900n 0
+    85199n 0
+    85200n 1.8
+    85299n 1.8
+    85300n 0
+    85599n 0
+    85600n 1.8
+    85699n 1.8
+    85700n 0
+    85999n 0
+    86000n 1.8
+    86099n 1.8
+    86100n 0
+    86399n 0
+    86400n 1.8
+    86499n 1.8
+    86500n 0
+    86799n 0
+    86800n 1.8
+    86899n 1.8
+    86900n 0
+    87199n 0
+    87200n 1.8
+    87299n 1.8
+    87300n 0
+    87599n 0
+    87600n 1.8
+    87699n 1.8
+    87700n 0
+    87999n 0
+    88000n 1.8
+    88099n 1.8
+    88100n 0
+    88399n 0
+    88400n 1.8
+    88499n 1.8
+    88500n 0
+    88799n 0
+    88800n 1.8
+    88899n 1.8
+    88900n 0
+    89199n 0
+    89200n 1.8
+    89299n 1.8
+    89300n 0
+    89599n 0
+    89600n 1.8
+    89699n 1.8
+    89700n 0
+    89999n 0
+    90000n 1.8
+    90099n 1.8
+    90100n 0
+    90399n 0
+    90400n 1.8
+    90499n 1.8
+    90500n 0
+    90799n 0
+    90800n 1.8
+    90899n 1.8
+    90900n 0
+    91199n 0
+    91200n 1.8
+    91299n 1.8
+    91300n 0
+    91599n 0
+    91600n 1.8
+    91699n 1.8
+    91700n 0
+    91999n 0
+    92000n 1.8
+    92099n 1.8
+    92100n 0
+    92399n 0
+    92400n 1.8
+    92499n 1.8
+    92500n 0
+    92799n 0
+    92800n 1.8
+    92899n 1.8
+    92900n 0
+    93199n 0
+    93200n 1.8
+    93299n 1.8
+    93300n 0
+    93599n 0
+    93600n 1.8
+    93699n 1.8
+    93700n 0
+    93999n 0
+    94000n 1.8
+    94099n 1.8
+    94100n 0
+    94399n 0
+    94400n 1.8
+    94499n 1.8
+    94500n 0
+    94799n 0
+    94800n 1.8
+    94899n 1.8
+    94900n 0
+    95199n 0
+    95200n 1.8
+    95299n 1.8
+    95300n 0
+    95599n 0
+    95600n 1.8
+    95699n 1.8
+    95700n 0
+    95999n 0
+    96000n 1.8
+    96099n 1.8
+    96100n 0
+    96399n 0
+    96400n 1.8
+    96499n 1.8
+    96500n 0
+    96799n 0
+    96800n 1.8
+    96899n 1.8
+    96900n 0
+    97199n 0
+    97200n 1.8
+    97299n 1.8
+    97300n 0
+    97599n 0
+    97600n 1.8
+    97699n 1.8
+    97700n 0
+    97999n 0
+    98000n 1.8
+    98099n 1.8
+    98100n 0
+    98399n 0
+    98400n 1.8
+    98499n 1.8
+    98500n 0
+    98799n 0
+    98800n 1.8
+    98899n 1.8
+    98900n 0
+    99199n 0
+    99200n 1.8
+    99299n 1.8
+    99300n 0
+    99599n 0
+    99600n 1.8
+    99699n 1.8
+    99700n 0
+    99999n 0
+    100000n 1.8
+    100099n 1.8
+    100100n 0
+    100399n 0
+    100400n 1.8
+    100499n 1.8
+    100500n 0
+    100799n 0
+    100800n 1.8
+    100899n 1.8
+    100900n 0
+    101199n 0
+    101200n 1.8
+    101299n 1.8
+    101300n 0
+    101599n 0
+    101600n 1.8
+    101699n 1.8
+    101700n 0
+    101999n 0
+    102000n 1.8
+    102099n 1.8
+    102100n 0
+    102399n 0
+    102400n 1.8
+    102499n 1.8
+    102500n 0
+    102799n 0
+    102800n 1.8
+    102899n 1.8
+    102900n 0
+    103199n 0
+    103200n 1.8
+    103299n 1.8
+    103300n 0
+    103599n 0
+    103600n 1.8
+    103699n 1.8
+    103700n 0
+    103999n 0
+    104000n 1.8
+    104099n 1.8
+    104100n 0
+    104399n 0
+    104400n 1.8
+    104499n 1.8
+    104500n 0
+    104799n 0
+    104800n 1.8
+    104899n 1.8
+    104900n 0
+    105199n 0
+    105200n 1.8
+    105299n 1.8
+    105300n 0
+    105599n 0
+    105600n 1.8
+    105699n 1.8
+    105700n 0
+    105999n 0
+    106000n 1.8
+    106099n 1.8
+    106100n 0
+    106399n 0
+    106400n 1.8
+    106499n 1.8
+    106500n 0
+    106799n 0
+    106800n 1.8
+    106899n 1.8
+    106900n 0
+    107199n 0
+    107200n 1.8
+    107299n 1.8
+    107300n 0
+    107599n 0
+    107600n 1.8
+    107699n 1.8
+    107700n 0
+    107999n 0
+    108000n 1.8
+    108099n 1.8
+    108100n 0
+    108399n 0
+    108400n 1.8
+    108499n 1.8
+    108500n 0
+    108799n 0
+    108800n 1.8
+    108899n 1.8
+    108900n 0
+    109199n 0
+    109200n 1.8
+    109299n 1.8
+    109300n 0
+    109599n 0
+    109600n 1.8
+    109699n 1.8
+    109700n 0
+    109999n 0
+    110000n 1.8
+    110099n 1.8
+    110100n 0
+    110399n 0
+    110400n 1.8
+    110499n 1.8
+    110500n 0
+    110799n 0
+    110800n 1.8
+    110899n 1.8
+    110900n 0
+    111199n 0
+    111200n 1.8
+    111299n 1.8
+    111300n 0
+    111599n 0
+    111600n 1.8
+    111699n 1.8
+    111700n 0
+    111999n 0
+    112000n 1.8
+    112099n 1.8
+    112100n 0
+    112399n 0
+    112400n 1.8
+    112499n 1.8
+    112500n 0
+    112799n 0
+    112800n 1.8
+    112899n 1.8
+    112900n 0
+    113199n 0
+    113200n 1.8
+    113299n 1.8
+    113300n 0
+    113599n 0
+    113600n 1.8
+    113699n 1.8
+    113700n 0
+    113999n 0
+    114000n 1.8
+    114099n 1.8
+    114100n 0
+    114399n 0
+    114400n 1.8
+    114499n 1.8
+    114500n 0
+    114799n 0
+    114800n 1.8
+    114899n 1.8
+    114900n 0
+    115199n 0
+    115200n 1.8
+    115299n 1.8
+    115300n 0
+    115599n 0
+    115600n 1.8
+    115699n 1.8
+    115700n 0
+    115999n 0
+    116000n 1.8
+    116099n 1.8
+    116100n 0
+    116399n 0
+    116400n 1.8
+    116499n 1.8
+    116500n 0
+    116799n 0
+    116800n 1.8
+    116899n 1.8
+    116900n 0
+    117199n 0
+    117200n 1.8
+    117299n 1.8
+    117300n 0
+    117599n 0
+    117600n 1.8
+    117699n 1.8
+    117700n 0
+    117999n 0
+    118000n 1.8
+    118099n 1.8
+    118100n 0
+    118399n 0
+    118400n 1.8
+    118499n 1.8
+    118500n 0
+    118799n 0
+    118800n 1.8
+    118899n 1.8
+    118900n 0
+    119199n 0
+    119200n 1.8
+    119299n 1.8
+    119300n 0
+    119599n 0
+    119600n 1.8
+    119699n 1.8
+    119700n 0
+    119999n 0
+    120000n 1.8
+    120099n 1.8
+    120100n 0
+    120399n 0
+    120400n 1.8
+    120499n 1.8
+    120500n 0
+    120799n 0
+    120800n 1.8
+    120899n 1.8
+    120900n 0
+    121199n 0
+    121200n 1.8
+    121299n 1.8
+    121300n 0
+    121599n 0
+    121600n 1.8
+    121699n 1.8
+    121700n 0
+    121999n 0
+    122000n 1.8
+    122099n 1.8
+    122100n 0
+    122399n 0
+    122400n 1.8
+    122499n 1.8
+    122500n 0
+    122799n 0
+    122800n 1.8
+    122899n 1.8
+    122900n 0
+    123199n 0
+    123200n 1.8
+    123299n 1.8
+    123300n 0
+    123599n 0
+    123600n 1.8
+    123699n 1.8
+    123700n 0
+    123999n 0
+    124000n 1.8
+    124099n 1.8
+    124100n 0
+    124399n 0
+    124400n 1.8
+    124499n 1.8
+    124500n 0
+    124799n 0
+    124800n 1.8
+    124899n 1.8
+    124900n 0
+    125199n 0
+    125200n 1.8
+    125299n 1.8
+    125300n 0
+    125599n 0
+    125600n 1.8
+    125699n 1.8
+    125700n 0
+    125999n 0
+    126000n 1.8
+    126099n 1.8
+    126100n 0
+    126399n 0
+    126400n 1.8
+    126499n 1.8
+    126500n 0
+    126799n 0
+    126800n 1.8
+    126899n 1.8
+    126900n 0
+    127199n 0
+    127200n 1.8
+    127299n 1.8
+    127300n 0
+    127599n 0
+    127600n 1.8
+    127699n 1.8
+    127700n 0
+    127999n 0
+    128000n 1.8
+    128099n 1.8
+    128100n 0
+    128399n 0
+    128400n 1.8
+    128499n 1.8
+    128500n 0
+    128799n 0
+    128800n 1.8
+    128899n 1.8
+    128900n 0
+    129199n 0
+    129200n 1.8
+    129299n 1.8
+    129300n 0
+    129599n 0
+    129600n 1.8
+    129699n 1.8
+    129700n 0
+    129999n 0
+    130000n 1.8
+    130099n 1.8
+    130100n 0
+    130399n 0
+    130400n 1.8
+    130499n 1.8
+    130500n 0
+    130799n 0
+    130800n 1.8
+    130899n 1.8
+    130900n 0
+    131199n 0
+    131200n 1.8
+    131299n 1.8
+    131300n 0
+    131599n 0
+    131600n 1.8
+    131699n 1.8
+    131700n 0
+    131999n 0
+    132000n 1.8
+    132099n 1.8
+    132100n 0
+    132399n 0
+    132400n 1.8
+    132499n 1.8
+    132500n 0
+    132799n 0
+    132800n 1.8
+    132899n 1.8
+    132900n 0
+    133199n 0
+    133200n 1.8
+    133299n 1.8
+    133300n 0
+    133599n 0
+    133600n 1.8
+    133699n 1.8
+    133700n 0
+    133999n 0
+    134000n 1.8
+    134099n 1.8
+    134100n 0
+    134399n 0
+    134400n 1.8
+    134499n 1.8
+    134500n 0
+    134799n 0
+    134800n 1.8
+    134899n 1.8
+    134900n 0
+    135199n 0
+    135200n 1.8
+    135299n 1.8
+    135300n 0
+    135599n 0
+    135600n 1.8
+    135699n 1.8
+    135700n 0
+    135999n 0
+    136000n 1.8
+    136099n 1.8
+    136100n 0
+    136399n 0
+    136400n 1.8
+    136499n 1.8
+    136500n 0
+    136799n 0
+    136800n 1.8
+    136899n 1.8
+    136900n 0
+    137199n 0
+    137200n 1.8
+    137299n 1.8
+    137300n 0
+    137599n 0
+    137600n 1.8
+    137699n 1.8
+    137700n 0
+    137999n 0
+    138000n 1.8
+    138099n 1.8
+    138100n 0
+    138399n 0
+    138400n 1.8
+    138499n 1.8
+    138500n 0
+    138799n 0
+    138800n 1.8
+    138899n 1.8
+    138900n 0
+    139199n 0
+    139200n 1.8
+    139299n 1.8
+    139300n 0
+    139599n 0
+    139600n 1.8
+    139699n 1.8
+    139700n 0
+    139999n 0
+    140000n 1.8
+    140099n 1.8
+    140100n 0
+    140399n 0
+    140400n 1.8
+    140499n 1.8
+    140500n 0
+    140799n 0
+    140800n 1.8
+    140899n 1.8
+    140900n 0
+    141199n 0
+    141200n 1.8
+    141299n 1.8
+    141300n 0
+    141599n 0
+    141600n 1.8
+    141699n 1.8
+    141700n 0
+    141999n 0
+    142000n 1.8
+    142099n 1.8
+    142100n 0
+    142399n 0
+    142400n 1.8
+    142499n 1.8
+    142500n 0
+    142799n 0
+    142800n 1.8
+    142899n 1.8
+    142900n 0
+    143199n 0
+    143200n 1.8
+    143299n 1.8
+    143300n 0
+    143599n 0
+    143600n 1.8
+    143699n 1.8
+    143700n 0
+    143999n 0
+    144000n 1.8
+    144099n 1.8
+    144100n 0
+    144399n 0
+    144400n 1.8
+    144499n 1.8
+    144500n 0
+    144799n 0
+    144800n 1.8
+    144899n 1.8
+    144900n 0
+    145199n 0
+    145200n 1.8
+    145299n 1.8
+    145300n 0
+    145599n 0
+    145600n 1.8
+    145699n 1.8
+    145700n 0
+    145999n 0
+    146000n 1.8
+    146099n 1.8
+    146100n 0
+    146399n 0
+    146400n 1.8
+    146499n 1.8
+    146500n 0
+    146799n 0
+    146800n 1.8
+    146899n 1.8
+    146900n 0
+    147199n 0
+    147200n 1.8
+    147299n 1.8
+    147300n 0
+    147599n 0
+    147600n 1.8
+    147699n 1.8
+    147700n 0
+    147999n 0
+    148000n 1.8
+    148099n 1.8
+    148100n 0
+    148399n 0
+    148400n 1.8
+    148499n 1.8
+    148500n 0
+    148799n 0
+    148800n 1.8
+    148899n 1.8
+    148900n 0
+    149199n 0
+    149200n 1.8
+    149299n 1.8
+    149300n 0
+    149599n 0
+    149600n 1.8
+    149699n 1.8
+    149700n 0
+    149999n 0
+    150000n 1.8
+    150099n 1.8
+    150100n 0
+    150399n 0
+    150400n 1.8
+    150499n 1.8
+    150500n 0
+    150799n 0
+    150800n 1.8
+    150899n 1.8
+    150900n 0
+    151199n 0
+    151200n 1.8
+    151299n 1.8
+    151300n 0
+    151599n 0
+    151600n 1.8
+    151699n 1.8
+    151700n 0
+    151999n 0
+    152000n 1.8
+    152099n 1.8
+    152100n 0
+    152399n 0
+    152400n 1.8
+    152499n 1.8
+    152500n 0
+    152799n 0
+    152800n 1.8
+    152899n 1.8
+    152900n 0
+    153199n 0
+    153200n 1.8
+    153299n 1.8
+    153300n 0
+    153599n 0
+    153600n 1.8
+    153699n 1.8
+    153700n 0
+    153999n 0
+    154000n 1.8
+    154099n 1.8
+    154100n 0
+    154399n 0
+    154400n 1.8
+    154499n 1.8
+    154500n 0
+    154799n 0
+    154800n 1.8
+    154899n 1.8
+    154900n 0
+    155199n 0
+    155200n 1.8
+    155299n 1.8
+    155300n 0
+    155599n 0
+    155600n 1.8
+    155699n 1.8
+    155700n 0
+    155999n 0
+    156000n 1.8
+    156099n 1.8
+    156100n 0
+    156399n 0
+    156400n 1.8
+    156499n 1.8
+    156500n 0
+    156799n 0
+    156800n 1.8
+    156899n 1.8
+    156900n 0
+    157199n 0
+    157200n 1.8
+    157299n 1.8
+    157300n 0
+    157599n 0
+    157600n 1.8
+    157699n 1.8
+    157700n 0
+    157999n 0
+    158000n 1.8
+    158099n 1.8
+    158100n 0
+    158399n 0
+    158400n 1.8
+    158499n 1.8
+    158500n 0
+    158799n 0
+    158800n 1.8
+    158899n 1.8
+    158900n 0
+    159199n 0
+    159200n 1.8
+    159299n 1.8
+    159300n 0
+    159599n 0
+    159600n 1.8
+    159699n 1.8
+    159700n 0
+    159999n 0
+    160000n 1.8
+    160099n 1.8
+    160100n 0
+    160399n 0
+    160400n 1.8
+    160499n 1.8
+    160500n 0
+    160799n 0
+    160800n 1.8
+    160899n 1.8
+    160900n 0
+    161199n 0
+    161200n 1.8
+    161299n 1.8
+    161300n 0
+    161599n 0
+    161600n 1.8
+    161699n 1.8
+    161700n 0
+    161999n 0
+    162000n 1.8
+    162099n 1.8
+    162100n 0
+    162399n 0
+    162400n 1.8
+    162499n 1.8
+    162500n 0
+    162799n 0
+    162800n 1.8
+    162899n 1.8
+    162900n 0
+    163199n 0
+    163200n 1.8
+    163299n 1.8
+    163300n 0
+    163599n 0
+    163600n 1.8
+    163699n 1.8
+    163700n 0
+    163999n 0
+    164000n 1.8
+    164099n 1.8
+    164100n 0
+    164399n 0
+    164400n 1.8
+    164499n 1.8
+    164500n 0
+    164799n 0
+    164800n 1.8
+    164899n 1.8
+    164900n 0
+    165199n 0
+    165200n 1.8
+    165299n 1.8
+    165300n 0
+    165599n 0
+    165600n 1.8
+    165699n 1.8
+    165700n 0
+    165999n 0
+    166000n 1.8
+    166099n 1.8
+    166100n 0
+    166399n 0
+    166400n 1.8
+    166499n 1.8
+    166500n 0
+    166799n 0
+    166800n 1.8
+    166899n 1.8
+    166900n 0
+    167199n 0
+    167200n 1.8
+    167299n 1.8
+    167300n 0
+    167599n 0
+    167600n 1.8
+    167699n 1.8
+    167700n 0
+    167999n 0
+    168000n 1.8
+    168099n 1.8
+    168100n 0
+    168399n 0
+    168400n 1.8
+    168499n 1.8
+    168500n 0
+    168799n 0
+    168800n 1.8
+    168899n 1.8
+    168900n 0
+    169199n 0
+    169200n 1.8
+    169299n 1.8
+    169300n 0
+    169599n 0
+    169600n 1.8
+    169699n 1.8
+    169700n 0
+    169999n 0
+    170000n 1.8
+    170099n 1.8
+    170100n 0
+    170399n 0
+    170400n 1.8
+    170499n 1.8
+    170500n 0
+    170799n 0
+    170800n 1.8
+    170899n 1.8
+    170900n 0
+    171199n 0
+    171200n 1.8
+    171299n 1.8
+    171300n 0
+    171599n 0
+    171600n 1.8
+    171699n 1.8
+    171700n 0
+    171999n 0
+    172000n 1.8
+    172099n 1.8
+    172100n 0
+    172399n 0
+    172400n 1.8
+    172499n 1.8
+    172500n 0
+    172799n 0
+    172800n 1.8
+    172899n 1.8
+    172900n 0
+    173199n 0
+    173200n 1.8
+    173299n 1.8
+    173300n 0
+    173599n 0
+    173600n 1.8
+    173699n 1.8
+    173700n 0
+    173999n 0
+    174000n 1.8
+    174099n 1.8
+    174100n 0
+    174399n 0
+    174400n 1.8
+    174499n 1.8
+    174500n 0
+    174799n 0
+    174800n 1.8
+    174899n 1.8
+    174900n 0
+    175199n 0
+    175200n 1.8
+    175299n 1.8
+    175300n 0
+    175599n 0
+    175600n 1.8
+    175699n 1.8
+    175700n 0
+    175999n 0
+    176000n 1.8
+    176099n 1.8
+    176100n 0
+    176399n 0
+    176400n 1.8
+    176499n 1.8
+    176500n 0
+    176799n 0
+    176800n 1.8
+    176899n 1.8
+    176900n 0
+    177199n 0
+    177200n 1.8
+    177299n 1.8
+    177300n 0
+    177599n 0
+    177600n 1.8
+    177699n 1.8
+    177700n 0
+    177999n 0
+    178000n 1.8
+    178099n 1.8
+    178100n 0
+    178399n 0
+    178400n 1.8
+    178499n 1.8
+    178500n 0
+    178799n 0
+    178800n 1.8
+    178899n 1.8
+    178900n 0
+    179199n 0
+    179200n 1.8
+    179299n 1.8
+    179300n 0
+    179599n 0
+    179600n 1.8
+    179699n 1.8
+    179700n 0
+    179999n 0
+    180000n 1.8
+    180099n 1.8
+    180100n 0
+    180399n 0
+    180400n 1.8
+    180499n 1.8
+    180500n 0
+    180799n 0
+    180800n 1.8
+    180899n 1.8
+    180900n 0
+    181199n 0
+    181200n 1.8
+    181299n 1.8
+    181300n 0
+    181599n 0
+    181600n 1.8
+    181699n 1.8
+    181700n 0
+    181999n 0
+    182000n 1.8
+    182099n 1.8
+    182100n 0
+    182399n 0
+    182400n 1.8
+    182499n 1.8
+    182500n 0
+    182799n 0
+    182800n 1.8
+    182899n 1.8
+    182900n 0
+    183199n 0
+    183200n 1.8
+    183299n 1.8
+    183300n 0
+    183599n 0
+    183600n 1.8
+    183699n 1.8
+    183700n 0
+    183999n 0
+    184000n 1.8
+    184099n 1.8
+    184100n 0
+    184399n 0
+    184400n 1.8
+    184499n 1.8
+    184500n 0
+    184799n 0
+    184800n 1.8
+    184899n 1.8
+    184900n 0
+    185199n 0
+    185200n 1.8
+    185299n 1.8
+    185300n 0
+    185599n 0
+    185600n 1.8
+    185699n 1.8
+    185700n 0
+    185999n 0
+    186000n 1.8
+    186099n 1.8
+    186100n 0
+    186399n 0
+    186400n 1.8
+    186499n 1.8
+    186500n 0
+    186799n 0
+    186800n 1.8
+    186899n 1.8
+    186900n 0
+    187199n 0
+    187200n 1.8
+    187299n 1.8
+    187300n 0
+    187599n 0
+    187600n 1.8
+    187699n 1.8
+    187700n 0
+    187999n 0
+    188000n 1.8
+    188099n 1.8
+    188100n 0
+    188399n 0
+    188400n 1.8
+    188499n 1.8
+    188500n 0
+    188799n 0
+    188800n 1.8
+    188899n 1.8
+    188900n 0
+    189199n 0
+    189200n 1.8
+    189299n 1.8
+    189300n 0
+    189599n 0
+    189600n 1.8
+    189699n 1.8
+    189700n 0
+    189999n 0
+    190000n 1.8
+    190099n 1.8
+    190100n 0
+    190399n 0
+    190400n 1.8
+    190499n 1.8
+    190500n 0
+    190799n 0
+    190800n 1.8
+    190899n 1.8
+    190900n 0
+    191199n 0
+    191200n 1.8
+    191299n 1.8
+    191300n 0
+    191599n 0
+    191600n 1.8
+    191699n 1.8
+    191700n 0
+    191999n 0
+    192000n 1.8
+    192099n 1.8
+    192100n 0
+    192399n 0
+    192400n 1.8
+    192499n 1.8
+    192500n 0
+    192799n 0
+    192800n 1.8
+    192899n 1.8
+    192900n 0
+    193199n 0
+    193200n 1.8
+    193299n 1.8
+    193300n 0
+    193599n 0
+    193600n 1.8
+    193699n 1.8
+    193700n 0
+    193999n 0
+    194000n 1.8
+    194099n 1.8
+    194100n 0
+    194399n 0
+    194400n 1.8
+    194499n 1.8
+    194500n 0
+    194799n 0
+    194800n 1.8
+    194899n 1.8
+    194900n 0
+    195199n 0
+    195200n 1.8
+    195299n 1.8
+    195300n 0
+    195599n 0
+    195600n 1.8
+    195699n 1.8
+    195700n 0
+    195999n 0
+    196000n 1.8
+    196099n 1.8
+    196100n 0
+    196399n 0
+    196400n 1.8
+    196499n 1.8
+    196500n 0
+    196799n 0
+    196800n 1.8
+    196899n 1.8
+    196900n 0
+    197199n 0
+    197200n 1.8
+    197299n 1.8
+    197300n 0
+    197599n 0
+    197600n 1.8
+    197699n 1.8
+    197700n 0
+    197999n 0
+    198000n 1.8
+    198099n 1.8
+    198100n 0
+    198399n 0
+    198400n 1.8
+    198499n 1.8
+    198500n 0
+    198799n 0
+    198800n 1.8
+    198899n 1.8
+    198900n 0
+    199199n 0
+    199200n 1.8
+    199299n 1.8
+    199300n 0
+    199599n 0
+    199600n 1.8
+    199699n 1.8
+    199700n 0
+    199999n 0
+    200000n 1.8
+    200099n 1.8
+    200100n 0
+    200399n 0
+    200400n 1.8
+    200499n 1.8
+    200500n 0
+    200799n 0
+    200800n 1.8
+    200899n 1.8
+    200900n 0
+    201199n 0
+    201200n 1.8
+    201299n 1.8
+    201300n 0
+    201599n 0
+    201600n 1.8
+    201699n 1.8
+    201700n 0
+    201999n 0
+    202000n 1.8
+    202099n 1.8
+    202100n 0
+    202399n 0
+    202400n 1.8
+    202499n 1.8
+    202500n 0
+    202799n 0
+    202800n 1.8
+    202899n 1.8
+    202900n 0
+    203199n 0
+    203200n 1.8
+    203299n 1.8
+    203300n 0
+    203599n 0
+    203600n 1.8
+    203699n 1.8
+    203700n 0
+    203999n 0
+    204000n 1.8
+    204099n 1.8
+    204100n 0
+    204399n 0
+    204400n 1.8
+    204499n 1.8
+    204500n 0
+    204799n 0
+    204800n 1.8
+    204899n 1.8
+    204900n 0
+    205199n 0
+    205200n 1.8
+    205299n 1.8
+    205300n 0
+    205599n 0
+    205600n 1.8
+    205699n 1.8
+    205700n 0
+    205999n 0
+    206000n 1.8
+    206099n 1.8
+    206100n 0
+    206399n 0
+    206400n 1.8
+    206499n 1.8
+    206500n 0
+    206799n 0
+    206800n 1.8
+    206899n 1.8
+    206900n 0
+    207199n 0
+    207200n 1.8
+    207299n 1.8
+    207300n 0
+    207599n 0
+    207600n 1.8
+    207699n 1.8
+    207700n 0
+    207999n 0
+    208000n 1.8
+    208099n 1.8
+    208100n 0
+    208399n 0
+    208400n 1.8
+    208499n 1.8
+    208500n 0
+    208799n 0
+    208800n 1.8
+    208899n 1.8
+    208900n 0
+    209199n 0
+    209200n 1.8
+    209299n 1.8
+    209300n 0
+    209599n 0
+    209600n 1.8
+    209699n 1.8
+    209700n 0
+    209999n 0
+    210000n 1.8
+    210099n 1.8
+    210100n 0
+    210399n 0
+    210400n 1.8
+    210499n 1.8
+    210500n 0
+    210799n 0
+    210800n 1.8
+    210899n 1.8
+    210900n 0
+    211199n 0
+    211200n 1.8
+    211299n 1.8
+    211300n 0
+    211599n 0
+    211600n 1.8
+    211699n 1.8
+    211700n 0
+    211999n 0
+    212000n 1.8
+    212099n 1.8
+    212100n 0
+    212399n 0
+    212400n 1.8
+    212499n 1.8
+    212500n 0
+    212799n 0
+    212800n 1.8
+    212899n 1.8
+    212900n 0
+    213199n 0
+    213200n 1.8
+    213299n 1.8
+    213300n 0
+    213599n 0
+    213600n 1.8
+    213699n 1.8
+    213700n 0
+    213999n 0
+    214000n 1.8
+    214099n 1.8
+    214100n 0
+    214399n 0
+    214400n 1.8
+    214499n 1.8
+    214500n 0
+    214799n 0
+    214800n 1.8
+    214899n 1.8
+    214900n 0
+    215199n 0
+    215200n 1.8
+    215299n 1.8
+    215300n 0
+    215599n 0
+    215600n 1.8
+    215699n 1.8
+    215700n 0
+    215999n 0
+    216000n 1.8
+    216099n 1.8
+    216100n 0
+    216399n 0
+    216400n 1.8
+    216499n 1.8
+    216500n 0
+    216799n 0
+    216800n 1.8
+    216899n 1.8
+    216900n 0
+    217199n 0
+    217200n 1.8
+    217299n 1.8
+    217300n 0
+    217599n 0
+    217600n 1.8
+    217699n 1.8
+    217700n 0
+    217999n 0
+    218000n 1.8
+    218099n 1.8
+    218100n 0
+    218399n 0
+    218400n 1.8
+    218499n 1.8
+    218500n 0
+    218799n 0
+    218800n 1.8
+    218899n 1.8
+    218900n 0
+    219199n 0
+    219200n 1.8
+    219299n 1.8
+    219300n 0
+    219599n 0
+    219600n 1.8
+    219699n 1.8
+    219700n 0
+    219999n 0
+    220000n 1.8
+    220099n 1.8
+    220100n 0
+    220399n 0
+    220400n 1.8
+    220499n 1.8
+    220500n 0
+    220799n 0
+    220800n 1.8
+    220899n 1.8
+    220900n 0
+    221199n 0
+    221200n 1.8
+    221299n 1.8
+    221300n 0
+    221599n 0
+    221600n 1.8
+    221699n 1.8
+    221700n 0
+    221999n 0
+    222000n 1.8
+    222099n 1.8
+    222100n 0
+    222399n 0
+    222400n 1.8
+    222499n 1.8
+    222500n 0
+    222799n 0
+    222800n 1.8
+    222899n 1.8
+    222900n 0
+    223199n 0
+    223200n 1.8
+    223299n 1.8
+    223300n 0
+    223599n 0
+    223600n 1.8
+    223699n 1.8
+    223700n 0
+    223999n 0
+    224000n 1.8
+    224099n 1.8
+    224100n 0
+    224399n 0
+    224400n 1.8
+    224499n 1.8
+    224500n 0
+    224799n 0
+    224800n 1.8
+    224899n 1.8
+    224900n 0
+    225199n 0
+    225200n 1.8
+    225299n 1.8
+    225300n 0
+    225599n 0
+    225600n 1.8
+    225699n 1.8
+    225700n 0
+    225999n 0
+    226000n 1.8
+    226099n 1.8
+    226100n 0
+    226399n 0
+    226400n 1.8
+    226499n 1.8
+    226500n 0
+    226799n 0
+    226800n 1.8
+    226899n 1.8
+    226900n 0
+    227199n 0
+    227200n 1.8
+    227299n 1.8
+    227300n 0
+    227599n 0
+    227600n 1.8
+    227699n 1.8
+    227700n 0
+    227999n 0
+    228000n 1.8
+    228099n 1.8
+    228100n 0
+    228399n 0
+    228400n 1.8
+    228499n 1.8
+    228500n 0
+    228799n 0
+    228800n 1.8
+    228899n 1.8
+    228900n 0
+    229199n 0
+    229200n 1.8
+    229299n 1.8
+    229300n 0
+    229599n 0
+    229600n 1.8
+    229699n 1.8
+    229700n 0
+    229999n 0
+    230000n 1.8
+    230099n 1.8
+    230100n 0
+    230399n 0
+    230400n 1.8
+    230499n 1.8
+    230500n 0
+    230799n 0
+    230800n 1.8
+    230899n 1.8
+    230900n 0
+    231199n 0
+    231200n 1.8
+    231299n 1.8
+    231300n 0
+    231599n 0
+    231600n 1.8
+    231699n 1.8
+    231700n 0
+    231999n 0
+    232000n 1.8
+    232099n 1.8
+    232100n 0
+    232399n 0
+    232400n 1.8
+    232499n 1.8
+    232500n 0
+    232799n 0
+    232800n 1.8
+    232899n 1.8
+    232900n 0
+    233199n 0
+    233200n 1.8
+    233299n 1.8
+    233300n 0
+    233599n 0
+    233600n 1.8
+    233699n 1.8
+    233700n 0
+    233999n 0
+    234000n 1.8
+    234099n 1.8
+    234100n 0
+    234399n 0
+    234400n 1.8
+    234499n 1.8
+    234500n 0
+    234799n 0
+    234800n 1.8
+    234899n 1.8
+    234900n 0
+    235199n 0
+    235200n 1.8
+    235299n 1.8
+    235300n 0
+    235599n 0
+    235600n 1.8
+    235699n 1.8
+    235700n 0
+    235999n 0
+    236000n 1.8
+    236099n 1.8
+    236100n 0
+    236399n 0
+    236400n 1.8
+    236499n 1.8
+    236500n 0
+    236799n 0
+    236800n 1.8
+    236899n 1.8
+    236900n 0
+    237199n 0
+    237200n 1.8
+    237299n 1.8
+    237300n 0
+    237599n 0
+    237600n 1.8
+    237699n 1.8
+    237700n 0
+    237999n 0
+    238000n 1.8
+    238099n 1.8
+    238100n 0
+    238399n 0
+    238400n 1.8
+    238499n 1.8
+    238500n 0
+    238799n 0
+    238800n 1.8
+    238899n 1.8
+    238900n 0
+    239199n 0
+    239200n 1.8
+    239299n 1.8
+    239300n 0
+    239599n 0
+    239600n 1.8
+    239699n 1.8
+    239700n 0
+    239999n 0
+    240000n 1.8
+    240099n 1.8
+    240100n 0
+    240399n 0
+    240400n 1.8
+    240499n 1.8
+    240500n 0
+    240799n 0
+    240800n 1.8
+    240899n 1.8
+    240900n 0
+    241199n 0
+    241200n 1.8
+    241299n 1.8
+    241300n 0
+    241599n 0
+    241600n 1.8
+    241699n 1.8
+    241700n 0
+    241999n 0
+    242000n 1.8
+    242099n 1.8
+    242100n 0
+    242399n 0
+    242400n 1.8
+    242499n 1.8
+    242500n 0
+    242799n 0
+    242800n 1.8
+    242899n 1.8
+    242900n 0
+    243199n 0
+    243200n 1.8
+    243299n 1.8
+    243300n 0
+    243599n 0
+    243600n 1.8
+    243699n 1.8
+    243700n 0
+    243999n 0
+    244000n 1.8
+    244099n 1.8
+    244100n 0
+    244399n 0
+    244400n 1.8
+    244499n 1.8
+    244500n 0
+    244799n 0
+    244800n 1.8
+    244899n 1.8
+    244900n 0
+    245199n 0
+    245200n 1.8
+    245299n 1.8
+    245300n 0
+    245599n 0
+    245600n 1.8
+    245699n 1.8
+    245700n 0
+    245999n 0
+    246000n 1.8
+    246099n 1.8
+    246100n 0
+    246399n 0
+    246400n 1.8
+    246499n 1.8
+    246500n 0
+    246799n 0
+    246800n 1.8
+    246899n 1.8
+    246900n 0
+    247199n 0
+    247200n 1.8
+    247299n 1.8
+    247300n 0
+    247599n 0
+    247600n 1.8
+    247699n 1.8
+    247700n 0
+    247999n 0
+    248000n 1.8
+    248099n 1.8
+    248100n 0
+    248399n 0
+    248400n 1.8
+    248499n 1.8
+    248500n 0
+    248799n 0
+    248800n 1.8
+    248899n 1.8
+    248900n 0
+    249199n 0
+    249200n 1.8
+    249299n 1.8
+    249300n 0
+    249599n 0
+    249600n 1.8
+    249699n 1.8
+    249700n 0
+    249999n 0
+    250000n 1.8
+    250099n 1.8
+    250100n 0
+    250399n 0
+    250400n 1.8
+    250499n 1.8
+    250500n 0
+    250799n 0
+    250800n 1.8
+    250899n 1.8
+    250900n 0
+    251199n 0
+    251200n 1.8
+    251299n 1.8
+    251300n 0
+    251599n 0
+    251600n 1.8
+    251699n 1.8
+    251700n 0
+    251999n 0
+    252000n 1.8
+    252099n 1.8
+    252100n 0
+    252399n 0
+    252400n 1.8
+    252499n 1.8
+    252500n 0
+    252799n 0
+    252800n 1.8
+    252899n 1.8
+    252900n 0
+    253199n 0
+    253200n 1.8
+    253299n 1.8
+    253300n 0
+    253599n 0
+    253600n 1.8
+    253699n 1.8
+    253700n 0
+    253999n 0
+    254000n 1.8
+    254099n 1.8
+    254100n 0
+    254399n 0
+    254400n 1.8
+    254499n 1.8
+    254500n 0
+    254799n 0
+    254800n 1.8
+    254899n 1.8
+    254900n 0
+    255199n 0
+    255200n 1.8
+    255299n 1.8
+    255300n 0
+    255599n 0
+    255600n 1.8
+    255699n 1.8
+    255700n 0
+    255999n 0
+    256000n 1.8
+    256099n 1.8
+    256100n 0
+    256399n 0
+    256400n 1.8
+    256499n 1.8
+    256500n 0
+    256799n 0
+    256800n 1.8
+    256899n 1.8
+    256900n 0
+    257199n 0
+    257200n 1.8
+    257299n 1.8
+    257300n 0
+    257599n 0
+    257600n 1.8
+    257699n 1.8
+    257700n 0
+    257999n 0
+    258000n 1.8
+    258099n 1.8
+    258100n 0
+    258399n 0
+    258400n 1.8
+    258499n 1.8
+    258500n 0
+    258799n 0
+    258800n 1.8
+    258899n 1.8
+    258900n 0
+    259199n 0
+    259200n 1.8
+    259299n 1.8
+    259300n 0
+    259599n 0
+    259600n 1.8
+    259699n 1.8
+    259700n 0
+    259999n 0
+    260000n 1.8
+    260099n 1.8
+    260100n 0
+    260399n 0
+    260400n 1.8
+    260499n 1.8
+    260500n 0
+    260799n 0
+    260800n 1.8
+    260899n 1.8
+    260900n 0
+    261199n 0
+    261200n 1.8
+    261299n 1.8
+    261300n 0
+    261599n 0
+    261600n 1.8
+    261699n 1.8
+    261700n 0
+    261999n 0
+    262000n 1.8
+    262099n 1.8
+    262100n 0
+    262399n 0
+    262400n 1.8
+    262499n 1.8
+    262500n 0
+    262799n 0
+    262800n 1.8
+    262899n 1.8
+    262900n 0
+    263199n 0
+    263200n 1.8
+    263299n 1.8
+    263300n 0
+    263599n 0
+    263600n 1.8
+    263699n 1.8
+    263700n 0
+    263999n 0
+    264000n 1.8
+    264099n 1.8
+    264100n 0
+    264399n 0
+    264400n 1.8
+    264499n 1.8
+    264500n 0
+    264799n 0
+    264800n 1.8
+    264899n 1.8
+    264900n 0
+    265199n 0
+    265200n 1.8
+    265299n 1.8
+    265300n 0
+    265599n 0
+    265600n 1.8
+    265699n 1.8
+    265700n 0
+    265999n 0
+    266000n 1.8
+    266099n 1.8
+    266100n 0
+    266399n 0
+    266400n 1.8
+    266499n 1.8
+    266500n 0
+    266799n 0
+    266800n 1.8
+    266899n 1.8
+    266900n 0
+    267199n 0
+    267200n 1.8
+    267299n 1.8
+    267300n 0
+    267599n 0
+    267600n 1.8
+    267699n 1.8
+    267700n 0
+    267999n 0
+    268000n 1.8
+    268099n 1.8
+    268100n 0
+    268399n 0
+    268400n 1.8
+    268499n 1.8
+    268500n 0
+    268799n 0
+    268800n 1.8
+    268899n 1.8
+    268900n 0
+    269199n 0
+    269200n 1.8
+    269299n 1.8
+    269300n 0
+    269599n 0
+    269600n 1.8
+    269699n 1.8
+    269700n 0
+    269999n 0
+    270000n 1.8
+    270099n 1.8
+    270100n 0
+    270399n 0
+    270400n 1.8
+    270499n 1.8
+    270500n 0
+    270799n 0
+    270800n 1.8
+    270899n 1.8
+    270900n 0
+    271199n 0
+    271200n 1.8
+    271299n 1.8
+    271300n 0
+    271599n 0
+    271600n 1.8
+    271699n 1.8
+    271700n 0
+    271999n 0
+    272000n 1.8
+    272099n 1.8
+    272100n 0
+    272399n 0
+    272400n 1.8
+    272499n 1.8
+    272500n 0
+    272799n 0
+    272800n 1.8
+    272899n 1.8
+    272900n 0
+    273199n 0
+    273200n 1.8
+    273299n 1.8
+    273300n 0
+    273599n 0
+    273600n 1.8
+    273699n 1.8
+    273700n 0
+    273999n 0
+    274000n 1.8
+    274099n 1.8
+    274100n 0
+    274399n 0
+    274400n 1.8
+    274499n 1.8
+    274500n 0
+    274799n 0
+    274800n 1.8
+    274899n 1.8
+    274900n 0
+    275199n 0
+    275200n 1.8
+    275299n 1.8
+    275300n 0
+    275599n 0
+    275600n 1.8
+    275699n 1.8
+    275700n 0
+    275999n 0
+    276000n 1.8
+    276099n 1.8
+    276100n 0
+    276399n 0
+    276400n 1.8
+    276499n 1.8
+    276500n 0
+    276799n 0
+    276800n 1.8
+    276899n 1.8
+    276900n 0
+    277199n 0
+    277200n 1.8
+    277299n 1.8
+    277300n 0
+    277599n 0
+    277600n 1.8
+    277699n 1.8
+    277700n 0
+    277999n 0
+    278000n 1.8
+    278099n 1.8
+    278100n 0
+    278399n 0
+    278400n 1.8
+    278499n 1.8
+    278500n 0
+    278799n 0
+    278800n 1.8
+    278899n 1.8
+    278900n 0
+    279199n 0
+    279200n 1.8
+    279299n 1.8
+    279300n 0
+    279599n 0
+    279600n 1.8
+    279699n 1.8
+    279700n 0
+    279999n 0
+    280000n 1.8
+    280099n 1.8
+    280100n 0
+    280399n 0
+    280400n 1.8
+    280499n 1.8
+    280500n 0
+    280799n 0
+    280800n 1.8
+    280899n 1.8
+    280900n 0
+    281199n 0
+    281200n 1.8
+    281299n 1.8
+    281300n 0
+    281599n 0
+    281600n 1.8
+    281699n 1.8
+    281700n 0
+    281999n 0
+    282000n 1.8
+    282099n 1.8
+    282100n 0
+    282399n 0
+    282400n 1.8
+    282499n 1.8
+    282500n 0
+    282799n 0
+    282800n 1.8
+    282899n 1.8
+    282900n 0
+    283199n 0
+    283200n 1.8
+    283299n 1.8
+    283300n 0
+    283599n 0
+    283600n 1.8
+    283699n 1.8
+    283700n 0
+    283999n 0
+    284000n 1.8
+    284099n 1.8
+    284100n 0
+    284399n 0
+    284400n 1.8
+    284499n 1.8
+    284500n 0
+    284799n 0
+    284800n 1.8
+    284899n 1.8
+    284900n 0
+    285199n 0
+    285200n 1.8
+    285299n 1.8
+    285300n 0
+    285599n 0
+    285600n 1.8
+    285699n 1.8
+    285700n 0
+    285999n 0
+    286000n 1.8
+    286099n 1.8
+    286100n 0
+    286399n 0
+    286400n 1.8
+    286499n 1.8
+    286500n 0
+    286799n 0
+    286800n 1.8
+    286899n 1.8
+    286900n 0
+    287199n 0
+    287200n 1.8
+    287299n 1.8
+    287300n 0
+    287599n 0
+    287600n 1.8
+    287699n 1.8
+    287700n 0
+    287999n 0
+    288000n 1.8
+    288099n 1.8
+    288100n 0
+    288399n 0
+    288400n 1.8
+    288499n 1.8
+    288500n 0
+    288799n 0
+    288800n 1.8
+    288899n 1.8
+    288900n 0
+    289199n 0
+    289200n 1.8
+    289299n 1.8
+    289300n 0
+    289599n 0
+    289600n 1.8
+    289699n 1.8
+    289700n 0
+    289999n 0
+    290000n 1.8
+    290099n 1.8
+    290100n 0
+    290399n 0
+    290400n 1.8
+    290499n 1.8
+    290500n 0
+    290799n 0
+    290800n 1.8
+    290899n 1.8
+    290900n 0
+    291199n 0
+    291200n 1.8
+    291299n 1.8
+    291300n 0
+    291599n 0
+    291600n 1.8
+    291699n 1.8
+    291700n 0
+    291999n 0
+    292000n 1.8
+    292099n 1.8
+    292100n 0
+    292399n 0
+    292400n 1.8
+    292499n 1.8
+    292500n 0
+    292799n 0
+    292800n 1.8
+    292899n 1.8
+    292900n 0
+    293199n 0
+    293200n 1.8
+    293299n 1.8
+    293300n 0
+    293599n 0
+    293600n 1.8
+    293699n 1.8
+    293700n 0
+    293999n 0
+    294000n 1.8
+    294099n 1.8
+    294100n 0
+    294399n 0
+    294400n 1.8
+    294499n 1.8
+    294500n 0
+    294799n 0
+    294800n 1.8
+    294899n 1.8
+    294900n 0
+    295199n 0
+    295200n 1.8
+    295299n 1.8
+    295300n 0
+    295599n 0
+    295600n 1.8
+    295699n 1.8
+    295700n 0
+    295999n 0
+    296000n 1.8
+    296099n 1.8
+    296100n 0
+    296399n 0
+    296400n 1.8
+    296499n 1.8
+    296500n 0
+    296799n 0
+    296800n 1.8
+    296899n 1.8
+    296900n 0
+    297199n 0
+    297200n 1.8
+    297299n 1.8
+    297300n 0
+    297599n 0
+    297600n 1.8
+    297699n 1.8
+    297700n 0
+    297999n 0
+    298000n 1.8
+    298099n 1.8
+    298100n 0
+    298399n 0
+    298400n 1.8
+    298499n 1.8
+    298500n 0
+    298799n 0
+    298800n 1.8
+    298899n 1.8
+    298900n 0
+    299199n 0
+    299200n 1.8
+    299299n 1.8
+    299300n 0
+    299599n 0
+    299600n 1.8
+    299699n 1.8
+    299700n 0
+    299999n 0
+    300000n 1.8
+    300099n 1.8
+    300100n 0
+    300399n 0
+    300400n 1.8
+    300499n 1.8
+    300500n 0
+    300799n 0
+    300800n 1.8
+    300899n 1.8
+    300900n 0
+    301199n 0
+    301200n 1.8
+    301299n 1.8
+    301300n 0
+    301599n 0
+    301600n 1.8
+    301699n 1.8
+    301700n 0
+    301999n 0
+    302000n 1.8
+    302099n 1.8
+    302100n 0
+    302399n 0
+    302400n 1.8
+    302499n 1.8
+    302500n 0
+    302799n 0
+    302800n 1.8
+    302899n 1.8
+    302900n 0
+    303199n 0
+    303200n 1.8
+    303299n 1.8
+    303300n 0
+    303599n 0
+    303600n 1.8
+    303699n 1.8
+    303700n 0
+    303999n 0
+    304000n 1.8
+    304099n 1.8
+    304100n 0
+    304399n 0
+    304400n 1.8
+    304499n 1.8
+    304500n 0
+    304799n 0
+    304800n 1.8
+    304899n 1.8
+    304900n 0
+    305199n 0
+    305200n 1.8
+    305299n 1.8
+    305300n 0
+    305599n 0
+    305600n 1.8
+    305699n 1.8
+    305700n 0
+    305999n 0
+    306000n 1.8
+    306099n 1.8
+    306100n 0
+    306399n 0
+    306400n 1.8
+    306499n 1.8
+    306500n 0
+    306799n 0
+    306800n 1.8
+    306899n 1.8
+    306900n 0
+    307199n 0
+    307200n 1.8
+    307299n 1.8
+    307300n 0
+    307599n 0
+    307600n 1.8
+    307699n 1.8
+    307700n 0
+    307999n 0
+    308000n 1.8
+    308099n 1.8
+    308100n 0
+    308399n 0
+    308400n 1.8
+    308499n 1.8
+    308500n 0
+    308799n 0
+    308800n 1.8
+    308899n 1.8
+    308900n 0
+    309199n 0
+    309200n 1.8
+    309299n 1.8
+    309300n 0
+    309599n 0
+    309600n 1.8
+    309699n 1.8
+    309700n 0
+    309999n 0
+    310000n 1.8
+    310099n 1.8
+    310100n 0
+    310399n 0
+    310400n 1.8
+    310499n 1.8
+    310500n 0
+    310799n 0
+    310800n 1.8
+    310899n 1.8
+    310900n 0
+    311199n 0
+    311200n 1.8
+    311299n 1.8
+    311300n 0
+    311599n 0
+    311600n 1.8
+    311699n 1.8
+    311700n 0
+    311999n 0
+    312000n 1.8
+    312099n 1.8
+    312100n 0
+    312399n 0
+    312400n 1.8
+    312499n 1.8
+    312500n 0
+    312799n 0
+    312800n 1.8
+    312899n 1.8
+    312900n 0
+    313199n 0
+    313200n 1.8
+    313299n 1.8
+    313300n 0
+    313599n 0
+    313600n 1.8
+    313699n 1.8
+    313700n 0
+    313999n 0
+    314000n 1.8
+    314099n 1.8
+    314100n 0
+    314399n 0
+    314400n 1.8
+    314499n 1.8
+    314500n 0
+    314799n 0
+    314800n 1.8
+    314899n 1.8
+    314900n 0
+    315199n 0
+    315200n 1.8
+    315299n 1.8
+    315300n 0
+    315599n 0
+    315600n 1.8
+    315699n 1.8
+    315700n 0
+    315999n 0
+    316000n 1.8
+    316099n 1.8
+    316100n 0
+    316399n 0
+    316400n 1.8
+    316499n 1.8
+    316500n 0
+    316799n 0
+    316800n 1.8
+    316899n 1.8
+    316900n 0
+    317199n 0
+    317200n 1.8
+    317299n 1.8
+    317300n 0
+    317599n 0
+    317600n 1.8
+    317699n 1.8
+    317700n 0
+    317999n 0
+    318000n 1.8
+    318099n 1.8
+    318100n 0
+    318399n 0
+    318400n 1.8
+    318499n 1.8
+    318500n 0
+    318799n 0
+    318800n 1.8
+    318899n 1.8
+    318900n 0
+    319199n 0
+    319200n 1.8
+    319299n 1.8
+    319300n 0
+    319599n 0
+    319600n 1.8
+    319699n 1.8
+    319700n 0
+    319999n 0
+    320000n 1.8
+    320099n 1.8
+    320100n 0
+    320399n 0
+    320400n 1.8
+    320499n 1.8
+    320500n 0
+    320799n 0
+    320800n 1.8
+    320899n 1.8
+    320900n 0
+    321199n 0
+    321200n 1.8
+    321299n 1.8
+    321300n 0
+    321599n 0
+    321600n 1.8
+    321699n 1.8
+    321700n 0
+    321999n 0
+    322000n 1.8
+    322099n 1.8
+    322100n 0
+    322399n 0
+    322400n 1.8
+    322499n 1.8
+    322500n 0
+    322799n 0
+    322800n 1.8
+    322899n 1.8
+    322900n 0
+    323199n 0
+    323200n 1.8
+    323299n 1.8
+    323300n 0
+    323599n 0
+    323600n 1.8
+    323699n 1.8
+    323700n 0
+    323999n 0
+    324000n 1.8
+    324099n 1.8
+    324100n 0
+    324399n 0
+    324400n 1.8
+    324499n 1.8
+    324500n 0
+    324799n 0
+    324800n 1.8
+    324899n 1.8
+    324900n 0
+    325199n 0
+    325200n 1.8
+    325299n 1.8
+    325300n 0
+    325599n 0
+    325600n 1.8
+    325699n 1.8
+    325700n 0
+    325999n 0
+    326000n 1.8
+    326099n 1.8
+    326100n 0
+    326399n 0
+    326400n 1.8
+    326499n 1.8
+    326500n 0
+    326799n 0
+    326800n 1.8
+    326899n 1.8
+    326900n 0
+    327199n 0
+    327200n 1.8
+    327299n 1.8
+    327300n 0
+    327599n 0
+    327600n 1.8
+    327699n 1.8
+    327700n 0
+    327999n 0
+    328000n 1.8
+    328099n 1.8
+    328100n 0
+    328399n 0
+    328400n 1.8
+    328499n 1.8
+    328500n 0
+    328799n 0
+    328800n 1.8
+    328899n 1.8
+    328900n 0
+    329199n 0
+    329200n 1.8
+    329299n 1.8
+    329300n 0
+    329599n 0
+    329600n 1.8
+    329699n 1.8
+    329700n 0
+    329999n 0
+    330000n 1.8
+    330099n 1.8
+    330100n 0
+    330399n 0
+    330400n 1.8
+    330499n 1.8
+    330500n 0
+    330799n 0
+    330800n 1.8
+    330899n 1.8
+    330900n 0
+    331199n 0
+    331200n 1.8
+    331299n 1.8
+    331300n 0
+    331599n 0
+    331600n 1.8
+    331699n 1.8
+    331700n 0
+    331999n 0
+    332000n 1.8
+    332099n 1.8
+    332100n 0
+    332399n 0
+    332400n 1.8
+    332499n 1.8
+    332500n 0
+    332799n 0
+    332800n 1.8
+    332899n 1.8
+    332900n 0
+    333199n 0
+    333200n 1.8
+    333299n 1.8
+    333300n 0
+    333599n 0
+    333600n 1.8
+    333699n 1.8
+    333700n 0
+    333999n 0
+    334000n 1.8
+    334099n 1.8
+    334100n 0
+    334399n 0
+    334400n 1.8
+    334499n 1.8
+    334500n 0
+    334799n 0
+    334800n 1.8
+    334899n 1.8
+    334900n 0
+    335199n 0
+    335200n 1.8
+    335299n 1.8
+    335300n 0
+    335599n 0
+    335600n 1.8
+    335699n 1.8
+    335700n 0
+    335999n 0
+    336000n 1.8
+    336099n 1.8
+    336100n 0
+    336399n 0
+    336400n 1.8
+    336499n 1.8
+    336500n 0
+    336799n 0
+    336800n 1.8
+    336899n 1.8
+    336900n 0
+    337199n 0
+    337200n 1.8
+    337299n 1.8
+    337300n 0
+    337599n 0
+    337600n 1.8
+    337699n 1.8
+    337700n 0
+    337999n 0
+    338000n 1.8
+    338099n 1.8
+    338100n 0
+    338399n 0
+    338400n 1.8
+    338499n 1.8
+    338500n 0
+    338799n 0
+    338800n 1.8
+    338899n 1.8
+    338900n 0
+    339199n 0
+    339200n 1.8
+    339299n 1.8
+    339300n 0
+    339599n 0
+    339600n 1.8
+    339699n 1.8
+    339700n 0
+    339999n 0
+    340000n 1.8
+    340099n 1.8
+    340100n 0
+    340399n 0
+    340400n 1.8
+    340499n 1.8
+    340500n 0
+    340799n 0
+    340800n 1.8
+    340899n 1.8
+    340900n 0
+    341199n 0
+    341200n 1.8
+    341299n 1.8
+    341300n 0
+    341599n 0
+    341600n 1.8
+    341699n 1.8
+    341700n 0
+    341999n 0
+    342000n 1.8
+    342099n 1.8
+    342100n 0
+    342399n 0
+    342400n 1.8
+    342499n 1.8
+    342500n 0
+    342799n 0
+    342800n 1.8
+    342899n 1.8
+    342900n 0
+    343199n 0
+    343200n 1.8
+    343299n 1.8
+    343300n 0
+    343599n 0
+    343600n 1.8
+    343699n 1.8
+    343700n 0
+    343999n 0
+    344000n 1.8
+    344099n 1.8
+    344100n 0
+    344399n 0
+    344400n 1.8
+    344499n 1.8
+    344500n 0
+    344799n 0
+    344800n 1.8
+    344899n 1.8
+    344900n 0
+    345199n 0
+    345200n 1.8
+    345299n 1.8
+    345300n 0
+    345599n 0
+    345600n 1.8
+    345699n 1.8
+    345700n 0
+    345999n 0
+    346000n 1.8
+    346099n 1.8
+    346100n 0
+    346399n 0
+    346400n 1.8
+    346499n 1.8
+    346500n 0
+    346799n 0
+    346800n 1.8
+    346899n 1.8
+    346900n 0
+    347199n 0
+    347200n 1.8
+    347299n 1.8
+    347300n 0
+    347599n 0
+    347600n 1.8
+    347699n 1.8
+    347700n 0
+    347999n 0
+    348000n 1.8
+    348099n 1.8
+    348100n 0
+    348399n 0
+    348400n 1.8
+    348499n 1.8
+    348500n 0
+    348799n 0
+    348800n 1.8
+    348899n 1.8
+    348900n 0
+    349199n 0
+    349200n 1.8
+    349299n 1.8
+    349300n 0
+    349599n 0
+    349600n 1.8
+    349699n 1.8
+    349700n 0
+    349999n 0
+    350000n 1.8
+    350099n 1.8
+    350100n 0
+    350399n 0
+    350400n 1.8
+    350499n 1.8
+    350500n 0
+    350799n 0
+    350800n 1.8
+    350899n 1.8
+    350900n 0
+    351199n 0
+    351200n 1.8
+    351299n 1.8
+    351300n 0
+    351599n 0
+    351600n 1.8
+    351699n 1.8
+    351700n 0
+    351999n 0
+    352000n 1.8
+    352099n 1.8
+    352100n 0
+    352399n 0
+    352400n 1.8
+    352499n 1.8
+    352500n 0
+    352799n 0
+    352800n 1.8
+    352899n 1.8
+    352900n 0
+    353199n 0
+    353200n 1.8
+    353299n 1.8
+    353300n 0
+    353599n 0
+    353600n 1.8
+    353699n 1.8
+    353700n 0
+    353999n 0
+    354000n 1.8
+    354099n 1.8
+    354100n 0
+    354399n 0
+    354400n 1.8
+    354499n 1.8
+    354500n 0
+    354799n 0
+    354800n 1.8
+    354899n 1.8
+    354900n 0
+    355199n 0
+    355200n 1.8
+    355299n 1.8
+    355300n 0
+    355599n 0
+    355600n 1.8
+    355699n 1.8
+    355700n 0
+    355999n 0
+    356000n 1.8
+    356099n 1.8
+    356100n 0
+    356399n 0
+    356400n 1.8
+    356499n 1.8
+    356500n 0
+    356799n 0
+    356800n 1.8
+    356899n 1.8
+    356900n 0
+    357199n 0
+    357200n 1.8
+    357299n 1.8
+    357300n 0
+    357599n 0
+    357600n 1.8
+    357699n 1.8
+    357700n 0
+    357999n 0
+    358000n 1.8
+    358099n 1.8
+    358100n 0
+    358399n 0
+    358400n 1.8
+    358499n 1.8
+    358500n 0
+    358799n 0
+    358800n 1.8
+    358899n 1.8
+    358900n 0
+    359199n 0
+    359200n 1.8
+    359299n 1.8
+    359300n 0
+    359599n 0
+    359600n 1.8
+    359699n 1.8
+    359700n 0
+    359999n 0
+    360000n 1.8
+    360099n 1.8
+    360100n 0
+    360399n 0
+    360400n 1.8
+    360499n 1.8
+    360500n 0
+    360799n 0
+    360800n 1.8
+    360899n 1.8
+    360900n 0
+    361199n 0
+    361200n 1.8
+    361299n 1.8
+    361300n 0
+    361599n 0
+    361600n 1.8
+    361699n 1.8
+    361700n 0
+    361999n 0
+    362000n 1.8
+    362099n 1.8
+    362100n 0
+    362399n 0
+    362400n 1.8
+    362499n 1.8
+    362500n 0
+    362799n 0
+    362800n 1.8
+    362899n 1.8
+    362900n 0
+    363199n 0
+    363200n 1.8
+    363299n 1.8
+    363300n 0
+    363599n 0
+    363600n 1.8
+    363699n 1.8
+    363700n 0
+    363999n 0
+    364000n 1.8
+    364099n 1.8
+    364100n 0
+    364399n 0
+    364400n 1.8
+    364499n 1.8
+    364500n 0
+    364799n 0
+    364800n 1.8
+    364899n 1.8
+    364900n 0
+    365199n 0
+    365200n 1.8
+    365299n 1.8
+    365300n 0
+    365599n 0
+    365600n 1.8
+    365699n 1.8
+    365700n 0
+    365999n 0
+    366000n 1.8
+    366099n 1.8
+    366100n 0
+    366399n 0
+    366400n 1.8
+    366499n 1.8
+    366500n 0
+    366799n 0
+    366800n 1.8
+    366899n 1.8
+    366900n 0
+    367199n 0
+    367200n 1.8
+    367299n 1.8
+    367300n 0
+    367599n 0
+    367600n 1.8
+    367699n 1.8
+    367700n 0
+    367999n 0
+    368000n 1.8
+    368099n 1.8
+    368100n 0
+    368399n 0
+    368400n 1.8
+    368499n 1.8
+    368500n 0
+    368799n 0
+    368800n 1.8
+    368899n 1.8
+    368900n 0
+    369199n 0
+    369200n 1.8
+    369299n 1.8
+    369300n 0
+    369599n 0
+    369600n 1.8
+    369699n 1.8
+    369700n 0
+    369999n 0
+    370000n 1.8
+    370099n 1.8
+    370100n 0
+    370399n 0
+    370400n 1.8
+    370499n 1.8
+    370500n 0
+    370799n 0
+    370800n 1.8
+    370899n 1.8
+    370900n 0
+    371199n 0
+    371200n 1.8
+    371299n 1.8
+    371300n 0
+    371599n 0
+    371600n 1.8
+    371699n 1.8
+    371700n 0
+    371999n 0
+    372000n 1.8
+    372099n 1.8
+    372100n 0
+    372399n 0
+    372400n 1.8
+    372499n 1.8
+    372500n 0
+    372799n 0
+    372800n 1.8
+    372899n 1.8
+    372900n 0
+    373199n 0
+    373200n 1.8
+    373299n 1.8
+    373300n 0
+    373599n 0
+    373600n 1.8
+    373699n 1.8
+    373700n 0
+    373999n 0
+    374000n 1.8
+    374099n 1.8
+    374100n 0
+    374399n 0
+    374400n 1.8
+    374499n 1.8
+    374500n 0
+    374799n 0
+    374800n 1.8
+    374899n 1.8
+    374900n 0
+    375199n 0
+    375200n 1.8
+    375299n 1.8
+    375300n 0
+    375599n 0
+    375600n 1.8
+    375699n 1.8
+    375700n 0
+    375999n 0
+    376000n 1.8
+    376099n 1.8
+    376100n 0
+    376399n 0
+    376400n 1.8
+    376499n 1.8
+    376500n 0
+    376799n 0
+    376800n 1.8
+    376899n 1.8
+    376900n 0
+    377199n 0
+    377200n 1.8
+    377299n 1.8
+    377300n 0
+    377599n 0
+    377600n 1.8
+    377699n 1.8
+    377700n 0
+    377999n 0
+    378000n 1.8
+    378099n 1.8
+    378100n 0
+    378399n 0
+    378400n 1.8
+    378499n 1.8
+    378500n 0
+    378799n 0
+    378800n 1.8
+    378899n 1.8
+    378900n 0
+    379199n 0
+    379200n 1.8
+    379299n 1.8
+    379300n 0
+    379599n 0
+    379600n 1.8
+    379699n 1.8
+    379700n 0
+    379999n 0
+    380000n 1.8
+    380099n 1.8
+    380100n 0
+    380399n 0
+    380400n 1.8
+    380499n 1.8
+    380500n 0
+    380799n 0
+    380800n 1.8
+    380899n 1.8
+    380900n 0
+    381199n 0
+    381200n 1.8
+    381299n 1.8
+    381300n 0
+    381599n 0
+    381600n 1.8
+    381699n 1.8
+    381700n 0
+    381999n 0
+    382000n 1.8
+    382099n 1.8
+    382100n 0
+    382399n 0
+    382400n 1.8
+    382499n 1.8
+    382500n 0
+    382799n 0
+    382800n 1.8
+    382899n 1.8
+    382900n 0
+    383199n 0
+    383200n 1.8
+    383299n 1.8
+    383300n 0
+    383599n 0
+    383600n 1.8
+    383699n 1.8
+    383700n 0
+    383999n 0
+    384000n 1.8
+    384099n 1.8
+    384100n 0
+    384399n 0
+    384400n 1.8
+    384499n 1.8
+    384500n 0
+    384799n 0
+    384800n 1.8
+    384899n 1.8
+    384900n 0
+    385199n 0
+    385200n 1.8
+    385299n 1.8
+    385300n 0
+    385599n 0
+    385600n 1.8
+    385699n 1.8
+    385700n 0
+    385999n 0
+    386000n 1.8
+    386099n 1.8
+    386100n 0
+    386399n 0
+    386400n 1.8
+    386499n 1.8
+    386500n 0
+    386799n 0
+    386800n 1.8
+    386899n 1.8
+    386900n 0
+    387199n 0
+    387200n 1.8
+    387299n 1.8
+    387300n 0
+    387599n 0
+    387600n 1.8
+    387699n 1.8
+    387700n 0
+    387999n 0
+    388000n 1.8
+    388099n 1.8
+    388100n 0
+    388399n 0
+    388400n 1.8
+    388499n 1.8
+    388500n 0
+    388799n 0
+    388800n 1.8
+    388899n 1.8
+    388900n 0
+    389199n 0
+    389200n 1.8
+    389299n 1.8
+    389300n 0
+    389599n 0
+    389600n 1.8
+    389699n 1.8
+    389700n 0
+    389999n 0
+    390000n 1.8
+    390099n 1.8
+    390100n 0
+    390399n 0
+    390400n 1.8
+    390499n 1.8
+    390500n 0
+    390799n 0
+    390800n 1.8
+    390899n 1.8
+    390900n 0
+    391199n 0
+    391200n 1.8
+    391299n 1.8
+    391300n 0
+    391599n 0
+    391600n 1.8
+    391699n 1.8
+    391700n 0
+    391999n 0
+    392000n 1.8
+    392099n 1.8
+    392100n 0
+    392399n 0
+    392400n 1.8
+    392499n 1.8
+    392500n 0
+    392799n 0
+    392800n 1.8
+    392899n 1.8
+    392900n 0
+    393199n 0
+    393200n 1.8
+    393299n 1.8
+    393300n 0
+    393599n 0
+    393600n 1.8
+    393699n 1.8
+    393700n 0
+    393999n 0
+    394000n 1.8
+    394099n 1.8
+    394100n 0
+    394399n 0
+    394400n 1.8
+    394499n 1.8
+    394500n 0
+    394799n 0
+    394800n 1.8
+    394899n 1.8
+    394900n 0
+    395199n 0
+    395200n 1.8
+    395299n 1.8
+    395300n 0
+    395599n 0
+    395600n 1.8
+    395699n 1.8
+    395700n 0
+    395999n 0
+    396000n 1.8
+    396099n 1.8
+    396100n 0
+    396399n 0
+    396400n 1.8
+    396499n 1.8
+    396500n 0
+    396799n 0
+    396800n 1.8
+    396899n 1.8
+    396900n 0
+    397199n 0
+    397200n 1.8
+    397299n 1.8
+    397300n 0
+    397599n 0
+    397600n 1.8
+    397699n 1.8
+    397700n 0
+    397999n 0
+    398000n 1.8
+    398099n 1.8
+    398100n 0
+    398399n 0
+    398400n 1.8
+    398499n 1.8
+    398500n 0
+    398799n 0
+    398800n 1.8
+    398899n 1.8
+    398900n 0
+    399199n 0
+    399200n 1.8
+    399299n 1.8
+    399300n 0
+    399599n 0
+    399600n 1.8
+    399699n 1.8
+    399700n 0
+    399999n 0
+    400000n 1.8
+    400099n 1.8
+    400100n 0
+    400399n 0
+    400400n 1.8
+    400499n 1.8
+    400500n 0
+    400799n 0
+    400800n 1.8
+    400899n 1.8
+    400900n 0
+    401199n 0
+    401200n 1.8
+    401299n 1.8
+    401300n 0
+    401599n 0
+    401600n 1.8
+    401699n 1.8
+    401700n 0
+    401999n 0
+    402000n 1.8
+    402099n 1.8
+    402100n 0
+    402399n 0
+    402400n 1.8
+    402499n 1.8
+    402500n 0
+    402799n 0
+    402800n 1.8
+    402899n 1.8
+    402900n 0
+    403199n 0
+    403200n 1.8
+    403299n 1.8
+    403300n 0
+    403599n 0
+    403600n 1.8
+    403699n 1.8
+    403700n 0
+    403999n 0
+    404000n 1.8
+    404099n 1.8
+    404100n 0
+    404399n 0
+    404400n 1.8
+    404499n 1.8
+    404500n 0
+    404799n 0
+    404800n 1.8
+    404899n 1.8
+    404900n 0
+    405199n 0
+    405200n 1.8
+    405299n 1.8
+    405300n 0
+    405599n 0
+    405600n 1.8
+    405699n 1.8
+    405700n 0
+    405999n 0
+    406000n 1.8
+    406099n 1.8
+    406100n 0
+    406399n 0
+    406400n 1.8
+    406499n 1.8
+    406500n 0
+    406799n 0
+    406800n 1.8
+    406899n 1.8
+    406900n 0
+    407199n 0
+    407200n 1.8
+    407299n 1.8
+    407300n 0
+    407599n 0
+    407600n 1.8
+    407699n 1.8
+    407700n 0
+    407999n 0
+    408000n 1.8
+    408099n 1.8
+    408100n 0
+    408399n 0
+    408400n 1.8
+    408499n 1.8
+    408500n 0
+    408799n 0
+    408800n 1.8
+    408899n 1.8
+    408900n 0
+    409199n 0
+    409200n 1.8
+    409299n 1.8
+    409300n 0
+    409599n 0
+    409600n 1.8
+    409699n 1.8
+    409700n 0
+    409999n 0
+    410000n 1.8
+    410099n 1.8
+    410100n 0
+    410399n 0
+    410400n 1.8
+    410499n 1.8
+    410500n 0
+    410799n 0
+    410800n 1.8
+    410899n 1.8
+    410900n 0
+    411199n 0
+    411200n 1.8
+    411299n 1.8
+    411300n 0
+    411599n 0
+    411600n 1.8
+    411699n 1.8
+    411700n 0
+    411999n 0
+    412000n 1.8
+    412099n 1.8
+    412100n 0
+    412399n 0
+    412400n 1.8
+    412499n 1.8
+    412500n 0
+    412799n 0
+    412800n 1.8
+    412899n 1.8
+    412900n 0
+    413199n 0
+    413200n 1.8
+    413299n 1.8
+    413300n 0
+    413599n 0
+    413600n 1.8
+    413699n 1.8
+    413700n 0
+    413999n 0
+    414000n 1.8
+    414099n 1.8
+    414100n 0
+    414399n 0
+    414400n 1.8
+    414499n 1.8
+    414500n 0
+    414799n 0
+    414800n 1.8
+    414899n 1.8
+    414900n 0
+    415199n 0
+    415200n 1.8
+    415299n 1.8
+    415300n 0
+    415599n 0
+    415600n 1.8
+    415699n 1.8
+    415700n 0
+    415999n 0
+    416000n 1.8
+    416099n 1.8
+    416100n 0
+    416399n 0
+    416400n 1.8
+    416499n 1.8
+    416500n 0
+    416799n 0
+    416800n 1.8
+    416899n 1.8
+    416900n 0
+    417199n 0
+    417200n 1.8
+    417299n 1.8
+    417300n 0
+    417599n 0
+    417600n 1.8
+    417699n 1.8
+    417700n 0
+    417999n 0
+    418000n 1.8
+    418099n 1.8
+    418100n 0
+    418399n 0
+    418400n 1.8
+    418499n 1.8
+    418500n 0
+    418799n 0
+    418800n 1.8
+    418899n 1.8
+    418900n 0
+    419199n 0
+    419200n 1.8
+    419299n 1.8
+    419300n 0
+    419599n 0
+    419600n 1.8
+    419699n 1.8
+    419700n 0
+    419999n 0
+    420000n 1.8
+    420099n 1.8
+    420100n 0
+    420399n 0
+    420400n 1.8
+    420499n 1.8
+    420500n 0
+    420799n 0
+    420800n 1.8
+    420899n 1.8
+    420900n 0
+    421199n 0
+    421200n 1.8
+    421299n 1.8
+    421300n 0
+    421599n 0
+    421600n 1.8
+    421699n 1.8
+    421700n 0
+    421999n 0
+    422000n 1.8
+    422099n 1.8
+    422100n 0
+    422399n 0
+    422400n 1.8
+    422499n 1.8
+    422500n 0
+    422799n 0
+    422800n 1.8
+    422899n 1.8
+    422900n 0
+    423199n 0
+    423200n 1.8
+    423299n 1.8
+    423300n 0
+    423599n 0
+    423600n 1.8
+    423699n 1.8
+    423700n 0
+    423999n 0
+    424000n 1.8
+    424099n 1.8
+    424100n 0
+    424399n 0
+    424400n 1.8
+    424499n 1.8
+    424500n 0
+    424799n 0
+    424800n 1.8
+    424899n 1.8
+    424900n 0
+    425199n 0
+    425200n 1.8
+    425299n 1.8
+    425300n 0
+    425599n 0
+    425600n 1.8
+    425699n 1.8
+    425700n 0
+    425999n 0
+    426000n 1.8
+    426099n 1.8
+    426100n 0
+    426399n 0
+    426400n 1.8
+    426499n 1.8
+    426500n 0
+    426799n 0
+    426800n 1.8
+    426899n 1.8
+    426900n 0
+    427199n 0
+    427200n 1.8
+    427299n 1.8
+    427300n 0
+    427599n 0
+    427600n 1.8
+    427699n 1.8
+    427700n 0
+    427999n 0
+    428000n 1.8
+    428099n 1.8
+    428100n 0
+    428399n 0
+    428400n 1.8
+    428499n 1.8
+    428500n 0
+    428799n 0
+    428800n 1.8
+    428899n 1.8
+    428900n 0
+    429199n 0
+    429200n 1.8
+    429299n 1.8
+    429300n 0
+    429599n 0
+    429600n 1.8
+    429699n 1.8
+    429700n 0
+    429999n 0
+    430000n 1.8
+    430099n 1.8
+    430100n 0
+    430399n 0
+    430400n 1.8
+    430499n 1.8
+    430500n 0
+    430799n 0
+    430800n 1.8
+    430899n 1.8
+    430900n 0
+    431199n 0
+    431200n 1.8
+    431299n 1.8
+    431300n 0
+    431599n 0
+    431600n 1.8
+    431699n 1.8
+    431700n 0
+    431999n 0
+    432000n 1.8
+    432099n 1.8
+    432100n 0
+    432399n 0
+    432400n 1.8
+    432499n 1.8
+    432500n 0
+    432799n 0
+    432800n 1.8
+    432899n 1.8
+    432900n 0
+    433199n 0
+    433200n 1.8
+    433299n 1.8
+    433300n 0
+    433599n 0
+    433600n 1.8
+    433699n 1.8
+    433700n 0
+    433999n 0
+    434000n 1.8
+    434099n 1.8
+    434100n 0
+    434399n 0
+    434400n 1.8
+    434499n 1.8
+    434500n 0
+    434799n 0
+    434800n 1.8
+    434899n 1.8
+    434900n 0
+    435199n 0
+    435200n 1.8
+    435299n 1.8
+    435300n 0
+    435599n 0
+    435600n 1.8
+    435699n 1.8
+    435700n 0
+    435999n 0
+    436000n 1.8
+    436099n 1.8
+    436100n 0
+    436399n 0
+    436400n 1.8
+    436499n 1.8
+    436500n 0
+    436799n 0
+    436800n 1.8
+    436899n 1.8
+    436900n 0
+    437199n 0
+    437200n 1.8
+    437299n 1.8
+    437300n 0
+    437599n 0
+    437600n 1.8
+    437699n 1.8
+    437700n 0
+    437999n 0
+    438000n 1.8
+    438099n 1.8
+    438100n 0
+    438399n 0
+    438400n 1.8
+    438499n 1.8
+    438500n 0
+    438799n 0
+    438800n 1.8
+    438899n 1.8
+    438900n 0
+    439199n 0
+    439200n 1.8
+    439299n 1.8
+    439300n 0
+    439599n 0
+    439600n 1.8
+    439699n 1.8
+    439700n 0
+    439999n 0
+    440000n 1.8
+    440099n 1.8
+    440100n 0
+    440399n 0
+    440400n 1.8
+    440499n 1.8
+    440500n 0
+    440799n 0
+    440800n 1.8
+    440899n 1.8
+    440900n 0
+    441199n 0
+    441200n 1.8
+    441299n 1.8
+    441300n 0
+    441599n 0
+    441600n 1.8
+    441699n 1.8
+    441700n 0
+    441999n 0
+    442000n 1.8
+    442099n 1.8
+    442100n 0
+    442399n 0
+    442400n 1.8
+    442499n 1.8
+    442500n 0
+    442799n 0
+    442800n 1.8
+    442899n 1.8
+    442900n 0
+    443199n 0
+    443200n 1.8
+    443299n 1.8
+    443300n 0
+    443599n 0
+    443600n 1.8
+    443699n 1.8
+    443700n 0
+    443999n 0
+    444000n 1.8
+    444099n 1.8
+    444100n 0
+    444399n 0
+    444400n 1.8
+    444499n 1.8
+    444500n 0
+    444799n 0
+    444800n 1.8
+    444899n 1.8
+    444900n 0
+    445199n 0
+    445200n 1.8
+    445299n 1.8
+    445300n 0
+    445599n 0
+    445600n 1.8
+    445699n 1.8
+    445700n 0
+    445999n 0
+    446000n 1.8
+    446099n 1.8
+    446100n 0
+    446399n 0
+    446400n 1.8
+    446499n 1.8
+    446500n 0
+    446799n 0
+    446800n 1.8
+    446899n 1.8
+    446900n 0
+    447199n 0
+    447200n 1.8
+    447299n 1.8
+    447300n 0
+    447599n 0
+    447600n 1.8
+    447699n 1.8
+    447700n 0
+    447999n 0
+    448000n 1.8
+    448099n 1.8
+    448100n 0
+    448399n 0
+    448400n 1.8
+    448499n 1.8
+    448500n 0
+    448799n 0
+    448800n 1.8
+    448899n 1.8
+    448900n 0
+    449199n 0
+    449200n 1.8
+    449299n 1.8
+    449300n 0
+    449599n 0
+    449600n 1.8
+    449699n 1.8
+    449700n 0
+    449999n 0
+    450000n 1.8
+    450099n 1.8
+    450100n 0
+    450399n 0
+    450400n 1.8
+    450499n 1.8
+    450500n 0
+    450799n 0
+    450800n 1.8
+    450899n 1.8
+    450900n 0
+    451199n 0
+    451200n 1.8
+    451299n 1.8
+    451300n 0
+    451599n 0
+    451600n 1.8
+    451699n 1.8
+    451700n 0
+    451999n 0
+    452000n 1.8
+    452099n 1.8
+    452100n 0
+    452399n 0
+    452400n 1.8
+    452499n 1.8
+    452500n 0
+    452799n 0
+    452800n 1.8
+    452899n 1.8
+    452900n 0
+    453199n 0
+    453200n 1.8
+    453299n 1.8
+    453300n 0
+    453599n 0
+    453600n 1.8
+    453699n 1.8
+    453700n 0
+    453999n 0
+    454000n 1.8
+    454099n 1.8
+    454100n 0
+    454399n 0
+    454400n 1.8
+    454499n 1.8
+    454500n 0
+    454799n 0
+    454800n 1.8
+    454899n 1.8
+    454900n 0
+    455199n 0
+    455200n 1.8
+    455299n 1.8
+    455300n 0
+    455599n 0
+    455600n 1.8
+    455699n 1.8
+    455700n 0
+    455999n 0
+    456000n 1.8
+    456099n 1.8
+    456100n 0
+    456399n 0
+    456400n 1.8
+    456499n 1.8
+    456500n 0
+    456799n 0
+    456800n 1.8
+    456899n 1.8
+    456900n 0
+    457199n 0
+    457200n 1.8
+    457299n 1.8
+    457300n 0
+    457599n 0
+    457600n 1.8
+    457699n 1.8
+    457700n 0
+    457999n 0
+    458000n 1.8
+    458099n 1.8
+    458100n 0
+    458399n 0
+    458400n 1.8
+    458499n 1.8
+    458500n 0
+    458799n 0
+    458800n 1.8
+    458899n 1.8
+    458900n 0
+    459199n 0
+    459200n 1.8
+    459299n 1.8
+    459300n 0
+    459599n 0
+    459600n 1.8
+    459699n 1.8
+    459700n 0
+    459999n 0
+    460000n 1.8
+    460099n 1.8
+    460100n 0
+    460399n 0
+    460400n 1.8
+    460499n 1.8
+    460500n 0
+    460799n 0
+    460800n 1.8
+    460899n 1.8
+    460900n 0
+    461199n 0
+    461200n 1.8
+    461299n 1.8
+    461300n 0
+    461599n 0
+    461600n 1.8
+    461699n 1.8
+    461700n 0
+    461999n 0
+    462000n 1.8
+    462099n 1.8
+    462100n 0
+    462399n 0
+    462400n 1.8
+    462499n 1.8
+    462500n 0
+    462799n 0
+    462800n 1.8
+    462899n 1.8
+    462900n 0
+    463199n 0
+    463200n 1.8
+    463299n 1.8
+    463300n 0
+    463599n 0
+    463600n 1.8
+    463699n 1.8
+    463700n 0
+    463999n 0
+    464000n 1.8
+    464099n 1.8
+    464100n 0
+    464399n 0
+    464400n 1.8
+    464499n 1.8
+    464500n 0
+    464799n 0
+    464800n 1.8
+    464899n 1.8
+    464900n 0
+    465199n 0
+    465200n 1.8
+    465299n 1.8
+    465300n 0
+    465599n 0
+    465600n 1.8
+    465699n 1.8
+    465700n 0
+    465999n 0
+    466000n 1.8
+    466099n 1.8
+    466100n 0
+    466399n 0
+    466400n 1.8
+    466499n 1.8
+    466500n 0
+    466799n 0
+    466800n 1.8
+    466899n 1.8
+    466900n 0
+    467199n 0
+    467200n 1.8
+    467299n 1.8
+    467300n 0
+    467599n 0
+    467600n 1.8
+    467699n 1.8
+    467700n 0
+    467999n 0
+    468000n 1.8
+    468099n 1.8
+    468100n 0
+    468399n 0
+    468400n 1.8
+    468499n 1.8
+    468500n 0
+    468799n 0
+    468800n 1.8
+    468899n 1.8
+    468900n 0
+    469199n 0
+    469200n 1.8
+    469299n 1.8
+    469300n 0
+    469599n 0
+    469600n 1.8
+    469699n 1.8
+    469700n 0
+    469999n 0
+    470000n 1.8
+    470099n 1.8
+    470100n 0
+    470399n 0
+    470400n 1.8
+    470499n 1.8
+    470500n 0
+    470799n 0
+    470800n 1.8
+    470899n 1.8
+    470900n 0
+    471199n 0
+    471200n 1.8
+    471299n 1.8
+    471300n 0
+    471599n 0
+    471600n 1.8
+    471699n 1.8
+    471700n 0
+    471999n 0
+    472000n 1.8
+    472099n 1.8
+    472100n 0
+    472399n 0
+    472400n 1.8
+    472499n 1.8
+    472500n 0
+    472799n 0
+    472800n 1.8
+    472899n 1.8
+    472900n 0
+    473199n 0
+    473200n 1.8
+    473299n 1.8
+    473300n 0
+    473599n 0
+    473600n 1.8
+    473699n 1.8
+    473700n 0
+    473999n 0
+    474000n 1.8
+    474099n 1.8
+    474100n 0
+    474399n 0
+    474400n 1.8
+    474499n 1.8
+    474500n 0
+    474799n 0
+    474800n 1.8
+    474899n 1.8
+    474900n 0
+    475199n 0
+    475200n 1.8
+    475299n 1.8
+    475300n 0
+    475599n 0
+    475600n 1.8
+    475699n 1.8
+    475700n 0
+    475999n 0
+    476000n 1.8
+    476099n 1.8
+    476100n 0
+    476399n 0
+    476400n 1.8
+    476499n 1.8
+    476500n 0
+    476799n 0
+    476800n 1.8
+    476899n 1.8
+    476900n 0
+    477199n 0
+    477200n 1.8
+    477299n 1.8
+    477300n 0
+    477599n 0
+    477600n 1.8
+    477699n 1.8
+    477700n 0
+    477999n 0
+    478000n 1.8
+    478099n 1.8
+    478100n 0
+    478399n 0
+    478400n 1.8
+    478499n 1.8
+    478500n 0
+    478799n 0
+    478800n 1.8
+    478899n 1.8
+    478900n 0
+    479199n 0
+    479200n 1.8
+    479299n 1.8
+    479300n 0
+    479599n 0
+    479600n 1.8
+    479699n 1.8
+    479700n 0
+    479999n 0
+    480000n 1.8
+    480099n 1.8
+    480100n 0
+    480399n 0
+    480400n 1.8
+    480499n 1.8
+    480500n 0
+    480799n 0
+    480800n 1.8
+    480899n 1.8
+    480900n 0
+    481199n 0
+    481200n 1.8
+    481299n 1.8
+    481300n 0
+    481599n 0
+    481600n 1.8
+    481699n 1.8
+    481700n 0
+    481999n 0
+    482000n 1.8
+    482099n 1.8
+    482100n 0
+    482399n 0
+    482400n 1.8
+    482499n 1.8
+    482500n 0
+    482799n 0
+    482800n 1.8
+    482899n 1.8
+    482900n 0
+    483199n 0
+    483200n 1.8
+    483299n 1.8
+    483300n 0
+    483599n 0
+    483600n 1.8
+    483699n 1.8
+    483700n 0
+    483999n 0
+    484000n 1.8
+    484099n 1.8
+    484100n 0
+    484399n 0
+    484400n 1.8
+    484499n 1.8
+    484500n 0
+    484799n 0
+    484800n 1.8
+    484899n 1.8
+    484900n 0
+    485199n 0
+    485200n 1.8
+    485299n 1.8
+    485300n 0
+    485599n 0
+    485600n 1.8
+    485699n 1.8
+    485700n 0
+    485999n 0
+    486000n 1.8
+    486099n 1.8
+    486100n 0
+    486399n 0
+    486400n 1.8
+    486499n 1.8
+    486500n 0
+    486799n 0
+    486800n 1.8
+    486899n 1.8
+    486900n 0
+    487199n 0
+    487200n 1.8
+    487299n 1.8
+    487300n 0
+    487599n 0
+    487600n 1.8
+    487699n 1.8
+    487700n 0
+    487999n 0
+    488000n 1.8
+    488099n 1.8
+    488100n 0
+    488399n 0
+    488400n 1.8
+    488499n 1.8
+    488500n 0
+    488799n 0
+    488800n 1.8
+    488899n 1.8
+    488900n 0
+    489199n 0
+    489200n 1.8
+    489299n 1.8
+    489300n 0
+    489599n 0
+    489600n 1.8
+    489699n 1.8
+    489700n 0
+    489999n 0
+    490000n 1.8
+    490099n 1.8
+    490100n 0
+    490399n 0
+    490400n 1.8
+    490499n 1.8
+    490500n 0
+    490799n 0
+    490800n 1.8
+    490899n 1.8
+    490900n 0
+    491199n 0
+    491200n 1.8
+    491299n 1.8
+    491300n 0
+    491599n 0
+    491600n 1.8
+    491699n 1.8
+    491700n 0
+    491999n 0
+    492000n 1.8
+    492099n 1.8
+    492100n 0
+    492399n 0
+    492400n 1.8
+    492499n 1.8
+    492500n 0
+    492799n 0
+    492800n 1.8
+    492899n 1.8
+    492900n 0
+    493199n 0
+    493200n 1.8
+    493299n 1.8
+    493300n 0
+    493599n 0
+    493600n 1.8
+    493699n 1.8
+    493700n 0
+    493999n 0
+    494000n 1.8
+    494099n 1.8
+    494100n 0
+    494399n 0
+    494400n 1.8
+    494499n 1.8
+    494500n 0
+    494799n 0
+    494800n 1.8
+    494899n 1.8
+    494900n 0
+    495199n 0
+    495200n 1.8
+    495299n 1.8
+    495300n 0
+    495599n 0
+    495600n 1.8
+    495699n 1.8
+    495700n 0
+    495999n 0
+    496000n 1.8
+    496099n 1.8
+    496100n 0
+    496399n 0
+    496400n 1.8
+    496499n 1.8
+    496500n 0
+    496799n 0
+    496800n 1.8
+    496899n 1.8
+    496900n 0
+    497199n 0
+    497200n 1.8
+    497299n 1.8
+    497300n 0
+    497599n 0
+    497600n 1.8
+    497699n 1.8
+    497700n 0
+    497999n 0
+    498000n 1.8
+    498099n 1.8
+    498100n 0
+    498399n 0
+    498400n 1.8
+    498499n 1.8
+    498500n 0
+    498799n 0
+    498800n 1.8
+    498899n 1.8
+    498900n 0
+    499199n 0
+    499200n 1.8
+    499299n 1.8
+    499300n 0
+    499599n 0
+    499600n 1.8
+    499699n 1.8
+    499700n 0
+    499999n 0
+    500000n 1.8
+    500099n 1.8
+    500100n 0
+    500399n 0
+    500400n 1.8
+    500499n 1.8
+    500500n 0
+    500799n 0
+    500800n 1.8
+    500899n 1.8
+    500900n 0
+    501199n 0
+    501200n 1.8
+    501299n 1.8
+    501300n 0
+    501599n 0
+    501600n 1.8
+    501699n 1.8
+    501700n 0
+    501999n 0
+    502000n 1.8
+    502099n 1.8
+    502100n 0
+    502399n 0
+    502400n 1.8
+    502499n 1.8
+    502500n 0
+    502799n 0
+    502800n 1.8
+    502899n 1.8
+    502900n 0
+    503199n 0
+    503200n 1.8
+    503299n 1.8
+    503300n 0
+    503599n 0
+    503600n 1.8
+    503699n 1.8
+    503700n 0
+    503999n 0
+    504000n 1.8
+    504099n 1.8
+    504100n 0
+    504399n 0
+    504400n 1.8
+    504499n 1.8
+    504500n 0
+    504799n 0
+    504800n 1.8
+    504899n 1.8
+    504900n 0
+    505199n 0
+    505200n 1.8
+    505299n 1.8
+    505300n 0
+    505599n 0
+    505600n 1.8
+    505699n 1.8
+    505700n 0
+    505999n 0
+    506000n 1.8
+    506099n 1.8
+    506100n 0
+    506399n 0
+    506400n 1.8
+    506499n 1.8
+    506500n 0
+    506799n 0
+    506800n 1.8
+    506899n 1.8
+    506900n 0
+    507199n 0
+    507200n 1.8
+    507299n 1.8
+    507300n 0
+    507599n 0
+    507600n 1.8
+    507699n 1.8
+    507700n 0
+    507999n 0
+    508000n 1.8
+    508099n 1.8
+    508100n 0
+    508399n 0
+    508400n 1.8
+    508499n 1.8
+    508500n 0
+    508799n 0
+    508800n 1.8
+    508899n 1.8
+    508900n 0
+    509199n 0
+    509200n 1.8
+    509299n 1.8
+    509300n 0
+    509599n 0
+    509600n 1.8
+    509699n 1.8
+    509700n 0
+    509999n 0
+    510000n 1.8
+    510099n 1.8
+    510100n 0
+    510399n 0
+    510400n 1.8
+    510499n 1.8
+    510500n 0
+    510799n 0
+    510800n 1.8
+    510899n 1.8
+    510900n 0
+    511199n 0
+    511200n 1.8
+    511299n 1.8
+    511300n 0
+    511599n 0
+    511600n 1.8
+    511699n 1.8
+    511700n 0
+    511999n 0
+    512000n 1.8
+    512099n 1.8
+    512100n 0
+    512399n 0
+    512400n 1.8
+    512499n 1.8
+    512500n 0
+    512799n 0
+    512800n 1.8
+    512899n 1.8
+    512900n 0
+    513199n 0
+    513200n 1.8
+    513299n 1.8
+    513300n 0
+    513599n 0
+    513600n 1.8
+    513699n 1.8
+    513700n 0
+    513999n 0
+    514000n 1.8
+    514099n 1.8
+    514100n 0
+    514399n 0
+    514400n 1.8
+    514499n 1.8
+    514500n 0
+    514799n 0
+    514800n 1.8
+    514899n 1.8
+    514900n 0
+    515199n 0
+    515200n 1.8
+    515299n 1.8
+    515300n 0
+    515599n 0
+    515600n 1.8
+    515699n 1.8
+    515700n 0
+    515999n 0
+    516000n 1.8
+    516099n 1.8
+    516100n 0
+    516399n 0
+    516400n 1.8
+    516499n 1.8
+    516500n 0
+    516799n 0
+    516800n 1.8
+    516899n 1.8
+    516900n 0
+    517199n 0
+    517200n 1.8
+    517299n 1.8
+    517300n 0
+    517599n 0
+    517600n 1.8
+    517699n 1.8
+    517700n 0
+    517999n 0
+    518000n 1.8
+    518099n 1.8
+    518100n 0
+    518399n 0
+    518400n 1.8
+    518499n 1.8
+    518500n 0
+    518799n 0
+    518800n 1.8
+    518899n 1.8
+    518900n 0
+    519199n 0
+    519200n 1.8
+    519299n 1.8
+    519300n 0
+    519599n 0
+    519600n 1.8
+    519699n 1.8
+    519700n 0
+    519999n 0
+    520000n 1.8
+    520099n 1.8
+    520100n 0
+    520399n 0
+    520400n 1.8
+    520499n 1.8
+    520500n 0
+    520799n 0
+    520800n 1.8
+    520899n 1.8
+    520900n 0
+    521199n 0
+    521200n 1.8
+    521299n 1.8
+    521300n 0
+    521599n 0
+    521600n 1.8
+    521699n 1.8
+    521700n 0
+    521999n 0
+    522000n 1.8
+    522099n 1.8
+    522100n 0
+    522399n 0
+    522400n 1.8
+    522499n 1.8
+    522500n 0
+    522799n 0
+    522800n 1.8
+    522899n 1.8
+    522900n 0
+    523199n 0
+    523200n 1.8
+    523299n 1.8
+    523300n 0
+    523599n 0
+    523600n 1.8
+    523699n 1.8
+    523700n 0
+    523999n 0
+    524000n 1.8
+    524099n 1.8
+    524100n 0
+    524399n 0
+    524400n 1.8
+    524499n 1.8
+    524500n 0
+    524799n 0
+    524800n 1.8
+    524899n 1.8
+    524900n 0
+    525199n 0
+    525200n 1.8
+    525299n 1.8
+    525300n 0
+    525599n 0
+    525600n 1.8
+    525699n 1.8
+    525700n 0
+    525999n 0
+    526000n 1.8
+    526099n 1.8
+    526100n 0
+    526399n 0
+    526400n 1.8
+    526499n 1.8
+    526500n 0
+    526799n 0
+    526800n 1.8
+    526899n 1.8
+    526900n 0
+    527199n 0
+    527200n 1.8
+    527299n 1.8
+    527300n 0
+    527599n 0
+    527600n 1.8
+    527699n 1.8
+    527700n 0
+    527999n 0
+    528000n 1.8
+    528099n 1.8
+    528100n 0
+    528399n 0
+    528400n 1.8
+    528499n 1.8
+    528500n 0
+    528799n 0
+    528800n 1.8
+    528899n 1.8
+    528900n 0
+    529199n 0
+    529200n 1.8
+    529299n 1.8
+    529300n 0
+    529599n 0
+    529600n 1.8
+    529699n 1.8
+    529700n 0
+    529999n 0
+    530000n 1.8
+    530099n 1.8
+    530100n 0
+    530399n 0
+    530400n 1.8
+    530499n 1.8
+    530500n 0
+    530799n 0
+    530800n 1.8
+    530899n 1.8
+    530900n 0
+    531199n 0
+    531200n 1.8
+    531299n 1.8
+    531300n 0
+    531599n 0
+    531600n 1.8
+    531699n 1.8
+    531700n 0
+    531999n 0
+    532000n 1.8
+    532099n 1.8
+    532100n 0
+    532399n 0
+    532400n 1.8
+    532499n 1.8
+    532500n 0
+    532799n 0
+    532800n 1.8
+    532899n 1.8
+    532900n 0
+    533199n 0
+    533200n 1.8
+    533299n 1.8
+    533300n 0
+    533599n 0
+    533600n 1.8
+    533699n 1.8
+    533700n 0
+    533999n 0
+    534000n 1.8
+    534099n 1.8
+    534100n 0
+    534399n 0
+    534400n 1.8
+    534499n 1.8
+    534500n 0
+    534799n 0
+    534800n 1.8
+    534899n 1.8
+    534900n 0
+    535199n 0
+    535200n 1.8
+    535299n 1.8
+    535300n 0
+    535599n 0
+    535600n 1.8
+    535699n 1.8
+    535700n 0
+    535999n 0
+    536000n 1.8
+    536099n 1.8
+    536100n 0
+    536399n 0
+    536400n 1.8
+    536499n 1.8
+    536500n 0
+    536799n 0
+    536800n 1.8
+    536899n 1.8
+    536900n 0
+    537199n 0
+    537200n 1.8
+    537299n 1.8
+    537300n 0
+    537599n 0
+    537600n 1.8
+    537699n 1.8
+    537700n 0
+    537999n 0
+    538000n 1.8
+    538099n 1.8
+    538100n 0
+    538399n 0
+    538400n 1.8
+    538499n 1.8
+    538500n 0
+    538799n 0
+    538800n 1.8
+    538899n 1.8
+    538900n 0
+    539199n 0
+    539200n 1.8
+    539299n 1.8
+    539300n 0
+    539599n 0
+    539600n 1.8
+    539699n 1.8
+    539700n 0
+    539999n 0
+    540000n 1.8
+    540099n 1.8
+    540100n 0
+    540399n 0
+    540400n 1.8
+    540499n 1.8
+    540500n 0
+    540799n 0
+    540800n 1.8
+    540899n 1.8
+    540900n 0
+    541199n 0
+    541200n 1.8
+    541299n 1.8
+    541300n 0
+    541599n 0
+    541600n 1.8
+    541699n 1.8
+    541700n 0
+    541999n 0
+    542000n 1.8
+    542099n 1.8
+    542100n 0
+    542399n 0
+    542400n 1.8
+    542499n 1.8
+    542500n 0
+    542799n 0
+    542800n 1.8
+    542899n 1.8
+    542900n 0
+    543199n 0
+    543200n 1.8
+    543299n 1.8
+    543300n 0
+    543599n 0
+    543600n 1.8
+    543699n 1.8
+    543700n 0
+    543999n 0
+    544000n 1.8
+    544099n 1.8
+    544100n 0
+    544399n 0
+    544400n 1.8
+    544499n 1.8
+    544500n 0
+    544799n 0
+    544800n 1.8
+    544899n 1.8
+    544900n 0
+    545199n 0
+    545200n 1.8
+    545299n 1.8
+    545300n 0
+    545599n 0
+    545600n 1.8
+    545699n 1.8
+    545700n 0
+    545999n 0
+    546000n 1.8
+    546099n 1.8
+    546100n 0
+    546399n 0
+    546400n 1.8
+    546499n 1.8
+    546500n 0
+    546799n 0
+    546800n 1.8
+    546899n 1.8
+    546900n 0
+    547199n 0
+    547200n 1.8
+    547299n 1.8
+    547300n 0
+    547599n 0
+    547600n 1.8
+    547699n 1.8
+    547700n 0
+    547999n 0
+    548000n 1.8
+    548099n 1.8
+    548100n 0
+    548399n 0
+    548400n 1.8
+    548499n 1.8
+    548500n 0
+    548799n 0
+    548800n 1.8
+    548899n 1.8
+    548900n 0
+    549199n 0
+    549200n 1.8
+    549299n 1.8
+    549300n 0
+    549599n 0
+    549600n 1.8
+    549699n 1.8
+    549700n 0
+    549999n 0
+    550000n 1.8
+    550099n 1.8
+    550100n 0
+    550399n 0
+    550400n 1.8
+    550499n 1.8
+    550500n 0
+    550799n 0
+    550800n 1.8
+    550899n 1.8
+    550900n 0
+    551199n 0
+    551200n 1.8
+    551299n 1.8
+    551300n 0
+    551599n 0
+    551600n 1.8
+    551699n 1.8
+    551700n 0
+    551999n 0
+    552000n 1.8
+    552099n 1.8
+    552100n 0
+    552399n 0
+    552400n 1.8
+    552499n 1.8
+    552500n 0
+    552799n 0
+    552800n 1.8
+    552899n 1.8
+    552900n 0
+    553199n 0
+    553200n 1.8
+    553299n 1.8
+    553300n 0
+    553599n 0
+    553600n 1.8
+    553699n 1.8
+    553700n 0
+    553999n 0
+    554000n 1.8
+    554099n 1.8
+    554100n 0
+    554399n 0
+    554400n 1.8
+    554499n 1.8
+    554500n 0
+    554799n 0
+    554800n 1.8
+    554899n 1.8
+    554900n 0
+    555199n 0
+    555200n 1.8
+    555299n 1.8
+    555300n 0
+    555599n 0
+    555600n 1.8
+    555699n 1.8
+    555700n 0
+    555999n 0
+    556000n 1.8
+    556099n 1.8
+    556100n 0
+    556399n 0
+    556400n 1.8
+    556499n 1.8
+    556500n 0
+    556799n 0
+    556800n 1.8
+    556899n 1.8
+    556900n 0
+    557199n 0
+    557200n 1.8
+    557299n 1.8
+    557300n 0
+    557599n 0
+    557600n 1.8
+    557699n 1.8
+    557700n 0
+    557999n 0
+    558000n 1.8
+    558099n 1.8
+    558100n 0
+    558399n 0
+    558400n 1.8
+    558499n 1.8
+    558500n 0
+    558799n 0
+    558800n 1.8
+    558899n 1.8
+    558900n 0
+    559199n 0
+    559200n 1.8
+    559299n 1.8
+    559300n 0
+    559599n 0
+    559600n 1.8
+    559699n 1.8
+    559700n 0
+    559999n 0
+    560000n 1.8
+    560099n 1.8
+    560100n 0
+    560399n 0
+    560400n 1.8
+    560499n 1.8
+    560500n 0
+    560799n 0
+    560800n 1.8
+    560899n 1.8
+    560900n 0
+    561199n 0
+    561200n 1.8
+    561299n 1.8
+    561300n 0
+    561599n 0
+    561600n 1.8
+    561699n 1.8
+    561700n 0
+    561999n 0
+    562000n 1.8
+    562099n 1.8
+    562100n 0
+    562399n 0
+    562400n 1.8
+    562499n 1.8
+    562500n 0
+    562799n 0
+    562800n 1.8
+    562899n 1.8
+    562900n 0
+    563199n 0
+    563200n 1.8
+    563299n 1.8
+    563300n 0
+    563599n 0
+    563600n 1.8
+    563699n 1.8
+    563700n 0
+    563999n 0
+    564000n 1.8
+    564099n 1.8
+    564100n 0
+    564399n 0
+    564400n 1.8
+    564499n 1.8
+    564500n 0
+    564799n 0
+    564800n 1.8
+    564899n 1.8
+    564900n 0
+    565199n 0
+    565200n 1.8
+    565299n 1.8
+    565300n 0
+    565599n 0
+    565600n 1.8
+    565699n 1.8
+    565700n 0
+    565999n 0
+    566000n 1.8
+    566099n 1.8
+    566100n 0
+    566399n 0
+    566400n 1.8
+    566499n 1.8
+    566500n 0
+    566799n 0
+    566800n 1.8
+    566899n 1.8
+    566900n 0
+    567199n 0
+    567200n 1.8
+    567299n 1.8
+    567300n 0
+    567599n 0
+    567600n 1.8
+    567699n 1.8
+    567700n 0
+    567999n 0
+    568000n 1.8
+    568099n 1.8
+    568100n 0
+    568399n 0
+    568400n 1.8
+    568499n 1.8
+    568500n 0
+    568799n 0
+    568800n 1.8
+    568899n 1.8
+    568900n 0
+    569199n 0
+    569200n 1.8
+    569299n 1.8
+    569300n 0
+    569599n 0
+    569600n 1.8
+    569699n 1.8
+    569700n 0
+    569999n 0
+    570000n 1.8
+    570099n 1.8
+    570100n 0
+    570399n 0
+    570400n 1.8
+    570499n 1.8
+    570500n 0
+    570799n 0
+    570800n 1.8
+    570899n 1.8
+    570900n 0
+    571199n 0
+    571200n 1.8
+    571299n 1.8
+    571300n 0
+    571599n 0
+    571600n 1.8
+    571699n 1.8
+    571700n 0
+    571999n 0
+    572000n 1.8
+    572099n 1.8
+    572100n 0
+    572399n 0
+    572400n 1.8
+    572499n 1.8
+    572500n 0
+    572799n 0
+    572800n 1.8
+    572899n 1.8
+    572900n 0
+    573199n 0
+    573200n 1.8
+    573299n 1.8
+    573300n 0
+    573599n 0
+    573600n 1.8
+    573699n 1.8
+    573700n 0
+    573999n 0
+    574000n 1.8
+    574099n 1.8
+    574100n 0
+    574399n 0
+    574400n 1.8
+    574499n 1.8
+    574500n 0
+    574799n 0
+    574800n 1.8
+    574899n 1.8
+    574900n 0
+    575199n 0
+    575200n 1.8
+    575299n 1.8
+    575300n 0
+    575599n 0
+    575600n 1.8
+    575699n 1.8
+    575700n 0
+    575999n 0
+    576000n 1.8
+    576099n 1.8
+    576100n 0
+    576399n 0
+    576400n 1.8
+    576499n 1.8
+    576500n 0
+    576799n 0
+    576800n 1.8
+    576899n 1.8
+    576900n 0
+    577199n 0
+    577200n 1.8
+    577299n 1.8
+    577300n 0
+    577599n 0
+    577600n 1.8
+    577699n 1.8
+    577700n 0
+    577999n 0
+    578000n 1.8
+    578099n 1.8
+    578100n 0
+    578399n 0
+    578400n 1.8
+    578499n 1.8
+    578500n 0
+    578799n 0
+    578800n 1.8
+    578899n 1.8
+    578900n 0
+    579199n 0
+    579200n 1.8
+    579299n 1.8
+    579300n 0
+    579599n 0
+    579600n 1.8
+    579699n 1.8
+    579700n 0
+    579999n 0
+    580000n 1.8
+    580099n 1.8
+    580100n 0
+    580399n 0
+    580400n 1.8
+    580499n 1.8
+    580500n 0
+    580799n 0
+    580800n 1.8
+    580899n 1.8
+    580900n 0
+    581199n 0
+    581200n 1.8
+    581299n 1.8
+    581300n 0
+    581599n 0
+    581600n 1.8
+    581699n 1.8
+    581700n 0
+    581999n 0
+    582000n 1.8
+    582099n 1.8
+    582100n 0
+    582399n 0
+    582400n 1.8
+    582499n 1.8
+    582500n 0
+    582799n 0
+    582800n 1.8
+    582899n 1.8
+    582900n 0
+    583199n 0
+    583200n 1.8
+    583299n 1.8
+    583300n 0
+    583599n 0
+    583600n 1.8
+    583699n 1.8
+    583700n 0
+    583999n 0
+    584000n 1.8
+    584099n 1.8
+    584100n 0
+    584399n 0
+    584400n 1.8
+    584499n 1.8
+    584500n 0
+    584799n 0
+    584800n 1.8
+    584899n 1.8
+    584900n 0
+    585199n 0
+    585200n 1.8
+    585299n 1.8
+    585300n 0
+    585599n 0
+    585600n 1.8
+    585699n 1.8
+    585700n 0
+    585999n 0
+    586000n 1.8
+    586099n 1.8
+    586100n 0
+    586399n 0
+    586400n 1.8
+    586499n 1.8
+    586500n 0
+    586799n 0
+    586800n 1.8
+    586899n 1.8
+    586900n 0
+    587199n 0
+    587200n 1.8
+    587299n 1.8
+    587300n 0
+    587599n 0
+    587600n 1.8
+    587699n 1.8
+    587700n 0
+    587999n 0
+    588000n 1.8
+    588099n 1.8
+    588100n 0
+    588399n 0
+    588400n 1.8
+    588499n 1.8
+    588500n 0
+    588799n 0
+    588800n 1.8
+    588899n 1.8
+    588900n 0
+    589199n 0
+    589200n 1.8
+    589299n 1.8
+    589300n 0
+    589599n 0
+    589600n 1.8
+    589699n 1.8
+    589700n 0
+    589999n 0
+    590000n 1.8
+    590099n 1.8
+    590100n 0
+    590399n 0
+    590400n 1.8
+    590499n 1.8
+    590500n 0
+    590799n 0
+    590800n 1.8
+    590899n 1.8
+    590900n 0
+    591199n 0
+    591200n 1.8
+    591299n 1.8
+    591300n 0
+    591599n 0
+    591600n 1.8
+    591699n 1.8
+    591700n 0
+    591999n 0
+    592000n 1.8
+    592099n 1.8
+    592100n 0
+    592399n 0
+    592400n 1.8
+    592499n 1.8
+    592500n 0
+    592799n 0
+    592800n 1.8
+    592899n 1.8
+    592900n 0
+    593199n 0
+    593200n 1.8
+    593299n 1.8
+    593300n 0
+    593599n 0
+    593600n 1.8
+    593699n 1.8
+    593700n 0
+    593999n 0
+    594000n 1.8
+    594099n 1.8
+    594100n 0
+    594399n 0
+    594400n 1.8
+    594499n 1.8
+    594500n 0
+    594799n 0
+    594800n 1.8
+    594899n 1.8
+    594900n 0
+    595199n 0
+    595200n 1.8
+    595299n 1.8
+    595300n 0
+    595599n 0
+    595600n 1.8
+    595699n 1.8
+    595700n 0
+    595999n 0
+    596000n 1.8
+    596099n 1.8
+    596100n 0
+    596399n 0
+    596400n 1.8
+    596499n 1.8
+    596500n 0
+    596799n 0
+    596800n 1.8
+    596899n 1.8
+    596900n 0
+    597199n 0
+    597200n 1.8
+    597299n 1.8
+    597300n 0
+    597599n 0
+    597600n 1.8
+    597699n 1.8
+    597700n 0
+    597999n 0
+    598000n 1.8
+    598099n 1.8
+    598100n 0
+    598399n 0
+    598400n 1.8
+    598499n 1.8
+    598500n 0
+    598799n 0
+    598800n 1.8
+    598899n 1.8
+    598900n 0
+    599199n 0
+    599200n 1.8
+    599299n 1.8
+    599300n 0
+    599599n 0
+    599600n 1.8
+    599699n 1.8
+    599700n 0
+    599999n 0
+    600000n 1.8
+    600099n 1.8
+    600100n 0
+    600399n 0
+    600400n 1.8
+    600499n 1.8
+    600500n 0
+    600799n 0
+    600800n 1.8
+    600899n 1.8
+    600900n 0
+    601199n 0
+    601200n 1.8
+    601299n 1.8
+    601300n 0
+    601599n 0
+    601600n 1.8
+    601699n 1.8
+    601700n 0
+    601999n 0
+    602000n 1.8
+    602099n 1.8
+    602100n 0
+    602399n 0
+    602400n 1.8
+    602499n 1.8
+    602500n 0
+    602799n 0
+    602800n 1.8
+    602899n 1.8
+    602900n 0
+    603199n 0
+    603200n 1.8
+    603299n 1.8
+    603300n 0
+    603599n 0
+    603600n 1.8
+    603699n 1.8
+    603700n 0
+    603999n 0
+    604000n 1.8
+    604099n 1.8
+    604100n 0
+    604399n 0
+    604400n 1.8
+    604499n 1.8
+    604500n 0
+    604799n 0
+    604800n 1.8
+    604899n 1.8
+    604900n 0
+    605199n 0
+    605200n 1.8
+    605299n 1.8
+    605300n 0
+    605599n 0
+    605600n 1.8
+    605699n 1.8
+    605700n 0
+    605999n 0
+    606000n 1.8
+    606099n 1.8
+    606100n 0
+    606399n 0
+    606400n 1.8
+    606499n 1.8
+    606500n 0
+    606799n 0
+    606800n 1.8
+    606899n 1.8
+    606900n 0
+    607199n 0
+    607200n 1.8
+    607299n 1.8
+    607300n 0
+    607599n 0
+    607600n 1.8
+    607699n 1.8
+    607700n 0
+    607999n 0
+    608000n 1.8
+    608099n 1.8
+    608100n 0
+    608399n 0
+    608400n 1.8
+    608499n 1.8
+    608500n 0
+    608799n 0
+    608800n 1.8
+    608899n 1.8
+    608900n 0
+    609199n 0
+    609200n 1.8
+    609299n 1.8
+    609300n 0
+    609599n 0
+    609600n 1.8
+    609699n 1.8
+    609700n 0
+    609999n 0
+    610000n 1.8
+    610099n 1.8
+    610100n 0
+    610399n 0
+    610400n 1.8
+    610499n 1.8
+    610500n 0
+    610799n 0
+    610800n 1.8
+    610899n 1.8
+    610900n 0
+    611199n 0
+    611200n 1.8
+    611299n 1.8
+    611300n 0
+    611599n 0
+    611600n 1.8
+    611699n 1.8
+    611700n 0
+    611999n 0
+    612000n 1.8
+    612099n 1.8
+    612100n 0
+    612399n 0
+    612400n 1.8
+    612499n 1.8
+    612500n 0
+    612799n 0
+    612800n 1.8
+    612899n 1.8
+    612900n 0
+    613199n 0
+    613200n 1.8
+    613299n 1.8
+    613300n 0
+    613599n 0
+    613600n 1.8
+    613699n 1.8
+    613700n 0
+    613999n 0
+    614000n 1.8
+    614099n 1.8
+    614100n 0
+    614399n 0
+    614400n 1.8
+    614499n 1.8
+    614500n 0
+    614799n 0
+    614800n 1.8
+    614899n 1.8
+    614900n 0
+    615199n 0
+    615200n 1.8
+    615299n 1.8
+    615300n 0
+    615599n 0
+    615600n 1.8
+    615699n 1.8
+    615700n 0
+    615999n 0
+    616000n 1.8
+    616099n 1.8
+    616100n 0
+    616399n 0
+    616400n 1.8
+    616499n 1.8
+    616500n 0
+    616799n 0
+    616800n 1.8
+    616899n 1.8
+    616900n 0
+    617199n 0
+    617200n 1.8
+    617299n 1.8
+    617300n 0
+    617599n 0
+    617600n 1.8
+    617699n 1.8
+    617700n 0
+    617999n 0
+    618000n 1.8
+    618099n 1.8
+    618100n 0
+    618399n 0
+    618400n 1.8
+    618499n 1.8
+    618500n 0
+    618799n 0
+    618800n 1.8
+    618899n 1.8
+    618900n 0
+    619199n 0
+    619200n 1.8
+    619299n 1.8
+    619300n 0
+    619599n 0
+    619600n 1.8
+    619699n 1.8
+    619700n 0
+    619999n 0
+    620000n 1.8
+    620099n 1.8
+    620100n 0
+    620399n 0
+    620400n 1.8
+    620499n 1.8
+    620500n 0
+    620799n 0
+    620800n 1.8
+    620899n 1.8
+    620900n 0
+    621199n 0
+    621200n 1.8
+    621299n 1.8
+    621300n 0
+    621599n 0
+    621600n 1.8
+    621699n 1.8
+    621700n 0
+    621999n 0
+    622000n 1.8
+    622099n 1.8
+    622100n 0
+    622399n 0
+    622400n 1.8
+    622499n 1.8
+    622500n 0
+    622799n 0
+    622800n 1.8
+    622899n 1.8
+    622900n 0
+    623199n 0
+    623200n 1.8
+    623299n 1.8
+    623300n 0
+    623599n 0
+    623600n 1.8
+    623699n 1.8
+    623700n 0
+    623999n 0
+    624000n 1.8
+    624099n 1.8
+    624100n 0
+    624399n 0
+    624400n 1.8
+    624499n 1.8
+    624500n 0
+    624799n 0
+    624800n 1.8
+    624899n 1.8
+    624900n 0
+    625199n 0
+    625200n 1.8
+    625299n 1.8
+    625300n 0
+    625599n 0
+    625600n 1.8
+    625699n 1.8
+    625700n 0
+    625999n 0
+    626000n 1.8
+    626099n 1.8
+    626100n 0
+    626399n 0
+    626400n 1.8
+    626499n 1.8
+    626500n 0
+    626799n 0
+    626800n 1.8
+    626899n 1.8
+    626900n 0
+    627199n 0
+    627200n 1.8
+    627299n 1.8
+    627300n 0
+    627599n 0
+    627600n 1.8
+    627699n 1.8
+    627700n 0
+    627999n 0
+    628000n 1.8
+    628099n 1.8
+    628100n 0
+    628399n 0
+    628400n 1.8
+    628499n 1.8
+    628500n 0
+    628799n 0
+    628800n 1.8
+    628899n 1.8
+    628900n 0
+    629199n 0
+    629200n 1.8
+    629299n 1.8
+    629300n 0
+    629599n 0
+    629600n 1.8
+    629699n 1.8
+    629700n 0
+    629999n 0
+    630000n 1.8
+    630099n 1.8
+    630100n 0
+    630399n 0
+    630400n 1.8
+    630499n 1.8
+    630500n 0
+    630799n 0
+    630800n 1.8
+    630899n 1.8
+    630900n 0
+    631199n 0
+    631200n 1.8
+    631299n 1.8
+    631300n 0
+    631599n 0
+    631600n 1.8
+    631699n 1.8
+    631700n 0
+    631999n 0
+    632000n 1.8
+    632099n 1.8
+    632100n 0
+    632399n 0
+    632400n 1.8
+    632499n 1.8
+    632500n 0
+    632799n 0
+    632800n 1.8
+    632899n 1.8
+    632900n 0
+    633199n 0
+    633200n 1.8
+    633299n 1.8
+    633300n 0
+    633599n 0
+    633600n 1.8
+    633699n 1.8
+    633700n 0
+    633999n 0
+    634000n 1.8
+    634099n 1.8
+    634100n 0
+    634399n 0
+    634400n 1.8
+    634499n 1.8
+    634500n 0
+    634799n 0
+    634800n 1.8
+    634899n 1.8
+    634900n 0
+    635199n 0
+    635200n 1.8
+    635299n 1.8
+    635300n 0
+    635599n 0
+    635600n 1.8
+    635699n 1.8
+    635700n 0
+    635999n 0
+    636000n 1.8
+    636099n 1.8
+    636100n 0
+    636399n 0
+    636400n 1.8
+    636499n 1.8
+    636500n 0
+    636799n 0
+    636800n 1.8
+    636899n 1.8
+    636900n 0
+    637199n 0
+    637200n 1.8
+    637299n 1.8
+    637300n 0
+    637599n 0
+    637600n 1.8
+    637699n 1.8
+    637700n 0
+    637999n 0
+    638000n 1.8
+    638099n 1.8
+    638100n 0
+    638399n 0
+    638400n 1.8
+    638499n 1.8
+    638500n 0
+    638799n 0
+    638800n 1.8
+    638899n 1.8
+    638900n 0
+    639199n 0
+    639200n 1.8
+    639299n 1.8
+    639300n 0
+    639599n 0
+    639600n 1.8
+    639699n 1.8
+    639700n 0
+    639999n 0
+    640000n 1.8
+    640099n 1.8
+    640100n 0
+    640399n 0
+    640400n 1.8
+    640499n 1.8
+    640500n 0
+    640799n 0
+    640800n 1.8
+    640899n 1.8
+    640900n 0
+    641199n 0
+    641200n 1.8
+    641299n 1.8
+    641300n 0
+    641599n 0
+    641600n 1.8
+    641699n 1.8
+    641700n 0
+    641999n 0
+    642000n 1.8
+    642099n 1.8
+    642100n 0
+    642399n 0
+    642400n 1.8
+    642499n 1.8
+    642500n 0
+    642799n 0
+    642800n 1.8
+    642899n 1.8
+    642900n 0
+    643199n 0
+    643200n 1.8
+    643299n 1.8
+    643300n 0
+    643599n 0
+    643600n 1.8
+    643699n 1.8
+    643700n 0
+    643999n 0
+    644000n 1.8
+    644099n 1.8
+    644100n 0
+    644399n 0
+    644400n 1.8
+    644499n 1.8
+    644500n 0
+    644799n 0
+    644800n 1.8
+    644899n 1.8
+    644900n 0
+    645199n 0
+    645200n 1.8
+    645299n 1.8
+    645300n 0
+    645599n 0
+    645600n 1.8
+    645699n 1.8
+    645700n 0
+    645999n 0
+    646000n 1.8
+    646099n 1.8
+    646100n 0
+    646399n 0
+    646400n 1.8
+    646499n 1.8
+    646500n 0
+    646799n 0
+    646800n 1.8
+    646899n 1.8
+    646900n 0
+    647199n 0
+    647200n 1.8
+    647299n 1.8
+    647300n 0
+    647599n 0
+    647600n 1.8
+    647699n 1.8
+    647700n 0
+    647999n 0
+    648000n 1.8
+    648099n 1.8
+    648100n 0
+    648399n 0
+    648400n 1.8
+    648499n 1.8
+    648500n 0
+    648799n 0
+    648800n 1.8
+    648899n 1.8
+    648900n 0
+    649199n 0
+    649200n 1.8
+    649299n 1.8
+    649300n 0
+    649599n 0
+    649600n 1.8
+    649699n 1.8
+    649700n 0
+    649999n 0
+    650000n 1.8
+    650099n 1.8
+    650100n 0
+    650399n 0
+    650400n 1.8
+    650499n 1.8
+    650500n 0
+    650799n 0
+    650800n 1.8
+    650899n 1.8
+    650900n 0
+    651199n 0
+    651200n 1.8
+    651299n 1.8
+    651300n 0
+    651599n 0
+    651600n 1.8
+    651699n 1.8
+    651700n 0
+    651999n 0
+    652000n 1.8
+    652099n 1.8
+    652100n 0
+    652399n 0
+    652400n 1.8
+    652499n 1.8
+    652500n 0
+    652799n 0
+    652800n 1.8
+    652899n 1.8
+    652900n 0
+    653199n 0
+    653200n 1.8
+    653299n 1.8
+    653300n 0
+    653599n 0
+    653600n 1.8
+    653699n 1.8
+    653700n 0
+    653999n 0
+    654000n 1.8
+    654099n 1.8
+    654100n 0
+    654399n 0
+    654400n 1.8
+    654499n 1.8
+    654500n 0
+    654799n 0
+    654800n 1.8
+    654899n 1.8
+    654900n 0
+    655199n 0
+    655200n 1.8
+    655299n 1.8
+    655300n 0
+    655599n 0
+    655600n 1.8
+    655699n 1.8
+    655700n 0
+    655999n 0
+    656000n 1.8
+    656099n 1.8
+    656100n 0
+    656399n 0
+    656400n 1.8
+    656499n 1.8
+    656500n 0
+    656799n 0
+    656800n 1.8
+    656899n 1.8
+    656900n 0
+    657199n 0
+    657200n 1.8
+    657299n 1.8
+    657300n 0
+    657599n 0
+    657600n 1.8
+    657699n 1.8
+    657700n 0
+    657999n 0
+    658000n 1.8
+    658099n 1.8
+    658100n 0
+    658399n 0
+    658400n 1.8
+    658499n 1.8
+    658500n 0
+    658799n 0
+    658800n 1.8
+    658899n 1.8
+    658900n 0
+    659199n 0
+    659200n 1.8
+    659299n 1.8
+    659300n 0
+    659599n 0
+    659600n 1.8
+    659699n 1.8
+    659700n 0
+    659999n 0
+    660000n 1.8
+    660099n 1.8
+    660100n 0
+    660399n 0
+    660400n 1.8
+    660499n 1.8
+    660500n 0
+    660799n 0
+    660800n 1.8
+    660899n 1.8
+    660900n 0
+    661199n 0
+    661200n 1.8
+    661299n 1.8
+    661300n 0
+    661599n 0
+    661600n 1.8
+    661699n 1.8
+    661700n 0
+    661999n 0
+    662000n 1.8
+    662099n 1.8
+    662100n 0
+    662399n 0
+    662400n 1.8
+    662499n 1.8
+    662500n 0
+    662799n 0
+    662800n 1.8
+    662899n 1.8
+    662900n 0
+    663199n 0
+    663200n 1.8
+    663299n 1.8
+    663300n 0
+    663599n 0
+    663600n 1.8
+    663699n 1.8
+    663700n 0
+    663999n 0
+    664000n 1.8
+    664099n 1.8
+    664100n 0
+    664399n 0
+    664400n 1.8
+    664499n 1.8
+    664500n 0
+    664799n 0
+    664800n 1.8
+    664899n 1.8
+    664900n 0
+    665199n 0
+    665200n 1.8
+    665299n 1.8
+    665300n 0
+    665599n 0
+    665600n 1.8
+    665699n 1.8
+    665700n 0
+    665999n 0
+    666000n 1.8
+    666099n 1.8
+    666100n 0
+    666399n 0
+    666400n 1.8
+    666499n 1.8
+    666500n 0
+    666799n 0
+    666800n 1.8
+    666899n 1.8
+    666900n 0
+    667199n 0
+    667200n 1.8
+    667299n 1.8
+    667300n 0
+    667599n 0
+    667600n 1.8
+    667699n 1.8
+    667700n 0
+    667999n 0
+    668000n 1.8
+    668099n 1.8
+    668100n 0
+    668399n 0
+    668400n 1.8
+    668499n 1.8
+    668500n 0
+    668799n 0
+    668800n 1.8
+    668899n 1.8
+    668900n 0
+    669199n 0
+    669200n 1.8
+    669299n 1.8
+    669300n 0
+    669599n 0
+    669600n 1.8
+    669699n 1.8
+    669700n 0
+    669999n 0
+    670000n 1.8
+    670099n 1.8
+    670100n 0
+    670399n 0
+    670400n 1.8
+    670499n 1.8
+    670500n 0
+    670799n 0
+    670800n 1.8
+    670899n 1.8
+    670900n 0
+    671199n 0
+    671200n 1.8
+    671299n 1.8
+    671300n 0
+    671599n 0
+    671600n 1.8
+    671699n 1.8
+    671700n 0
+    671999n 0
+    672000n 1.8
+    672099n 1.8
+    672100n 0
+    672399n 0
+    672400n 1.8
+    672499n 1.8
+    672500n 0
+    672799n 0
+    672800n 1.8
+    672899n 1.8
+    672900n 0
+    673199n 0
+    673200n 1.8
+    673299n 1.8
+    673300n 0
+    673599n 0
+    673600n 1.8
+    673699n 1.8
+    673700n 0
+    673999n 0
+    674000n 1.8
+    674099n 1.8
+    674100n 0
+    674399n 0
+    674400n 1.8
+    674499n 1.8
+    674500n 0
+    674799n 0
+    674800n 1.8
+    674899n 1.8
+    674900n 0
+    675199n 0
+    675200n 1.8
+    675299n 1.8
+    675300n 0
+    675599n 0
+    675600n 1.8
+    675699n 1.8
+    675700n 0
+    675999n 0
+    676000n 1.8
+    676099n 1.8
+    676100n 0
+    676399n 0
+    676400n 1.8
+    676499n 1.8
+    676500n 0
+    676799n 0
+    676800n 1.8
+    676899n 1.8
+    676900n 0
+    677199n 0
+    677200n 1.8
+    677299n 1.8
+    677300n 0
+    677599n 0
+    677600n 1.8
+    677699n 1.8
+    677700n 0
+    677999n 0
+    678000n 1.8
+    678099n 1.8
+    678100n 0
+    678399n 0
+    678400n 1.8
+    678499n 1.8
+    678500n 0
+    678799n 0
+    678800n 1.8
+    678899n 1.8
+    678900n 0
+    679199n 0
+    679200n 1.8
+    679299n 1.8
+    679300n 0
+    679599n 0
+    679600n 1.8
+    679699n 1.8
+    679700n 0
+    679999n 0
+    680000n 1.8
+    680099n 1.8
+    680100n 0
+    680399n 0
+    680400n 1.8
+    680499n 1.8
+    680500n 0
+    680799n 0
+    680800n 1.8
+    680899n 1.8
+    680900n 0
+    681199n 0
+    681200n 1.8
+    681299n 1.8
+    681300n 0
+    681599n 0
+    681600n 1.8
+    681699n 1.8
+    681700n 0
+    681999n 0
+    682000n 1.8
+    682099n 1.8
+    682100n 0
+    682399n 0
+    682400n 1.8
+    682499n 1.8
+    682500n 0
+    682799n 0
+    682800n 1.8
+    682899n 1.8
+    682900n 0
+    683199n 0
+    683200n 1.8
+    683299n 1.8
+    683300n 0
+    683599n 0
+    683600n 1.8
+    683699n 1.8
+    683700n 0
+    683999n 0
+    684000n 1.8
+    684099n 1.8
+    684100n 0
+    684399n 0
+    684400n 1.8
+    684499n 1.8
+    684500n 0
+    684799n 0
+    684800n 1.8
+    684899n 1.8
+    684900n 0
+    685199n 0
+    685200n 1.8
+    685299n 1.8
+    685300n 0
+    685599n 0
+    685600n 1.8
+    685699n 1.8
+    685700n 0
+    685999n 0
+    686000n 1.8
+    686099n 1.8
+    686100n 0
+    686399n 0
+    686400n 1.8
+    686499n 1.8
+    686500n 0
+    686799n 0
+    686800n 1.8
+    686899n 1.8
+    686900n 0
+    687199n 0
+    687200n 1.8
+    687299n 1.8
+    687300n 0
+    687599n 0
+    687600n 1.8
+    687699n 1.8
+    687700n 0
+    687999n 0
+    688000n 1.8
+    688099n 1.8
+    688100n 0
+    688399n 0
+    688400n 1.8
+    688499n 1.8
+    688500n 0
+    688799n 0
+    688800n 1.8
+    688899n 1.8
+    688900n 0
+    689199n 0
+    689200n 1.8
+    689299n 1.8
+    689300n 0
+    689599n 0
+    689600n 1.8
+    689699n 1.8
+    689700n 0
+    689999n 0
+    690000n 1.8
+    690099n 1.8
+    690100n 0
+    690399n 0
+    690400n 1.8
+    690499n 1.8
+    690500n 0
+    690799n 0
+    690800n 1.8
+    690899n 1.8
+    690900n 0
+    691199n 0
+    691200n 1.8
+    691299n 1.8
+    691300n 0
+    691599n 0
+    691600n 1.8
+    691699n 1.8
+    691700n 0
+    691999n 0
+    692000n 1.8
+    692099n 1.8
+    692100n 0
+    692399n 0
+    692400n 1.8
+    692499n 1.8
+    692500n 0
+    692799n 0
+    692800n 1.8
+    692899n 1.8
+    692900n 0
+    693199n 0
+    693200n 1.8
+    693299n 1.8
+    693300n 0
+    693599n 0
+    693600n 1.8
+    693699n 1.8
+    693700n 0
+    693999n 0
+    694000n 1.8
+    694099n 1.8
+    694100n 0
+    694399n 0
+    694400n 1.8
+    694499n 1.8
+    694500n 0
+    694799n 0
+    694800n 1.8
+    694899n 1.8
+    694900n 0
+    695199n 0
+    695200n 1.8
+    695299n 1.8
+    695300n 0
+    695599n 0
+    695600n 1.8
+    695699n 1.8
+    695700n 0
+    695999n 0
+    696000n 1.8
+    696099n 1.8
+    696100n 0
+    696399n 0
+    696400n 1.8
+    696499n 1.8
+    696500n 0
+    696799n 0
+    696800n 1.8
+    696899n 1.8
+    696900n 0
+    697199n 0
+    697200n 1.8
+    697299n 1.8
+    697300n 0
+    697599n 0
+    697600n 1.8
+    697699n 1.8
+    697700n 0
+    697999n 0
+    698000n 1.8
+    698099n 1.8
+    698100n 0
+    698399n 0
+    698400n 1.8
+    698499n 1.8
+    698500n 0
+    698799n 0
+    698800n 1.8
+    698899n 1.8
+    698900n 0
+    699199n 0
+    699200n 1.8
+    699299n 1.8
+    699300n 0
+    699599n 0
+    699600n 1.8
+    699699n 1.8
+    699700n 0
+    699999n 0
+    700000n 1.8
+    700099n 1.8
+    700100n 0
+    700399n 0
+    700400n 1.8
+    700499n 1.8
+    700500n 0
+    700799n 0
+    700800n 1.8
+    700899n 1.8
+    700900n 0
+    701199n 0
+    701200n 1.8
+    701299n 1.8
+    701300n 0
+    701599n 0
+    701600n 1.8
+    701699n 1.8
+    701700n 0
+    701999n 0
+    702000n 1.8
+    702099n 1.8
+    702100n 0
+    702399n 0
+    702400n 1.8
+    702499n 1.8
+    702500n 0
+    702799n 0
+    702800n 1.8
+    702899n 1.8
+    702900n 0
+    703199n 0
+    703200n 1.8
+    703299n 1.8
+    703300n 0
+    703599n 0
+    703600n 1.8
+    703699n 1.8
+    703700n 0
+    703999n 0
+    704000n 1.8
+    704099n 1.8
+    704100n 0
+    704399n 0
+    704400n 1.8
+    704499n 1.8
+    704500n 0
+    704799n 0
+    704800n 1.8
+    704899n 1.8
+    704900n 0
+    705199n 0
+    705200n 1.8
+    705299n 1.8
+    705300n 0
+    705599n 0
+    705600n 1.8
+    705699n 1.8
+    705700n 0
+    705999n 0
+    706000n 1.8
+    706099n 1.8
+    706100n 0
+    706399n 0
+    706400n 1.8
+    706499n 1.8
+    706500n 0
+    706799n 0
+    706800n 1.8
+    706899n 1.8
+    706900n 0
+    707199n 0
+    707200n 1.8
+    707299n 1.8
+    707300n 0
+    707599n 0
+    707600n 1.8
+    707699n 1.8
+    707700n 0
+    707999n 0
+    708000n 1.8
+    708099n 1.8
+    708100n 0
+    708399n 0
+    708400n 1.8
+    708499n 1.8
+    708500n 0
+    708799n 0
+    708800n 1.8
+    708899n 1.8
+    708900n 0
+    709199n 0
+    709200n 1.8
+    709299n 1.8
+    709300n 0
+    709599n 0
+    709600n 1.8
+    709699n 1.8
+    709700n 0
+    709999n 0
+    710000n 1.8
+    710099n 1.8
+    710100n 0
+    710399n 0
+    710400n 1.8
+    710499n 1.8
+    710500n 0
+    710799n 0
+    710800n 1.8
+    710899n 1.8
+    710900n 0
+    711199n 0
+    711200n 1.8
+    711299n 1.8
+    711300n 0
+    711599n 0
+    711600n 1.8
+    711699n 1.8
+    711700n 0
+    711999n 0
+    712000n 1.8
+    712099n 1.8
+    712100n 0
+    712399n 0
+    712400n 1.8
+    712499n 1.8
+    712500n 0
+    712799n 0
+    712800n 1.8
+    712899n 1.8
+    712900n 0
+    713199n 0
+    713200n 1.8
+    713299n 1.8
+    713300n 0
+    713599n 0
+    713600n 1.8
+    713699n 1.8
+    713700n 0
+    713999n 0
+    714000n 1.8
+    714099n 1.8
+    714100n 0
+    714399n 0
+    714400n 1.8
+    714499n 1.8
+    714500n 0
+    714799n 0
+    714800n 1.8
+    714899n 1.8
+    714900n 0
+    715199n 0
+    715200n 1.8
+    715299n 1.8
+    715300n 0
+    715599n 0
+    715600n 1.8
+    715699n 1.8
+    715700n 0
+    715999n 0
+    716000n 1.8
+    716099n 1.8
+    716100n 0
+    716399n 0
+    716400n 1.8
+    716499n 1.8
+    716500n 0
+    716799n 0
+    716800n 1.8
+    716899n 1.8
+    716900n 0
+    717199n 0
+    717200n 1.8
+    717299n 1.8
+    717300n 0
+    717599n 0
+    717600n 1.8
+    717699n 1.8
+    717700n 0
+    717999n 0
+    718000n 1.8
+    718099n 1.8
+    718100n 0
+    718399n 0
+    718400n 1.8
+    718499n 1.8
+    718500n 0
+    718799n 0
+    718800n 1.8
+    718899n 1.8
+    718900n 0
+    719199n 0
+    719200n 1.8
+    719299n 1.8
+    719300n 0
+    719599n 0
+    719600n 1.8
+    719699n 1.8
+    719700n 0
+    719999n 0
+    720000n 1.8
+    720099n 1.8
+    720100n 0
+    720399n 0
+    720400n 1.8
+    720499n 1.8
+    720500n 0
+    720799n 0
+    720800n 1.8
+    720899n 1.8
+    720900n 0
+    721199n 0
+    721200n 1.8
+    721299n 1.8
+    721300n 0
+    721599n 0
+    721600n 1.8
+    721699n 1.8
+    721700n 0
+    721999n 0
+    722000n 1.8
+    722099n 1.8
+    722100n 0
+    722399n 0
+    722400n 1.8
+    722499n 1.8
+    722500n 0
+    722799n 0
+    722800n 1.8
+    722899n 1.8
+    722900n 0
+    723199n 0
+    723200n 1.8
+    723299n 1.8
+    723300n 0
+    723599n 0
+    723600n 1.8
+    723699n 1.8
+    723700n 0
+    723999n 0
+    724000n 1.8
+    724099n 1.8
+    724100n 0
+    724399n 0
+    724400n 1.8
+    724499n 1.8
+    724500n 0
+    724799n 0
+    724800n 1.8
+    724899n 1.8
+    724900n 0
+    725199n 0
+    725200n 1.8
+    725299n 1.8
+    725300n 0
+    725599n 0
+    725600n 1.8
+    725699n 1.8
+    725700n 0
+    725999n 0
+    726000n 1.8
+    726099n 1.8
+    726100n 0
+    726399n 0
+    726400n 1.8
+    726499n 1.8
+    726500n 0
+    726799n 0
+    726800n 1.8
+    726899n 1.8
+    726900n 0
+    727199n 0
+    727200n 1.8
+    727299n 1.8
+    727300n 0
+    727599n 0
+    727600n 1.8
+    727699n 1.8
+    727700n 0
+    727999n 0
+    728000n 1.8
+    728099n 1.8
+    728100n 0
+    728399n 0
+    728400n 1.8
+    728499n 1.8
+    728500n 0
+    728799n 0
+    728800n 1.8
+    728899n 1.8
+    728900n 0
+    729199n 0
+    729200n 1.8
+    729299n 1.8
+    729300n 0
+    729599n 0
+    729600n 1.8
+    729699n 1.8
+    729700n 0
+    729999n 0
+    730000n 1.8
+    730099n 1.8
+    730100n 0
+    730399n 0
+    730400n 1.8
+    730499n 1.8
+    730500n 0
+    730799n 0
+    730800n 1.8
+    730899n 1.8
+    730900n 0
+    731199n 0
+    731200n 1.8
+    731299n 1.8
+    731300n 0
+    731599n 0
+    731600n 1.8
+    731699n 1.8
+    731700n 0
+    731999n 0
+    732000n 1.8
+    732099n 1.8
+    732100n 0
+    732399n 0
+    732400n 1.8
+    732499n 1.8
+    732500n 0
+    732799n 0
+    732800n 1.8
+    732899n 1.8
+    732900n 0
+    733199n 0
+    733200n 1.8
+    733299n 1.8
+    733300n 0
+    733599n 0
+    733600n 1.8
+    733699n 1.8
+    733700n 0
+    733999n 0
+    734000n 1.8
+    734099n 1.8
+    734100n 0
+    734399n 0
+    734400n 1.8
+    734499n 1.8
+    734500n 0
+    734799n 0
+    734800n 1.8
+    734899n 1.8
+    734900n 0
+    735199n 0
+    735200n 1.8
+    735299n 1.8
+    735300n 0
+    735599n 0
+    735600n 1.8
+    735699n 1.8
+    735700n 0
+    735999n 0
+    736000n 1.8
+    736099n 1.8
+    736100n 0
+    736399n 0
+    736400n 1.8
+    736499n 1.8
+    736500n 0
+    736799n 0
+    736800n 1.8
+    736899n 1.8
+    736900n 0
+    737199n 0
+    737200n 1.8
+    737299n 1.8
+    737300n 0
+    737599n 0
+    737600n 1.8
+    737699n 1.8
+    737700n 0
+    737999n 0
+    738000n 1.8
+    738099n 1.8
+    738100n 0
+    738399n 0
+    738400n 1.8
+    738499n 1.8
+    738500n 0
+    738799n 0
+    738800n 1.8
+    738899n 1.8
+    738900n 0
+    739199n 0
+    739200n 1.8
+    739299n 1.8
+    739300n 0
+    739599n 0
+    739600n 1.8
+    739699n 1.8
+    739700n 0
+    739999n 0
+    740000n 1.8
+    740099n 1.8
+    740100n 0
+    740399n 0
+    740400n 1.8
+    740499n 1.8
+    740500n 0
+    740799n 0
+    740800n 1.8
+    740899n 1.8
+    740900n 0
+    741199n 0
+    741200n 1.8
+    741299n 1.8
+    741300n 0
+    741599n 0
+    741600n 1.8
+    741699n 1.8
+    741700n 0
+    741999n 0
+    742000n 1.8
+    742099n 1.8
+    742100n 0
+    742399n 0
+    742400n 1.8
+    742499n 1.8
+    742500n 0
+    742799n 0
+    742800n 1.8
+    742899n 1.8
+    742900n 0
+    743199n 0
+    743200n 1.8
+    743299n 1.8
+    743300n 0
+    743599n 0
+    743600n 1.8
+    743699n 1.8
+    743700n 0
+    743999n 0
+    744000n 1.8
+    744099n 1.8
+    744100n 0
+    744399n 0
+    744400n 1.8
+    744499n 1.8
+    744500n 0
+    744799n 0
+    744800n 1.8
+    744899n 1.8
+    744900n 0
+    745199n 0
+    745200n 1.8
+    745299n 1.8
+    745300n 0
+    745599n 0
+    745600n 1.8
+    745699n 1.8
+    745700n 0
+    745999n 0
+    746000n 1.8
+    746099n 1.8
+    746100n 0
+    746399n 0
+    746400n 1.8
+    746499n 1.8
+    746500n 0
+    746799n 0
+    746800n 1.8
+    746899n 1.8
+    746900n 0
+    747199n 0
+    747200n 1.8
+    747299n 1.8
+    747300n 0
+    747599n 0
+    747600n 1.8
+    747699n 1.8
+    747700n 0
+    747999n 0
+    748000n 1.8
+    748099n 1.8
+    748100n 0
+    748399n 0
+    748400n 1.8
+    748499n 1.8
+    748500n 0
+    748799n 0
+    748800n 1.8
+    748899n 1.8
+    748900n 0
+    749199n 0
+    749200n 1.8
+    749299n 1.8
+    749300n 0
+    749599n 0
+    749600n 1.8
+    749699n 1.8
+    749700n 0
+    749999n 0
+    750000n 1.8
+    750099n 1.8
+    750100n 0
+    750399n 0
+    750400n 1.8
+    750499n 1.8
+    750500n 0
+    750799n 0
+    750800n 1.8
+    750899n 1.8
+    750900n 0
+    751199n 0
+    751200n 1.8
+    751299n 1.8
+    751300n 0
+    751599n 0
+    751600n 1.8
+    751699n 1.8
+    751700n 0
+    751999n 0
+    752000n 1.8
+    752099n 1.8
+    752100n 0
+    752399n 0
+    752400n 1.8
+    752499n 1.8
+    752500n 0
+    752799n 0
+    752800n 1.8
+    752899n 1.8
+    752900n 0
+    753199n 0
+    753200n 1.8
+    753299n 1.8
+    753300n 0
+    753599n 0
+    753600n 1.8
+    753699n 1.8
+    753700n 0
+    753999n 0
+    754000n 1.8
+    754099n 1.8
+    754100n 0
+    754399n 0
+    754400n 1.8
+    754499n 1.8
+    754500n 0
+    754799n 0
+    754800n 1.8
+    754899n 1.8
+    754900n 0
+    755199n 0
+    755200n 1.8
+    755299n 1.8
+    755300n 0
+    755599n 0
+    755600n 1.8
+    755699n 1.8
+    755700n 0
+    755999n 0
+    756000n 1.8
+    756099n 1.8
+    756100n 0
+    756399n 0
+    756400n 1.8
+    756499n 1.8
+    756500n 0
+    756799n 0
+    756800n 1.8
+    756899n 1.8
+    756900n 0
+    757199n 0
+    757200n 1.8
+    757299n 1.8
+    757300n 0
+    757599n 0
+    757600n 1.8
+    757699n 1.8
+    757700n 0
+    757999n 0
+    758000n 1.8
+    758099n 1.8
+    758100n 0
+    758399n 0
+    758400n 1.8
+    758499n 1.8
+    758500n 0
+    758799n 0
+    758800n 1.8
+    758899n 1.8
+    758900n 0
+    759199n 0
+    759200n 1.8
+    759299n 1.8
+    759300n 0
+    759599n 0
+    759600n 1.8
+    759699n 1.8
+    759700n 0
+    759999n 0
+    760000n 1.8
+    760099n 1.8
+    760100n 0
+    760399n 0
+    760400n 1.8
+    760499n 1.8
+    760500n 0
+    760799n 0
+    760800n 1.8
+    760899n 1.8
+    760900n 0
+    761199n 0
+    761200n 1.8
+    761299n 1.8
+    761300n 0
+    761599n 0
+    761600n 1.8
+    761699n 1.8
+    761700n 0
+    761999n 0
+    762000n 1.8
+    762099n 1.8
+    762100n 0
+    762399n 0
+    762400n 1.8
+    762499n 1.8
+    762500n 0
+    762799n 0
+    762800n 1.8
+    762899n 1.8
+    762900n 0
+    763199n 0
+    763200n 1.8
+    763299n 1.8
+    763300n 0
+    763599n 0
+    763600n 1.8
+    763699n 1.8
+    763700n 0
+    763999n 0
+    764000n 1.8
+    764099n 1.8
+    764100n 0
+    764399n 0
+    764400n 1.8
+    764499n 1.8
+    764500n 0
+    764799n 0
+    764800n 1.8
+    764899n 1.8
+    764900n 0
+    765199n 0
+    765200n 1.8
+    765299n 1.8
+    765300n 0
+    765599n 0
+    765600n 1.8
+    765699n 1.8
+    765700n 0
+    765999n 0
+    766000n 1.8
+    766099n 1.8
+    766100n 0
+    766399n 0
+    766400n 1.8
+    766499n 1.8
+    766500n 0
+    766799n 0
+    766800n 1.8
+    766899n 1.8
+    766900n 0
+    767199n 0
+    767200n 1.8
+    767299n 1.8
+    767300n 0
+    767599n 0
+    767600n 1.8
+    767699n 1.8
+    767700n 0
+    767999n 0
+    768000n 1.8
+    768099n 1.8
+    768100n 0
+    768399n 0
+    768400n 1.8
+    768499n 1.8
+    768500n 0
+    768799n 0
+    768800n 1.8
+    768899n 1.8
+    768900n 0
+    769199n 0
+    769200n 1.8
+    769299n 1.8
+    769300n 0
+    769599n 0
+    769600n 1.8
+    769699n 1.8
+    769700n 0
+    769999n 0
+    770000n 1.8
+    770099n 1.8
+    770100n 0
+    770399n 0
+    770400n 1.8
+    770499n 1.8
+    770500n 0
+    770799n 0
+    770800n 1.8
+    770899n 1.8
+    770900n 0
+    771199n 0
+    771200n 1.8
+    771299n 1.8
+    771300n 0
+    771599n 0
+    771600n 1.8
+    771699n 1.8
+    771700n 0
+    771999n 0
+    772000n 1.8
+    772099n 1.8
+    772100n 0
+    772399n 0
+    772400n 1.8
+    772499n 1.8
+    772500n 0
+    772799n 0
+    772800n 1.8
+    772899n 1.8
+    772900n 0
+    773199n 0
+    773200n 1.8
+    773299n 1.8
+    773300n 0
+    773599n 0
+    773600n 1.8
+    773699n 1.8
+    773700n 0
+    773999n 0
+    774000n 1.8
+    774099n 1.8
+    774100n 0
+    774399n 0
+    774400n 1.8
+    774499n 1.8
+    774500n 0
+    774799n 0
+    774800n 1.8
+    774899n 1.8
+    774900n 0
+    775199n 0
+    775200n 1.8
+    775299n 1.8
+    775300n 0
+    775599n 0
+    775600n 1.8
+    775699n 1.8
+    775700n 0
+    775999n 0
+    776000n 1.8
+    776099n 1.8
+    776100n 0
+    776399n 0
+    776400n 1.8
+    776499n 1.8
+    776500n 0
+    776799n 0
+    776800n 1.8
+    776899n 1.8
+    776900n 0
+    777199n 0
+    777200n 1.8
+    777299n 1.8
+    777300n 0
+    777599n 0
+    777600n 1.8
+    777699n 1.8
+    777700n 0
+    777999n 0
+    778000n 1.8
+    778099n 1.8
+    778100n 0
+    778399n 0
+    778400n 1.8
+    778499n 1.8
+    778500n 0
+    778799n 0
+    778800n 1.8
+    778899n 1.8
+    778900n 0
+    779199n 0
+    779200n 1.8
+    779299n 1.8
+    779300n 0
+    779599n 0
+    779600n 1.8
+    779699n 1.8
+    779700n 0
+    779999n 0
+    780000n 1.8
+    780099n 1.8
+    780100n 0
+    780399n 0
+    780400n 1.8
+    780499n 1.8
+    780500n 0
+    780799n 0
+    780800n 1.8
+    780899n 1.8
+    780900n 0
+    781199n 0
+    781200n 1.8
+    781299n 1.8
+    781300n 0
+    781599n 0
+    781600n 1.8
+    781699n 1.8
+    781700n 0
+    781999n 0
+    782000n 1.8
+    782099n 1.8
+    782100n 0
+    782399n 0
+    782400n 1.8
+    782499n 1.8
+    782500n 0
+    782799n 0
+    782800n 1.8
+    782899n 1.8
+    782900n 0
+    783199n 0
+    783200n 1.8
+    783299n 1.8
+    783300n 0
+    783599n 0
+    783600n 1.8
+    783699n 1.8
+    783700n 0
+    783999n 0
+    784000n 1.8
+    784099n 1.8
+    784100n 0
+    784399n 0
+    784400n 1.8
+    784499n 1.8
+    784500n 0
+    784799n 0
+    784800n 1.8
+    784899n 1.8
+    784900n 0
+    785199n 0
+    785200n 1.8
+    785299n 1.8
+    785300n 0
+    785599n 0
+    785600n 1.8
+    785699n 1.8
+    785700n 0
+    785999n 0
+    786000n 1.8
+    786099n 1.8
+    786100n 0
+    786399n 0
+    786400n 1.8
+    786499n 1.8
+    786500n 0
+    786799n 0
+    786800n 1.8
+    786899n 1.8
+    786900n 0
+    787199n 0
+    787200n 1.8
+    787299n 1.8
+    787300n 0
+    787599n 0
+    787600n 1.8
+    787699n 1.8
+    787700n 0
+    787999n 0
+    788000n 1.8
+    788099n 1.8
+    788100n 0
+    788399n 0
+    788400n 1.8
+    788499n 1.8
+    788500n 0
+    788799n 0
+    788800n 1.8
+    788899n 1.8
+    788900n 0
+    789199n 0
+    789200n 1.8
+    789299n 1.8
+    789300n 0
+    789599n 0
+    789600n 1.8
+    789699n 1.8
+    789700n 0
+    789999n 0
+    790000n 1.8
+    790099n 1.8
+    790100n 0
+    790399n 0
+    790400n 1.8
+    790499n 1.8
+    790500n 0
+    790799n 0
+    790800n 1.8
+    790899n 1.8
+    790900n 0
+    791199n 0
+    791200n 1.8
+    791299n 1.8
+    791300n 0
+    791599n 0
+    791600n 1.8
+    791699n 1.8
+    791700n 0
+    791999n 0
+    792000n 1.8
+    792099n 1.8
+    792100n 0
+    792399n 0
+    792400n 1.8
+    792499n 1.8
+    792500n 0
+    792799n 0
+    792800n 1.8
+    792899n 1.8
+    792900n 0
+    793199n 0
+    793200n 1.8
+    793299n 1.8
+    793300n 0
+    793599n 0
+    793600n 1.8
+    793699n 1.8
+    793700n 0
+    793999n 0
+    794000n 1.8
+    794099n 1.8
+    794100n 0
+    794399n 0
+    794400n 1.8
+    794499n 1.8
+    794500n 0
+    794799n 0
+    794800n 1.8
+    794899n 1.8
+    794900n 0
+    795199n 0
+    795200n 1.8
+    795299n 1.8
+    795300n 0
+    795599n 0
+    795600n 1.8
+    795699n 1.8
+    795700n 0
+    795999n 0
+    796000n 1.8
+    796099n 1.8
+    796100n 0
+    796399n 0
+    796400n 1.8
+    796499n 1.8
+    796500n 0
+    796799n 0
+    796800n 1.8
+    796899n 1.8
+    796900n 0
+    797199n 0
+    797200n 1.8
+    797299n 1.8
+    797300n 0
+    797599n 0
+    797600n 1.8
+    797699n 1.8
+    797700n 0
+    797999n 0
+    798000n 1.8
+    798099n 1.8
+    798100n 0
+    798399n 0
+    798400n 1.8
+    798499n 1.8
+    798500n 0
+    798799n 0
+    798800n 1.8
+    798899n 1.8
+    798900n 0
+    799199n 0
+    799200n 1.8
+    799299n 1.8
+    799300n 0
+    799599n 0
+    799600n 1.8
+    799699n 1.8
+    799700n 0
+    799999n 0
+    800000n 1.8
+    800099n 1.8
+    800100n 0
+    800399n 0
+    800400n 1.8
+    800499n 1.8
+    800500n 0
+    800799n 0
+    800800n 1.8
+    800899n 1.8
+    800900n 0
+    801199n 0
+    801200n 1.8
+    801299n 1.8
+    801300n 0
+    801599n 0
+    801600n 1.8
+    801699n 1.8
+    801700n 0
+    801999n 0
+    802000n 1.8
+    802099n 1.8
+    802100n 0
+    802399n 0
+    802400n 1.8
+    802499n 1.8
+    802500n 0
+    802799n 0
+    802800n 1.8
+    802899n 1.8
+    802900n 0
+    803199n 0
+    803200n 1.8
+    803299n 1.8
+    803300n 0
+    803599n 0
+    803600n 1.8
+    803699n 1.8
+    803700n 0
+    803999n 0
+    804000n 1.8
+    804099n 1.8
+    804100n 0
+    804399n 0
+    804400n 1.8
+    804499n 1.8
+    804500n 0
+    804799n 0
+    804800n 1.8
+    804899n 1.8
+    804900n 0
+    805199n 0
+    805200n 1.8
+    805299n 1.8
+    805300n 0
+    805599n 0
+    805600n 1.8
+    805699n 1.8
+    805700n 0
+    805999n 0
+    806000n 1.8
+    806099n 1.8
+    806100n 0
+    806399n 0
+    806400n 1.8
+    806499n 1.8
+    806500n 0
+    806799n 0
+    806800n 1.8
+    806899n 1.8
+    806900n 0
+    807199n 0
+    807200n 1.8
+    807299n 1.8
+    807300n 0
+    807599n 0
+    807600n 1.8
+    807699n 1.8
+    807700n 0
+    807999n 0
+    808000n 1.8
+    808099n 1.8
+    808100n 0
+    808399n 0
+    808400n 1.8
+    808499n 1.8
+    808500n 0
+    808799n 0
+    808800n 1.8
+    808899n 1.8
+    808900n 0
+    809199n 0
+    809200n 1.8
+    809299n 1.8
+    809300n 0
+    809599n 0
+    809600n 1.8
+    809699n 1.8
+    809700n 0
+    809999n 0
+    810000n 1.8
+    810099n 1.8
+    810100n 0
+    810399n 0
+    810400n 1.8
+    810499n 1.8
+    810500n 0
+    810799n 0
+    810800n 1.8
+    810899n 1.8
+    810900n 0
+    811199n 0
+    811200n 1.8
+    811299n 1.8
+    811300n 0
+    811599n 0
+    811600n 1.8
+    811699n 1.8
+    811700n 0
+    811999n 0
+    812000n 1.8
+    812099n 1.8
+    812100n 0
+    812399n 0
+    812400n 1.8
+    812499n 1.8
+    812500n 0
+    812799n 0
+    812800n 1.8
+    812899n 1.8
+    812900n 0
+    813199n 0
+    813200n 1.8
+    813299n 1.8
+    813300n 0
+    813599n 0
+    813600n 1.8
+    813699n 1.8
+    813700n 0
+    813999n 0
+    814000n 1.8
+    814099n 1.8
+    814100n 0
+    814399n 0
+    814400n 1.8
+    814499n 1.8
+    814500n 0
+    814799n 0
+    814800n 1.8
+    814899n 1.8
+    814900n 0
+    815199n 0
+    815200n 1.8
+    815299n 1.8
+    815300n 0
+    815599n 0
+    815600n 1.8
+    815699n 1.8
+    815700n 0
+    815999n 0
+    816000n 1.8
+    816099n 1.8
+    816100n 0
+    816399n 0
+    816400n 1.8
+    816499n 1.8
+    816500n 0
+    816799n 0
+    816800n 1.8
+    816899n 1.8
+    816900n 0
+    817199n 0
+    817200n 1.8
+    817299n 1.8
+    817300n 0
+    817599n 0
+    817600n 1.8
+    817699n 1.8
+    817700n 0
+    817999n 0
+    818000n 1.8
+    818099n 1.8
+    818100n 0
+    818399n 0
+    818400n 1.8
+    818499n 1.8
+    818500n 0
+    818799n 0
+    818800n 1.8
+    818899n 1.8
+    818900n 0
+    819199n 0
+    819200n 1.8
+    819299n 1.8
+    819300n 0
+    819599n 0
+    819600n 1.8
+    819699n 1.8
+    819700n 0
+    819999n 0
+    820000n 1.8
+    820099n 1.8
+    820100n 0
+    820399n 0
+    820400n 1.8
+    820499n 1.8
+    820500n 0
+    820799n 0
+    820800n 1.8
+    820899n 1.8
+    820900n 0
+    821199n 0
+    821200n 1.8
+    821299n 1.8
+    821300n 0
+    821599n 0
+    821600n 1.8
+    821699n 1.8
+    821700n 0
+    821999n 0
+    822000n 1.8
+    822099n 1.8
+    822100n 0
+    822399n 0
+    822400n 1.8
+    822499n 1.8
+    822500n 0
+    822799n 0
+    822800n 1.8
+    822899n 1.8
+    822900n 0
+    823199n 0
+    823200n 1.8
+    823299n 1.8
+    823300n 0
+    823599n 0
+    823600n 1.8
+    823699n 1.8
+    823700n 0
+    823999n 0
+    824000n 1.8
+    824099n 1.8
+    824100n 0
+    824399n 0
+    824400n 1.8
+    824499n 1.8
+    824500n 0
+    824799n 0
+    824800n 1.8
+    824899n 1.8
+    824900n 0
+    825199n 0
+    825200n 1.8
+    825299n 1.8
+    825300n 0
+    825599n 0
+    825600n 1.8
+    825699n 1.8
+    825700n 0
+    825999n 0
+    826000n 1.8
+    826099n 1.8
+    826100n 0
+    826399n 0
+    826400n 1.8
+    826499n 1.8
+    826500n 0
+    826799n 0
+    826800n 1.8
+    826899n 1.8
+    826900n 0
+    827199n 0
+    827200n 1.8
+    827299n 1.8
+    827300n 0
+    827599n 0
+    827600n 1.8
+    827699n 1.8
+    827700n 0
+    827999n 0
+    828000n 1.8
+    828099n 1.8
+    828100n 0
+    828399n 0
+    828400n 1.8
+    828499n 1.8
+    828500n 0
+    828799n 0
+    828800n 1.8
+    828899n 1.8
+    828900n 0
+    829199n 0
+    829200n 1.8
+    829299n 1.8
+    829300n 0
+    829599n 0
+    829600n 1.8
+    829699n 1.8
+    829700n 0
+    829999n 0
+    830000n 1.8
+    830099n 1.8
+    830100n 0
+    830399n 0
+    830400n 1.8
+    830499n 1.8
+    830500n 0
+    830799n 0
+    830800n 1.8
+    830899n 1.8
+    830900n 0
+    831199n 0
+    831200n 1.8
+    831299n 1.8
+    831300n 0
+    831599n 0
+    831600n 1.8
+    831699n 1.8
+    831700n 0
+    831999n 0
+    832000n 1.8
+    832099n 1.8
+    832100n 0
+    832399n 0
+    832400n 1.8
+    832499n 1.8
+    832500n 0
+    832799n 0
+    832800n 1.8
+    832899n 1.8
+    832900n 0
+    833199n 0
+    833200n 1.8
+    833299n 1.8
+    833300n 0
+    833599n 0
+    833600n 1.8
+    833699n 1.8
+    833700n 0
+    833999n 0
+    834000n 1.8
+    834099n 1.8
+    834100n 0
+    834399n 0
+    834400n 1.8
+    834499n 1.8
+    834500n 0
+    834799n 0
+    834800n 1.8
+    834899n 1.8
+    834900n 0
+    835199n 0
+    835200n 1.8
+    835299n 1.8
+    835300n 0
+    835599n 0
+    835600n 1.8
+    835699n 1.8
+    835700n 0
+    835999n 0
+    836000n 1.8
+    836099n 1.8
+    836100n 0
+    836399n 0
+    836400n 1.8
+    836499n 1.8
+    836500n 0
+    836799n 0
+    836800n 1.8
+    836899n 1.8
+    836900n 0
+    837199n 0
+    837200n 1.8
+    837299n 1.8
+    837300n 0
+    837599n 0
+    837600n 1.8
+    837699n 1.8
+    837700n 0
+    837999n 0
+    838000n 1.8
+    838099n 1.8
+    838100n 0
+    838399n 0
+    838400n 1.8
+    838499n 1.8
+    838500n 0
+    838799n 0
+    838800n 1.8
+    838899n 1.8
+    838900n 0
+    839199n 0
+    839200n 1.8
+    839299n 1.8
+    839300n 0
+    839599n 0
+    839600n 1.8
+    839699n 1.8
+    839700n 0
+    839999n 0
+    840000n 1.8
+    840099n 1.8
+    840100n 0
+    840399n 0
+    840400n 1.8
+    840499n 1.8
+    840500n 0
+    840799n 0
+    840800n 1.8
+    840899n 1.8
+    840900n 0
+    841199n 0
+    841200n 1.8
+    841299n 1.8
+    841300n 0
+    841599n 0
+    841600n 1.8
+    841699n 1.8
+    841700n 0
+    841999n 0
+    842000n 1.8
+    842099n 1.8
+    842100n 0
+    842399n 0
+    842400n 1.8
+    842499n 1.8
+    842500n 0
+    842799n 0
+    842800n 1.8
+    842899n 1.8
+    842900n 0
+    843199n 0
+    843200n 1.8
+    843299n 1.8
+    843300n 0
+    843599n 0
+    843600n 1.8
+    843699n 1.8
+    843700n 0
+    843999n 0
+    844000n 1.8
+    844099n 1.8
+    844100n 0
+    844399n 0
+    844400n 1.8
+    844499n 1.8
+    844500n 0
+    844799n 0
+    844800n 1.8
+    844899n 1.8
+    844900n 0
+    845199n 0
+    845200n 1.8
+    845299n 1.8
+    845300n 0
+    845599n 0
+    845600n 1.8
+    845699n 1.8
+    845700n 0
+    845999n 0
+    846000n 1.8
+    846099n 1.8
+    846100n 0
+    846399n 0
+    846400n 1.8
+    846499n 1.8
+    846500n 0
+    846799n 0
+    846800n 1.8
+    846899n 1.8
+    846900n 0
+    847199n 0
+    847200n 1.8
+    847299n 1.8
+    847300n 0
+    847599n 0
+    847600n 1.8
+    847699n 1.8
+    847700n 0
+    847999n 0
+    848000n 1.8
+    848099n 1.8
+    848100n 0
+    848399n 0
+    848400n 1.8
+    848499n 1.8
+    848500n 0
+    848799n 0
+    848800n 1.8
+    848899n 1.8
+    848900n 0
+    849199n 0
+    849200n 1.8
+    849299n 1.8
+    849300n 0
+    849599n 0
+    849600n 1.8
+    849699n 1.8
+    849700n 0
+    849999n 0
+    850000n 1.8
+    850099n 1.8
+    850100n 0
+    850399n 0
+    850400n 1.8
+    850499n 1.8
+    850500n 0
+    850799n 0
+    850800n 1.8
+    850899n 1.8
+    850900n 0
+    851199n 0
+    851200n 1.8
+    851299n 1.8
+    851300n 0
+    851599n 0
+    851600n 1.8
+    851699n 1.8
+    851700n 0
+    851999n 0
+    852000n 1.8
+    852099n 1.8
+    852100n 0
+    852399n 0
+    852400n 1.8
+    852499n 1.8
+    852500n 0
+    852799n 0
+    852800n 1.8
+    852899n 1.8
+    852900n 0
+    853199n 0
+    853200n 1.8
+    853299n 1.8
+    853300n 0
+    853599n 0
+    853600n 1.8
+    853699n 1.8
+    853700n 0
+    853999n 0
+    854000n 1.8
+    854099n 1.8
+    854100n 0
+    854399n 0
+    854400n 1.8
+    854499n 1.8
+    854500n 0
+    854799n 0
+    854800n 1.8
+    854899n 1.8
+    854900n 0
+    855199n 0
+    855200n 1.8
+    855299n 1.8
+    855300n 0
+    855599n 0
+    855600n 1.8
+    855699n 1.8
+    855700n 0
+    855999n 0
+    856000n 1.8
+    856099n 1.8
+    856100n 0
+    856399n 0
+    856400n 1.8
+    856499n 1.8
+    856500n 0
+    856799n 0
+    856800n 1.8
+    856899n 1.8
+    856900n 0
+    857199n 0
+    857200n 1.8
+    857299n 1.8
+    857300n 0
+    857599n 0
+    857600n 1.8
+    857699n 1.8
+    857700n 0
+    857999n 0
+    858000n 1.8
+    858099n 1.8
+    858100n 0
+    858399n 0
+    858400n 1.8
+    858499n 1.8
+    858500n 0
+    858799n 0
+    858800n 1.8
+    858899n 1.8
+    858900n 0
+    859199n 0
+    859200n 1.8
+    859299n 1.8
+    859300n 0
+    859599n 0
+    859600n 1.8
+    859699n 1.8
+    859700n 0
+    859999n 0
+    860000n 1.8
+    860099n 1.8
+    860100n 0
+    860399n 0
+    860400n 1.8
+    860499n 1.8
+    860500n 0
+    860799n 0
+    860800n 1.8
+    860899n 1.8
+    860900n 0
+    861199n 0
+    861200n 1.8
+    861299n 1.8
+    861300n 0
+    861599n 0
+    861600n 1.8
+    861699n 1.8
+    861700n 0
+    861999n 0
+    862000n 1.8
+    862099n 1.8
+    862100n 0
+    862399n 0
+    862400n 1.8
+    862499n 1.8
+    862500n 0
+    862799n 0
+    862800n 1.8
+    862899n 1.8
+    862900n 0
+    863199n 0
+    863200n 1.8
+    863299n 1.8
+    863300n 0
+    863599n 0
+    863600n 1.8
+    863699n 1.8
+    863700n 0
+    863999n 0
+    864000n 1.8
+    864099n 1.8
+    864100n 0
+    864399n 0
+    864400n 1.8
+    864499n 1.8
+    864500n 0
+    864799n 0
+    864800n 1.8
+    864899n 1.8
+    864900n 0
+    865199n 0
+    865200n 1.8
+    865299n 1.8
+    865300n 0
+    865599n 0
+    865600n 1.8
+    865699n 1.8
+    865700n 0
+    865999n 0
+    866000n 1.8
+    866099n 1.8
+    866100n 0
+    866399n 0
+    866400n 1.8
+    866499n 1.8
+    866500n 0
+    866799n 0
+    866800n 1.8
+    866899n 1.8
+    866900n 0
+    867199n 0
+    867200n 1.8
+    867299n 1.8
+    867300n 0
+    867599n 0
+    867600n 1.8
+    867699n 1.8
+    867700n 0
+    867999n 0
+    868000n 1.8
+    868099n 1.8
+    868100n 0
+    868399n 0
+    868400n 1.8
+    868499n 1.8
+    868500n 0
+    868799n 0
+    868800n 1.8
+    868899n 1.8
+    868900n 0
+    869199n 0
+    869200n 1.8
+    869299n 1.8
+    869300n 0
+    869599n 0
+    869600n 1.8
+    869699n 1.8
+    869700n 0
+    869999n 0
+    870000n 1.8
+    870099n 1.8
+    870100n 0
+    870399n 0
+    870400n 1.8
+    870499n 1.8
+    870500n 0
+    870799n 0
+    870800n 1.8
+    870899n 1.8
+    870900n 0
+    871199n 0
+    871200n 1.8
+    871299n 1.8
+    871300n 0
+    871599n 0
+    871600n 1.8
+    871699n 1.8
+    871700n 0
+    871999n 0
+    872000n 1.8
+    872099n 1.8
+    872100n 0
+    872399n 0
+    872400n 1.8
+    872499n 1.8
+    872500n 0
+    872799n 0
+    872800n 1.8
+    872899n 1.8
+    872900n 0
+    873199n 0
+    873200n 1.8
+    873299n 1.8
+    873300n 0
+    873599n 0
+    873600n 1.8
+    873699n 1.8
+    873700n 0
+    873999n 0
+    874000n 1.8
+    874099n 1.8
+    874100n 0
+    874399n 0
+    874400n 1.8
+    874499n 1.8
+    874500n 0
+    874799n 0
+    874800n 1.8
+    874899n 1.8
+    874900n 0
+    875199n 0
+    875200n 1.8
+    875299n 1.8
+    875300n 0
+    875599n 0
+    875600n 1.8
+    875699n 1.8
+    875700n 0
+    875999n 0
+    876000n 1.8
+    876099n 1.8
+    876100n 0
+    876399n 0
+    876400n 1.8
+    876499n 1.8
+    876500n 0
+    876799n 0
+    876800n 1.8
+    876899n 1.8
+    876900n 0
+    877199n 0
+    877200n 1.8
+    877299n 1.8
+    877300n 0
+    877599n 0
+    877600n 1.8
+    877699n 1.8
+    877700n 0
+    877999n 0
+    878000n 1.8
+    878099n 1.8
+    878100n 0
+    878399n 0
+    878400n 1.8
+    878499n 1.8
+    878500n 0
+    878799n 0
+    878800n 1.8
+    878899n 1.8
+    878900n 0
+    879199n 0
+    879200n 1.8
+    879299n 1.8
+    879300n 0
+    879599n 0
+    879600n 1.8
+    879699n 1.8
+    879700n 0
+    879999n 0
+    880000n 1.8
+    880099n 1.8
+    880100n 0
+    880399n 0
+    880400n 1.8
+    880499n 1.8
+    880500n 0
+    880799n 0
+    880800n 1.8
+    880899n 1.8
+    880900n 0
+    881199n 0
+    881200n 1.8
+    881299n 1.8
+    881300n 0
+    881599n 0
+    881600n 1.8
+    881699n 1.8
+    881700n 0
+    881999n 0
+    882000n 1.8
+    882099n 1.8
+    882100n 0
+    882399n 0
+    882400n 1.8
+    882499n 1.8
+    882500n 0
+    882799n 0
+    882800n 1.8
+    882899n 1.8
+    882900n 0
+    883199n 0
+    883200n 1.8
+    883299n 1.8
+    883300n 0
+    883599n 0
+    883600n 1.8
+    883699n 1.8
+    883700n 0
+    883999n 0
+    884000n 1.8
+    884099n 1.8
+    884100n 0
+    884399n 0
+    884400n 1.8
+    884499n 1.8
+    884500n 0
+    884799n 0
+    884800n 1.8
+    884899n 1.8
+    884900n 0
+    885199n 0
+    885200n 1.8
+    885299n 1.8
+    885300n 0
+    885599n 0
+    885600n 1.8
+    885699n 1.8
+    885700n 0
+    885999n 0
+    886000n 1.8
+    886099n 1.8
+    886100n 0
+    886399n 0
+    886400n 1.8
+    886499n 1.8
+    886500n 0
+    886799n 0
+    886800n 1.8
+    886899n 1.8
+    886900n 0
+    887199n 0
+    887200n 1.8
+    887299n 1.8
+    887300n 0
+    887599n 0
+    887600n 1.8
+    887699n 1.8
+    887700n 0
+    887999n 0
+    888000n 1.8
+    888099n 1.8
+    888100n 0
+    888399n 0
+    888400n 1.8
+    888499n 1.8
+    888500n 0
+    888799n 0
+    888800n 1.8
+    888899n 1.8
+    888900n 0
+    889199n 0
+    889200n 1.8
+    889299n 1.8
+    889300n 0
+    889599n 0
+    889600n 1.8
+    889699n 1.8
+    889700n 0
+    889999n 0
+    890000n 1.8
+    890099n 1.8
+    890100n 0
+    890399n 0
+    890400n 1.8
+    890499n 1.8
+    890500n 0
+    890799n 0
+    890800n 1.8
+    890899n 1.8
+    890900n 0
+    891199n 0
+    891200n 1.8
+    891299n 1.8
+    891300n 0
+    891599n 0
+    891600n 1.8
+    891699n 1.8
+    891700n 0
+    891999n 0
+    892000n 1.8
+    892099n 1.8
+    892100n 0
+    892399n 0
+    892400n 1.8
+    892499n 1.8
+    892500n 0
+    892799n 0
+    892800n 1.8
+    892899n 1.8
+    892900n 0
+    893199n 0
+    893200n 1.8
+    893299n 1.8
+    893300n 0
+    893599n 0
+    893600n 1.8
+    893699n 1.8
+    893700n 0
+    893999n 0
+    894000n 1.8
+    894099n 1.8
+    894100n 0
+    894399n 0
+    894400n 1.8
+    894499n 1.8
+    894500n 0
+    894799n 0
+    894800n 1.8
+    894899n 1.8
+    894900n 0
+    895199n 0
+    895200n 1.8
+    895299n 1.8
+    895300n 0
+    895599n 0
+    895600n 1.8
+    895699n 1.8
+    895700n 0
+    895999n 0
+    896000n 1.8
+    896099n 1.8
+    896100n 0
+    896399n 0
+    896400n 1.8
+    896499n 1.8
+    896500n 0
+    896799n 0
+    896800n 1.8
+    896899n 1.8
+    896900n 0
+    897199n 0
+    897200n 1.8
+    897299n 1.8
+    897300n 0
+    897599n 0
+    897600n 1.8
+    897699n 1.8
+    897700n 0
+    897999n 0
+    898000n 1.8
+    898099n 1.8
+    898100n 0
+    898399n 0
+    898400n 1.8
+    898499n 1.8
+    898500n 0
+    898799n 0
+    898800n 1.8
+    898899n 1.8
+    898900n 0
+    899199n 0
+    899200n 1.8
+    899299n 1.8
+    899300n 0
+    899599n 0
+    899600n 1.8
+    899699n 1.8
+    899700n 0
+    899999n 0
+    900000n 1.8
+    900099n 1.8
+    900100n 0
+    900399n 0
+    900400n 1.8
+    900499n 1.8
+    900500n 0
+    900799n 0
+    900800n 1.8
+    900899n 1.8
+    900900n 0
+    901199n 0
+    901200n 1.8
+    901299n 1.8
+    901300n 0
+    901599n 0
+    901600n 1.8
+    901699n 1.8
+    901700n 0
+    901999n 0
+    902000n 1.8
+    902099n 1.8
+    902100n 0
+    902399n 0
+    902400n 1.8
+    902499n 1.8
+    902500n 0
+    902799n 0
+    902800n 1.8
+    902899n 1.8
+    902900n 0
+    903199n 0
+    903200n 1.8
+    903299n 1.8
+    903300n 0
+    903599n 0
+    903600n 1.8
+    903699n 1.8
+    903700n 0
+    903999n 0
+    904000n 1.8
+    904099n 1.8
+    904100n 0
+    904399n 0
+    904400n 1.8
+    904499n 1.8
+    904500n 0
+    904799n 0
+    904800n 1.8
+    904899n 1.8
+    904900n 0
+    905199n 0
+    905200n 1.8
+    905299n 1.8
+    905300n 0
+    905599n 0
+    905600n 1.8
+    905699n 1.8
+    905700n 0
+    905999n 0
+    906000n 1.8
+    906099n 1.8
+    906100n 0
+    906399n 0
+    906400n 1.8
+    906499n 1.8
+    906500n 0
+    906799n 0
+    906800n 1.8
+    906899n 1.8
+    906900n 0
+    907199n 0
+    907200n 1.8
+    907299n 1.8
+    907300n 0
+    907599n 0
+    907600n 1.8
+    907699n 1.8
+    907700n 0
+    907999n 0
+    908000n 1.8
+    908099n 1.8
+    908100n 0
+    908399n 0
+    908400n 1.8
+    908499n 1.8
+    908500n 0
+    908799n 0
+    908800n 1.8
+    908899n 1.8
+    908900n 0
+    909199n 0
+    909200n 1.8
+    909299n 1.8
+    909300n 0
+    909599n 0
+    909600n 1.8
+    909699n 1.8
+    909700n 0
+    909999n 0
+    910000n 1.8
+    910099n 1.8
+    910100n 0
+    910399n 0
+    910400n 1.8
+    910499n 1.8
+    910500n 0
+    910799n 0
+    910800n 1.8
+    910899n 1.8
+    910900n 0
+    911199n 0
+    911200n 1.8
+    911299n 1.8
+    911300n 0
+    911599n 0
+    911600n 1.8
+    911699n 1.8
+    911700n 0
+    911999n 0
+    912000n 1.8
+    912099n 1.8
+    912100n 0
+    912399n 0
+    912400n 1.8
+    912499n 1.8
+    912500n 0
+    912799n 0
+    912800n 1.8
+    912899n 1.8
+    912900n 0
+    913199n 0
+    913200n 1.8
+    913299n 1.8
+    913300n 0
+    913599n 0
+    913600n 1.8
+    913699n 1.8
+    913700n 0
+    913999n 0
+    914000n 1.8
+    914099n 1.8
+    914100n 0
+    914399n 0
+    914400n 1.8
+    914499n 1.8
+    914500n 0
+    914799n 0
+    914800n 1.8
+    914899n 1.8
+    914900n 0
+    915199n 0
+    915200n 1.8
+    915299n 1.8
+    915300n 0
+    915599n 0
+    915600n 1.8
+    915699n 1.8
+    915700n 0
+    915999n 0
+    916000n 1.8
+    916099n 1.8
+    916100n 0
+    916399n 0
+    916400n 1.8
+    916499n 1.8
+    916500n 0
+    916799n 0
+    916800n 1.8
+    916899n 1.8
+    916900n 0
+    917199n 0
+    917200n 1.8
+    917299n 1.8
+    917300n 0
+    917599n 0
+    917600n 1.8
+    917699n 1.8
+    917700n 0
+    917999n 0
+    918000n 1.8
+    918099n 1.8
+    918100n 0
+    918399n 0
+    918400n 1.8
+    918499n 1.8
+    918500n 0
+    918799n 0
+    918800n 1.8
+    918899n 1.8
+    918900n 0
+    919199n 0
+    919200n 1.8
+    919299n 1.8
+    919300n 0
+    919599n 0
+    919600n 1.8
+    919699n 1.8
+    919700n 0
+    919999n 0
+    920000n 1.8
+    920099n 1.8
+    920100n 0
+    920399n 0
+    920400n 1.8
+    920499n 1.8
+    920500n 0
+    920799n 0
+    920800n 1.8
+    920899n 1.8
+    920900n 0
+    921199n 0
+    921200n 1.8
+    921299n 1.8
+    921300n 0
+    921599n 0
+    921600n 1.8
+    921699n 1.8
+    921700n 0
+    921999n 0
+    922000n 1.8
+    922099n 1.8
+    922100n 0
+    922399n 0
+    922400n 1.8
+    922499n 1.8
+    922500n 0
+    922799n 0
+    922800n 1.8
+    922899n 1.8
+    922900n 0
+    923199n 0
+    923200n 1.8
+    923299n 1.8
+    923300n 0
+    923599n 0
+    923600n 1.8
+    923699n 1.8
+    923700n 0
+    923999n 0
+    924000n 1.8
+    924099n 1.8
+    924100n 0
+    924399n 0
+    924400n 1.8
+    924499n 1.8
+    924500n 0
+    924799n 0
+    924800n 1.8
+    924899n 1.8
+    924900n 0
+    925199n 0
+    925200n 1.8
+    925299n 1.8
+    925300n 0
+    925599n 0
+    925600n 1.8
+    925699n 1.8
+    925700n 0
+    925999n 0
+    926000n 1.8
+    926099n 1.8
+    926100n 0
+    926399n 0
+    926400n 1.8
+    926499n 1.8
+    926500n 0
+    926799n 0
+    926800n 1.8
+    926899n 1.8
+    926900n 0
+    927199n 0
+    927200n 1.8
+    927299n 1.8
+    927300n 0
+    927599n 0
+    927600n 1.8
+    927699n 1.8
+    927700n 0
+    927999n 0
+    928000n 1.8
+    928099n 1.8
+    928100n 0
+    928399n 0
+    928400n 1.8
+    928499n 1.8
+    928500n 0
+    928799n 0
+    928800n 1.8
+    928899n 1.8
+    928900n 0
+    929199n 0
+    929200n 1.8
+    929299n 1.8
+    929300n 0
+    929599n 0
+    929600n 1.8
+    929699n 1.8
+    929700n 0
+    929999n 0
+    930000n 1.8
+    930099n 1.8
+    930100n 0
+    930399n 0
+    930400n 1.8
+    930499n 1.8
+    930500n 0
+    930799n 0
+    930800n 1.8
+    930899n 1.8
+    930900n 0
+    931199n 0
+    931200n 1.8
+    931299n 1.8
+    931300n 0
+    931599n 0
+    931600n 1.8
+    931699n 1.8
+    931700n 0
+    931999n 0
+    932000n 1.8
+    932099n 1.8
+    932100n 0
+    932399n 0
+    932400n 1.8
+    932499n 1.8
+    932500n 0
+    932799n 0
+    932800n 1.8
+    932899n 1.8
+    932900n 0
+    933199n 0
+    933200n 1.8
+    933299n 1.8
+    933300n 0
+    933599n 0
+    933600n 1.8
+    933699n 1.8
+    933700n 0
+    933999n 0
+    934000n 1.8
+    934099n 1.8
+    934100n 0
+    934399n 0
+    934400n 1.8
+    934499n 1.8
+    934500n 0
+    934799n 0
+    934800n 1.8
+    934899n 1.8
+    934900n 0
+    935199n 0
+    935200n 1.8
+    935299n 1.8
+    935300n 0
+    935599n 0
+    935600n 1.8
+    935699n 1.8
+    935700n 0
+    935999n 0
+    936000n 1.8
+    936099n 1.8
+    936100n 0
+    936399n 0
+    936400n 1.8
+    936499n 1.8
+    936500n 0
+    936799n 0
+    936800n 1.8
+    936899n 1.8
+    936900n 0
+    937199n 0
+    937200n 1.8
+    937299n 1.8
+    937300n 0
+    937599n 0
+    937600n 1.8
+    937699n 1.8
+    937700n 0
+    937999n 0
+    938000n 1.8
+    938099n 1.8
+    938100n 0
+    938399n 0
+    938400n 1.8
+    938499n 1.8
+    938500n 0
+    938799n 0
+    938800n 1.8
+    938899n 1.8
+    938900n 0
+    939199n 0
+    939200n 1.8
+    939299n 1.8
+    939300n 0
+    939599n 0
+    939600n 1.8
+    939699n 1.8
+    939700n 0
+    939999n 0
+    940000n 1.8
+    940099n 1.8
+    940100n 0
+    940399n 0
+    940400n 1.8
+    940499n 1.8
+    940500n 0
+    940799n 0
+    940800n 1.8
+    940899n 1.8
+    940900n 0
+    941199n 0
+    941200n 1.8
+    941299n 1.8
+    941300n 0
+    941599n 0
+    941600n 1.8
+    941699n 1.8
+    941700n 0
+    941999n 0
+    942000n 1.8
+    942099n 1.8
+    942100n 0
+    942399n 0
+    942400n 1.8
+    942499n 1.8
+    942500n 0
+    942799n 0
+    942800n 1.8
+    942899n 1.8
+    942900n 0
+    943199n 0
+    943200n 1.8
+    943299n 1.8
+    943300n 0
+    943599n 0
+    943600n 1.8
+    943699n 1.8
+    943700n 0
+    943999n 0
+    944000n 1.8
+    944099n 1.8
+    944100n 0
+    944399n 0
+    944400n 1.8
+    944499n 1.8
+    944500n 0
+    944799n 0
+    944800n 1.8
+    944899n 1.8
+    944900n 0
+    945199n 0
+    945200n 1.8
+    945299n 1.8
+    945300n 0
+    945599n 0
+    945600n 1.8
+    945699n 1.8
+    945700n 0
+    945999n 0
+    946000n 1.8
+    946099n 1.8
+    946100n 0
+    946399n 0
+    946400n 1.8
+    946499n 1.8
+    946500n 0
+    946799n 0
+    946800n 1.8
+    946899n 1.8
+    946900n 0
+    947199n 0
+    947200n 1.8
+    947299n 1.8
+    947300n 0
+    947599n 0
+    947600n 1.8
+    947699n 1.8
+    947700n 0
+    947999n 0
+    948000n 1.8
+    948099n 1.8
+    948100n 0
+    948399n 0
+    948400n 1.8
+    948499n 1.8
+    948500n 0
+    948799n 0
+    948800n 1.8
+    948899n 1.8
+    948900n 0
+    949199n 0
+    949200n 1.8
+    949299n 1.8
+    949300n 0
+    949599n 0
+    949600n 1.8
+    949699n 1.8
+    949700n 0
+    949999n 0
+    950000n 1.8
+    950099n 1.8
+    950100n 0
+    950399n 0
+    950400n 1.8
+    950499n 1.8
+    950500n 0
+    950799n 0
+    950800n 1.8
+    950899n 1.8
+    950900n 0
+    951199n 0
+    951200n 1.8
+    951299n 1.8
+    951300n 0
+    951599n 0
+    951600n 1.8
+    951699n 1.8
+    951700n 0
+    951999n 0
+    952000n 1.8
+    952099n 1.8
+    952100n 0
+    952399n 0
+    952400n 1.8
+    952499n 1.8
+    952500n 0
+    952799n 0
+    952800n 1.8
+    952899n 1.8
+    952900n 0
+    953199n 0
+    953200n 1.8
+    953299n 1.8
+    953300n 0
+    953599n 0
+    953600n 1.8
+    953699n 1.8
+    953700n 0
+    953999n 0
+    954000n 1.8
+    954099n 1.8
+    954100n 0
+    954399n 0
+    954400n 1.8
+    954499n 1.8
+    954500n 0
+    954799n 0
+    954800n 1.8
+    954899n 1.8
+    954900n 0
+    955199n 0
+    955200n 1.8
+    955299n 1.8
+    955300n 0
+    955599n 0
+    955600n 1.8
+    955699n 1.8
+    955700n 0
+    955999n 0
+    956000n 1.8
+    956099n 1.8
+    956100n 0
+    956399n 0
+    956400n 1.8
+    956499n 1.8
+    956500n 0
+    956799n 0
+    956800n 1.8
+    956899n 1.8
+    956900n 0
+    957199n 0
+    957200n 1.8
+    957299n 1.8
+    957300n 0
+    957599n 0
+    957600n 1.8
+    957699n 1.8
+    957700n 0
+    957999n 0
+    958000n 1.8
+    958099n 1.8
+    958100n 0
+    958399n 0
+    958400n 1.8
+    958499n 1.8
+    958500n 0
+    958799n 0
+    958800n 1.8
+    958899n 1.8
+    958900n 0
+    959199n 0
+    959200n 1.8
+    959299n 1.8
+    959300n 0
+    959599n 0
+    959600n 1.8
+    959699n 1.8
+    959700n 0
+    959999n 0
+    960000n 1.8
+    960099n 1.8
+    960100n 0
+    960399n 0
+    960400n 1.8
+    960499n 1.8
+    960500n 0
+    960799n 0
+    960800n 1.8
+    960899n 1.8
+    960900n 0
+    961199n 0
+    961200n 1.8
+    961299n 1.8
+    961300n 0
+    961599n 0
+    961600n 1.8
+    961699n 1.8
+    961700n 0
+    961999n 0
+    962000n 1.8
+    962099n 1.8
+    962100n 0
+    962399n 0
+    962400n 1.8
+    962499n 1.8
+    962500n 0
+    962799n 0
+    962800n 1.8
+    962899n 1.8
+    962900n 0
+    963199n 0
+    963200n 1.8
+    963299n 1.8
+    963300n 0
+    963599n 0
+    963600n 1.8
+    963699n 1.8
+    963700n 0
+    963999n 0
+    964000n 1.8
+    964099n 1.8
+    964100n 0
+    964399n 0
+    964400n 1.8
+    964499n 1.8
+    964500n 0
+    964799n 0
+    964800n 1.8
+    964899n 1.8
+    964900n 0
+    965199n 0
+    965200n 1.8
+    965299n 1.8
+    965300n 0
+    965599n 0
+    965600n 1.8
+    965699n 1.8
+    965700n 0
+    965999n 0
+    966000n 1.8
+    966099n 1.8
+    966100n 0
+    966399n 0
+    966400n 1.8
+    966499n 1.8
+    966500n 0
+    966799n 0
+    966800n 1.8
+    966899n 1.8
+    966900n 0
+    967199n 0
+    967200n 1.8
+    967299n 1.8
+    967300n 0
+    967599n 0
+    967600n 1.8
+    967699n 1.8
+    967700n 0
+    967999n 0
+    968000n 1.8
+    968099n 1.8
+    968100n 0
+    968399n 0
+    968400n 1.8
+    968499n 1.8
+    968500n 0
+    968799n 0
+    968800n 1.8
+    968899n 1.8
+    968900n 0
+    969199n 0
+    969200n 1.8
+    969299n 1.8
+    969300n 0
+    969599n 0
+    969600n 1.8
+    969699n 1.8
+    969700n 0
+    969999n 0
+    970000n 1.8
+    970099n 1.8
+    970100n 0
+    970399n 0
+    970400n 1.8
+    970499n 1.8
+    970500n 0
+    970799n 0
+    970800n 1.8
+    970899n 1.8
+    970900n 0
+    971199n 0
+    971200n 1.8
+    971299n 1.8
+    971300n 0
+    971599n 0
+    971600n 1.8
+    971699n 1.8
+    971700n 0
+    971999n 0
+    972000n 1.8
+    972099n 1.8
+    972100n 0
+    972399n 0
+    972400n 1.8
+    972499n 1.8
+    972500n 0
+    972799n 0
+    972800n 1.8
+    972899n 1.8
+    972900n 0
+    973199n 0
+    973200n 1.8
+    973299n 1.8
+    973300n 0
+    973599n 0
+    973600n 1.8
+    973699n 1.8
+    973700n 0
+    973999n 0
+    974000n 1.8
+    974099n 1.8
+    974100n 0
+    974399n 0
+    974400n 1.8
+    974499n 1.8
+    974500n 0
+    974799n 0
+    974800n 1.8
+    974899n 1.8
+    974900n 0
+    975199n 0
+    975200n 1.8
+    975299n 1.8
+    975300n 0
+    975599n 0
+    975600n 1.8
+    975699n 1.8
+    975700n 0
+    975999n 0
+    976000n 1.8
+    976099n 1.8
+    976100n 0
+    976399n 0
+    976400n 1.8
+    976499n 1.8
+    976500n 0
+    976799n 0
+    976800n 1.8
+    976899n 1.8
+    976900n 0
+    977199n 0
+    977200n 1.8
+    977299n 1.8
+    977300n 0
+    977599n 0
+    977600n 1.8
+    977699n 1.8
+    977700n 0
+    977999n 0
+    978000n 1.8
+    978099n 1.8
+    978100n 0
+    978399n 0
+    978400n 1.8
+    978499n 1.8
+    978500n 0
+    978799n 0
+    978800n 1.8
+    978899n 1.8
+    978900n 0
+    979199n 0
+    979200n 1.8
+    979299n 1.8
+    979300n 0
+    979599n 0
+    979600n 1.8
+    979699n 1.8
+    979700n 0
+    979999n 0
+    980000n 1.8
+    980099n 1.8
+    980100n 0
+    980399n 0
+    980400n 1.8
+    980499n 1.8
+    980500n 0
+    980799n 0
+    980800n 1.8
+    980899n 1.8
+    980900n 0
+    981199n 0
+    981200n 1.8
+    981299n 1.8
+    981300n 0
+    981599n 0
+    981600n 1.8
+    981699n 1.8
+    981700n 0
+    981999n 0
+    982000n 1.8
+    982099n 1.8
+    982100n 0
+    982399n 0
+    982400n 1.8
+    982499n 1.8
+    982500n 0
+    982799n 0
+    982800n 1.8
+    982899n 1.8
+    982900n 0
+    983199n 0
+    983200n 1.8
+    983299n 1.8
+    983300n 0
+    983599n 0
+    983600n 1.8
+    983699n 1.8
+    983700n 0
+    983999n 0
+    984000n 1.8
+    984099n 1.8
+    984100n 0
+    984399n 0
+    984400n 1.8
+    984499n 1.8
+    984500n 0
+    984799n 0
+    984800n 1.8
+    984899n 1.8
+    984900n 0
+    985199n 0
+    985200n 1.8
+    985299n 1.8
+    985300n 0
+    985599n 0
+    985600n 1.8
+    985699n 1.8
+    985700n 0
+    985999n 0
+    986000n 1.8
+    986099n 1.8
+    986100n 0
+    986399n 0
+    986400n 1.8
+    986499n 1.8
+    986500n 0
+    986799n 0
+    986800n 1.8
+    986899n 1.8
+    986900n 0
+    987199n 0
+    987200n 1.8
+    987299n 1.8
+    987300n 0
+    987599n 0
+    987600n 1.8
+    987699n 1.8
+    987700n 0
+    987999n 0
+    988000n 1.8
+    988099n 1.8
+    988100n 0
+    988399n 0
+    988400n 1.8
+    988499n 1.8
+    988500n 0
+    988799n 0
+    988800n 1.8
+    988899n 1.8
+    988900n 0
+    989199n 0
+    989200n 1.8
+    989299n 1.8
+    989300n 0
+    989599n 0
+    989600n 1.8
+    989699n 1.8
+    989700n 0
+    989999n 0
+    990000n 1.8
+    990099n 1.8
+    990100n 0
+    990399n 0
+    990400n 1.8
+    990499n 1.8
+    990500n 0
+    990799n 0
+    990800n 1.8
+    990899n 1.8
+    990900n 0
+    991199n 0
+    991200n 1.8
+    991299n 1.8
+    991300n 0
+    991599n 0
+    991600n 1.8
+    991699n 1.8
+    991700n 0
+    991999n 0
+    992000n 1.8
+    992099n 1.8
+    992100n 0
+    992399n 0
+    992400n 1.8
+    992499n 1.8
+    992500n 0
+    992799n 0
+    992800n 1.8
+    992899n 1.8
+    992900n 0
+    993199n 0
+    993200n 1.8
+    993299n 1.8
+    993300n 0
+    993599n 0
+    993600n 1.8
+    993699n 1.8
+    993700n 0
+    993999n 0
+    994000n 1.8
+    994099n 1.8
+    994100n 0
+    994399n 0
+    994400n 1.8
+    994499n 1.8
+    994500n 0
+    994799n 0
+    994800n 1.8
+    994899n 1.8
+    994900n 0
+    995199n 0
+    995200n 1.8
+    995299n 1.8
+    995300n 0
+    995599n 0
+    995600n 1.8
+    995699n 1.8
+    995700n 0
+    995999n 0
+    996000n 1.8
+    996099n 1.8
+    996100n 0
+    996399n 0
+    996400n 1.8
+    996499n 1.8
+    996500n 0
+    996799n 0
+    996800n 1.8
+    996899n 1.8
+    996900n 0
+    997199n 0
+    997200n 1.8
+    997299n 1.8
+    997300n 0
+    997599n 0
+    997600n 1.8
+    997699n 1.8
+    997700n 0
+    997999n 0
+    998000n 1.8
+    998099n 1.8
+    998100n 0
+    998399n 0
+    998400n 1.8
+    998499n 1.8
+    998500n 0
+    998799n 0
+    998800n 1.8
+    998899n 1.8
+    998900n 0
+    999199n 0
+    999200n 1.8
+    999299n 1.8
+    999300n 0
+    999599n 0
+    999600n 1.8
+    999699n 1.8
+    999700n 0
+    999999n 0
+    1000000n 1.8
+    1000099n 1.8
+    1000100n 0
+    1000399n 0
+    1000400n 1.8
+    1000499n 1.8
+    1000500n 0
+    1000799n 0
+    1000800n 1.8
+    1000899n 1.8
+    1000900n 0
+    1001199n 0
+    1001200n 1.8
+    1001299n 1.8
+    1001300n 0
+    1001599n 0
+    1001600n 1.8
+    1001699n 1.8
+    1001700n 0
+    1001999n 0
+    1002000n 1.8
+    1002099n 1.8
+    1002100n 0
+    1002399n 0
+    1002400n 1.8
+    1002499n 1.8
+    1002500n 0
+    1002799n 0
+    1002800n 1.8
+    1002899n 1.8
+    1002900n 0
+    1003199n 0
+    1003200n 1.8
+    1003299n 1.8
+    1003300n 0
+    1003599n 0
+    1003600n 1.8
+    1003699n 1.8
+    1003700n 0
+    1003999n 0
+    1004000n 1.8
+    1004099n 1.8
+    1004100n 0
+    1004399n 0
+    1004400n 1.8
+    1004499n 1.8
+    1004500n 0
+    1004799n 0
+    1004800n 1.8
+    1004899n 1.8
+    1004900n 0
+    1005199n 0
+    1005200n 1.8
+    1005299n 1.8
+    1005300n 0
+    1005599n 0
+    1005600n 1.8
+    1005699n 1.8
+    1005700n 0
+    1005999n 0
+    1006000n 1.8
+    1006099n 1.8
+    1006100n 0
+    1006399n 0
+    1006400n 1.8
+    1006499n 1.8
+    1006500n 0
+    1006799n 0
+    1006800n 1.8
+    1006899n 1.8
+    1006900n 0
+    1007199n 0
+    1007200n 1.8
+    1007299n 1.8
+    1007300n 0
+    1007599n 0
+    1007600n 1.8
+    1007699n 1.8
+    1007700n 0
+    1007999n 0
+    1008000n 1.8
+    1008099n 1.8
+    1008100n 0
+    1008399n 0
+    1008400n 1.8
+    1008499n 1.8
+    1008500n 0
+    1008799n 0
+    1008800n 1.8
+    1008899n 1.8
+    1008900n 0
+    1009199n 0
+    1009200n 1.8
+    1009299n 1.8
+    1009300n 0
+    1009599n 0
+    1009600n 1.8
+    1009699n 1.8
+    1009700n 0
+    1009999n 0
+    1010000n 1.8
+    1010099n 1.8
+    1010100n 0
+    1010399n 0
+    1010400n 1.8
+    1010499n 1.8
+    1010500n 0
+    1010799n 0
+    1010800n 1.8
+    1010899n 1.8
+    1010900n 0
+    1011199n 0
+    1011200n 1.8
+    1011299n 1.8
+    1011300n 0
+    1011599n 0
+    1011600n 1.8
+    1011699n 1.8
+    1011700n 0
+    1011999n 0
+    1012000n 1.8
+    1012099n 1.8
+    1012100n 0
+    1012399n 0
+    1012400n 1.8
+    1012499n 1.8
+    1012500n 0
+    1012799n 0
+    1012800n 1.8
+    1012899n 1.8
+    1012900n 0
+    1013199n 0
+    1013200n 1.8
+    1013299n 1.8
+    1013300n 0
+    1013599n 0
+    1013600n 1.8
+    1013699n 1.8
+    1013700n 0
+    1013999n 0
+    1014000n 1.8
+    1014099n 1.8
+    1014100n 0
+    1014399n 0
+    1014400n 1.8
+    1014499n 1.8
+    1014500n 0
+    1014799n 0
+    1014800n 1.8
+    1014899n 1.8
+    1014900n 0
+    1015199n 0
+    1015200n 1.8
+    1015299n 1.8
+    1015300n 0
+    1015599n 0
+    1015600n 1.8
+    1015699n 1.8
+    1015700n 0
+    1015999n 0
+    1016000n 1.8
+    1016099n 1.8
+    1016100n 0
+    1016399n 0
+    1016400n 1.8
+    1016499n 1.8
+    1016500n 0
+    1016799n 0
+    1016800n 1.8
+    1016899n 1.8
+    1016900n 0
+    1017199n 0
+    1017200n 1.8
+    1017299n 1.8
+    1017300n 0
+    1017599n 0
+    1017600n 1.8
+    1017699n 1.8
+    1017700n 0
+    1017999n 0
+    1018000n 1.8
+    1018099n 1.8
+    1018100n 0
+    1018399n 0
+    1018400n 1.8
+    1018499n 1.8
+    1018500n 0
+    1018799n 0
+    1018800n 1.8
+    1018899n 1.8
+    1018900n 0
+    1019199n 0
+    1019200n 1.8
+    1019299n 1.8
+    1019300n 0
+    1019599n 0
+    1019600n 1.8
+    1019699n 1.8
+    1019700n 0
+    1019999n 0
+    1020000n 1.8
+    1020099n 1.8
+    1020100n 0
+    1020399n 0
+    1020400n 1.8
+    1020499n 1.8
+    1020500n 0
+    1020799n 0
+    1020800n 1.8
+    1020899n 1.8
+    1020900n 0
+    1021199n 0
+    1021200n 1.8
+    1021299n 1.8
+    1021300n 0
+    1021599n 0
+    1021600n 1.8
+    1021699n 1.8
+    1021700n 0
+    1021999n 0
+    1022000n 1.8
+    1022099n 1.8
+    1022100n 0
+    1022399n 0
+    1022400n 1.8
+    1022499n 1.8
+    1022500n 0
+    1022799n 0
+    1022800n 1.8
+    1022899n 1.8
+    1022900n 0
+    1023199n 0
+    1023200n 1.8
+    1023299n 1.8
+    1023300n 0
+    1023599n 0
+    1023600n 1.8
+    1023699n 1.8
+    1023700n 0
+    1023999n 0
+    1024000n 1.8
+    1024099n 1.8
+    1024100n 0
+    1024399n 0
+    1024400n 1.8
+    1024499n 1.8
+    1024500n 0
+    1024799n 0
+    1024800n 1.8
+    1024899n 1.8
+    1024900n 0
+    1025199n 0
+    1025200n 1.8
+    1025299n 1.8
+    1025300n 0
+    1025599n 0
+    1025600n 1.8
+    1025699n 1.8
+    1025700n 0
+    1025999n 0
+    1026000n 1.8
+    1026099n 1.8
+    1026100n 0
+    1026399n 0
+    1026400n 1.8
+    1026499n 1.8
+    1026500n 0
+    1026799n 0
+    1026800n 1.8
+    1026899n 1.8
+    1026900n 0
+    1027199n 0
+    1027200n 1.8
+    1027299n 1.8
+    1027300n 0
+    1027599n 0
+    1027600n 1.8
+    1027699n 1.8
+    1027700n 0
+    1027999n 0
+    1028000n 1.8
+    1028099n 1.8
+    1028100n 0
+    1028399n 0
+    1028400n 1.8
+    1028499n 1.8
+    1028500n 0
+    1028799n 0
+    1028800n 1.8
+    1028899n 1.8
+    1028900n 0
+    1029199n 0
+    1029200n 1.8
+    1029299n 1.8
+    1029300n 0
+    1029599n 0
+    1029600n 1.8
+    1029699n 1.8
+    1029700n 0
+    1029999n 0
+    1030000n 1.8
+    1030099n 1.8
+    1030100n 0
+    1030399n 0
+    1030400n 1.8
+    1030499n 1.8
+    1030500n 0
+    1030799n 0
+    1030800n 1.8
+    1030899n 1.8
+    1030900n 0
+    1031199n 0
+    1031200n 1.8
+    1031299n 1.8
+    1031300n 0
+    1031599n 0
+    1031600n 1.8
+    1031699n 1.8
+    1031700n 0
+    1031999n 0
+    1032000n 1.8
+    1032099n 1.8
+    1032100n 0
+    1032399n 0
+    1032400n 1.8
+    1032499n 1.8
+    1032500n 0
+    1032799n 0
+    1032800n 1.8
+    1032899n 1.8
+    1032900n 0
+    1033199n 0
+    1033200n 1.8
+    1033299n 1.8
+    1033300n 0
+    1033599n 0
+    1033600n 1.8
+    1033699n 1.8
+    1033700n 0
+    1033999n 0
+    1034000n 1.8
+    1034099n 1.8
+    1034100n 0
+    1034399n 0
+    1034400n 1.8
+    1034499n 1.8
+    1034500n 0
+    1034799n 0
+    1034800n 1.8
+    1034899n 1.8
+    1034900n 0
+    1035199n 0
+    1035200n 1.8
+    1035299n 1.8
+    1035300n 0
+    1035599n 0
+    1035600n 1.8
+    1035699n 1.8
+    1035700n 0
+    1035999n 0
+    1036000n 1.8
+    1036099n 1.8
+    1036100n 0
+    1036399n 0
+    1036400n 1.8
+    1036499n 1.8
+    1036500n 0
+    1036799n 0
+    1036800n 1.8
+    1036899n 1.8
+    1036900n 0
+    1037199n 0
+    1037200n 1.8
+    1037299n 1.8
+    1037300n 0
+    1037599n 0
+    1037600n 1.8
+    1037699n 1.8
+    1037700n 0
+    1037999n 0
+    1038000n 1.8
+    1038099n 1.8
+    1038100n 0
+    1038399n 0
+    1038400n 1.8
+    1038499n 1.8
+    1038500n 0
+    1038799n 0
+    1038800n 1.8
+    1038899n 1.8
+    1038900n 0
+    1039199n 0
+    1039200n 1.8
+    1039299n 1.8
+    1039300n 0
+    1039599n 0
+    1039600n 1.8
+    1039699n 1.8
+    1039700n 0
+    1039999n 0
+    1040000n 1.8
+    1040099n 1.8
+    1040100n 0
+    1040399n 0
+    1040400n 1.8
+    1040499n 1.8
+    1040500n 0
+    1040799n 0
+    1040800n 1.8
+    1040899n 1.8
+    1040900n 0
+    1041199n 0
+    1041200n 1.8
+    1041299n 1.8
+    1041300n 0
+    1041599n 0
+    1041600n 1.8
+    1041699n 1.8
+    1041700n 0
+    1041999n 0
+    1042000n 1.8
+    1042099n 1.8
+    1042100n 0
+    1042399n 0
+    1042400n 1.8
+    1042499n 1.8
+    1042500n 0
+    1042799n 0
+    1042800n 1.8
+    1042899n 1.8
+    1042900n 0
+    1043199n 0
+    1043200n 1.8
+    1043299n 1.8
+    1043300n 0
+    1043599n 0
+    1043600n 1.8
+    1043699n 1.8
+    1043700n 0
+    1043999n 0
+    1044000n 1.8
+    1044099n 1.8
+    1044100n 0
+    1044399n 0
+    1044400n 1.8
+    1044499n 1.8
+    1044500n 0
+    1044799n 0
+    1044800n 1.8
+    1044899n 1.8
+    1044900n 0
+    1045199n 0
+    1045200n 1.8
+    1045299n 1.8
+    1045300n 0
+    1045599n 0
+    1045600n 1.8
+    1045699n 1.8
+    1045700n 0
+    1045999n 0
+    1046000n 1.8
+    1046099n 1.8
+    1046100n 0
+    1046399n 0
+    1046400n 1.8
+    1046499n 1.8
+    1046500n 0
+    1046799n 0
+    1046800n 1.8
+    1046899n 1.8
+    1046900n 0
+    1047199n 0
+    1047200n 1.8
+    1047299n 1.8
+    1047300n 0
+    1047599n 0
+    1047600n 1.8
+    1047699n 1.8
+    1047700n 0
+    1047999n 0
+    1048000n 1.8
+    1048099n 1.8
+    1048100n 0
+    1048399n 0
+    1048400n 1.8
+    1048499n 1.8
+    1048500n 0
+    1048799n 0
+    1048800n 1.8
+    1048899n 1.8
+    1048900n 0
+    1049199n 0
+    1049200n 1.8
+    1049299n 1.8
+    1049300n 0
+    1049599n 0
+    1049600n 1.8
+    1049699n 1.8
+    1049700n 0
+    1049999n 0
+    1050000n 1.8
+    1050099n 1.8
+    1050100n 0
+    1050399n 0
+    1050400n 1.8
+    1050499n 1.8
+    1050500n 0
+    1050799n 0
+    1050800n 1.8
+    1050899n 1.8
+    1050900n 0
+    1051199n 0
+    1051200n 1.8
+    1051299n 1.8
+    1051300n 0
+    1051599n 0
+    1051600n 1.8
+    1051699n 1.8
+    1051700n 0
+    1051999n 0
+    1052000n 1.8
+    1052099n 1.8
+    1052100n 0
+    1052399n 0
+    1052400n 1.8
+    1052499n 1.8
+    1052500n 0
+    1052799n 0
+    1052800n 1.8
+    1052899n 1.8
+    1052900n 0
+    1053199n 0
+    1053200n 1.8
+    1053299n 1.8
+    1053300n 0
+    1053599n 0
+    1053600n 1.8
+    1053699n 1.8
+    1053700n 0
+    1053999n 0
+    1054000n 1.8
+    1054099n 1.8
+    1054100n 0
+    1054399n 0
+    1054400n 1.8
+    1054499n 1.8
+    1054500n 0
+    1054799n 0
+    1054800n 1.8
+    1054899n 1.8
+    1054900n 0
+    1055199n 0
+    1055200n 1.8
+    1055299n 1.8
+    1055300n 0
+    1055599n 0
+    1055600n 1.8
+    1055699n 1.8
+    1055700n 0
+    1055999n 0
+    1056000n 1.8
+    1056099n 1.8
+    1056100n 0
+    1056399n 0
+    1056400n 1.8
+    1056499n 1.8
+    1056500n 0
+    1056799n 0
+    1056800n 1.8
+    1056899n 1.8
+    1056900n 0
+    1057199n 0
+    1057200n 1.8
+    1057299n 1.8
+    1057300n 0
+    1057599n 0
+    1057600n 1.8
+    1057699n 1.8
+    1057700n 0
+    1057999n 0
+    1058000n 1.8
+    1058099n 1.8
+    1058100n 0
+    1058399n 0
+    1058400n 1.8
+    1058499n 1.8
+    1058500n 0
+    1058799n 0
+    1058800n 1.8
+    1058899n 1.8
+    1058900n 0
+    1059199n 0
+    1059200n 1.8
+    1059299n 1.8
+    1059300n 0
+    1059599n 0
+    1059600n 1.8
+    1059699n 1.8
+    1059700n 0
+    1059999n 0
+    1060000n 1.8
+    1060099n 1.8
+    1060100n 0
+    1060399n 0
+    1060400n 1.8
+    1060499n 1.8
+    1060500n 0
+    1060799n 0
+    1060800n 1.8
+    1060899n 1.8
+    1060900n 0
+    1061199n 0
+    1061200n 1.8
+    1061299n 1.8
+    1061300n 0
+    1061599n 0
+    1061600n 1.8
+    1061699n 1.8
+    1061700n 0
+    1061999n 0
+    1062000n 1.8
+    1062099n 1.8
+    1062100n 0
+    1062399n 0
+    1062400n 1.8
+    1062499n 1.8
+    1062500n 0
+    1062799n 0
+    1062800n 1.8
+    1062899n 1.8
+    1062900n 0
+    1063199n 0
+    1063200n 1.8
+    1063299n 1.8
+    1063300n 0
+    1063599n 0
+    1063600n 1.8
+    1063699n 1.8
+    1063700n 0
+    1063999n 0
+    1064000n 1.8
+    1064099n 1.8
+    1064100n 0
+    1064399n 0
+    1064400n 1.8
+    1064499n 1.8
+    1064500n 0
+    1064799n 0
+    1064800n 1.8
+    1064899n 1.8
+    1064900n 0
+    1065199n 0
+    1065200n 1.8
+    1065299n 1.8
+    1065300n 0
+    1065599n 0
+    1065600n 1.8
+    1065699n 1.8
+    1065700n 0
+    1065999n 0
+    1066000n 1.8
+    1066099n 1.8
+    1066100n 0
+    1066399n 0
+    1066400n 1.8
+    1066499n 1.8
+    1066500n 0
+    1066799n 0
+    1066800n 1.8
+    1066899n 1.8
+    1066900n 0
+    1067199n 0
+    1067200n 1.8
+    1067299n 1.8
+    1067300n 0
+    1067599n 0
+    1067600n 1.8
+    1067699n 1.8
+    1067700n 0
+    1067999n 0
+    1068000n 1.8
+    1068099n 1.8
+    1068100n 0
+    1068399n 0
+    1068400n 1.8
+    1068499n 1.8
+    1068500n 0
+    1068799n 0
+    1068800n 1.8
+    1068899n 1.8
+    1068900n 0
+    1069199n 0
+    1069200n 1.8
+    1069299n 1.8
+    1069300n 0
+    1069599n 0
+    1069600n 1.8
+    1069699n 1.8
+    1069700n 0
+    1069999n 0
+    1070000n 1.8
+    1070099n 1.8
+    1070100n 0
+    1070399n 0
+    1070400n 1.8
+    1070499n 1.8
+    1070500n 0
+    1070799n 0
+    1070800n 1.8
+    1070899n 1.8
+    1070900n 0
+    1071199n 0
+    1071200n 1.8
+    1071299n 1.8
+    1071300n 0
+    1071599n 0
+    1071600n 1.8
+    1071699n 1.8
+    1071700n 0
+    1071999n 0
+    1072000n 1.8
+    1072099n 1.8
+    1072100n 0
+    1072399n 0
+    1072400n 1.8
+    1072499n 1.8
+    1072500n 0
+    1072799n 0
+    1072800n 1.8
+    1072899n 1.8
+    1072900n 0
+    1073199n 0
+    1073200n 1.8
+    1073299n 1.8
+    1073300n 0
+    1073599n 0
+    1073600n 1.8
+    1073699n 1.8
+    1073700n 0
+    1073999n 0
+    1074000n 1.8
+    1074099n 1.8
+    1074100n 0
+    1074399n 0
+    1074400n 1.8
+    1074499n 1.8
+    1074500n 0
+    1074799n 0
+    1074800n 1.8
+    1074899n 1.8
+    1074900n 0
+    1075199n 0
+    1075200n 1.8
+    1075299n 1.8
+    1075300n 0
+    1075599n 0
+    1075600n 1.8
+    1075699n 1.8
+    1075700n 0
+    1075999n 0
+    1076000n 1.8
+    1076099n 1.8
+    1076100n 0
+    1076399n 0
+    1076400n 1.8
+    1076499n 1.8
+    1076500n 0
+    1076799n 0
+    1076800n 1.8
+    1076899n 1.8
+    1076900n 0
+    1077199n 0
+    1077200n 1.8
+    1077299n 1.8
+    1077300n 0
+    1077599n 0
+    1077600n 1.8
+    1077699n 1.8
+    1077700n 0
+    1077999n 0
+    1078000n 1.8
+    1078099n 1.8
+    1078100n 0
+    1078399n 0
+    1078400n 1.8
+    1078499n 1.8
+    1078500n 0
+    1078799n 0
+    1078800n 1.8
+    1078899n 1.8
+    1078900n 0
+    1079199n 0
+    1079200n 1.8
+    1079299n 1.8
+    1079300n 0
+    1079599n 0
+    1079600n 1.8
+    1079699n 1.8
+    1079700n 0
+    1079999n 0
+    1080000n 1.8
+    1080099n 1.8
+    1080100n 0
+    1080399n 0
+    1080400n 1.8
+    1080499n 1.8
+    1080500n 0
+    1080799n 0
+    1080800n 1.8
+    1080899n 1.8
+    1080900n 0
+    1081199n 0
+    1081200n 1.8
+    1081299n 1.8
+    1081300n 0
+    1081599n 0
+    1081600n 1.8
+    1081699n 1.8
+    1081700n 0
+    1081999n 0
+    1082000n 1.8
+    1082099n 1.8
+    1082100n 0
+    1082399n 0
+    1082400n 1.8
+    1082499n 1.8
+    1082500n 0
+    1082799n 0
+    1082800n 1.8
+    1082899n 1.8
+    1082900n 0
+    1083199n 0
+    1083200n 1.8
+    1083299n 1.8
+    1083300n 0
+    1083599n 0
+    1083600n 1.8
+    1083699n 1.8
+    1083700n 0
+    1083999n 0
+    1084000n 1.8
+    1084099n 1.8
+    1084100n 0
+    1084399n 0
+    1084400n 1.8
+    1084499n 1.8
+    1084500n 0
+    1084799n 0
+    1084800n 1.8
+    1084899n 1.8
+    1084900n 0
+    1085199n 0
+    1085200n 1.8
+    1085299n 1.8
+    1085300n 0
+    1085599n 0
+    1085600n 1.8
+    1085699n 1.8
+    1085700n 0
+    1085999n 0
+    1086000n 1.8
+    1086099n 1.8
+    1086100n 0
+    1086399n 0
+    1086400n 1.8
+    1086499n 1.8
+    1086500n 0
+    1086799n 0
+    1086800n 1.8
+    1086899n 1.8
+    1086900n 0
+    1087199n 0
+    1087200n 1.8
+    1087299n 1.8
+    1087300n 0
+    1087599n 0
+    1087600n 1.8
+    1087699n 1.8
+    1087700n 0
+    1087999n 0
+    1088000n 1.8
+    1088099n 1.8
+    1088100n 0
+    1088399n 0
+    1088400n 1.8
+    1088499n 1.8
+    1088500n 0
+    1088799n 0
+    1088800n 1.8
+    1088899n 1.8
+    1088900n 0
+    1089199n 0
+    1089200n 1.8
+    1089299n 1.8
+    1089300n 0
+    1089599n 0
+    1089600n 1.8
+    1089699n 1.8
+    1089700n 0
+    1089999n 0
+    1090000n 1.8
+    1090099n 1.8
+    1090100n 0
+    1090399n 0
+    1090400n 1.8
+    1090499n 1.8
+    1090500n 0
+    1090799n 0
+    1090800n 1.8
+    1090899n 1.8
+    1090900n 0
+    1091199n 0
+    1091200n 1.8
+    1091299n 1.8
+    1091300n 0
+    1091599n 0
+    1091600n 1.8
+    1091699n 1.8
+    1091700n 0
+    1091999n 0
+    1092000n 1.8
+    1092099n 1.8
+    1092100n 0
+    1092399n 0
+    1092400n 1.8
+    1092499n 1.8
+    1092500n 0
+    1092799n 0
+    1092800n 1.8
+    1092899n 1.8
+    1092900n 0
+    1093199n 0
+    1093200n 1.8
+    1093299n 1.8
+    1093300n 0
+    1093599n 0
+    1093600n 1.8
+    1093699n 1.8
+    1093700n 0
+    1093999n 0
+    1094000n 1.8
+    1094099n 1.8
+    1094100n 0
+    1094399n 0
+    1094400n 1.8
+    1094499n 1.8
+    1094500n 0
+    1094799n 0
+    1094800n 1.8
+    1094899n 1.8
+    1094900n 0
+    1095199n 0
+    1095200n 1.8
+    1095299n 1.8
+    1095300n 0
+    1095599n 0
+    1095600n 1.8
+    1095699n 1.8
+    1095700n 0
+    1095999n 0
+    1096000n 1.8
+    1096099n 1.8
+    1096100n 0
+    1096399n 0
+    1096400n 1.8
+    1096499n 1.8
+    1096500n 0
+    1096799n 0
+    1096800n 1.8
+    1096899n 1.8
+    1096900n 0
+    1097199n 0
+    1097200n 1.8
+    1097299n 1.8
+    1097300n 0
+    1097599n 0
+    1097600n 1.8
+    1097699n 1.8
+    1097700n 0
+    1097999n 0
+    1098000n 1.8
+    1098099n 1.8
+    1098100n 0
+    1098399n 0
+    1098400n 1.8
+    1098499n 1.8
+    1098500n 0
+    1098799n 0
+    1098800n 1.8
+    1098899n 1.8
+    1098900n 0
+    1099199n 0
+    1099200n 1.8
+    1099299n 1.8
+    1099300n 0
+    1099599n 0
+    1099600n 1.8
+    1099699n 1.8
+    1099700n 0
+    1099999n 0
+    1100000n 1.8
+    1100099n 1.8
+    1100100n 0
+    1100399n 0
+    1100400n 1.8
+    1100499n 1.8
+    1100500n 0
+    1100799n 0
+    1100800n 1.8
+    1100899n 1.8
+    1100900n 0
+    1101199n 0
+    1101200n 1.8
+    1101299n 1.8
+    1101300n 0
+    1101599n 0
+    1101600n 1.8
+    1101699n 1.8
+    1101700n 0
+    1101999n 0
+    1102000n 1.8
+    1102099n 1.8
+    1102100n 0
+    1102399n 0
+    1102400n 1.8
+    1102499n 1.8
+    1102500n 0
+    1102799n 0
+    1102800n 1.8
+    1102899n 1.8
+    1102900n 0
+    1103199n 0
+    1103200n 1.8
+    1103299n 1.8
+    1103300n 0
+    1103599n 0
+    1103600n 1.8
+    1103699n 1.8
+    1103700n 0
+    1103999n 0
+    1104000n 1.8
+    1104099n 1.8
+    1104100n 0
+    1104399n 0
+    1104400n 1.8
+    1104499n 1.8
+    1104500n 0
+    1104799n 0
+    1104800n 1.8
+    1104899n 1.8
+    1104900n 0
+    1105199n 0
+    1105200n 1.8
+    1105299n 1.8
+    1105300n 0
+    1105599n 0
+    1105600n 1.8
+    1105699n 1.8
+    1105700n 0
+    1105999n 0
+    1106000n 1.8
+    1106099n 1.8
+    1106100n 0
+    1106399n 0
+    1106400n 1.8
+    1106499n 1.8
+    1106500n 0
+    1106799n 0
+    1106800n 1.8
+    1106899n 1.8
+    1106900n 0
+    1107199n 0
+    1107200n 1.8
+    1107299n 1.8
+    1107300n 0
+    1107599n 0
+    1107600n 1.8
+    1107699n 1.8
+    1107700n 0
+    1107999n 0
+    1108000n 1.8
+    1108099n 1.8
+    1108100n 0
+    1108399n 0
+    1108400n 1.8
+    1108499n 1.8
+    1108500n 0
+    1108799n 0
+    1108800n 1.8
+    1108899n 1.8
+    1108900n 0
+    1109199n 0
+    1109200n 1.8
+    1109299n 1.8
+    1109300n 0
+    1109599n 0
+    1109600n 1.8
+    1109699n 1.8
+    1109700n 0
+    1109999n 0
+    1110000n 1.8
+    1110099n 1.8
+    1110100n 0
+    1110399n 0
+    1110400n 1.8
+    1110499n 1.8
+    1110500n 0
+    1110799n 0
+    1110800n 1.8
+    1110899n 1.8
+    1110900n 0
+    1111199n 0
+    1111200n 1.8
+    1111299n 1.8
+    1111300n 0
+    1111599n 0
+    1111600n 1.8
+    1111699n 1.8
+    1111700n 0
+    1111999n 0
+    1112000n 1.8
+    1112099n 1.8
+    1112100n 0
+    1112399n 0
+    1112400n 1.8
+    1112499n 1.8
+    1112500n 0
+    1112799n 0
+    1112800n 1.8
+    1112899n 1.8
+    1112900n 0
+    1113199n 0
+    1113200n 1.8
+    1113299n 1.8
+    1113300n 0
+    1113599n 0
+    1113600n 1.8
+    1113699n 1.8
+    1113700n 0
+    1113999n 0
+    1114000n 1.8
+    1114099n 1.8
+    1114100n 0
+    1114399n 0
+    1114400n 1.8
+    1114499n 1.8
+    1114500n 0
+    1114799n 0
+    1114800n 1.8
+    1114899n 1.8
+    1114900n 0
+    1115199n 0
+    1115200n 1.8
+    1115299n 1.8
+    1115300n 0
+    1115599n 0
+    1115600n 1.8
+    1115699n 1.8
+    1115700n 0
+    1115999n 0
+    1116000n 1.8
+    1116099n 1.8
+    1116100n 0
+    1116399n 0
+    1116400n 1.8
+    1116499n 1.8
+    1116500n 0
+    1116799n 0
+    1116800n 1.8
+    1116899n 1.8
+    1116900n 0
+    1117199n 0
+    1117200n 1.8
+    1117299n 1.8
+    1117300n 0
+    1117599n 0
+    1117600n 1.8
+    1117699n 1.8
+    1117700n 0
+    1117999n 0
+    1118000n 1.8
+    1118099n 1.8
+    1118100n 0
+    1118399n 0
+    1118400n 1.8
+    1118499n 1.8
+    1118500n 0
+    1118799n 0
+    1118800n 1.8
+    1118899n 1.8
+    1118900n 0
+    1119199n 0
+    1119200n 1.8
+    1119299n 1.8
+    1119300n 0
+    1119599n 0
+    1119600n 1.8
+    1119699n 1.8
+    1119700n 0
+    1119999n 0
+    1120000n 1.8
+    1120099n 1.8
+    1120100n 0
+    1120399n 0
+    1120400n 1.8
+    1120499n 1.8
+    1120500n 0
+    1120799n 0
+    1120800n 1.8
+    1120899n 1.8
+    1120900n 0
+    1121199n 0
+    1121200n 1.8
+    1121299n 1.8
+    1121300n 0
+    1121599n 0
+    1121600n 1.8
+    1121699n 1.8
+    1121700n 0
+    1121999n 0
+    1122000n 1.8
+    1122099n 1.8
+    1122100n 0
+    1122399n 0
+    1122400n 1.8
+    1122499n 1.8
+    1122500n 0
+    1122799n 0
+    1122800n 1.8
+    1122899n 1.8
+    1122900n 0
+    1123199n 0
+    1123200n 1.8
+    1123299n 1.8
+    1123300n 0
+    1123599n 0
+    1123600n 1.8
+    1123699n 1.8
+    1123700n 0
+    1123999n 0
+    1124000n 1.8
+    1124099n 1.8
+    1124100n 0
+    1124399n 0
+    1124400n 1.8
+    1124499n 1.8
+    1124500n 0
+    1124799n 0
+    1124800n 1.8
+    1124899n 1.8
+    1124900n 0
+    1125199n 0
+    1125200n 1.8
+    1125299n 1.8
+    1125300n 0
+    1125599n 0
+    1125600n 1.8
+    1125699n 1.8
+    1125700n 0
+    1125999n 0
+    1126000n 1.8
+    1126099n 1.8
+    1126100n 0
+    1126399n 0
+    1126400n 1.8
+    1126499n 1.8
+    1126500n 0
+    1126799n 0
+    1126800n 1.8
+    1126899n 1.8
+    1126900n 0
+    1127199n 0
+    1127200n 1.8
+    1127299n 1.8
+    1127300n 0
+    1127599n 0
+    1127600n 1.8
+    1127699n 1.8
+    1127700n 0
+    1127999n 0
+    1128000n 1.8
+    1128099n 1.8
+    1128100n 0
+    1128399n 0
+    1128400n 1.8
+    1128499n 1.8
+    1128500n 0
+    1128799n 0
+    1128800n 1.8
+    1128899n 1.8
+    1128900n 0
+    1129199n 0
+    1129200n 1.8
+    1129299n 1.8
+    1129300n 0
+    1129599n 0
+    1129600n 1.8
+    1129699n 1.8
+    1129700n 0
+    1129999n 0
+    1130000n 1.8
+    1130099n 1.8
+    1130100n 0
+    1130399n 0
+    1130400n 1.8
+    1130499n 1.8
+    1130500n 0
+    1130799n 0
+    1130800n 1.8
+    1130899n 1.8
+    1130900n 0
+    1131199n 0
+    1131200n 1.8
+    1131299n 1.8
+    1131300n 0
+    1131599n 0
+    1131600n 1.8
+    1131699n 1.8
+    1131700n 0
+    1131999n 0
+    1132000n 1.8
+    1132099n 1.8
+    1132100n 0
+    1132399n 0
+    1132400n 1.8
+    1132499n 1.8
+    1132500n 0
+    1132799n 0
+    1132800n 1.8
+    1132899n 1.8
+    1132900n 0
+    1133199n 0
+    1133200n 1.8
+    1133299n 1.8
+    1133300n 0
+    1133599n 0
+    1133600n 1.8
+    1133699n 1.8
+    1133700n 0
+    1133999n 0
+    1134000n 1.8
+    1134099n 1.8
+    1134100n 0
+    1134399n 0
+    1134400n 1.8
+    1134499n 1.8
+    1134500n 0
+    1134799n 0
+    1134800n 1.8
+    1134899n 1.8
+    1134900n 0
+    1135199n 0
+    1135200n 1.8
+    1135299n 1.8
+    1135300n 0
+    1135599n 0
+    1135600n 1.8
+    1135699n 1.8
+    1135700n 0
+    1135999n 0
+    1136000n 1.8
+    1136099n 1.8
+    1136100n 0
+    1136399n 0
+    1136400n 1.8
+    1136499n 1.8
+    1136500n 0
+    1136799n 0
+    1136800n 1.8
+    1136899n 1.8
+    1136900n 0
+    1137199n 0
+    1137200n 1.8
+    1137299n 1.8
+    1137300n 0
+    1137599n 0
+    1137600n 1.8
+    1137699n 1.8
+    1137700n 0
+    1137999n 0
+    1138000n 1.8
+    1138099n 1.8
+    1138100n 0
+    1138399n 0
+    1138400n 1.8
+    1138499n 1.8
+    1138500n 0
+    1138799n 0
+    1138800n 1.8
+    1138899n 1.8
+    1138900n 0
+    1139199n 0
+    1139200n 1.8
+    1139299n 1.8
+    1139300n 0
+    1139599n 0
+    1139600n 1.8
+    1139699n 1.8
+    1139700n 0
+    1139999n 0
+    1140000n 1.8
+    1140099n 1.8
+    1140100n 0
+    1140399n 0
+    1140400n 1.8
+    1140499n 1.8
+    1140500n 0
+    1140799n 0
+    1140800n 1.8
+    1140899n 1.8
+    1140900n 0
+    1141199n 0
+    1141200n 1.8
+    1141299n 1.8
+    1141300n 0
+    1141599n 0
+    1141600n 1.8
+    1141699n 1.8
+    1141700n 0
+    1141999n 0
+    1142000n 1.8
+    1142099n 1.8
+    1142100n 0
+    1142399n 0
+    1142400n 1.8
+    1142499n 1.8
+    1142500n 0
+    1142799n 0
+    1142800n 1.8
+    1142899n 1.8
+    1142900n 0
+    1143199n 0
+    1143200n 1.8
+    1143299n 1.8
+    1143300n 0
+    1143599n 0
+    1143600n 1.8
+    1143699n 1.8
+    1143700n 0
+    1143999n 0
+    1144000n 1.8
+    1144099n 1.8
+    1144100n 0
+    1144399n 0
+    1144400n 1.8
+    1144499n 1.8
+    1144500n 0
+    1144799n 0
+    1144800n 1.8
+    1144899n 1.8
+    1144900n 0
+    1145199n 0
+    1145200n 1.8
+    1145299n 1.8
+    1145300n 0
+    1145599n 0
+    1145600n 1.8
+    1145699n 1.8
+    1145700n 0
+    1145999n 0
+    1146000n 1.8
+    1146099n 1.8
+    1146100n 0
+    1146399n 0
+    1146400n 1.8
+    1146499n 1.8
+    1146500n 0
+    1146799n 0
+    1146800n 1.8
+    1146899n 1.8
+    1146900n 0
+    1147199n 0
+    1147200n 1.8
+    1147299n 1.8
+    1147300n 0
+    1147599n 0
+    1147600n 1.8
+    1147699n 1.8
+    1147700n 0
+    1147999n 0
+    1148000n 1.8
+    1148099n 1.8
+    1148100n 0
+    1148399n 0
+    1148400n 1.8
+    1148499n 1.8
+    1148500n 0
+    1148799n 0
+    1148800n 1.8
+    1148899n 1.8
+    1148900n 0
+    1149199n 0
+    1149200n 1.8
+    1149299n 1.8
+    1149300n 0
+    1149599n 0
+    1149600n 1.8
+    1149699n 1.8
+    1149700n 0
+    1149999n 0
+    1150000n 1.8
+    1150099n 1.8
+    1150100n 0
+    1150399n 0
+    1150400n 1.8
+    1150499n 1.8
+    1150500n 0
+    1150799n 0
+    1150800n 1.8
+    1150899n 1.8
+    1150900n 0
+    1151199n 0
+    1151200n 1.8
+    1151299n 1.8
+    1151300n 0
+    1151599n 0
+    1151600n 1.8
+    1151699n 1.8
+    1151700n 0
+    1151999n 0
+    1152000n 1.8
+    1152099n 1.8
+    1152100n 0
+    1152399n 0
+    1152400n 1.8
+    1152499n 1.8
+    1152500n 0
+    1152799n 0
+    1152800n 1.8
+    1152899n 1.8
+    1152900n 0
+    1153199n 0
+    1153200n 1.8
+    1153299n 1.8
+    1153300n 0
+    1153599n 0
+    1153600n 1.8
+    1153699n 1.8
+    1153700n 0
+    1153999n 0
+    1154000n 1.8
+    1154099n 1.8
+    1154100n 0
+    1154399n 0
+    1154400n 1.8
+    1154499n 1.8
+    1154500n 0
+    1154799n 0
+    1154800n 1.8
+    1154899n 1.8
+    1154900n 0
+    1155199n 0
+    1155200n 1.8
+    1155299n 1.8
+    1155300n 0
+    1155599n 0
+    1155600n 1.8
+    1155699n 1.8
+    1155700n 0
+    1155999n 0
+    1156000n 1.8
+    1156099n 1.8
+    1156100n 0
+    1156399n 0
+    1156400n 1.8
+    1156499n 1.8
+    1156500n 0
+    1156799n 0
+    1156800n 1.8
+    1156899n 1.8
+    1156900n 0
+    1157199n 0
+    1157200n 1.8
+    1157299n 1.8
+    1157300n 0
+    1157599n 0
+    1157600n 1.8
+    1157699n 1.8
+    1157700n 0
+    1157999n 0
+    1158000n 1.8
+    1158099n 1.8
+    1158100n 0
+    1158399n 0
+    1158400n 1.8
+    1158499n 1.8
+    1158500n 0
+    1158799n 0
+    1158800n 1.8
+    1158899n 1.8
+    1158900n 0
+    1159199n 0
+    1159200n 1.8
+    1159299n 1.8
+    1159300n 0
+    1159599n 0
+    1159600n 1.8
+    1159699n 1.8
+    1159700n 0
+    1159999n 0
+    1160000n 1.8
+    1160099n 1.8
+    1160100n 0
+    1160399n 0
+    1160400n 1.8
+    1160499n 1.8
+    1160500n 0
+    1160799n 0
+    1160800n 1.8
+    1160899n 1.8
+    1160900n 0
+    1161199n 0
+    1161200n 1.8
+    1161299n 1.8
+    1161300n 0
+    1161599n 0
+    1161600n 1.8
+    1161699n 1.8
+    1161700n 0
+    1161999n 0
+    1162000n 1.8
+    1162099n 1.8
+    1162100n 0
+    1162399n 0
+    1162400n 1.8
+    1162499n 1.8
+    1162500n 0
+    1162799n 0
+    1162800n 1.8
+    1162899n 1.8
+    1162900n 0
+    1163199n 0
+    1163200n 1.8
+    1163299n 1.8
+    1163300n 0
+    1163599n 0
+    1163600n 1.8
+    1163699n 1.8
+    1163700n 0
+    1163999n 0
+    1164000n 1.8
+    1164099n 1.8
+    1164100n 0
+    1164399n 0
+    1164400n 1.8
+    1164499n 1.8
+    1164500n 0
+    1164799n 0
+    1164800n 1.8
+    1164899n 1.8
+    1164900n 0
+    1165199n 0
+    1165200n 1.8
+    1165299n 1.8
+    1165300n 0
+    1165599n 0
+    1165600n 1.8
+    1165699n 1.8
+    1165700n 0
+    1165999n 0
+    1166000n 1.8
+    1166099n 1.8
+    1166100n 0
+    1166399n 0
+    1166400n 1.8
+    1166499n 1.8
+    1166500n 0
+    1166799n 0
+    1166800n 1.8
+    1166899n 1.8
+    1166900n 0
+    1167199n 0
+    1167200n 1.8
+    1167299n 1.8
+    1167300n 0
+    1167599n 0
+    1167600n 1.8
+    1167699n 1.8
+    1167700n 0
+    1167999n 0
+    1168000n 1.8
+    1168099n 1.8
+    1168100n 0
+    1168399n 0
+    1168400n 1.8
+    1168499n 1.8
+    1168500n 0
+    1168799n 0
+    1168800n 1.8
+    1168899n 1.8
+    1168900n 0
+    1169199n 0
+    1169200n 1.8
+    1169299n 1.8
+    1169300n 0
+    1169599n 0
+    1169600n 1.8
+    1169699n 1.8
+    1169700n 0
+    1169999n 0
+    1170000n 1.8
+    1170099n 1.8
+    1170100n 0
+    1170399n 0
+    1170400n 1.8
+    1170499n 1.8
+    1170500n 0
+    1170799n 0
+    1170800n 1.8
+    1170899n 1.8
+    1170900n 0
+    1171199n 0
+    1171200n 1.8
+    1171299n 1.8
+    1171300n 0
+    1171599n 0
+    1171600n 1.8
+    1171699n 1.8
+    1171700n 0
+    1171999n 0
+    1172000n 1.8
+    1172099n 1.8
+    1172100n 0
+    1172399n 0
+    1172400n 1.8
+    1172499n 1.8
+    1172500n 0
+    1172799n 0
+    1172800n 1.8
+    1172899n 1.8
+    1172900n 0
+    1173199n 0
+    1173200n 1.8
+    1173299n 1.8
+    1173300n 0
+    1173599n 0
+    1173600n 1.8
+    1173699n 1.8
+    1173700n 0
+    1173999n 0
+    1174000n 1.8
+    1174099n 1.8
+    1174100n 0
+    1174399n 0
+    1174400n 1.8
+    1174499n 1.8
+    1174500n 0
+    1174799n 0
+    1174800n 1.8
+    1174899n 1.8
+    1174900n 0
+    1175199n 0
+    1175200n 1.8
+    1175299n 1.8
+    1175300n 0
+    1175599n 0
+    1175600n 1.8
+    1175699n 1.8
+    1175700n 0
+    1175999n 0
+    1176000n 1.8
+    1176099n 1.8
+    1176100n 0
+    1176399n 0
+    1176400n 1.8
+    1176499n 1.8
+    1176500n 0
+    1176799n 0
+    1176800n 1.8
+    1176899n 1.8
+    1176900n 0
+    1177199n 0
+    1177200n 1.8
+    1177299n 1.8
+    1177300n 0
+    1177599n 0
+    1177600n 1.8
+    1177699n 1.8
+    1177700n 0
+    1177999n 0
+    1178000n 1.8
+    1178099n 1.8
+    1178100n 0
+    1178399n 0
+    1178400n 1.8
+    1178499n 1.8
+    1178500n 0
+    1178799n 0
+    1178800n 1.8
+    1178899n 1.8
+    1178900n 0
+    1179199n 0
+    1179200n 1.8
+    1179299n 1.8
+    1179300n 0
+    1179599n 0
+    1179600n 1.8
+    1179699n 1.8
+    1179700n 0
+    1179999n 0
+    1180000n 1.8
+    1180099n 1.8
+    1180100n 0
+    1180399n 0
+    1180400n 1.8
+    1180499n 1.8
+    1180500n 0
+    1180799n 0
+    1180800n 1.8
+    1180899n 1.8
+    1180900n 0
+    1181199n 0
+    1181200n 1.8
+    1181299n 1.8
+    1181300n 0
+    1181599n 0
+    1181600n 1.8
+    1181699n 1.8
+    1181700n 0
+    1181999n 0
+    1182000n 1.8
+    1182099n 1.8
+    1182100n 0
+    1182399n 0
+    1182400n 1.8
+    1182499n 1.8
+    1182500n 0
+    1182799n 0
+    1182800n 1.8
+    1182899n 1.8
+    1182900n 0
+    1183199n 0
+    1183200n 1.8
+    1183299n 1.8
+    1183300n 0
+    1183599n 0
+    1183600n 1.8
+    1183699n 1.8
+    1183700n 0
+    1183999n 0
+    1184000n 1.8
+    1184099n 1.8
+    1184100n 0
+    1184399n 0
+    1184400n 1.8
+    1184499n 1.8
+    1184500n 0
+    1184799n 0
+    1184800n 1.8
+    1184899n 1.8
+    1184900n 0
+    1185199n 0
+    1185200n 1.8
+    1185299n 1.8
+    1185300n 0
+    1185599n 0
+    1185600n 1.8
+    1185699n 1.8
+    1185700n 0
+    1185999n 0
+    1186000n 1.8
+    1186099n 1.8
+    1186100n 0
+    1186399n 0
+    1186400n 1.8
+    1186499n 1.8
+    1186500n 0
+    1186799n 0
+    1186800n 1.8
+    1186899n 1.8
+    1186900n 0
+    1187199n 0
+    1187200n 1.8
+    1187299n 1.8
+    1187300n 0
+    1187599n 0
+    1187600n 1.8
+    1187699n 1.8
+    1187700n 0
+    1187999n 0
+    1188000n 1.8
+    1188099n 1.8
+    1188100n 0
+    1188399n 0
+    1188400n 1.8
+    1188499n 1.8
+    1188500n 0
+    1188799n 0
+    1188800n 1.8
+    1188899n 1.8
+    1188900n 0
+    1189199n 0
+    1189200n 1.8
+    1189299n 1.8
+    1189300n 0
+    1189599n 0
+    1189600n 1.8
+    1189699n 1.8
+    1189700n 0
+    1189999n 0
+    1190000n 1.8
+    1190099n 1.8
+    1190100n 0
+    1190399n 0
+    1190400n 1.8
+    1190499n 1.8
+    1190500n 0
+    1190799n 0
+    1190800n 1.8
+    1190899n 1.8
+    1190900n 0
+    1191199n 0
+    1191200n 1.8
+    1191299n 1.8
+    1191300n 0
+    1191599n 0
+    1191600n 1.8
+    1191699n 1.8
+    1191700n 0
+    1191999n 0
+    1192000n 1.8
+    1192099n 1.8
+    1192100n 0
+    1192399n 0
+    1192400n 1.8
+    1192499n 1.8
+    1192500n 0
+    1192799n 0
+    1192800n 1.8
+    1192899n 1.8
+    1192900n 0
+    1193199n 0
+    1193200n 1.8
+    1193299n 1.8
+    1193300n 0
+    1193599n 0
+    1193600n 1.8
+    1193699n 1.8
+    1193700n 0
+    1193999n 0
+    1194000n 1.8
+    1194099n 1.8
+    1194100n 0
+    1194399n 0
+    1194400n 1.8
+    1194499n 1.8
+    1194500n 0
+    1194799n 0
+    1194800n 1.8
+    1194899n 1.8
+    1194900n 0
+    1195199n 0
+    1195200n 1.8
+    1195299n 1.8
+    1195300n 0
+    1195599n 0
+    1195600n 1.8
+    1195699n 1.8
+    1195700n 0
+    1195999n 0
+    1196000n 1.8
+    1196099n 1.8
+    1196100n 0
+    1196399n 0
+    1196400n 1.8
+    1196499n 1.8
+    1196500n 0
+    1196799n 0
+    1196800n 1.8
+    1196899n 1.8
+    1196900n 0
+    1197199n 0
+    1197200n 1.8
+    1197299n 1.8
+    1197300n 0
+    1197599n 0
+    1197600n 1.8
+    1197699n 1.8
+    1197700n 0
+    1197999n 0
+    1198000n 1.8
+    1198099n 1.8
+    1198100n 0
+    1198399n 0
+    1198400n 1.8
+    1198499n 1.8
+    1198500n 0
+    1198799n 0
+    1198800n 1.8
+    1198899n 1.8
+    1198900n 0
+    1199199n 0
+    1199200n 1.8
+    1199299n 1.8
+    1199300n 0
+    1199599n 0
+    1199600n 1.8
+    1199699n 1.8
+    1199700n 0
+    1199999n 0
+    1200000n 1.8
+    1200099n 1.8
+    1200100n 0
+    1200399n 0
+    1200400n 1.8
+    1200499n 1.8
+    1200500n 0
+    1200799n 0
+    1200800n 1.8
+    1200899n 1.8
+    1200900n 0
+    1201199n 0
+    1201200n 1.8
+    1201299n 1.8
+    1201300n 0
+    1201599n 0
+    1201600n 1.8
+    1201699n 1.8
+    1201700n 0
+    1201999n 0
+    1202000n 1.8
+    1202099n 1.8
+    1202100n 0
+    1202399n 0
+    1202400n 1.8
+    1202499n 1.8
+    1202500n 0
+    1202799n 0
+    1202800n 1.8
+    1202899n 1.8
+    1202900n 0
+    1203199n 0
+    1203200n 1.8
+    1203299n 1.8
+    1203300n 0
+    1203599n 0
+    1203600n 1.8
+    1203699n 1.8
+    1203700n 0
+    1203999n 0
+    1204000n 1.8
+    1204099n 1.8
+    1204100n 0
+    1204399n 0
+    1204400n 1.8
+    1204499n 1.8
+    1204500n 0
+    1204799n 0
+    1204800n 1.8
+    1204899n 1.8
+    1204900n 0
+    1205199n 0
+    1205200n 1.8
+    1205299n 1.8
+    1205300n 0
+    1205599n 0
+    1205600n 1.8
+    1205699n 1.8
+    1205700n 0
+    1205999n 0
+    1206000n 1.8
+    1206099n 1.8
+    1206100n 0
+    1206399n 0
+    1206400n 1.8
+    1206499n 1.8
+    1206500n 0
+    1206799n 0
+    1206800n 1.8
+    1206899n 1.8
+    1206900n 0
+    1207199n 0
+    1207200n 1.8
+    1207299n 1.8
+    1207300n 0
+    1207599n 0
+    1207600n 1.8
+    1207699n 1.8
+    1207700n 0
+    1207999n 0
+    1208000n 1.8
+    1208099n 1.8
+    1208100n 0
+    1208399n 0
+    1208400n 1.8
+    1208499n 1.8
+    1208500n 0
+    1208799n 0
+    1208800n 1.8
+    1208899n 1.8
+    1208900n 0
+    1209199n 0
+    1209200n 1.8
+    1209299n 1.8
+    1209300n 0
+    1209599n 0
+    1209600n 1.8
+    1209699n 1.8
+    1209700n 0
+    1209999n 0
+    1210000n 1.8
+    1210099n 1.8
+    1210100n 0
+    1210399n 0
+    1210400n 1.8
+    1210499n 1.8
+    1210500n 0
+    1210799n 0
+    1210800n 1.8
+    1210899n 1.8
+    1210900n 0
+    1211199n 0
+    1211200n 1.8
+    1211299n 1.8
+    1211300n 0
+    1211599n 0
+    1211600n 1.8
+    1211699n 1.8
+    1211700n 0
+    1211999n 0
+    1212000n 1.8
+    1212099n 1.8
+    1212100n 0
+    1212399n 0
+    1212400n 1.8
+    1212499n 1.8
+    1212500n 0
+    1212799n 0
+    1212800n 1.8
+    1212899n 1.8
+    1212900n 0
+    1213199n 0
+    1213200n 1.8
+    1213299n 1.8
+    1213300n 0
+    1213599n 0
+    1213600n 1.8
+    1213699n 1.8
+    1213700n 0
+    1213999n 0
+    1214000n 1.8
+    1214099n 1.8
+    1214100n 0
+    1214399n 0
+    1214400n 1.8
+    1214499n 1.8
+    1214500n 0
+    1214799n 0
+    1214800n 1.8
+    1214899n 1.8
+    1214900n 0
+    1215199n 0
+    1215200n 1.8
+    1215299n 1.8
+    1215300n 0
+    1215599n 0
+    1215600n 1.8
+    1215699n 1.8
+    1215700n 0
+    1215999n 0
+    1216000n 1.8
+    1216099n 1.8
+    1216100n 0
+    1216399n 0
+    1216400n 1.8
+    1216499n 1.8
+    1216500n 0
+    1216799n 0
+    1216800n 1.8
+    1216899n 1.8
+    1216900n 0
+    1217199n 0
+    1217200n 1.8
+    1217299n 1.8
+    1217300n 0
+    1217599n 0
+    1217600n 1.8
+    1217699n 1.8
+    1217700n 0
+    1217999n 0
+    1218000n 1.8
+    1218099n 1.8
+    1218100n 0
+    1218399n 0
+    1218400n 1.8
+    1218499n 1.8
+    1218500n 0
+    1218799n 0
+    1218800n 1.8
+    1218899n 1.8
+    1218900n 0
+    1219199n 0
+    1219200n 1.8
+    1219299n 1.8
+    1219300n 0
+    1219599n 0
+    1219600n 1.8
+    1219699n 1.8
+    1219700n 0
+    1219999n 0
+    1220000n 1.8
+    1220099n 1.8
+    1220100n 0
+    1220399n 0
+    1220400n 1.8
+    1220499n 1.8
+    1220500n 0
+    1220799n 0
+    1220800n 1.8
+    1220899n 1.8
+    1220900n 0
+    1221199n 0
+    1221200n 1.8
+    1221299n 1.8
+    1221300n 0
+    1221599n 0
+    1221600n 1.8
+    1221699n 1.8
+    1221700n 0
+    1221999n 0
+    1222000n 1.8
+    1222099n 1.8
+    1222100n 0
+    1222399n 0
+    1222400n 1.8
+    1222499n 1.8
+    1222500n 0
+    1222799n 0
+    1222800n 1.8
+    1222899n 1.8
+    1222900n 0
+    1223199n 0
+    1223200n 1.8
+    1223299n 1.8
+    1223300n 0
+    1223599n 0
+    1223600n 1.8
+    1223699n 1.8
+    1223700n 0
+    1223999n 0
+    1224000n 1.8
+    1224099n 1.8
+    1224100n 0
+    1224399n 0
+    1224400n 1.8
+    1224499n 1.8
+    1224500n 0
+    1224799n 0
+    1224800n 1.8
+    1224899n 1.8
+    1224900n 0
+    1225199n 0
+    1225200n 1.8
+    1225299n 1.8
+    1225300n 0
+    1225599n 0
+    1225600n 1.8
+    1225699n 1.8
+    1225700n 0
+    1225999n 0
+    1226000n 1.8
+    1226099n 1.8
+    1226100n 0
+    1226399n 0
+    1226400n 1.8
+    1226499n 1.8
+    1226500n 0
+    1226799n 0
+    1226800n 1.8
+    1226899n 1.8
+    1226900n 0
+    1227199n 0
+    1227200n 1.8
+    1227299n 1.8
+    1227300n 0
+    1227599n 0
+    1227600n 1.8
+    1227699n 1.8
+    1227700n 0
+    1227999n 0
+    1228000n 1.8
+    1228099n 1.8
+    1228100n 0
+    1228399n 0
+    1228400n 1.8
+    1228499n 1.8
+    1228500n 0
+    1228799n 0
+    1228800n 1.8
+    1228899n 1.8
+    1228900n 0
+    1229199n 0
+    1229200n 1.8
+    1229299n 1.8
+    1229300n 0
+    1229599n 0
+    1229600n 1.8
+    1229699n 1.8
+    1229700n 0
+    1229999n 0
+    1230000n 1.8
+    1230099n 1.8
+    1230100n 0
+    1230399n 0
+    1230400n 1.8
+    1230499n 1.8
+    1230500n 0
+    1230799n 0
+    1230800n 1.8
+    1230899n 1.8
+    1230900n 0
+    1231199n 0
+    1231200n 1.8
+    1231299n 1.8
+    1231300n 0
+    1231599n 0
+    1231600n 1.8
+    1231699n 1.8
+    1231700n 0
+    1231999n 0
+    1232000n 1.8
+    1232099n 1.8
+    1232100n 0
+    1232399n 0
+    1232400n 1.8
+    1232499n 1.8
+    1232500n 0
+    1232799n 0
+    1232800n 1.8
+    1232899n 1.8
+    1232900n 0
+    1233199n 0
+    1233200n 1.8
+    1233299n 1.8
+    1233300n 0
+    1233599n 0
+    1233600n 1.8
+    1233699n 1.8
+    1233700n 0
+    1233999n 0
+    1234000n 1.8
+    1234099n 1.8
+    1234100n 0
+    1234399n 0
+    1234400n 1.8
+    1234499n 1.8
+    1234500n 0
+    1234799n 0
+    1234800n 1.8
+    1234899n 1.8
+    1234900n 0
+    1235199n 0
+    1235200n 1.8
+    1235299n 1.8
+    1235300n 0
+    1235599n 0
+    1235600n 1.8
+    1235699n 1.8
+    1235700n 0
+    1235999n 0
+    1236000n 1.8
+    1236099n 1.8
+    1236100n 0
+    1236399n 0
+    1236400n 1.8
+    1236499n 1.8
+    1236500n 0
+    1236799n 0
+    1236800n 1.8
+    1236899n 1.8
+    1236900n 0
+    1237199n 0
+    1237200n 1.8
+    1237299n 1.8
+    1237300n 0
+    1237599n 0
+    1237600n 1.8
+    1237699n 1.8
+    1237700n 0
+    1237999n 0
+    1238000n 1.8
+    1238099n 1.8
+    1238100n 0
+    1238399n 0
+    1238400n 1.8
+    1238499n 1.8
+    1238500n 0
+    1238799n 0
+    1238800n 1.8
+    1238899n 1.8
+    1238900n 0
+    1239199n 0
+    1239200n 1.8
+    1239299n 1.8
+    1239300n 0
+    1239599n 0
+    1239600n 1.8
+    1239699n 1.8
+    1239700n 0
+    1239999n 0
+    1240000n 1.8
+    1240099n 1.8
+    1240100n 0
+    1240399n 0
+    1240400n 1.8
+    1240499n 1.8
+    1240500n 0
+    1240799n 0
+    1240800n 1.8
+    1240899n 1.8
+    1240900n 0
+    1241199n 0
+    1241200n 1.8
+    1241299n 1.8
+    1241300n 0
+    1241599n 0
+    1241600n 1.8
+    1241699n 1.8
+    1241700n 0
+    1241999n 0
+    1242000n 1.8
+    1242099n 1.8
+    1242100n 0
+    1242399n 0
+    1242400n 1.8
+    1242499n 1.8
+    1242500n 0
+    1242799n 0
+    1242800n 1.8
+    1242899n 1.8
+    1242900n 0
+    1243199n 0
+    1243200n 1.8
+    1243299n 1.8
+    1243300n 0
+    1243599n 0
+    1243600n 1.8
+    1243699n 1.8
+    1243700n 0
+    1243999n 0
+    1244000n 1.8
+    1244099n 1.8
+    1244100n 0
+    1244399n 0
+    1244400n 1.8
+    1244499n 1.8
+    1244500n 0
+    1244799n 0
+    1244800n 1.8
+    1244899n 1.8
+    1244900n 0
+    1245199n 0
+    1245200n 1.8
+    1245299n 1.8
+    1245300n 0
+    1245599n 0
+    1245600n 1.8
+    1245699n 1.8
+    1245700n 0
+    1245999n 0
+    1246000n 1.8
+    1246099n 1.8
+    1246100n 0
+    1246399n 0
+    1246400n 1.8
+    1246499n 1.8
+    1246500n 0
+    1246799n 0
+    1246800n 1.8
+    1246899n 1.8
+    1246900n 0
+    1247199n 0
+    1247200n 1.8
+    1247299n 1.8
+    1247300n 0
+    1247599n 0
+    1247600n 1.8
+    1247699n 1.8
+    1247700n 0
+    1247999n 0
+    1248000n 1.8
+    1248099n 1.8
+    1248100n 0
+    1248399n 0
+    1248400n 1.8
+    1248499n 1.8
+    1248500n 0
+    1248799n 0
+    1248800n 1.8
+    1248899n 1.8
+    1248900n 0
+    1249199n 0
+    1249200n 1.8
+    1249299n 1.8
+    1249300n 0
+    1249599n 0
+    1249600n 1.8
+    1249699n 1.8
+    1249700n 0
+    1249999n 0
+    1250000n 1.8
+    1250099n 1.8
+    1250100n 0
+    1250399n 0
+    1250400n 1.8
+    1250499n 1.8
+    1250500n 0
+    1250799n 0
+    1250800n 1.8
+    1250899n 1.8
+    1250900n 0
+    1251199n 0
+    1251200n 1.8
+    1251299n 1.8
+    1251300n 0
+    1251599n 0
+    1251600n 1.8
+    1251699n 1.8
+    1251700n 0
+    1251999n 0
+    1252000n 1.8
+    1252099n 1.8
+    1252100n 0
+    1252399n 0
+    1252400n 1.8
+    1252499n 1.8
+    1252500n 0
+    1252799n 0
+    1252800n 1.8
+    1252899n 1.8
+    1252900n 0
+    1253199n 0
+    1253200n 1.8
+    1253299n 1.8
+    1253300n 0
+    1253599n 0
+    1253600n 1.8
+    1253699n 1.8
+    1253700n 0
+    1253999n 0
+    1254000n 1.8
+    1254099n 1.8
+    1254100n 0
+    1254399n 0
+    1254400n 1.8
+    1254499n 1.8
+    1254500n 0
+    1254799n 0
+    1254800n 1.8
+    1254899n 1.8
+    1254900n 0
+    1255199n 0
+    1255200n 1.8
+    1255299n 1.8
+    1255300n 0
+    1255599n 0
+    1255600n 1.8
+    1255699n 1.8
+    1255700n 0
+    1255999n 0
+    1256000n 1.8
+    1256099n 1.8
+    1256100n 0
+    1256399n 0
+    1256400n 1.8
+    1256499n 1.8
+    1256500n 0
+    1256799n 0
+    1256800n 1.8
+    1256899n 1.8
+    1256900n 0
+    1257199n 0
+    1257200n 1.8
+    1257299n 1.8
+    1257300n 0
+    1257599n 0
+    1257600n 1.8
+    1257699n 1.8
+    1257700n 0
+    1257999n 0
+    1258000n 1.8
+    1258099n 1.8
+    1258100n 0
+    1258399n 0
+    1258400n 1.8
+    1258499n 1.8
+    1258500n 0
+    1258799n 0
+    1258800n 1.8
+    1258899n 1.8
+    1258900n 0
+    1259199n 0
+    1259200n 1.8
+    1259299n 1.8
+    1259300n 0
+    1259599n 0
+    1259600n 1.8
+    1259699n 1.8
+    1259700n 0
+    1259999n 0
+    1260000n 1.8
+    1260099n 1.8
+    1260100n 0
+    1260399n 0
+    1260400n 1.8
+    1260499n 1.8
+    1260500n 0
+    1260799n 0
+    1260800n 1.8
+    1260899n 1.8
+    1260900n 0
+    1261199n 0
+    1261200n 1.8
+    1261299n 1.8
+    1261300n 0
+    1261599n 0
+    1261600n 1.8
+    1261699n 1.8
+    1261700n 0
+    1261999n 0
+    1262000n 1.8
+    1262099n 1.8
+    1262100n 0
+    1262399n 0
+    1262400n 1.8
+    1262499n 1.8
+    1262500n 0
+    1262799n 0
+    1262800n 1.8
+    1262899n 1.8
+    1262900n 0
+    1263199n 0
+    1263200n 1.8
+    1263299n 1.8
+    1263300n 0
+    1263599n 0
+    1263600n 1.8
+    1263699n 1.8
+    1263700n 0
+    1263999n 0
+    1264000n 1.8
+    1264099n 1.8
+    1264100n 0
+    1264399n 0
+    1264400n 1.8
+    1264499n 1.8
+    1264500n 0
+    1264799n 0
+    1264800n 1.8
+    1264899n 1.8
+    1264900n 0
+    1265199n 0
+    1265200n 1.8
+    1265299n 1.8
+    1265300n 0
+    1265599n 0
+    1265600n 1.8
+    1265699n 1.8
+    1265700n 0
+    1265999n 0
+    1266000n 1.8
+    1266099n 1.8
+    1266100n 0
+    1266399n 0
+    1266400n 1.8
+    1266499n 1.8
+    1266500n 0
+    1266799n 0
+    1266800n 1.8
+    1266899n 1.8
+    1266900n 0
+    1267199n 0
+    1267200n 1.8
+    1267299n 1.8
+    1267300n 0
+    1267599n 0
+    1267600n 1.8
+    1267699n 1.8
+    1267700n 0
+    1267999n 0
+    1268000n 1.8
+    1268099n 1.8
+    1268100n 0
+    1268399n 0
+    1268400n 1.8
+    1268499n 1.8
+    1268500n 0
+    1268799n 0
+    1268800n 1.8
+    1268899n 1.8
+    1268900n 0
+    1269199n 0
+    1269200n 1.8
+    1269299n 1.8
+    1269300n 0
+    1269599n 0
+    1269600n 1.8
+    1269699n 1.8
+    1269700n 0
+    1269999n 0
+    1270000n 1.8
+    1270099n 1.8
+    1270100n 0
+    1270399n 0
+    1270400n 1.8
+    1270499n 1.8
+    1270500n 0
+    1270799n 0
+    1270800n 1.8
+    1270899n 1.8
+    1270900n 0
+    1271199n 0
+    1271200n 1.8
+    1271299n 1.8
+    1271300n 0
+    1271599n 0
+    1271600n 1.8
+    1271699n 1.8
+    1271700n 0
+    1271999n 0
+    1272000n 1.8
+    1272099n 1.8
+    1272100n 0
+    1272399n 0
+    1272400n 1.8
+    1272499n 1.8
+    1272500n 0
+    1272799n 0
+    1272800n 1.8
+    1272899n 1.8
+    1272900n 0
+    1273199n 0
+    1273200n 1.8
+    1273299n 1.8
+    1273300n 0
+    1273599n 0
+    1273600n 1.8
+    1273699n 1.8
+    1273700n 0
+    1273999n 0
+    1274000n 1.8
+    1274099n 1.8
+    1274100n 0
+    1274399n 0
+    1274400n 1.8
+    1274499n 1.8
+    1274500n 0
+    1274799n 0
+    1274800n 1.8
+    1274899n 1.8
+    1274900n 0
+    1275199n 0
+    1275200n 1.8
+    1275299n 1.8
+    1275300n 0
+    1275599n 0
+    1275600n 1.8
+    1275699n 1.8
+    1275700n 0
+    1275999n 0
+    1276000n 1.8
+    1276099n 1.8
+    1276100n 0
+    1276399n 0
+    1276400n 1.8
+    1276499n 1.8
+    1276500n 0
+    1276799n 0
+    1276800n 1.8
+    1276899n 1.8
+    1276900n 0
+    1277199n 0
+    1277200n 1.8
+    1277299n 1.8
+    1277300n 0
+    1277599n 0
+    1277600n 1.8
+    1277699n 1.8
+    1277700n 0
+    1277999n 0
+    1278000n 1.8
+    1278099n 1.8
+    1278100n 0
+    1278399n 0
+    1278400n 1.8
+    1278499n 1.8
+    1278500n 0
+    1278799n 0
+    1278800n 1.8
+    1278899n 1.8
+    1278900n 0
+    1279199n 0
+    1279200n 1.8
+    1279299n 1.8
+    1279300n 0
+    1279599n 0
+    1279600n 1.8
+    1279699n 1.8
+    1279700n 0
+    1279999n 0
+    1280000n 1.8
+    1280099n 1.8
+    1280100n 0
+    1280399n 0
+    1280400n 1.8
+    1280499n 1.8
+    1280500n 0
+    1280799n 0
+    1280800n 1.8
+    1280899n 1.8
+    1280900n 0
+    1281199n 0
+    1281200n 1.8
+    1281299n 1.8
+    1281300n 0
+    1281599n 0
+    1281600n 1.8
+    1281699n 1.8
+    1281700n 0
+    1281999n 0
+    1282000n 1.8
+    1282099n 1.8
+    1282100n 0
+    1282399n 0
+    1282400n 1.8
+    1282499n 1.8
+    1282500n 0
+    1282799n 0
+    1282800n 1.8
+    1282899n 1.8
+    1282900n 0
+    1283199n 0
+    1283200n 1.8
+    1283299n 1.8
+    1283300n 0
+    1283599n 0
+    1283600n 1.8
+    1283699n 1.8
+    1283700n 0
+    1283999n 0
+    1284000n 1.8
+    1284099n 1.8
+    1284100n 0
+    1284399n 0
+    1284400n 1.8
+    1284499n 1.8
+    1284500n 0
+    1284799n 0
+    1284800n 1.8
+    1284899n 1.8
+    1284900n 0
+    1285199n 0
+    1285200n 1.8
+    1285299n 1.8
+    1285300n 0
+    1285599n 0
+    1285600n 1.8
+    1285699n 1.8
+    1285700n 0
+    1285999n 0
+    1286000n 1.8
+    1286099n 1.8
+    1286100n 0
+    1286399n 0
+    1286400n 1.8
+    1286499n 1.8
+    1286500n 0
+    1286799n 0
+    1286800n 1.8
+    1286899n 1.8
+    1286900n 0
+    1287199n 0
+    1287200n 1.8
+    1287299n 1.8
+    1287300n 0
+    1287599n 0
+    1287600n 1.8
+    1287699n 1.8
+    1287700n 0
+    1287999n 0
+    1288000n 1.8
+    1288099n 1.8
+    1288100n 0
+    1288399n 0
+    1288400n 1.8
+    1288499n 1.8
+    1288500n 0
+    1288799n 0
+    1288800n 1.8
+    1288899n 1.8
+    1288900n 0
+    1289199n 0
+    1289200n 1.8
+    1289299n 1.8
+    1289300n 0
+    1289599n 0
+    1289600n 1.8
+    1289699n 1.8
+    1289700n 0
+    1289999n 0
+    1290000n 1.8
+    1290099n 1.8
+    1290100n 0
+    1290399n 0
+    1290400n 1.8
+    1290499n 1.8
+    1290500n 0
+    1290799n 0
+    1290800n 1.8
+    1290899n 1.8
+    1290900n 0
+    1291199n 0
+    1291200n 1.8
+    1291299n 1.8
+    1291300n 0
+    1291599n 0
+    1291600n 1.8
+    1291699n 1.8
+    1291700n 0
+    1291999n 0
+    1292000n 1.8
+    1292099n 1.8
+    1292100n 0
+    1292399n 0
+    1292400n 1.8
+    1292499n 1.8
+    1292500n 0
+    1292799n 0
+    1292800n 1.8
+    1292899n 1.8
+    1292900n 0
+    1293199n 0
+    1293200n 1.8
+    1293299n 1.8
+    1293300n 0
+    1293599n 0
+    1293600n 1.8
+    1293699n 1.8
+    1293700n 0
+    1293999n 0
+    1294000n 1.8
+    1294099n 1.8
+    1294100n 0
+    1294399n 0
+    1294400n 1.8
+    1294499n 1.8
+    1294500n 0
+    1294799n 0
+    1294800n 1.8
+    1294899n 1.8
+    1294900n 0
+    1295199n 0
+    1295200n 1.8
+    1295299n 1.8
+    1295300n 0
+    1295599n 0
+    1295600n 1.8
+    1295699n 1.8
+    1295700n 0
+    1295999n 0
+    1296000n 1.8
+    1296099n 1.8
+    1296100n 0
+    1296399n 0
+    1296400n 1.8
+    1296499n 1.8
+    1296500n 0
+    1296799n 0
+    1296800n 1.8
+    1296899n 1.8
+    1296900n 0
+    1297199n 0
+    1297200n 1.8
+    1297299n 1.8
+    1297300n 0
+    1297599n 0
+    1297600n 1.8
+    1297699n 1.8
+    1297700n 0
+    1297999n 0
+    1298000n 1.8
+    1298099n 1.8
+    1298100n 0
+    1298399n 0
+    1298400n 1.8
+    1298499n 1.8
+    1298500n 0
+    1298799n 0
+    1298800n 1.8
+    1298899n 1.8
+    1298900n 0
+    1299199n 0
+    1299200n 1.8
+    1299299n 1.8
+    1299300n 0
+    1299599n 0
+    1299600n 1.8
+    1299699n 1.8
+    1299700n 0
+    1299999n 0
+    1300000n 1.8
+    1300099n 1.8
+    1300100n 0
+    1300399n 0
+    1300400n 1.8
+    1300499n 1.8
+    1300500n 0
+    1300799n 0
+    1300800n 1.8
+    1300899n 1.8
+    1300900n 0
+    1301199n 0
+    1301200n 1.8
+    1301299n 1.8
+    1301300n 0
+    1301599n 0
+    1301600n 1.8
+    1301699n 1.8
+    1301700n 0
+    1301999n 0
+    1302000n 1.8
+    1302099n 1.8
+    1302100n 0
+    1302399n 0
+    1302400n 1.8
+    1302499n 1.8
+    1302500n 0
+    1302799n 0
+    1302800n 1.8
+    1302899n 1.8
+    1302900n 0
+    1303199n 0
+    1303200n 1.8
+    1303299n 1.8
+    1303300n 0
+    1303599n 0
+    1303600n 1.8
+    1303699n 1.8
+    1303700n 0
+    1303999n 0
+    1304000n 1.8
+    1304099n 1.8
+    1304100n 0
+    1304399n 0
+    1304400n 1.8
+    1304499n 1.8
+    1304500n 0
+    1304799n 0
+    1304800n 1.8
+    1304899n 1.8
+    1304900n 0
+    1305199n 0
+    1305200n 1.8
+    1305299n 1.8
+    1305300n 0
+    1305599n 0
+    1305600n 1.8
+    1305699n 1.8
+    1305700n 0
+    1305999n 0
+    1306000n 1.8
+    1306099n 1.8
+    1306100n 0
+    1306399n 0
+    1306400n 1.8
+    1306499n 1.8
+    1306500n 0
+    1306799n 0
+    1306800n 1.8
+    1306899n 1.8
+    1306900n 0
+    1307199n 0
+    1307200n 1.8
+    1307299n 1.8
+    1307300n 0
+    1307599n 0
+    1307600n 1.8
+    1307699n 1.8
+    1307700n 0
+    1307999n 0
+    1308000n 1.8
+    1308099n 1.8
+    1308100n 0
+    1308399n 0
+    1308400n 1.8
+    1308499n 1.8
+    1308500n 0
+    1308799n 0
+    1308800n 1.8
+    1308899n 1.8
+    1308900n 0
+    1309199n 0
+    1309200n 1.8
+    1309299n 1.8
+    1309300n 0
+    1309599n 0
+    1309600n 1.8
+    1309699n 1.8
+    1309700n 0
+    1309999n 0
+    1310000n 1.8
+    1310099n 1.8
+    1310100n 0
+    1310399n 0
+    1310400n 1.8
+    1310499n 1.8
+    1310500n 0
+    1310799n 0
+    1310800n 1.8
+    1310899n 1.8
+    1310900n 0
+    1311199n 0
+    1311200n 1.8
+    1311299n 1.8
+    1311300n 0
+    1311599n 0
+    1311600n 1.8
+    1311699n 1.8
+    1311700n 0
+    1311999n 0
+    1312000n 1.8
+    1312099n 1.8
+    1312100n 0
+    1312399n 0
+    1312400n 1.8
+    1312499n 1.8
+    1312500n 0
+    1312799n 0
+    1312800n 1.8
+    1312899n 1.8
+    1312900n 0
+    1313199n 0
+    1313200n 1.8
+    1313299n 1.8
+    1313300n 0
+    1313599n 0
+    1313600n 1.8
+    1313699n 1.8
+    1313700n 0
+    1313999n 0
+    1314000n 1.8
+    1314099n 1.8
+    1314100n 0
+    1314399n 0
+    1314400n 1.8
+    1314499n 1.8
+    1314500n 0
+    1314799n 0
+    1314800n 1.8
+    1314899n 1.8
+    1314900n 0
+    1315199n 0
+    1315200n 1.8
+    1315299n 1.8
+    1315300n 0
+    1315599n 0
+    1315600n 1.8
+    1315699n 1.8
+    1315700n 0
+    1315999n 0
+    1316000n 1.8
+    1316099n 1.8
+    1316100n 0
+    1316399n 0
+    1316400n 1.8
+    1316499n 1.8
+    1316500n 0
+    1316799n 0
+    1316800n 1.8
+    1316899n 1.8
+    1316900n 0
+    1317199n 0
+    1317200n 1.8
+    1317299n 1.8
+    1317300n 0
+    1317599n 0
+    1317600n 1.8
+    1317699n 1.8
+    1317700n 0
+    1317999n 0
+    1318000n 1.8
+    1318099n 1.8
+    1318100n 0
+    1318399n 0
+    1318400n 1.8
+    1318499n 1.8
+    1318500n 0
+    1318799n 0
+    1318800n 1.8
+    1318899n 1.8
+    1318900n 0
+    1319199n 0
+    1319200n 1.8
+    1319299n 1.8
+    1319300n 0
+    1319599n 0
+    1319600n 1.8
+    1319699n 1.8
+    1319700n 0
+    1319999n 0
+    1320000n 1.8
+    1320099n 1.8
+    1320100n 0
+    1320399n 0
+    1320400n 1.8
+    1320499n 1.8
+    1320500n 0
+    1320799n 0
+    1320800n 1.8
+    1320899n 1.8
+    1320900n 0
+    1321199n 0
+    1321200n 1.8
+    1321299n 1.8
+    1321300n 0
+    1321599n 0
+    1321600n 1.8
+    1321699n 1.8
+    1321700n 0
+    1321999n 0
+    1322000n 1.8
+    1322099n 1.8
+    1322100n 0
+    1322399n 0
+    1322400n 1.8
+    1322499n 1.8
+    1322500n 0
+    1322799n 0
+    1322800n 1.8
+    1322899n 1.8
+    1322900n 0
+    1323199n 0
+    1323200n 1.8
+    1323299n 1.8
+    1323300n 0
+    1323599n 0
+    1323600n 1.8
+    1323699n 1.8
+    1323700n 0
+    1323999n 0
+    1324000n 1.8
+    1324099n 1.8
+    1324100n 0
+    1324399n 0
+    1324400n 1.8
+    1324499n 1.8
+    1324500n 0
+    1324799n 0
+    1324800n 1.8
+    1324899n 1.8
+    1324900n 0
+    1325199n 0
+    1325200n 1.8
+    1325299n 1.8
+    1325300n 0
+    1325599n 0
+    1325600n 1.8
+    1325699n 1.8
+    1325700n 0
+    1325999n 0
+    1326000n 1.8
+    1326099n 1.8
+    1326100n 0
+    1326399n 0
+    1326400n 1.8
+    1326499n 1.8
+    1326500n 0
+    1326799n 0
+    1326800n 1.8
+    1326899n 1.8
+    1326900n 0
+    1327199n 0
+    1327200n 1.8
+    1327299n 1.8
+    1327300n 0
+    1327599n 0
+    1327600n 1.8
+    1327699n 1.8
+    1327700n 0
+    1327999n 0
+    1328000n 1.8
+    1328099n 1.8
+    1328100n 0
+    1328399n 0
+    1328400n 1.8
+    1328499n 1.8
+    1328500n 0
+    1328799n 0
+    1328800n 1.8
+    1328899n 1.8
+    1328900n 0
+    1329199n 0
+    1329200n 1.8
+    1329299n 1.8
+    1329300n 0
+    1329599n 0
+    1329600n 1.8
+    1329699n 1.8
+    1329700n 0
+    1329999n 0
+    1330000n 1.8
+    1330099n 1.8
+    1330100n 0
+    1330399n 0
+    1330400n 1.8
+    1330499n 1.8
+    1330500n 0
+    1330799n 0
+    1330800n 1.8
+    1330899n 1.8
+    1330900n 0
+    1331199n 0
+    1331200n 1.8
+    1331299n 1.8
+    1331300n 0
+    1331599n 0
+    1331600n 1.8
+    1331699n 1.8
+    1331700n 0
+    1331999n 0
+    1332000n 1.8
+    1332099n 1.8
+    1332100n 0
+    1332399n 0
+    1332400n 1.8
+    1332499n 1.8
+    1332500n 0
+    1332799n 0
+    1332800n 1.8
+    1332899n 1.8
+    1332900n 0
+    1333199n 0
+    1333200n 1.8
+    1333299n 1.8
+    1333300n 0
+    1333599n 0
+    1333600n 1.8
+    1333699n 1.8
+    1333700n 0
+    1333999n 0
+    1334000n 1.8
+    1334099n 1.8
+    1334100n 0
+    1334399n 0
+    1334400n 1.8
+    1334499n 1.8
+    1334500n 0
+    1334799n 0
+    1334800n 1.8
+    1334899n 1.8
+    1334900n 0
+    1335199n 0
+    1335200n 1.8
+    1335299n 1.8
+    1335300n 0
+    1335599n 0
+    1335600n 1.8
+    1335699n 1.8
+    1335700n 0
+    1335999n 0
+    1336000n 1.8
+    1336099n 1.8
+    1336100n 0
+    1336399n 0
+    1336400n 1.8
+    1336499n 1.8
+    1336500n 0
+    1336799n 0
+    1336800n 1.8
+    1336899n 1.8
+    1336900n 0
+    1337199n 0
+    1337200n 1.8
+    1337299n 1.8
+    1337300n 0
+    1337599n 0
+    1337600n 1.8
+    1337699n 1.8
+    1337700n 0
+    1337999n 0
+    1338000n 1.8
+    1338099n 1.8
+    1338100n 0
+    1338399n 0
+    1338400n 1.8
+    1338499n 1.8
+    1338500n 0
+    1338799n 0
+    1338800n 1.8
+    1338899n 1.8
+    1338900n 0
+    1339199n 0
+    1339200n 1.8
+    1339299n 1.8
+    1339300n 0
+    1339599n 0
+    1339600n 1.8
+    1339699n 1.8
+    1339700n 0
+    1339999n 0
+    1340000n 1.8
+    1340099n 1.8
+    1340100n 0
+    1340399n 0
+    1340400n 1.8
+    1340499n 1.8
+    1340500n 0
+    1340799n 0
+    1340800n 1.8
+    1340899n 1.8
+    1340900n 0
+    1341199n 0
+    1341200n 1.8
+    1341299n 1.8
+    1341300n 0
+    1341599n 0
+    1341600n 1.8
+    1341699n 1.8
+    1341700n 0
+    1341999n 0
+    1342000n 1.8
+    1342099n 1.8
+    1342100n 0
+    1342399n 0
+    1342400n 1.8
+    1342499n 1.8
+    1342500n 0
+    1342799n 0
+    1342800n 1.8
+    1342899n 1.8
+    1342900n 0
+    1343199n 0
+    1343200n 1.8
+    1343299n 1.8
+    1343300n 0
+    1343599n 0
+    1343600n 1.8
+    1343699n 1.8
+    1343700n 0
+    1343999n 0
+    1344000n 1.8
+    1344099n 1.8
+    1344100n 0
+    1344399n 0
+    1344400n 1.8
+    1344499n 1.8
+    1344500n 0
+    1344799n 0
+    1344800n 1.8
+    1344899n 1.8
+    1344900n 0
+    1345199n 0
+    1345200n 1.8
+    1345299n 1.8
+    1345300n 0
+    1345599n 0
+    1345600n 1.8
+    1345699n 1.8
+    1345700n 0
+    1345999n 0
+    1346000n 1.8
+    1346099n 1.8
+    1346100n 0
+    1346399n 0
+    1346400n 1.8
+    1346499n 1.8
+    1346500n 0
+    1346799n 0
+    1346800n 1.8
+    1346899n 1.8
+    1346900n 0
+    1347199n 0
+    1347200n 1.8
+    1347299n 1.8
+    1347300n 0
+    1347599n 0
+    1347600n 1.8
+    1347699n 1.8
+    1347700n 0
+    1347999n 0
+    1348000n 1.8
+    1348099n 1.8
+    1348100n 0
+    1348399n 0
+    1348400n 1.8
+    1348499n 1.8
+    1348500n 0
+    1348799n 0
+    1348800n 1.8
+    1348899n 1.8
+    1348900n 0
+    1349199n 0
+    1349200n 1.8
+    1349299n 1.8
+    1349300n 0
+    1349599n 0
+    1349600n 1.8
+    1349699n 1.8
+    1349700n 0
+    1349999n 0
+    1350000n 1.8
+    1350099n 1.8
+    1350100n 0
+    1350399n 0
+    1350400n 1.8
+    1350499n 1.8
+    1350500n 0
+    1350799n 0
+    1350800n 1.8
+    1350899n 1.8
+    1350900n 0
+    1351199n 0
+    1351200n 1.8
+    1351299n 1.8
+    1351300n 0
+    1351599n 0
+    1351600n 1.8
+    1351699n 1.8
+    1351700n 0
+    1351999n 0
+    1352000n 1.8
+    1352099n 1.8
+    1352100n 0
+    1352399n 0
+    1352400n 1.8
+    1352499n 1.8
+    1352500n 0
+    1352799n 0
+    1352800n 1.8
+    1352899n 1.8
+    1352900n 0
+    1353199n 0
+    1353200n 1.8
+    1353299n 1.8
+    1353300n 0
+    1353599n 0
+    1353600n 1.8
+    1353699n 1.8
+    1353700n 0
+    1353999n 0
+    1354000n 1.8
+    1354099n 1.8
+    1354100n 0
+    1354399n 0
+    1354400n 1.8
+    1354499n 1.8
+    1354500n 0
+    1354799n 0
+    1354800n 1.8
+    1354899n 1.8
+    1354900n 0
+    1355199n 0
+    1355200n 1.8
+    1355299n 1.8
+    1355300n 0
+    1355599n 0
+    1355600n 1.8
+    1355699n 1.8
+    1355700n 0
+    1355999n 0
+    1356000n 1.8
+    1356099n 1.8
+    1356100n 0
+    1356399n 0
+    1356400n 1.8
+    1356499n 1.8
+    1356500n 0
+    1356799n 0
+    1356800n 1.8
+    1356899n 1.8
+    1356900n 0
+    1357199n 0
+    1357200n 1.8
+    1357299n 1.8
+    1357300n 0
+    1357599n 0
+    1357600n 1.8
+    1357699n 1.8
+    1357700n 0
+    1357999n 0
+    1358000n 1.8
+    1358099n 1.8
+    1358100n 0
+    1358399n 0
+    1358400n 1.8
+    1358499n 1.8
+    1358500n 0
+    1358799n 0
+    1358800n 1.8
+    1358899n 1.8
+    1358900n 0
+    1359199n 0
+    1359200n 1.8
+    1359299n 1.8
+    1359300n 0
+    1359599n 0
+    1359600n 1.8
+    1359699n 1.8
+    1359700n 0
+    1359999n 0
+    1360000n 1.8
+    1360099n 1.8
+    1360100n 0
+    1360399n 0
+    1360400n 1.8
+    1360499n 1.8
+    1360500n 0
+    1360799n 0
+    1360800n 1.8
+    1360899n 1.8
+    1360900n 0
+    1361199n 0
+    1361200n 1.8
+    1361299n 1.8
+    1361300n 0
+    1361599n 0
+    1361600n 1.8
+    1361699n 1.8
+    1361700n 0
+    1361999n 0
+    1362000n 1.8
+    1362099n 1.8
+    1362100n 0
+    1362399n 0
+    1362400n 1.8
+    1362499n 1.8
+    1362500n 0
+    1362799n 0
+    1362800n 1.8
+    1362899n 1.8
+    1362900n 0
+    1363199n 0
+    1363200n 1.8
+    1363299n 1.8
+    1363300n 0
+    1363599n 0
+    1363600n 1.8
+    1363699n 1.8
+    1363700n 0
+    1363999n 0
+    1364000n 1.8
+    1364099n 1.8
+    1364100n 0
+    1364399n 0
+    1364400n 1.8
+    1364499n 1.8
+    1364500n 0
+    1364799n 0
+    1364800n 1.8
+    1364899n 1.8
+    1364900n 0
+    1365199n 0
+    1365200n 1.8
+    1365299n 1.8
+    1365300n 0
+    1365599n 0
+    1365600n 1.8
+    1365699n 1.8
+    1365700n 0
+    1365999n 0
+    1366000n 1.8
+    1366099n 1.8
+    1366100n 0
+    1366399n 0
+    1366400n 1.8
+    1366499n 1.8
+    1366500n 0
+    1366799n 0
+    1366800n 1.8
+    1366899n 1.8
+    1366900n 0
+    1367199n 0
+    1367200n 1.8
+    1367299n 1.8
+    1367300n 0
+    1367599n 0
+    1367600n 1.8
+    1367699n 1.8
+    1367700n 0
+    1367999n 0
+    1368000n 1.8
+    1368099n 1.8
+    1368100n 0
+    1368399n 0
+    1368400n 1.8
+    1368499n 1.8
+    1368500n 0
+    1368799n 0
+    1368800n 1.8
+    1368899n 1.8
+    1368900n 0
+    1369199n 0
+    1369200n 1.8
+    1369299n 1.8
+    1369300n 0
+    1369599n 0
+    1369600n 1.8
+    1369699n 1.8
+    1369700n 0
+    1369999n 0
+    1370000n 1.8
+    1370099n 1.8
+    1370100n 0
+    1370399n 0
+    1370400n 1.8
+    1370499n 1.8
+    1370500n 0
+    1370799n 0
+    1370800n 1.8
+    1370899n 1.8
+    1370900n 0
+    1371199n 0
+    1371200n 1.8
+    1371299n 1.8
+    1371300n 0
+    1371599n 0
+    1371600n 1.8
+    1371699n 1.8
+    1371700n 0
+    1371999n 0
+    1372000n 1.8
+    1372099n 1.8
+    1372100n 0
+    1372399n 0
+    1372400n 1.8
+    1372499n 1.8
+    1372500n 0
+    1372799n 0
+    1372800n 1.8
+    1372899n 1.8
+    1372900n 0
+    1373199n 0
+    1373200n 1.8
+    1373299n 1.8
+    1373300n 0
+    1373599n 0
+    1373600n 1.8
+    1373699n 1.8
+    1373700n 0
+    1373999n 0
+    1374000n 1.8
+    1374099n 1.8
+    1374100n 0
+    1374399n 0
+    1374400n 1.8
+    1374499n 1.8
+    1374500n 0
+    1374799n 0
+    1374800n 1.8
+    1374899n 1.8
+    1374900n 0
+    1375199n 0
+    1375200n 1.8
+    1375299n 1.8
+    1375300n 0
+    1375599n 0
+    1375600n 1.8
+    1375699n 1.8
+    1375700n 0
+    1375999n 0
+    1376000n 1.8
+    1376099n 1.8
+    1376100n 0
+    1376399n 0
+    1376400n 1.8
+    1376499n 1.8
+    1376500n 0
+    1376799n 0
+    1376800n 1.8
+    1376899n 1.8
+    1376900n 0
+    1377199n 0
+    1377200n 1.8
+    1377299n 1.8
+    1377300n 0
+    1377599n 0
+    1377600n 1.8
+    1377699n 1.8
+    1377700n 0
+    1377999n 0
+    1378000n 1.8
+    1378099n 1.8
+    1378100n 0
+    1378399n 0
+    1378400n 1.8
+    1378499n 1.8
+    1378500n 0
+    1378799n 0
+    1378800n 1.8
+    1378899n 1.8
+    1378900n 0
+    1379199n 0
+    1379200n 1.8
+    1379299n 1.8
+    1379300n 0
+    1379599n 0
+    1379600n 1.8
+    1379699n 1.8
+    1379700n 0
+    1379999n 0
+    1380000n 1.8
+    1380099n 1.8
+    1380100n 0
+    1380399n 0
+    1380400n 1.8
+    1380499n 1.8
+    1380500n 0
+    1380799n 0
+    1380800n 1.8
+    1380899n 1.8
+    1380900n 0
+    1381199n 0
+    1381200n 1.8
+    1381299n 1.8
+    1381300n 0
+    1381599n 0
+    1381600n 1.8
+    1381699n 1.8
+    1381700n 0
+    1381999n 0
+    1382000n 1.8
+    1382099n 1.8
+    1382100n 0
+    1382399n 0
+    1382400n 1.8
+    1382499n 1.8
+    1382500n 0
+    1382799n 0
+    1382800n 1.8
+    1382899n 1.8
+    1382900n 0
+    1383199n 0
+    1383200n 1.8
+    1383299n 1.8
+    1383300n 0
+    1383599n 0
+    1383600n 1.8
+    1383699n 1.8
+    1383700n 0
+    1383999n 0
+    1384000n 1.8
+    1384099n 1.8
+    1384100n 0
+    1384399n 0
+    1384400n 1.8
+    1384499n 1.8
+    1384500n 0
+    1384799n 0
+    1384800n 1.8
+    1384899n 1.8
+    1384900n 0
+    1385199n 0
+    1385200n 1.8
+    1385299n 1.8
+    1385300n 0
+    1385599n 0
+    1385600n 1.8
+    1385699n 1.8
+    1385700n 0
+    1385999n 0
+    1386000n 1.8
+    1386099n 1.8
+    1386100n 0
+    1386399n 0
+    1386400n 1.8
+    1386499n 1.8
+    1386500n 0
+    1386799n 0
+    1386800n 1.8
+    1386899n 1.8
+    1386900n 0
+    1387199n 0
+    1387200n 1.8
+    1387299n 1.8
+    1387300n 0
+    1387599n 0
+    1387600n 1.8
+    1387699n 1.8
+    1387700n 0
+    1387999n 0
+    1388000n 1.8
+    1388099n 1.8
+    1388100n 0
+    1388399n 0
+    1388400n 1.8
+    1388499n 1.8
+    1388500n 0
+    1388799n 0
+    1388800n 1.8
+    1388899n 1.8
+    1388900n 0
+    1389199n 0
+    1389200n 1.8
+    1389299n 1.8
+    1389300n 0
+    1389599n 0
+    1389600n 1.8
+    1389699n 1.8
+    1389700n 0
+    1389999n 0
+    1390000n 1.8
+    1390099n 1.8
+    1390100n 0
+    1390399n 0
+    1390400n 1.8
+    1390499n 1.8
+    1390500n 0
+    1390799n 0
+    1390800n 1.8
+    1390899n 1.8
+    1390900n 0
+    1391199n 0
+    1391200n 1.8
+    1391299n 1.8
+    1391300n 0
+    1391599n 0
+    1391600n 1.8
+    1391699n 1.8
+    1391700n 0
+    1391999n 0
+    1392000n 1.8
+    1392099n 1.8
+    1392100n 0
+    1392399n 0
+    1392400n 1.8
+    1392499n 1.8
+    1392500n 0
+    1392799n 0
+    1392800n 1.8
+    1392899n 1.8
+    1392900n 0
+    1393199n 0
+    1393200n 1.8
+    1393299n 1.8
+    1393300n 0
+    1393599n 0
+    1393600n 1.8
+    1393699n 1.8
+    1393700n 0
+    1393999n 0
+    1394000n 1.8
+    1394099n 1.8
+    1394100n 0
+    1394399n 0
+    1394400n 1.8
+    1394499n 1.8
+    1394500n 0
+    1394799n 0
+    1394800n 1.8
+    1394899n 1.8
+    1394900n 0
+    1395199n 0
+    1395200n 1.8
+    1395299n 1.8
+    1395300n 0
+    1395599n 0
+    1395600n 1.8
+    1395699n 1.8
+    1395700n 0
+    1395999n 0
+    1396000n 1.8
+    1396099n 1.8
+    1396100n 0
+    1396399n 0
+    1396400n 1.8
+    1396499n 1.8
+    1396500n 0
+    1396799n 0
+    1396800n 1.8
+    1396899n 1.8
+    1396900n 0
+    1397199n 0
+    1397200n 1.8
+    1397299n 1.8
+    1397300n 0
+    1397599n 0
+    1397600n 1.8
+    1397699n 1.8
+    1397700n 0
+    1397999n 0
+    1398000n 1.8
+    1398099n 1.8
+    1398100n 0
+    1398399n 0
+    1398400n 1.8
+    1398499n 1.8
+    1398500n 0
+    1398799n 0
+    1398800n 1.8
+    1398899n 1.8
+    1398900n 0
+    1399199n 0
+    1399200n 1.8
+    1399299n 1.8
+    1399300n 0
+    1399599n 0
+    1399600n 1.8
+    1399699n 1.8
+    1399700n 0
+    1399999n 0
+    1400000n 1.8
+    1400099n 1.8
+    1400100n 0
+    1400399n 0
+    1400400n 1.8
+    1400499n 1.8
+    1400500n 0
+    1400799n 0
+    1400800n 1.8
+    1400899n 1.8
+    1400900n 0
+    1401199n 0
+    1401200n 1.8
+    1401299n 1.8
+    1401300n 0
+    1401599n 0
+    1401600n 1.8
+    1401699n 1.8
+    1401700n 0
+    1401999n 0
+    1402000n 1.8
+    1402099n 1.8
+    1402100n 0
+    1402399n 0
+    1402400n 1.8
+    1402499n 1.8
+    1402500n 0
+    1402799n 0
+    1402800n 1.8
+    1402899n 1.8
+    1402900n 0
+    1403199n 0
+    1403200n 1.8
+    1403299n 1.8
+    1403300n 0
+    1403599n 0
+    1403600n 1.8
+    1403699n 1.8
+    1403700n 0
+    1403999n 0
+    1404000n 1.8
+    1404099n 1.8
+    1404100n 0
+    1404399n 0
+    1404400n 1.8
+    1404499n 1.8
+    1404500n 0
+    1404799n 0
+    1404800n 1.8
+    1404899n 1.8
+    1404900n 0
+    1405199n 0
+    1405200n 1.8
+    1405299n 1.8
+    1405300n 0
+    1405599n 0
+    1405600n 1.8
+    1405699n 1.8
+    1405700n 0
+    1405999n 0
+    1406000n 1.8
+    1406099n 1.8
+    1406100n 0
+    1406399n 0
+    1406400n 1.8
+    1406499n 1.8
+    1406500n 0
+    1406799n 0
+    1406800n 1.8
+    1406899n 1.8
+    1406900n 0
+    1407199n 0
+    1407200n 1.8
+    1407299n 1.8
+    1407300n 0
+    1407599n 0
+    1407600n 1.8
+    1407699n 1.8
+    1407700n 0
+    1407999n 0
+    1408000n 1.8
+    1408099n 1.8
+    1408100n 0
+    1408399n 0
+    1408400n 1.8
+    1408499n 1.8
+    1408500n 0
+    1408799n 0
+    1408800n 1.8
+    1408899n 1.8
+    1408900n 0
+    1409199n 0
+    1409200n 1.8
+    1409299n 1.8
+    1409300n 0
+    1409599n 0
+    1409600n 1.8
+    1409699n 1.8
+    1409700n 0
+    1409999n 0
+    1410000n 1.8
+    1410099n 1.8
+    1410100n 0
+    1410399n 0
+    1410400n 1.8
+    1410499n 1.8
+    1410500n 0
+    1410799n 0
+    1410800n 1.8
+    1410899n 1.8
+    1410900n 0
+    1411199n 0
+    1411200n 1.8
+    1411299n 1.8
+    1411300n 0
+    1411599n 0
+    1411600n 1.8
+    1411699n 1.8
+    1411700n 0
+    1411999n 0
+    1412000n 1.8
+    1412099n 1.8
+    1412100n 0
+    1412399n 0
+    1412400n 1.8
+    1412499n 1.8
+    1412500n 0
+    1412799n 0
+    1412800n 1.8
+    1412899n 1.8
+    1412900n 0
+    1413199n 0
+    1413200n 1.8
+    1413299n 1.8
+    1413300n 0
+    1413599n 0
+    1413600n 1.8
+    1413699n 1.8
+    1413700n 0
+    1413999n 0
+    1414000n 1.8
+    1414099n 1.8
+    1414100n 0
+    1414399n 0
+    1414400n 1.8
+    1414499n 1.8
+    1414500n 0
+    1414799n 0
+    1414800n 1.8
+    1414899n 1.8
+    1414900n 0
+    1415199n 0
+    1415200n 1.8
+    1415299n 1.8
+    1415300n 0
+    1415599n 0
+    1415600n 1.8
+    1415699n 1.8
+    1415700n 0
+    1415999n 0
+    1416000n 1.8
+    1416099n 1.8
+    1416100n 0
+    1416399n 0
+    1416400n 1.8
+    1416499n 1.8
+    1416500n 0
+    1416799n 0
+    1416800n 1.8
+    1416899n 1.8
+    1416900n 0
+    1417199n 0
+    1417200n 1.8
+    1417299n 1.8
+    1417300n 0
+    1417599n 0
+    1417600n 1.8
+    1417699n 1.8
+    1417700n 0
+    1417999n 0
+    1418000n 1.8
+    1418099n 1.8
+    1418100n 0
+    1418399n 0
+    1418400n 1.8
+    1418499n 1.8
+    1418500n 0
+    1418799n 0
+    1418800n 1.8
+    1418899n 1.8
+    1418900n 0
+    1419199n 0
+    1419200n 1.8
+    1419299n 1.8
+    1419300n 0
+    1419599n 0
+    1419600n 1.8
+    1419699n 1.8
+    1419700n 0
+    1419999n 0
+    1420000n 1.8
+    1420099n 1.8
+    1420100n 0
+    1420399n 0
+    1420400n 1.8
+    1420499n 1.8
+    1420500n 0
+    1420799n 0
+    1420800n 1.8
+    1420899n 1.8
+    1420900n 0
+    1421199n 0
+    1421200n 1.8
+    1421299n 1.8
+    1421300n 0
+    1421599n 0
+    1421600n 1.8
+    1421699n 1.8
+    1421700n 0
+    1421999n 0
+    1422000n 1.8
+    1422099n 1.8
+    1422100n 0
+    1422399n 0
+    1422400n 1.8
+    1422499n 1.8
+    1422500n 0
+    1422799n 0
+    1422800n 1.8
+    1422899n 1.8
+    1422900n 0
+    1423199n 0
+    1423200n 1.8
+    1423299n 1.8
+    1423300n 0
+    1423599n 0
+    1423600n 1.8
+    1423699n 1.8
+    1423700n 0
+    1423999n 0
+    1424000n 1.8
+    1424099n 1.8
+    1424100n 0
+    1424399n 0
+    1424400n 1.8
+    1424499n 1.8
+    1424500n 0
+    1424799n 0
+    1424800n 1.8
+    1424899n 1.8
+    1424900n 0
+    1425199n 0
+    1425200n 1.8
+    1425299n 1.8
+    1425300n 0
+    1425599n 0
+    1425600n 1.8
+    1425699n 1.8
+    1425700n 0
+    1425999n 0
+    1426000n 1.8
+    1426099n 1.8
+    1426100n 0
+    1426399n 0
+    1426400n 1.8
+    1426499n 1.8
+    1426500n 0
+    1426799n 0
+    1426800n 1.8
+    1426899n 1.8
+    1426900n 0
+    1427199n 0
+    1427200n 1.8
+    1427299n 1.8
+    1427300n 0
+    1427599n 0
+    1427600n 1.8
+    1427699n 1.8
+    1427700n 0
+    1427999n 0
+    1428000n 1.8
+    1428099n 1.8
+    1428100n 0
+    1428399n 0
+    1428400n 1.8
+    1428499n 1.8
+    1428500n 0
+    1428799n 0
+    1428800n 1.8
+    1428899n 1.8
+    1428900n 0
+    1429199n 0
+    1429200n 1.8
+    1429299n 1.8
+    1429300n 0
+    1429599n 0
+    1429600n 1.8
+    1429699n 1.8
+    1429700n 0
+    1429999n 0
+    1430000n 1.8
+    1430099n 1.8
+    1430100n 0
+    1430399n 0
+    1430400n 1.8
+    1430499n 1.8
+    1430500n 0
+    1430799n 0
+    1430800n 1.8
+    1430899n 1.8
+    1430900n 0
+    1431199n 0
+    1431200n 1.8
+    1431299n 1.8
+    1431300n 0
+    1431599n 0
+    1431600n 1.8
+    1431699n 1.8
+    1431700n 0
+    1431999n 0
+    1432000n 1.8
+    1432099n 1.8
+    1432100n 0
+    1432399n 0
+    1432400n 1.8
+    1432499n 1.8
+    1432500n 0
+    1432799n 0
+    1432800n 1.8
+    1432899n 1.8
+    1432900n 0
+    1433199n 0
+    1433200n 1.8
+    1433299n 1.8
+    1433300n 0
+    1433599n 0
+    1433600n 1.8
+    1433699n 1.8
+    1433700n 0
+    1433999n 0
+    1434000n 1.8
+    1434099n 1.8
+    1434100n 0
+    1434399n 0
+    1434400n 1.8
+    1434499n 1.8
+    1434500n 0
+    1434799n 0
+    1434800n 1.8
+    1434899n 1.8
+    1434900n 0
+    1435199n 0
+    1435200n 1.8
+    1435299n 1.8
+    1435300n 0
+    1435599n 0
+    1435600n 1.8
+    1435699n 1.8
+    1435700n 0
+    1435999n 0
+    1436000n 1.8
+    1436099n 1.8
+    1436100n 0
+    1436399n 0
+    1436400n 1.8
+    1436499n 1.8
+    1436500n 0
+    1436799n 0
+    1436800n 1.8
+    1436899n 1.8
+    1436900n 0
+    1437199n 0
+    1437200n 1.8
+    1437299n 1.8
+    1437300n 0
+    1437599n 0
+    1437600n 1.8
+    1437699n 1.8
+    1437700n 0
+    1437999n 0
+    1438000n 1.8
+    1438099n 1.8
+    1438100n 0
+    1438399n 0
+    1438400n 1.8
+    1438499n 1.8
+    1438500n 0
+    1438799n 0
+    1438800n 1.8
+    1438899n 1.8
+    1438900n 0
+    1439199n 0
+    1439200n 1.8
+    1439299n 1.8
+    1439300n 0
+    1439599n 0
+    1439600n 1.8
+    1439699n 1.8
+    1439700n 0
+    1439999n 0
+    1440000n 1.8
+    1440099n 1.8
+    1440100n 0
+    1440399n 0
+    1440400n 1.8
+    1440499n 1.8
+    1440500n 0
+    1440799n 0
+    1440800n 1.8
+    1440899n 1.8
+    1440900n 0
+    1441199n 0
+    1441200n 1.8
+    1441299n 1.8
+    1441300n 0
+    1441599n 0
+    1441600n 1.8
+    1441699n 1.8
+    1441700n 0
+    1441999n 0
+    1442000n 1.8
+    1442099n 1.8
+    1442100n 0
+    1442399n 0
+    1442400n 1.8
+    1442499n 1.8
+    1442500n 0
+    1442799n 0
+    1442800n 1.8
+    1442899n 1.8
+    1442900n 0
+    1443199n 0
+    1443200n 1.8
+    1443299n 1.8
+    1443300n 0
+    1443599n 0
+    1443600n 1.8
+    1443699n 1.8
+    1443700n 0
+    1443999n 0
+    1444000n 1.8
+    1444099n 1.8
+    1444100n 0
+    1444399n 0
+    1444400n 1.8
+    1444499n 1.8
+    1444500n 0
+    1444799n 0
+    1444800n 1.8
+    1444899n 1.8
+    1444900n 0
+    1445199n 0
+    1445200n 1.8
+    1445299n 1.8
+    1445300n 0
+    1445599n 0
+    1445600n 1.8
+    1445699n 1.8
+    1445700n 0
+    1445999n 0
+    1446000n 1.8
+    1446099n 1.8
+    1446100n 0
+    1446399n 0
+    1446400n 1.8
+    1446499n 1.8
+    1446500n 0
+    1446799n 0
+    1446800n 1.8
+    1446899n 1.8
+    1446900n 0
+    1447199n 0
+    1447200n 1.8
+    1447299n 1.8
+    1447300n 0
+    1447599n 0
+    1447600n 1.8
+    1447699n 1.8
+    1447700n 0
+    1447999n 0
+    1448000n 1.8
+    1448099n 1.8
+    1448100n 0
+    1448399n 0
+    1448400n 1.8
+    1448499n 1.8
+    1448500n 0
+    1448799n 0
+    1448800n 1.8
+    1448899n 1.8
+    1448900n 0
+    1449199n 0
+    1449200n 1.8
+    1449299n 1.8
+    1449300n 0
+    1449599n 0
+    1449600n 1.8
+    1449699n 1.8
+    1449700n 0
+    1449999n 0
+    1450000n 1.8
+    1450099n 1.8
+    1450100n 0
+    1450399n 0
+    1450400n 1.8
+    1450499n 1.8
+    1450500n 0
+    1450799n 0
+    1450800n 1.8
+    1450899n 1.8
+    1450900n 0
+    1451199n 0
+    1451200n 1.8
+    1451299n 1.8
+    1451300n 0
+    1451599n 0
+    1451600n 1.8
+    1451699n 1.8
+    1451700n 0
+    1451999n 0
+    1452000n 1.8
+    1452099n 1.8
+    1452100n 0
+    1452399n 0
+    1452400n 1.8
+    1452499n 1.8
+    1452500n 0
+    1452799n 0
+    1452800n 1.8
+    1452899n 1.8
+    1452900n 0
+    1453199n 0
+    1453200n 1.8
+    1453299n 1.8
+    1453300n 0
+    1453599n 0
+    1453600n 1.8
+    1453699n 1.8
+    1453700n 0
+    1453999n 0
+    1454000n 1.8
+    1454099n 1.8
+    1454100n 0
+    1454399n 0
+    1454400n 1.8
+    1454499n 1.8
+    1454500n 0
+    1454799n 0
+    1454800n 1.8
+    1454899n 1.8
+    1454900n 0
+    1455199n 0
+    1455200n 1.8
+    1455299n 1.8
+    1455300n 0
+    1455599n 0
+    1455600n 1.8
+    1455699n 1.8
+    1455700n 0
+    1455999n 0
+    1456000n 1.8
+    1456099n 1.8
+    1456100n 0
+    1456399n 0
+    1456400n 1.8
+    1456499n 1.8
+    1456500n 0
+    1456799n 0
+    1456800n 1.8
+    1456899n 1.8
+    1456900n 0
+    1457199n 0
+    1457200n 1.8
+    1457299n 1.8
+    1457300n 0
+    1457599n 0
+    1457600n 1.8
+    1457699n 1.8
+    1457700n 0
+    1457999n 0
+    1458000n 1.8
+    1458099n 1.8
+    1458100n 0
+    1458399n 0
+    1458400n 1.8
+    1458499n 1.8
+    1458500n 0
+    1458799n 0
+    1458800n 1.8
+    1458899n 1.8
+    1458900n 0
+    1459199n 0
+    1459200n 1.8
+    1459299n 1.8
+    1459300n 0
+    1459599n 0
+    1459600n 1.8
+    1459699n 1.8
+    1459700n 0
+    1459999n 0
+    1460000n 1.8
+    1460099n 1.8
+    1460100n 0
+    1460399n 0
+    1460400n 1.8
+    1460499n 1.8
+    1460500n 0
+    1460799n 0
+    1460800n 1.8
+    1460899n 1.8
+    1460900n 0
+    1461199n 0
+    1461200n 1.8
+    1461299n 1.8
+    1461300n 0
+    1461599n 0
+    1461600n 1.8
+    1461699n 1.8
+    1461700n 0
+    1461999n 0
+    1462000n 1.8
+    1462099n 1.8
+    1462100n 0
+    1462399n 0
+    1462400n 1.8
+    1462499n 1.8
+    1462500n 0
+    1462799n 0
+    1462800n 1.8
+    1462899n 1.8
+    1462900n 0
+    1463199n 0
+    1463200n 1.8
+    1463299n 1.8
+    1463300n 0
+    1463599n 0
+    1463600n 1.8
+    1463699n 1.8
+    1463700n 0
+    1463999n 0
+    1464000n 1.8
+    1464099n 1.8
+    1464100n 0
+    1464399n 0
+    1464400n 1.8
+    1464499n 1.8
+    1464500n 0
+    1464799n 0
+    1464800n 1.8
+    1464899n 1.8
+    1464900n 0
+    1465199n 0
+    1465200n 1.8
+    1465299n 1.8
+    1465300n 0
+    1465599n 0
+    1465600n 1.8
+    1465699n 1.8
+    1465700n 0
+    1465999n 0
+    1466000n 1.8
+    1466099n 1.8
+    1466100n 0
+    1466399n 0
+    1466400n 1.8
+    1466499n 1.8
+    1466500n 0
+    1466799n 0
+    1466800n 1.8
+    1466899n 1.8
+    1466900n 0
+    1467199n 0
+    1467200n 1.8
+    1467299n 1.8
+    1467300n 0
+    1467599n 0
+    1467600n 1.8
+    1467699n 1.8
+    1467700n 0
+    1467999n 0
+    1468000n 1.8
+    1468099n 1.8
+    1468100n 0
+    1468399n 0
+    1468400n 1.8
+    1468499n 1.8
+    1468500n 0
+    1468799n 0
+    1468800n 1.8
+    1468899n 1.8
+    1468900n 0
+    1469199n 0
+    1469200n 1.8
+    1469299n 1.8
+    1469300n 0
+    1469599n 0
+    1469600n 1.8
+    1469699n 1.8
+    1469700n 0
+    1469999n 0
+    1470000n 1.8
+    1470099n 1.8
+    1470100n 0
+    1470399n 0
+    1470400n 1.8
+    1470499n 1.8
+    1470500n 0
+    1470799n 0
+    1470800n 1.8
+    1470899n 1.8
+    1470900n 0
+    1471199n 0
+    1471200n 1.8
+    1471299n 1.8
+    1471300n 0
+    1471599n 0
+    1471600n 1.8
+    1471699n 1.8
+    1471700n 0
+    1471999n 0
+    1472000n 1.8
+    1472099n 1.8
+    1472100n 0
+    1472399n 0
+    1472400n 1.8
+    1472499n 1.8
+    1472500n 0
+    1472799n 0
+    1472800n 1.8
+    1472899n 1.8
+    1472900n 0
+    1473199n 0
+    1473200n 1.8
+    1473299n 1.8
+    1473300n 0
+    1473599n 0
+    1473600n 1.8
+    1473699n 1.8
+    1473700n 0
+    1473999n 0
+    1474000n 1.8
+    1474099n 1.8
+    1474100n 0
+    1474399n 0
+    1474400n 1.8
+    1474499n 1.8
+    1474500n 0
+    1474799n 0
+    1474800n 1.8
+    1474899n 1.8
+    1474900n 0
+    1475199n 0
+    1475200n 1.8
+    1475299n 1.8
+    1475300n 0
+    1475599n 0
+    1475600n 1.8
+    1475699n 1.8
+    1475700n 0
+    1475999n 0
+    1476000n 1.8
+    1476099n 1.8
+    1476100n 0
+    1476399n 0
+    1476400n 1.8
+    1476499n 1.8
+    1476500n 0
+    1476799n 0
+    1476800n 1.8
+    1476899n 1.8
+    1476900n 0
+    1477199n 0
+    1477200n 1.8
+    1477299n 1.8
+    1477300n 0
+    1477599n 0
+    1477600n 1.8
+    1477699n 1.8
+    1477700n 0
+    1477999n 0
+    1478000n 1.8
+    1478099n 1.8
+    1478100n 0
+    1478399n 0
+    1478400n 1.8
+    1478499n 1.8
+    1478500n 0
+    1478799n 0
+    1478800n 1.8
+    1478899n 1.8
+    1478900n 0
+    1479199n 0
+    1479200n 1.8
+    1479299n 1.8
+    1479300n 0
+    1479599n 0
+    1479600n 1.8
+    1479699n 1.8
+    1479700n 0
+    1479999n 0
+    1480000n 1.8
+    1480099n 1.8
+    1480100n 0
+    1480399n 0
+    1480400n 1.8
+    1480499n 1.8
+    1480500n 0
+    1480799n 0
+    1480800n 1.8
+    1480899n 1.8
+    1480900n 0
+    1481199n 0
+    1481200n 1.8
+    1481299n 1.8
+    1481300n 0
+    1481599n 0
+    1481600n 1.8
+    1481699n 1.8
+    1481700n 0
+    1481999n 0
+    1482000n 1.8
+    1482099n 1.8
+    1482100n 0
+    1482399n 0
+    1482400n 1.8
+    1482499n 1.8
+    1482500n 0
+    1482799n 0
+    1482800n 1.8
+    1482899n 1.8
+    1482900n 0
+    1483199n 0
+    1483200n 1.8
+    1483299n 1.8
+    1483300n 0
+    1483599n 0
+    1483600n 1.8
+    1483699n 1.8
+    1483700n 0
+    1483999n 0
+    1484000n 1.8
+    1484099n 1.8
+    1484100n 0
+    1484399n 0
+    1484400n 1.8
+    1484499n 1.8
+    1484500n 0
+    1484799n 0
+    1484800n 1.8
+    1484899n 1.8
+    1484900n 0
+    1485199n 0
+    1485200n 1.8
+    1485299n 1.8
+    1485300n 0
+    1485599n 0
+    1485600n 1.8
+    1485699n 1.8
+    1485700n 0
+    1485999n 0
+    1486000n 1.8
+    1486099n 1.8
+    1486100n 0
+    1486399n 0
+    1486400n 1.8
+    1486499n 1.8
+    1486500n 0
+    1486799n 0
+    1486800n 1.8
+    1486899n 1.8
+    1486900n 0
+    1487199n 0
+    1487200n 1.8
+    1487299n 1.8
+    1487300n 0
+    1487599n 0
+    1487600n 1.8
+    1487699n 1.8
+    1487700n 0
+    1487999n 0
+    1488000n 1.8
+    1488099n 1.8
+    1488100n 0
+    1488399n 0
+    1488400n 1.8
+    1488499n 1.8
+    1488500n 0
+    1488799n 0
+    1488800n 1.8
+    1488899n 1.8
+    1488900n 0
+    1489199n 0
+    1489200n 1.8
+    1489299n 1.8
+    1489300n 0
+    1489599n 0
+    1489600n 1.8
+    1489699n 1.8
+    1489700n 0
+    1489999n 0
+    1490000n 1.8
+    1490099n 1.8
+    1490100n 0
+    1490399n 0
+    1490400n 1.8
+    1490499n 1.8
+    1490500n 0
+    1490799n 0
+    1490800n 1.8
+    1490899n 1.8
+    1490900n 0
+    1491199n 0
+    1491200n 1.8
+    1491299n 1.8
+    1491300n 0
+    1491599n 0
+    1491600n 1.8
+    1491699n 1.8
+    1491700n 0
+    1491999n 0
+    1492000n 1.8
+    1492099n 1.8
+    1492100n 0
+    1492399n 0
+    1492400n 1.8
+    1492499n 1.8
+    1492500n 0
+    1492799n 0
+    1492800n 1.8
+    1492899n 1.8
+    1492900n 0
+    1493199n 0
+    1493200n 1.8
+    1493299n 1.8
+    1493300n 0
+    1493599n 0
+    1493600n 1.8
+    1493699n 1.8
+    1493700n 0
+    1493999n 0
+    1494000n 1.8
+    1494099n 1.8
+    1494100n 0
+    1494399n 0
+    1494400n 1.8
+    1494499n 1.8
+    1494500n 0
+    1494799n 0
+    1494800n 1.8
+    1494899n 1.8
+    1494900n 0
+    1495199n 0
+    1495200n 1.8
+    1495299n 1.8
+    1495300n 0
+    1495599n 0
+    1495600n 1.8
+    1495699n 1.8
+    1495700n 0
+    1495999n 0
+    1496000n 1.8
+    1496099n 1.8
+    1496100n 0
+    1496399n 0
+    1496400n 1.8
+    1496499n 1.8
+    1496500n 0
+    1496799n 0
+    1496800n 1.8
+    1496899n 1.8
+    1496900n 0
+    1497199n 0
+    1497200n 1.8
+    1497299n 1.8
+    1497300n 0
+    1497599n 0
+    1497600n 1.8
+    1497699n 1.8
+    1497700n 0
+    1497999n 0
+    1498000n 1.8
+    1498099n 1.8
+    1498100n 0
+    1498399n 0
+    1498400n 1.8
+    1498499n 1.8
+    1498500n 0
+    1498799n 0
+    1498800n 1.8
+    1498899n 1.8
+    1498900n 0
+    1499199n 0
+    1499200n 1.8
+    1499299n 1.8
+    1499300n 0
+    1499599n 0
+    1499600n 1.8
+    1499699n 1.8
+    1499700n 0
+    1499999n 0
+    1500000n 1.8
+    1500099n 1.8
+    1500100n 0
+    1500399n 0
+    1500400n 1.8
+    1500499n 1.8
+    1500500n 0
+    1500799n 0
+    1500800n 1.8
+    1500899n 1.8
+    1500900n 0
+    1501199n 0
+    1501200n 1.8
+    1501299n 1.8
+    1501300n 0
+    1501599n 0
+    1501600n 1.8
+    1501699n 1.8
+    1501700n 0
+    1501999n 0
+    1502000n 1.8
+    1502099n 1.8
+    1502100n 0
+    1502399n 0
+    1502400n 1.8
+    1502499n 1.8
+    1502500n 0
+    1502799n 0
+    1502800n 1.8
+    1502899n 1.8
+    1502900n 0
+    1503199n 0
+    1503200n 1.8
+    1503299n 1.8
+    1503300n 0
+    1503599n 0
+    1503600n 1.8
+    1503699n 1.8
+    1503700n 0
+    1503999n 0
+    1504000n 1.8
+    1504099n 1.8
+    1504100n 0
+    1504399n 0
+    1504400n 1.8
+    1504499n 1.8
+    1504500n 0
+    1504799n 0
+    1504800n 1.8
+    1504899n 1.8
+    1504900n 0
+    1505199n 0
+    1505200n 1.8
+    1505299n 1.8
+    1505300n 0
+    1505599n 0
+    1505600n 1.8
+    1505699n 1.8
+    1505700n 0
+    1505999n 0
+    1506000n 1.8
+    1506099n 1.8
+    1506100n 0
+    1506399n 0
+    1506400n 1.8
+    1506499n 1.8
+    1506500n 0
+    1506799n 0
+    1506800n 1.8
+    1506899n 1.8
+    1506900n 0
+    1507199n 0
+    1507200n 1.8
+    1507299n 1.8
+    1507300n 0
+    1507599n 0
+    1507600n 1.8
+    1507699n 1.8
+    1507700n 0
+    1507999n 0
+    1508000n 1.8
+    1508099n 1.8
+    1508100n 0
+    1508399n 0
+    1508400n 1.8
+    1508499n 1.8
+    1508500n 0
+    1508799n 0
+    1508800n 1.8
+    1508899n 1.8
+    1508900n 0
+    1509199n 0
+    1509200n 1.8
+    1509299n 1.8
+    1509300n 0
+    1509599n 0
+    1509600n 1.8
+    1509699n 1.8
+    1509700n 0
+    1509999n 0
+    1510000n 1.8
+    1510099n 1.8
+    1510100n 0
+    1510399n 0
+    1510400n 1.8
+    1510499n 1.8
+    1510500n 0
+    1510799n 0
+    1510800n 1.8
+    1510899n 1.8
+    1510900n 0
+    1511199n 0
+    1511200n 1.8
+    1511299n 1.8
+    1511300n 0
+    1511599n 0
+    1511600n 1.8
+    1511699n 1.8
+    1511700n 0
+    1511999n 0
+    1512000n 1.8
+    1512099n 1.8
+    1512100n 0
+    1512399n 0
+    1512400n 1.8
+    1512499n 1.8
+    1512500n 0
+    1512799n 0
+    1512800n 1.8
+    1512899n 1.8
+    1512900n 0
+    1513199n 0
+    1513200n 1.8
+    1513299n 1.8
+    1513300n 0
+    1513599n 0
+    1513600n 1.8
+    1513699n 1.8
+    1513700n 0
+    1513999n 0
+    1514000n 1.8
+    1514099n 1.8
+    1514100n 0
+    1514399n 0
+    1514400n 1.8
+    1514499n 1.8
+    1514500n 0
+    1514799n 0
+    1514800n 1.8
+    1514899n 1.8
+    1514900n 0
+    1515199n 0
+    1515200n 1.8
+    1515299n 1.8
+    1515300n 0
+    1515599n 0
+    1515600n 1.8
+    1515699n 1.8
+    1515700n 0
+    1515999n 0
+    1516000n 1.8
+    1516099n 1.8
+    1516100n 0
+    1516399n 0
+    1516400n 1.8
+    1516499n 1.8
+    1516500n 0
+    1516799n 0
+    1516800n 1.8
+    1516899n 1.8
+    1516900n 0
+    1517199n 0
+    1517200n 1.8
+    1517299n 1.8
+    1517300n 0
+    1517599n 0
+    1517600n 1.8
+    1517699n 1.8
+    1517700n 0
+    1517999n 0
+    1518000n 1.8
+    1518099n 1.8
+    1518100n 0
+    1518399n 0
+    1518400n 1.8
+    1518499n 1.8
+    1518500n 0
+    1518799n 0
+    1518800n 1.8
+    1518899n 1.8
+    1518900n 0
+    1519199n 0
+    1519200n 1.8
+    1519299n 1.8
+    1519300n 0
+    1519599n 0
+    1519600n 1.8
+    1519699n 1.8
+    1519700n 0
+    1519999n 0
+    1520000n 1.8
+    1520099n 1.8
+    1520100n 0
+    1520399n 0
+    1520400n 1.8
+    1520499n 1.8
+    1520500n 0
+    1520799n 0
+    1520800n 1.8
+    1520899n 1.8
+    1520900n 0
+    1521199n 0
+    1521200n 1.8
+    1521299n 1.8
+    1521300n 0
+    1521599n 0
+    1521600n 1.8
+    1521699n 1.8
+    1521700n 0
+    1521999n 0
+    1522000n 1.8
+    1522099n 1.8
+    1522100n 0
+    1522399n 0
+    1522400n 1.8
+    1522499n 1.8
+    1522500n 0
+    1522799n 0
+    1522800n 1.8
+    1522899n 1.8
+    1522900n 0
+    1523199n 0
+    1523200n 1.8
+    1523299n 1.8
+    1523300n 0
+    1523599n 0
+    1523600n 1.8
+    1523699n 1.8
+    1523700n 0
+    1523999n 0
+    1524000n 1.8
+    1524099n 1.8
+    1524100n 0
+    1524399n 0
+    1524400n 1.8
+    1524499n 1.8
+    1524500n 0
+    1524799n 0
+    1524800n 1.8
+    1524899n 1.8
+    1524900n 0
+    1525199n 0
+    1525200n 1.8
+    1525299n 1.8
+    1525300n 0
+    1525599n 0
+    1525600n 1.8
+    1525699n 1.8
+    1525700n 0
+    1525999n 0
+    1526000n 1.8
+    1526099n 1.8
+    1526100n 0
+    1526399n 0
+    1526400n 1.8
+    1526499n 1.8
+    1526500n 0
+    1526799n 0
+    1526800n 1.8
+    1526899n 1.8
+    1526900n 0
+    1527199n 0
+    1527200n 1.8
+    1527299n 1.8
+    1527300n 0
+    1527599n 0
+    1527600n 1.8
+    1527699n 1.8
+    1527700n 0
+    1527999n 0
+    1528000n 1.8
+    1528099n 1.8
+    1528100n 0
+    1528399n 0
+    1528400n 1.8
+    1528499n 1.8
+    1528500n 0
+    1528799n 0
+    1528800n 1.8
+    1528899n 1.8
+    1528900n 0
+    1529199n 0
+    1529200n 1.8
+    1529299n 1.8
+    1529300n 0
+    1529599n 0
+    1529600n 1.8
+    1529699n 1.8
+    1529700n 0
+    1529999n 0
+    1530000n 1.8
+    1530099n 1.8
+    1530100n 0
+    1530399n 0
+    1530400n 1.8
+    1530499n 1.8
+    1530500n 0
+    1530799n 0
+    1530800n 1.8
+    1530899n 1.8
+    1530900n 0
+    1531199n 0
+    1531200n 1.8
+    1531299n 1.8
+    1531300n 0
+    1531599n 0
+    1531600n 1.8
+    1531699n 1.8
+    1531700n 0
+    1531999n 0
+    1532000n 1.8
+    1532099n 1.8
+    1532100n 0
+    1532399n 0
+    1532400n 1.8
+    1532499n 1.8
+    1532500n 0
+    1532799n 0
+    1532800n 1.8
+    1532899n 1.8
+    1532900n 0
+    1533199n 0
+    1533200n 1.8
+    1533299n 1.8
+    1533300n 0
+    1533599n 0
+    1533600n 1.8
+    1533699n 1.8
+    1533700n 0
+    1533999n 0
+    1534000n 1.8
+    1534099n 1.8
+    1534100n 0
+    1534399n 0
+    1534400n 1.8
+    1534499n 1.8
+    1534500n 0
+    1534799n 0
+    1534800n 1.8
+    1534899n 1.8
+    1534900n 0
+    1535199n 0
+    1535200n 1.8
+    1535299n 1.8
+    1535300n 0
+    1535599n 0
+    1535600n 1.8
+    1535699n 1.8
+    1535700n 0
+    1535999n 0
+    1536000n 1.8
+    1536099n 1.8
+    1536100n 0
+    1536399n 0
+    1536400n 1.8
+    1536499n 1.8
+    1536500n 0
+    1536799n 0
+    1536800n 1.8
+    1536899n 1.8
+    1536900n 0
+    1537199n 0
+    1537200n 1.8
+    1537299n 1.8
+    1537300n 0
+    1537599n 0
+    1537600n 1.8
+    1537699n 1.8
+    1537700n 0
+    1537999n 0
+    1538000n 1.8
+    1538099n 1.8
+    1538100n 0
+    1538399n 0
+    1538400n 1.8
+    1538499n 1.8
+    1538500n 0
+    1538799n 0
+    1538800n 1.8
+    1538899n 1.8
+    1538900n 0
+    1539199n 0
+    1539200n 1.8
+    1539299n 1.8
+    1539300n 0
+    1539599n 0
+    1539600n 1.8
+    1539699n 1.8
+    1539700n 0
+    1539999n 0
+    1540000n 1.8
+    1540099n 1.8
+    1540100n 0
+    1540399n 0
+    1540400n 1.8
+    1540499n 1.8
+    1540500n 0
+    1540799n 0
+    1540800n 1.8
+    1540899n 1.8
+    1540900n 0
+    1541199n 0
+    1541200n 1.8
+    1541299n 1.8
+    1541300n 0
+    1541599n 0
+    1541600n 1.8
+    1541699n 1.8
+    1541700n 0
+    1541999n 0
+    1542000n 1.8
+    1542099n 1.8
+    1542100n 0
+    1542399n 0
+    1542400n 1.8
+    1542499n 1.8
+    1542500n 0
+    1542799n 0
+    1542800n 1.8
+    1542899n 1.8
+    1542900n 0
+    1543199n 0
+    1543200n 1.8
+    1543299n 1.8
+    1543300n 0
+    1543599n 0
+    1543600n 1.8
+    1543699n 1.8
+    1543700n 0
+    1543999n 0
+    1544000n 1.8
+    1544099n 1.8
+    1544100n 0
+    1544399n 0
+    1544400n 1.8
+    1544499n 1.8
+    1544500n 0
+    1544799n 0
+    1544800n 1.8
+    1544899n 1.8
+    1544900n 0
+    1545199n 0
+    1545200n 1.8
+    1545299n 1.8
+    1545300n 0
+    1545599n 0
+    1545600n 1.8
+    1545699n 1.8
+    1545700n 0
+    1545999n 0
+    1546000n 1.8
+    1546099n 1.8
+    1546100n 0
+    1546399n 0
+    1546400n 1.8
+    1546499n 1.8
+    1546500n 0
+    1546799n 0
+    1546800n 1.8
+    1546899n 1.8
+    1546900n 0
+    1547199n 0
+    1547200n 1.8
+    1547299n 1.8
+    1547300n 0
+    1547599n 0
+    1547600n 1.8
+    1547699n 1.8
+    1547700n 0
+    1547999n 0
+    1548000n 1.8
+    1548099n 1.8
+    1548100n 0
+    1548399n 0
+    1548400n 1.8
+    1548499n 1.8
+    1548500n 0
+    1548799n 0
+    1548800n 1.8
+    1548899n 1.8
+    1548900n 0
+    1549199n 0
+    1549200n 1.8
+    1549299n 1.8
+    1549300n 0
+    1549599n 0
+    1549600n 1.8
+    1549699n 1.8
+    1549700n 0
+    1549999n 0
+    1550000n 1.8
+    1550099n 1.8
+    1550100n 0
+    1550399n 0
+    1550400n 1.8
+    1550499n 1.8
+    1550500n 0
+    1550799n 0
+    1550800n 1.8
+    1550899n 1.8
+    1550900n 0
+    1551199n 0
+    1551200n 1.8
+    1551299n 1.8
+    1551300n 0
+    1551599n 0
+    1551600n 1.8
+    1551699n 1.8
+    1551700n 0
+    1551999n 0
+    1552000n 1.8
+    1552099n 1.8
+    1552100n 0
+    1552399n 0
+    1552400n 1.8
+    1552499n 1.8
+    1552500n 0
+    1552799n 0
+    1552800n 1.8
+    1552899n 1.8
+    1552900n 0
+    1553199n 0
+    1553200n 1.8
+    1553299n 1.8
+    1553300n 0
+    1553599n 0
+    1553600n 1.8
+    1553699n 1.8
+    1553700n 0
+    1553999n 0
+    1554000n 1.8
+    1554099n 1.8
+    1554100n 0
+    1554399n 0
+    1554400n 1.8
+    1554499n 1.8
+    1554500n 0
+    1554799n 0
+    1554800n 1.8
+    1554899n 1.8
+    1554900n 0
+    1555199n 0
+    1555200n 1.8
+    1555299n 1.8
+    1555300n 0
+    1555599n 0
+    1555600n 1.8
+    1555699n 1.8
+    1555700n 0
+    1555999n 0
+    1556000n 1.8
+    1556099n 1.8
+    1556100n 0
+    1556399n 0
+    1556400n 1.8
+    1556499n 1.8
+    1556500n 0
+    1556799n 0
+    1556800n 1.8
+    1556899n 1.8
+    1556900n 0
+    1557199n 0
+    1557200n 1.8
+    1557299n 1.8
+    1557300n 0
+    1557599n 0
+    1557600n 1.8
+    1557699n 1.8
+    1557700n 0
+    1557999n 0
+    1558000n 1.8
+    1558099n 1.8
+    1558100n 0
+    1558399n 0
+    1558400n 1.8
+    1558499n 1.8
+    1558500n 0
+    1558799n 0
+    1558800n 1.8
+    1558899n 1.8
+    1558900n 0
+    1559199n 0
+    1559200n 1.8
+    1559299n 1.8
+    1559300n 0
+    1559599n 0
+    1559600n 1.8
+    1559699n 1.8
+    1559700n 0
+    1559999n 0
+    1560000n 1.8
+    1560099n 1.8
+    1560100n 0
+    1560399n 0
+    1560400n 1.8
+    1560499n 1.8
+    1560500n 0
+    1560799n 0
+    1560800n 1.8
+    1560899n 1.8
+    1560900n 0
+    1561199n 0
+    1561200n 1.8
+    1561299n 1.8
+    1561300n 0
+    1561599n 0
+    1561600n 1.8
+    1561699n 1.8
+    1561700n 0
+    1561999n 0
+    1562000n 1.8
+    1562099n 1.8
+    1562100n 0
+    1562399n 0
+    1562400n 1.8
+    1562499n 1.8
+    1562500n 0
+    1562799n 0
+    1562800n 1.8
+    1562899n 1.8
+    1562900n 0
+    1563199n 0
+    1563200n 1.8
+    1563299n 1.8
+    1563300n 0
+    1563599n 0
+    1563600n 1.8
+    1563699n 1.8
+    1563700n 0
+    1563999n 0
+    1564000n 1.8
+    1564099n 1.8
+    1564100n 0
+    1564399n 0
+    1564400n 1.8
+    1564499n 1.8
+    1564500n 0
+    1564799n 0
+    1564800n 1.8
+    1564899n 1.8
+    1564900n 0
+    1565199n 0
+    1565200n 1.8
+    1565299n 1.8
+    1565300n 0
+    1565599n 0
+    1565600n 1.8
+    1565699n 1.8
+    1565700n 0
+    1565999n 0
+    1566000n 1.8
+    1566099n 1.8
+    1566100n 0
+    1566399n 0
+    1566400n 1.8
+    1566499n 1.8
+    1566500n 0
+    1566799n 0
+    1566800n 1.8
+    1566899n 1.8
+    1566900n 0
+    1567199n 0
+    1567200n 1.8
+    1567299n 1.8
+    1567300n 0
+    1567599n 0
+    1567600n 1.8
+    1567699n 1.8
+    1567700n 0
+    1567999n 0
+    1568000n 1.8
+    1568099n 1.8
+    1568100n 0
+    1568399n 0
+    1568400n 1.8
+    1568499n 1.8
+    1568500n 0
+    1568799n 0
+    1568800n 1.8
+    1568899n 1.8
+    1568900n 0
+    1569199n 0
+    1569200n 1.8
+    1569299n 1.8
+    1569300n 0
+    1569599n 0
+    1569600n 1.8
+    1569699n 1.8
+    1569700n 0
+    1569999n 0
+    1570000n 1.8
+    1570099n 1.8
+    1570100n 0
+    1570399n 0
+    1570400n 1.8
+    1570499n 1.8
+    1570500n 0
+    1570799n 0
+    1570800n 1.8
+    1570899n 1.8
+    1570900n 0
+    1571199n 0
+    1571200n 1.8
+    1571299n 1.8
+    1571300n 0
+    1571599n 0
+    1571600n 1.8
+    1571699n 1.8
+    1571700n 0
+    1571999n 0
+    1572000n 1.8
+    1572099n 1.8
+    1572100n 0
+    1572399n 0
+    1572400n 1.8
+    1572499n 1.8
+    1572500n 0
+    1572799n 0
+    1572800n 1.8
+    1572899n 1.8
+    1572900n 0
+    1573199n 0
+    1573200n 1.8
+    1573299n 1.8
+    1573300n 0
+    1573599n 0
+    1573600n 1.8
+    1573699n 1.8
+    1573700n 0
+    1573999n 0
+    1574000n 1.8
+    1574099n 1.8
+    1574100n 0
+    1574399n 0
+    1574400n 1.8
+    1574499n 1.8
+    1574500n 0
+    1574799n 0
+    1574800n 1.8
+    1574899n 1.8
+    1574900n 0
+    1575199n 0
+    1575200n 1.8
+    1575299n 1.8
+    1575300n 0
+    1575599n 0
+    1575600n 1.8
+    1575699n 1.8
+    1575700n 0
+    1575999n 0
+    1576000n 1.8
+    1576099n 1.8
+    1576100n 0
+    1576399n 0
+    1576400n 1.8
+    1576499n 1.8
+    1576500n 0
+    1576799n 0
+    1576800n 1.8
+    1576899n 1.8
+    1576900n 0
+    1577199n 0
+    1577200n 1.8
+    1577299n 1.8
+    1577300n 0
+    1577599n 0
+    1577600n 1.8
+    1577699n 1.8
+    1577700n 0
+    1577999n 0
+    1578000n 1.8
+    1578099n 1.8
+    1578100n 0
+    1578399n 0
+    1578400n 1.8
+    1578499n 1.8
+    1578500n 0
+    1578799n 0
+    1578800n 1.8
+    1578899n 1.8
+    1578900n 0
+    1579199n 0
+    1579200n 1.8
+    1579299n 1.8
+    1579300n 0
+    1579599n 0
+    1579600n 1.8
+    1579699n 1.8
+    1579700n 0
+    1579999n 0
+    1580000n 1.8
+    1580099n 1.8
+    1580100n 0
+    1580399n 0
+    1580400n 1.8
+    1580499n 1.8
+    1580500n 0
+    1580799n 0
+    1580800n 1.8
+    1580899n 1.8
+    1580900n 0
+    1581199n 0
+    1581200n 1.8
+    1581299n 1.8
+    1581300n 0
+    1581599n 0
+    1581600n 1.8
+    1581699n 1.8
+    1581700n 0
+    1581999n 0
+    1582000n 1.8
+    1582099n 1.8
+    1582100n 0
+    1582399n 0
+    1582400n 1.8
+    1582499n 1.8
+    1582500n 0
+    1582799n 0
+    1582800n 1.8
+    1582899n 1.8
+    1582900n 0
+    1583199n 0
+    1583200n 1.8
+    1583299n 1.8
+    1583300n 0
+    1583599n 0
+    1583600n 1.8
+    1583699n 1.8
+    1583700n 0
+    1583999n 0
+    1584000n 1.8
+    1584099n 1.8
+    1584100n 0
+    1584399n 0
+    1584400n 1.8
+    1584499n 1.8
+    1584500n 0
+    1584799n 0
+    1584800n 1.8
+    1584899n 1.8
+    1584900n 0
+    1585199n 0
+    1585200n 1.8
+    1585299n 1.8
+    1585300n 0
+    1585599n 0
+    1585600n 1.8
+    1585699n 1.8
+    1585700n 0
+    1585999n 0
+    1586000n 1.8
+    1586099n 1.8
+    1586100n 0
+    1586399n 0
+    1586400n 1.8
+    1586499n 1.8
+    1586500n 0
+    1586799n 0
+    1586800n 1.8
+    1586899n 1.8
+    1586900n 0
+    1587199n 0
+    1587200n 1.8
+    1587299n 1.8
+    1587300n 0
+    1587599n 0
+    1587600n 1.8
+    1587699n 1.8
+    1587700n 0
+    1587999n 0
+    1588000n 1.8
+    1588099n 1.8
+    1588100n 0
+    1588399n 0
+    1588400n 1.8
+    1588499n 1.8
+    1588500n 0
+    1588799n 0
+    1588800n 1.8
+    1588899n 1.8
+    1588900n 0
+    1589199n 0
+    1589200n 1.8
+    1589299n 1.8
+    1589300n 0
+    1589599n 0
+    1589600n 1.8
+    1589699n 1.8
+    1589700n 0
+    1589999n 0
+    1590000n 1.8
+    1590099n 1.8
+    1590100n 0
+    1590399n 0
+    1590400n 1.8
+    1590499n 1.8
+    1590500n 0
+    1590799n 0
+    1590800n 1.8
+    1590899n 1.8
+    1590900n 0
+    1591199n 0
+    1591200n 1.8
+    1591299n 1.8
+    1591300n 0
+    1591599n 0
+    1591600n 1.8
+    1591699n 1.8
+    1591700n 0
+    1591999n 0
+    1592000n 1.8
+    1592099n 1.8
+    1592100n 0
+    1592399n 0
+    1592400n 1.8
+    1592499n 1.8
+    1592500n 0
+    1592799n 0
+    1592800n 1.8
+    1592899n 1.8
+    1592900n 0
+    1593199n 0
+    1593200n 1.8
+    1593299n 1.8
+    1593300n 0
+    1593599n 0
+    1593600n 1.8
+    1593699n 1.8
+    1593700n 0
+    1593999n 0
+    1594000n 1.8
+    1594099n 1.8
+    1594100n 0
+    1594399n 0
+    1594400n 1.8
+    1594499n 1.8
+    1594500n 0
+    1594799n 0
+    1594800n 1.8
+    1594899n 1.8
+    1594900n 0
+    1595199n 0
+    1595200n 1.8
+    1595299n 1.8
+    1595300n 0
+    1595599n 0
+    1595600n 1.8
+    1595699n 1.8
+    1595700n 0
+    1595999n 0
+    1596000n 1.8
+    1596099n 1.8
+    1596100n 0
+    1596399n 0
+    1596400n 1.8
+    1596499n 1.8
+    1596500n 0
+    1596799n 0
+    1596800n 1.8
+    1596899n 1.8
+    1596900n 0
+    1597199n 0
+    1597200n 1.8
+    1597299n 1.8
+    1597300n 0
+    1597599n 0
+    1597600n 1.8
+    1597699n 1.8
+    1597700n 0
+    1597999n 0
+    1598000n 1.8
+    1598099n 1.8
+    1598100n 0
+    1598399n 0
+    1598400n 1.8
+    1598499n 1.8
+    1598500n 0
+    1598799n 0
+    1598800n 1.8
+    1598899n 1.8
+    1598900n 0
+    1599199n 0
+    1599200n 1.8
+    1599299n 1.8
+    1599300n 0
+    1599599n 0
+    1599600n 1.8
+    1599699n 1.8
+    1599700n 0
+    1599999n 0
+    1600000n 1.8
+    1600099n 1.8
+    1600100n 0
+    1600399n 0
+    1600400n 1.8
+    1600499n 1.8
+    1600500n 0
+    1600799n 0
+    1600800n 1.8
+    1600899n 1.8
+    1600900n 0
+    1601199n 0
+    1601200n 1.8
+    1601299n 1.8
+    1601300n 0
+    1601599n 0
+    1601600n 1.8
+    1601699n 1.8
+    1601700n 0
+    1601999n 0
+    1602000n 1.8
+    1602099n 1.8
+    1602100n 0
+    1602399n 0
+    1602400n 1.8
+    1602499n 1.8
+    1602500n 0
+    1602799n 0
+    1602800n 1.8
+    1602899n 1.8
+    1602900n 0
+    1603199n 0
+    1603200n 1.8
+    1603299n 1.8
+    1603300n 0
+    1603599n 0
+    1603600n 1.8
+    1603699n 1.8
+    1603700n 0
+    1603999n 0
+    1604000n 1.8
+    1604099n 1.8
+    1604100n 0
+    1604399n 0
+    1604400n 1.8
+    1604499n 1.8
+    1604500n 0
+    1604799n 0
+    1604800n 1.8
+    1604899n 1.8
+    1604900n 0
+    1605199n 0
+    1605200n 1.8
+    1605299n 1.8
+    1605300n 0
+    1605599n 0
+    1605600n 1.8
+    1605699n 1.8
+    1605700n 0
+    1605999n 0
+    1606000n 1.8
+    1606099n 1.8
+    1606100n 0
+    1606399n 0
+    1606400n 1.8
+    1606499n 1.8
+    1606500n 0
+    1606799n 0
+    1606800n 1.8
+    1606899n 1.8
+    1606900n 0
+    1607199n 0
+    1607200n 1.8
+    1607299n 1.8
+    1607300n 0
+    1607599n 0
+    1607600n 1.8
+    1607699n 1.8
+    1607700n 0
+    1607999n 0
+    1608000n 1.8
+    1608099n 1.8
+    1608100n 0
+    1608399n 0
+    1608400n 1.8
+    1608499n 1.8
+    1608500n 0
+    1608799n 0
+    1608800n 1.8
+    1608899n 1.8
+    1608900n 0
+    1609199n 0
+    1609200n 1.8
+    1609299n 1.8
+    1609300n 0
+    1609599n 0
+    1609600n 1.8
+    1609699n 1.8
+    1609700n 0
+    1609999n 0
+    1610000n 1.8
+    1610099n 1.8
+    1610100n 0
+    1610399n 0
+    1610400n 1.8
+    1610499n 1.8
+    1610500n 0
+    1610799n 0
+    1610800n 1.8
+    1610899n 1.8
+    1610900n 0
+    1611199n 0
+    1611200n 1.8
+    1611299n 1.8
+    1611300n 0
+    1611599n 0
+    1611600n 1.8
+    1611699n 1.8
+    1611700n 0
+    1611999n 0
+    1612000n 1.8
+    1612099n 1.8
+    1612100n 0
+    1612399n 0
+    1612400n 1.8
+    1612499n 1.8
+    1612500n 0
+    1612799n 0
+    1612800n 1.8
+    1612899n 1.8
+    1612900n 0
+    1613199n 0
+    1613200n 1.8
+    1613299n 1.8
+    1613300n 0
+    1613599n 0
+    1613600n 1.8
+    1613699n 1.8
+    1613700n 0
+    1613999n 0
+    1614000n 1.8
+    1614099n 1.8
+    1614100n 0
+    1614399n 0
+    1614400n 1.8
+    1614499n 1.8
+    1614500n 0
+    1614799n 0
+    1614800n 1.8
+    1614899n 1.8
+    1614900n 0
+    1615199n 0
+    1615200n 1.8
+    1615299n 1.8
+    1615300n 0
+    1615599n 0
+    1615600n 1.8
+    1615699n 1.8
+    1615700n 0
+    1615999n 0
+    1616000n 1.8
+    1616099n 1.8
+    1616100n 0
+    1616399n 0
+    1616400n 1.8
+    1616499n 1.8
+    1616500n 0
+    1616799n 0
+    1616800n 1.8
+    1616899n 1.8
+    1616900n 0
+    1617199n 0
+    1617200n 1.8
+    1617299n 1.8
+    1617300n 0
+    1617599n 0
+    1617600n 1.8
+    1617699n 1.8
+    1617700n 0
+    1617999n 0
+    1618000n 1.8
+    1618099n 1.8
+    1618100n 0
+    1618399n 0
+    1618400n 1.8
+    1618499n 1.8
+    1618500n 0
+    1618799n 0
+    1618800n 1.8
+    1618899n 1.8
+    1618900n 0
+    1619199n 0
+    1619200n 1.8
+    1619299n 1.8
+    1619300n 0
+    1619599n 0
+    1619600n 1.8
+    1619699n 1.8
+    1619700n 0
+    1619999n 0
+    1620000n 1.8
+    1620099n 1.8
+    1620100n 0
+    1620399n 0
+    1620400n 1.8
+    1620499n 1.8
+    1620500n 0
+    1620799n 0
+    1620800n 1.8
+    1620899n 1.8
+    1620900n 0
+    1621199n 0
+    1621200n 1.8
+    1621299n 1.8
+    1621300n 0
+    1621599n 0
+    1621600n 1.8
+    1621699n 1.8
+    1621700n 0
+    1621999n 0
+    1622000n 1.8
+    1622099n 1.8
+    1622100n 0
+    1622399n 0
+    1622400n 1.8
+    1622499n 1.8
+    1622500n 0
+    1622799n 0
+    1622800n 1.8
+    1622899n 1.8
+    1622900n 0
+    1623199n 0
+    1623200n 1.8
+    1623299n 1.8
+    1623300n 0
+    1623599n 0
+    1623600n 1.8
+    1623699n 1.8
+    1623700n 0
+    1623999n 0
+    1624000n 1.8
+    1624099n 1.8
+    1624100n 0
+    1624399n 0
+    1624400n 1.8
+    1624499n 1.8
+    1624500n 0
+    1624799n 0
+    1624800n 1.8
+    1624899n 1.8
+    1624900n 0
+    1625199n 0
+    1625200n 1.8
+    1625299n 1.8
+    1625300n 0
+    1625599n 0
+    1625600n 1.8
+    1625699n 1.8
+    1625700n 0
+    1625999n 0
+    1626000n 1.8
+    1626099n 1.8
+    1626100n 0
+    1626399n 0
+    1626400n 1.8
+    1626499n 1.8
+    1626500n 0
+    1626799n 0
+    1626800n 1.8
+    1626899n 1.8
+    1626900n 0
+    1627199n 0
+    1627200n 1.8
+    1627299n 1.8
+    1627300n 0
+    1627599n 0
+    1627600n 1.8
+    1627699n 1.8
+    1627700n 0
+    1627999n 0
+    1628000n 1.8
+    1628099n 1.8
+    1628100n 0
+    1628399n 0
+    1628400n 1.8
+    1628499n 1.8
+    1628500n 0
+    1628799n 0
+    1628800n 1.8
+    1628899n 1.8
+    1628900n 0
+    1629199n 0
+    1629200n 1.8
+    1629299n 1.8
+    1629300n 0
+    1629599n 0
+    1629600n 1.8
+    1629699n 1.8
+    1629700n 0
+    1629999n 0
+    1630000n 1.8
+    1630099n 1.8
+    1630100n 0
+    1630399n 0
+    1630400n 1.8
+    1630499n 1.8
+    1630500n 0
+    1630799n 0
+    1630800n 1.8
+    1630899n 1.8
+    1630900n 0
+    1631199n 0
+    1631200n 1.8
+    1631299n 1.8
+    1631300n 0
+    1631599n 0
+    1631600n 1.8
+    1631699n 1.8
+    1631700n 0
+    1631999n 0
+    1632000n 1.8
+    1632099n 1.8
+    1632100n 0
+    1632399n 0
+    1632400n 1.8
+    1632499n 1.8
+    1632500n 0
+    1632799n 0
+    1632800n 1.8
+    1632899n 1.8
+    1632900n 0
+    1633199n 0
+    1633200n 1.8
+    1633299n 1.8
+    1633300n 0
+    1633599n 0
+    1633600n 1.8
+    1633699n 1.8
+    1633700n 0
+    1633999n 0
+    1634000n 1.8
+    1634099n 1.8
+    1634100n 0
+    1634399n 0
+    1634400n 1.8
+    1634499n 1.8
+    1634500n 0
+    1634799n 0
+    1634800n 1.8
+    1634899n 1.8
+    1634900n 0
+    1635199n 0
+    1635200n 1.8
+    1635299n 1.8
+    1635300n 0
+    1635599n 0
+    1635600n 1.8
+    1635699n 1.8
+    1635700n 0
+    1635999n 0
+    1636000n 1.8
+    1636099n 1.8
+    1636100n 0
+    1636399n 0
+    1636400n 1.8
+    1636499n 1.8
+    1636500n 0
+    1636799n 0
+    1636800n 1.8
+    1636899n 1.8
+    1636900n 0
+    1637199n 0
+    1637200n 1.8
+    1637299n 1.8
+    1637300n 0
+    1637599n 0
+    1637600n 1.8
+    1637699n 1.8
+    1637700n 0
+    1637999n 0
+    1638000n 1.8
+    1638099n 1.8
+    1638100n 0
+    1638399n 0
+    1638400n 1.8
+    1638499n 1.8
+    1638500n 0
+    1638799n 0
+    1638800n 1.8
+    1638899n 1.8
+    1638900n 0
+    1639199n 0
+    1639200n 1.8
+    1639299n 1.8
+    1639300n 0
+    1639599n 0
+    1639600n 1.8
+    1639699n 1.8
+    1639700n 0
+    1639999n 0
+    1640000n 1.8
+    1640099n 1.8
+    1640100n 0
+    1640399n 0
+    1640400n 1.8
+    1640499n 1.8
+    1640500n 0
+    1640799n 0
+    1640800n 1.8
+    1640899n 1.8
+    1640900n 0
+    1641199n 0
+    1641200n 1.8
+    1641299n 1.8
+    1641300n 0
+    1641599n 0
+    1641600n 1.8
+    1641699n 1.8
+    1641700n 0
+    1641999n 0
+    1642000n 1.8
+    1642099n 1.8
+    1642100n 0
+    1642399n 0
+    1642400n 1.8
+    1642499n 1.8
+    1642500n 0
+    1642799n 0
+    1642800n 1.8
+    1642899n 1.8
+    1642900n 0
+    1643199n 0
+    1643200n 1.8
+    1643299n 1.8
+    1643300n 0
+    1643599n 0
+    1643600n 1.8
+    1643699n 1.8
+    1643700n 0
+    1643999n 0
+    1644000n 1.8
+    1644099n 1.8
+    1644100n 0
+    1644399n 0
+    1644400n 1.8
+    1644499n 1.8
+    1644500n 0
+    1644799n 0
+    1644800n 1.8
+    1644899n 1.8
+    1644900n 0
+    1645199n 0
+    1645200n 1.8
+    1645299n 1.8
+    1645300n 0
+    1645599n 0
+    1645600n 1.8
+    1645699n 1.8
+    1645700n 0
+    1645999n 0
+    1646000n 1.8
+    1646099n 1.8
+    1646100n 0
+    1646399n 0
+    1646400n 1.8
+    1646499n 1.8
+    1646500n 0
+    1646799n 0
+    1646800n 1.8
+    1646899n 1.8
+    1646900n 0
+    1647199n 0
+    1647200n 1.8
+    1647299n 1.8
+    1647300n 0
+    1647599n 0
+    1647600n 1.8
+    1647699n 1.8
+    1647700n 0
+    1647999n 0
+    1648000n 1.8
+    1648099n 1.8
+    1648100n 0
+    1648399n 0
+    1648400n 1.8
+    1648499n 1.8
+    1648500n 0
+    1648799n 0
+    1648800n 1.8
+    1648899n 1.8
+    1648900n 0
+    1649199n 0
+    1649200n 1.8
+    1649299n 1.8
+    1649300n 0
+    1649599n 0
+    1649600n 1.8
+    1649699n 1.8
+    1649700n 0
+    1649999n 0
+    1650000n 1.8
+    1650099n 1.8
+    1650100n 0
+    1650399n 0
+    1650400n 1.8
+    1650499n 1.8
+    1650500n 0
+    1650799n 0
+    1650800n 1.8
+    1650899n 1.8
+    1650900n 0
+    1651199n 0
+    1651200n 1.8
+    1651299n 1.8
+    1651300n 0
+    1651599n 0
+    1651600n 1.8
+    1651699n 1.8
+    1651700n 0
+    1651999n 0
+    1652000n 1.8
+    1652099n 1.8
+    1652100n 0
+    1652399n 0
+    1652400n 1.8
+    1652499n 1.8
+    1652500n 0
+    1652799n 0
+    1652800n 1.8
+    1652899n 1.8
+    1652900n 0
+    1653199n 0
+    1653200n 1.8
+    1653299n 1.8
+    1653300n 0
+    1653599n 0
+    1653600n 1.8
+    1653699n 1.8
+    1653700n 0
+    1653999n 0
+    1654000n 1.8
+    1654099n 1.8
+    1654100n 0
+    1654399n 0
+    1654400n 1.8
+    1654499n 1.8
+    1654500n 0
+    1654799n 0
+    1654800n 1.8
+    1654899n 1.8
+    1654900n 0
+    1655199n 0
+    1655200n 1.8
+    1655299n 1.8
+    1655300n 0
+    1655599n 0
+    1655600n 1.8
+    1655699n 1.8
+    1655700n 0
+    1655999n 0
+    1656000n 1.8
+    1656099n 1.8
+    1656100n 0
+    1656399n 0
+    1656400n 1.8
+    1656499n 1.8
+    1656500n 0
+    1656799n 0
+    1656800n 1.8
+    1656899n 1.8
+    1656900n 0
+    1657199n 0
+    1657200n 1.8
+    1657299n 1.8
+    1657300n 0
+    1657599n 0
+    1657600n 1.8
+    1657699n 1.8
+    1657700n 0
+    1657999n 0
+    1658000n 1.8
+    1658099n 1.8
+    1658100n 0
+    1658399n 0
+    1658400n 1.8
+    1658499n 1.8
+    1658500n 0
+    1658799n 0
+    1658800n 1.8
+    1658899n 1.8
+    1658900n 0
+    1659199n 0
+    1659200n 1.8
+    1659299n 1.8
+    1659300n 0
+    1659599n 0
+    1659600n 1.8
+    1659699n 1.8
+    1659700n 0
+    1659999n 0
+    1660000n 1.8
+    1660099n 1.8
+    1660100n 0
+    1660399n 0
+    1660400n 1.8
+    1660499n 1.8
+    1660500n 0
+    1660799n 0
+    1660800n 1.8
+    1660899n 1.8
+    1660900n 0
+    1661199n 0
+    1661200n 1.8
+    1661299n 1.8
+    1661300n 0
+    1661599n 0
+    1661600n 1.8
+    1661699n 1.8
+    1661700n 0
+    1661999n 0
+    1662000n 1.8
+    1662099n 1.8
+    1662100n 0
+    1662399n 0
+    1662400n 1.8
+    1662499n 1.8
+    1662500n 0
+    1662799n 0
+    1662800n 1.8
+    1662899n 1.8
+    1662900n 0
+    1663199n 0
+    1663200n 1.8
+    1663299n 1.8
+    1663300n 0
+    1663599n 0
+    1663600n 1.8
+    1663699n 1.8
+    1663700n 0
+    1663999n 0
+    1664000n 1.8
+    1664099n 1.8
+    1664100n 0
+    1664399n 0
+    1664400n 1.8
+    1664499n 1.8
+    1664500n 0
+    1664799n 0
+    1664800n 1.8
+    1664899n 1.8
+    1664900n 0
+    1665199n 0
+    1665200n 1.8
+    1665299n 1.8
+    1665300n 0
+    1665599n 0
+    1665600n 1.8
+    1665699n 1.8
+    1665700n 0
+    1665999n 0
+    1666000n 1.8
+    1666099n 1.8
+    1666100n 0
+    1666399n 0
+    1666400n 1.8
+    1666499n 1.8
+    1666500n 0
+    1666799n 0
+    1666800n 1.8
+    1666899n 1.8
+    1666900n 0
+    1667199n 0
+    1667200n 1.8
+    1667299n 1.8
+    1667300n 0
+    1667599n 0
+    1667600n 1.8
+    1667699n 1.8
+    1667700n 0
+    1667999n 0
+    1668000n 1.8
+    1668099n 1.8
+    1668100n 0
+    1668399n 0
+    1668400n 1.8
+    1668499n 1.8
+    1668500n 0
+    1668799n 0
+    1668800n 1.8
+    1668899n 1.8
+    1668900n 0
+    1669199n 0
+    1669200n 1.8
+    1669299n 1.8
+    1669300n 0
+    1669599n 0
+    1669600n 1.8
+    1669699n 1.8
+    1669700n 0
+    1669999n 0
+    1670000n 1.8
+    1670099n 1.8
+    1670100n 0
+    1670399n 0
+    1670400n 1.8
+    1670499n 1.8
+    1670500n 0
+    1670799n 0
+    1670800n 1.8
+    1670899n 1.8
+    1670900n 0
+    1671199n 0
+    1671200n 1.8
+    1671299n 1.8
+    1671300n 0
+    1671599n 0
+    1671600n 1.8
+    1671699n 1.8
+    1671700n 0
+    1671999n 0
+    1672000n 1.8
+    1672099n 1.8
+    1672100n 0
+    1672399n 0
+    1672400n 1.8
+    1672499n 1.8
+    1672500n 0
+    1672799n 0
+    1672800n 1.8
+    1672899n 1.8
+    1672900n 0
+    1673199n 0
+    1673200n 1.8
+    1673299n 1.8
+    1673300n 0
+    1673599n 0
+    1673600n 1.8
+    1673699n 1.8
+    1673700n 0
+    1673999n 0
+    1674000n 1.8
+    1674099n 1.8
+    1674100n 0
+    1674399n 0
+    1674400n 1.8
+    1674499n 1.8
+    1674500n 0
+    1674799n 0
+    1674800n 1.8
+    1674899n 1.8
+    1674900n 0
+    1675199n 0
+    1675200n 1.8
+    1675299n 1.8
+    1675300n 0
+    1675599n 0
+    1675600n 1.8
+    1675699n 1.8
+    1675700n 0
+    1675999n 0
+    1676000n 1.8
+    1676099n 1.8
+    1676100n 0
+    1676399n 0
+    1676400n 1.8
+    1676499n 1.8
+    1676500n 0
+    1676799n 0
+    1676800n 1.8
+    1676899n 1.8
+    1676900n 0
+    1677199n 0
+    1677200n 1.8
+    1677299n 1.8
+    1677300n 0
+    1677599n 0
+    1677600n 1.8
+    1677699n 1.8
+    1677700n 0
+    1677999n 0
+    1678000n 1.8
+    1678099n 1.8
+    1678100n 0
+    1678399n 0
+    1678400n 1.8
+    1678499n 1.8
+    1678500n 0
+    1678799n 0
+    1678800n 1.8
+    1678899n 1.8
+    1678900n 0
+    1679199n 0
+    1679200n 1.8
+    1679299n 1.8
+    1679300n 0
+    1679599n 0
+    1679600n 1.8
+    1679699n 1.8
+    1679700n 0
+    1679999n 0
+    1680000n 1.8
+    1680099n 1.8
+    1680100n 0
+    1680399n 0
+    1680400n 1.8
+    1680499n 1.8
+    1680500n 0
+    1680799n 0
+    1680800n 1.8
+    1680899n 1.8
+    1680900n 0
+    1681199n 0
+    1681200n 1.8
+    1681299n 1.8
+    1681300n 0
+    1681599n 0
+    1681600n 1.8
+    1681699n 1.8
+    1681700n 0
+    1681999n 0
+    1682000n 1.8
+    1682099n 1.8
+    1682100n 0
+    1682399n 0
+    1682400n 1.8
+    1682499n 1.8
+    1682500n 0
+    1682799n 0
+    1682800n 1.8
+    1682899n 1.8
+    1682900n 0
+    1683199n 0
+    1683200n 1.8
+    1683299n 1.8
+    1683300n 0
+    1683599n 0
+    1683600n 1.8
+    1683699n 1.8
+    1683700n 0
+    1683999n 0
+    1684000n 1.8
+    1684099n 1.8
+    1684100n 0
+    1684399n 0
+    1684400n 1.8
+    1684499n 1.8
+    1684500n 0
+    1684799n 0
+    1684800n 1.8
+    1684899n 1.8
+    1684900n 0
+    1685199n 0
+    1685200n 1.8
+    1685299n 1.8
+    1685300n 0
+    1685599n 0
+    1685600n 1.8
+    1685699n 1.8
+    1685700n 0
+    1685999n 0
+    1686000n 1.8
+    1686099n 1.8
+    1686100n 0
+    1686399n 0
+    1686400n 1.8
+    1686499n 1.8
+    1686500n 0
+    1686799n 0
+    1686800n 1.8
+    1686899n 1.8
+    1686900n 0
+    1687199n 0
+    1687200n 1.8
+    1687299n 1.8
+    1687300n 0
+    1687599n 0
+    1687600n 1.8
+    1687699n 1.8
+    1687700n 0
+    1687999n 0
+    1688000n 1.8
+    1688099n 1.8
+    1688100n 0
+    1688399n 0
+    1688400n 1.8
+    1688499n 1.8
+    1688500n 0
+    1688799n 0
+    1688800n 1.8
+    1688899n 1.8
+    1688900n 0
+    1689199n 0
+    1689200n 1.8
+    1689299n 1.8
+    1689300n 0
+    1689599n 0
+    1689600n 1.8
+    1689699n 1.8
+    1689700n 0
+    1689999n 0
+    1690000n 1.8
+    1690099n 1.8
+    1690100n 0
+    1690399n 0
+    1690400n 1.8
+    1690499n 1.8
+    1690500n 0
+    1690799n 0
+    1690800n 1.8
+    1690899n 1.8
+    1690900n 0
+    1691199n 0
+    1691200n 1.8
+    1691299n 1.8
+    1691300n 0
+    1691599n 0
+    1691600n 1.8
+    1691699n 1.8
+    1691700n 0
+    1691999n 0
+    1692000n 1.8
+    1692099n 1.8
+    1692100n 0
+    1692399n 0
+    1692400n 1.8
+    1692499n 1.8
+    1692500n 0
+    1692799n 0
+    1692800n 1.8
+    1692899n 1.8
+    1692900n 0
+    1693199n 0
+    1693200n 1.8
+    1693299n 1.8
+    1693300n 0
+    1693599n 0
+    1693600n 1.8
+    1693699n 1.8
+    1693700n 0
+    1693999n 0
+    1694000n 1.8
+    1694099n 1.8
+    1694100n 0
+    1694399n 0
+    1694400n 1.8
+    1694499n 1.8
+    1694500n 0
+    1694799n 0
+    1694800n 1.8
+    1694899n 1.8
+    1694900n 0
+    1695199n 0
+    1695200n 1.8
+    1695299n 1.8
+    1695300n 0
+    1695599n 0
+    1695600n 1.8
+    1695699n 1.8
+    1695700n 0
+    1695999n 0
+    1696000n 1.8
+    1696099n 1.8
+    1696100n 0
+    1696399n 0
+    1696400n 1.8
+    1696499n 1.8
+    1696500n 0
+    1696799n 0
+    1696800n 1.8
+    1696899n 1.8
+    1696900n 0
+    1697199n 0
+    1697200n 1.8
+    1697299n 1.8
+    1697300n 0
+    1697599n 0
+    1697600n 1.8
+    1697699n 1.8
+    1697700n 0
+    1697999n 0
+    1698000n 1.8
+    1698099n 1.8
+    1698100n 0
+    1698399n 0
+    1698400n 1.8
+    1698499n 1.8
+    1698500n 0
+    1698799n 0
+    1698800n 1.8
+    1698899n 1.8
+    1698900n 0
+    1699199n 0
+    1699200n 1.8
+    1699299n 1.8
+    1699300n 0
+    1699599n 0
+    1699600n 1.8
+    1699699n 1.8
+    1699700n 0
+    1699999n 0
+    1700000n 1.8
+    1700099n 1.8
+    1700100n 0
+    1700399n 0
+    1700400n 1.8
+    1700499n 1.8
+    1700500n 0
+    1700799n 0
+    1700800n 1.8
+    1700899n 1.8
+    1700900n 0
+    1701199n 0
+    1701200n 1.8
+    1701299n 1.8
+    1701300n 0
+    1701599n 0
+    1701600n 1.8
+    1701699n 1.8
+    1701700n 0
+    1701999n 0
+    1702000n 1.8
+    1702099n 1.8
+    1702100n 0
+    1702399n 0
+    1702400n 1.8
+    1702499n 1.8
+    1702500n 0
+    1702799n 0
+    1702800n 1.8
+    1702899n 1.8
+    1702900n 0
+    1703199n 0
+    1703200n 1.8
+    1703299n 1.8
+    1703300n 0
+    1703599n 0
+    1703600n 1.8
+    1703699n 1.8
+    1703700n 0
+    1703999n 0
+    1704000n 1.8
+    1704099n 1.8
+    1704100n 0
+    1704399n 0
+    1704400n 1.8
+    1704499n 1.8
+    1704500n 0
+    1704799n 0
+    1704800n 1.8
+    1704899n 1.8
+    1704900n 0
+    1705199n 0
+    1705200n 1.8
+    1705299n 1.8
+    1705300n 0
+    1705599n 0
+    1705600n 1.8
+    1705699n 1.8
+    1705700n 0
+    1705999n 0
+    1706000n 1.8
+    1706099n 1.8
+    1706100n 0
+    1706399n 0
+    1706400n 1.8
+    1706499n 1.8
+    1706500n 0
+    1706799n 0
+    1706800n 1.8
+    1706899n 1.8
+    1706900n 0
+    1707199n 0
+    1707200n 1.8
+    1707299n 1.8
+    1707300n 0
+    1707599n 0
+    1707600n 1.8
+    1707699n 1.8
+    1707700n 0
+    1707999n 0
+    1708000n 1.8
+    1708099n 1.8
+    1708100n 0
+    1708399n 0
+    1708400n 1.8
+    1708499n 1.8
+    1708500n 0
+    1708799n 0
+    1708800n 1.8
+    1708899n 1.8
+    1708900n 0
+    1709199n 0
+    1709200n 1.8
+    1709299n 1.8
+    1709300n 0
+    1709599n 0
+    1709600n 1.8
+    1709699n 1.8
+    1709700n 0
+    1709999n 0
+    1710000n 1.8
+    1710099n 1.8
+    1710100n 0
+    1710399n 0
+    1710400n 1.8
+    1710499n 1.8
+    1710500n 0
+    1710799n 0
+    1710800n 1.8
+    1710899n 1.8
+    1710900n 0
+    1711199n 0
+    1711200n 1.8
+    1711299n 1.8
+    1711300n 0
+    1711599n 0
+    1711600n 1.8
+    1711699n 1.8
+    1711700n 0
+    1711999n 0
+    1712000n 1.8
+    1712099n 1.8
+    1712100n 0
+    1712399n 0
+    1712400n 1.8
+    1712499n 1.8
+    1712500n 0
+    1712799n 0
+    1712800n 1.8
+    1712899n 1.8
+    1712900n 0
+    1713199n 0
+    1713200n 1.8
+    1713299n 1.8
+    1713300n 0
+    1713599n 0
+    1713600n 1.8
+    1713699n 1.8
+    1713700n 0
+    1713999n 0
+    1714000n 1.8
+    1714099n 1.8
+    1714100n 0
+    1714399n 0
+    1714400n 1.8
+    1714499n 1.8
+    1714500n 0
+    1714799n 0
+    1714800n 1.8
+    1714899n 1.8
+    1714900n 0
+    1715199n 0
+    1715200n 1.8
+    1715299n 1.8
+    1715300n 0
+    1715599n 0
+    1715600n 1.8
+    1715699n 1.8
+    1715700n 0
+    1715999n 0
+    1716000n 1.8
+    1716099n 1.8
+    1716100n 0
+    1716399n 0
+    1716400n 1.8
+    1716499n 1.8
+    1716500n 0
+    1716799n 0
+    1716800n 1.8
+    1716899n 1.8
+    1716900n 0
+    1717199n 0
+    1717200n 1.8
+    1717299n 1.8
+    1717300n 0
+    1717599n 0
+    1717600n 1.8
+    1717699n 1.8
+    1717700n 0
+    1717999n 0
+    1718000n 1.8
+    1718099n 1.8
+    1718100n 0
+    1718399n 0
+    1718400n 1.8
+    1718499n 1.8
+    1718500n 0
+    1718799n 0
+    1718800n 1.8
+    1718899n 1.8
+    1718900n 0
+    1719199n 0
+    1719200n 1.8
+    1719299n 1.8
+    1719300n 0
+    1719599n 0
+    1719600n 1.8
+    1719699n 1.8
+    1719700n 0
+    1719999n 0
+    1720000n 1.8
+    1720099n 1.8
+    1720100n 0
+    1720399n 0
+    1720400n 1.8
+    1720499n 1.8
+    1720500n 0
+    1720799n 0
+    1720800n 1.8
+    1720899n 1.8
+    1720900n 0
+    1721199n 0
+    1721200n 1.8
+    1721299n 1.8
+    1721300n 0
+    1721599n 0
+    1721600n 1.8
+    1721699n 1.8
+    1721700n 0
+    1721999n 0
+    1722000n 1.8
+    1722099n 1.8
+    1722100n 0
+    1722399n 0
+    1722400n 1.8
+    1722499n 1.8
+    1722500n 0
+    1722799n 0
+    1722800n 1.8
+    1722899n 1.8
+    1722900n 0
+    1723199n 0
+    1723200n 1.8
+    1723299n 1.8
+    1723300n 0
+    1723599n 0
+    1723600n 1.8
+    1723699n 1.8
+    1723700n 0
+    1723999n 0
+    1724000n 1.8
+    1724099n 1.8
+    1724100n 0
+    1724399n 0
+    1724400n 1.8
+    1724499n 1.8
+    1724500n 0
+    1724799n 0
+    1724800n 1.8
+    1724899n 1.8
+    1724900n 0
+    1725199n 0
+    1725200n 1.8
+    1725299n 1.8
+    1725300n 0
+    1725599n 0
+    1725600n 1.8
+    1725699n 1.8
+    1725700n 0
+    1725999n 0
+    1726000n 1.8
+    1726099n 1.8
+    1726100n 0
+    1726399n 0
+    1726400n 1.8
+    1726499n 1.8
+    1726500n 0
+    1726799n 0
+    1726800n 1.8
+    1726899n 1.8
+    1726900n 0
+    1727199n 0
+    1727200n 1.8
+    1727299n 1.8
+    1727300n 0
+    1727599n 0
+    1727600n 1.8
+    1727699n 1.8
+    1727700n 0
+    1727999n 0
+    1728000n 1.8
+    1728099n 1.8
+    1728100n 0
+    1728399n 0
+    1728400n 1.8
+    1728499n 1.8
+    1728500n 0
+    1728799n 0
+    1728800n 1.8
+    1728899n 1.8
+    1728900n 0
+    1729199n 0
+    1729200n 1.8
+    1729299n 1.8
+    1729300n 0
+    1729599n 0
+    1729600n 1.8
+    1729699n 1.8
+    1729700n 0
+    1729999n 0
+    1730000n 1.8
+    1730099n 1.8
+    1730100n 0
+    1730399n 0
+    1730400n 1.8
+    1730499n 1.8
+    1730500n 0
+    1730799n 0
+    1730800n 1.8
+    1730899n 1.8
+    1730900n 0
+    1731199n 0
+    1731200n 1.8
+    1731299n 1.8
+    1731300n 0
+    1731599n 0
+    1731600n 1.8
+    1731699n 1.8
+    1731700n 0
+    1731999n 0
+    1732000n 1.8
+    1732099n 1.8
+    1732100n 0
+    1732399n 0
+    1732400n 1.8
+    1732499n 1.8
+    1732500n 0
+    1732799n 0
+    1732800n 1.8
+    1732899n 1.8
+    1732900n 0
+    1733199n 0
+    1733200n 1.8
+    1733299n 1.8
+    1733300n 0
+    1733599n 0
+    1733600n 1.8
+    1733699n 1.8
+    1733700n 0
+    1733999n 0
+    1734000n 1.8
+    1734099n 1.8
+    1734100n 0
+    1734399n 0
+    1734400n 1.8
+    1734499n 1.8
+    1734500n 0
+    1734799n 0
+    1734800n 1.8
+    1734899n 1.8
+    1734900n 0
+    1735199n 0
+    1735200n 1.8
+    1735299n 1.8
+    1735300n 0
+    1735599n 0
+    1735600n 1.8
+    1735699n 1.8
+    1735700n 0
+    1735999n 0
+    1736000n 1.8
+    1736099n 1.8
+    1736100n 0
+    1736399n 0
+    1736400n 1.8
+    1736499n 1.8
+    1736500n 0
+    1736799n 0
+    1736800n 1.8
+    1736899n 1.8
+    1736900n 0
+    1737199n 0
+    1737200n 1.8
+    1737299n 1.8
+    1737300n 0
+    1737599n 0
+    1737600n 1.8
+    1737699n 1.8
+    1737700n 0
+    1737999n 0
+    1738000n 1.8
+    1738099n 1.8
+    1738100n 0
+    1738399n 0
+    1738400n 1.8
+    1738499n 1.8
+    1738500n 0
+    1738799n 0
+    1738800n 1.8
+    1738899n 1.8
+    1738900n 0
+    1739199n 0
+    1739200n 1.8
+    1739299n 1.8
+    1739300n 0
+    1739599n 0
+    1739600n 1.8
+    1739699n 1.8
+    1739700n 0
+    1739999n 0
+    1740000n 1.8
+    1740099n 1.8
+    1740100n 0
+    1740399n 0
+    1740400n 1.8
+    1740499n 1.8
+    1740500n 0
+    1740799n 0
+    1740800n 1.8
+    1740899n 1.8
+    1740900n 0
+    1741199n 0
+    1741200n 1.8
+    1741299n 1.8
+    1741300n 0
+    1741599n 0
+    1741600n 1.8
+    1741699n 1.8
+    1741700n 0
+    1741999n 0
+    1742000n 1.8
+    1742099n 1.8
+    1742100n 0
+    1742399n 0
+    1742400n 1.8
+    1742499n 1.8
+    1742500n 0
+    1742799n 0
+    1742800n 1.8
+    1742899n 1.8
+    1742900n 0
+    1743199n 0
+    1743200n 1.8
+    1743299n 1.8
+    1743300n 0
+    1743599n 0
+    1743600n 1.8
+    1743699n 1.8
+    1743700n 0
+    1743999n 0
+    1744000n 1.8
+    1744099n 1.8
+    1744100n 0
+    1744399n 0
+    1744400n 1.8
+    1744499n 1.8
+    1744500n 0
+    1744799n 0
+    1744800n 1.8
+    1744899n 1.8
+    1744900n 0
+    1745199n 0
+    1745200n 1.8
+    1745299n 1.8
+    1745300n 0
+    1745599n 0
+    1745600n 1.8
+    1745699n 1.8
+    1745700n 0
+    1745999n 0
+    1746000n 1.8
+    1746099n 1.8
+    1746100n 0
+    1746399n 0
+    1746400n 1.8
+    1746499n 1.8
+    1746500n 0
+    1746799n 0
+    1746800n 1.8
+    1746899n 1.8
+    1746900n 0
+    1747199n 0
+    1747200n 1.8
+    1747299n 1.8
+    1747300n 0
+    1747599n 0
+    1747600n 1.8
+    1747699n 1.8
+    1747700n 0
+    1747999n 0
+    1748000n 1.8
+    1748099n 1.8
+    1748100n 0
+    1748399n 0
+    1748400n 1.8
+    1748499n 1.8
+    1748500n 0
+    1748799n 0
+    1748800n 1.8
+    1748899n 1.8
+    1748900n 0
+    1749199n 0
+    1749200n 1.8
+    1749299n 1.8
+    1749300n 0
+    1749599n 0
+    1749600n 1.8
+    1749699n 1.8
+    1749700n 0
+    1749999n 0
+    1750000n 1.8
+    1750099n 1.8
+    1750100n 0
+    1750399n 0
+    1750400n 1.8
+    1750499n 1.8
+    1750500n 0
+    1750799n 0
+    1750800n 1.8
+    1750899n 1.8
+    1750900n 0
+    1751199n 0
+    1751200n 1.8
+    1751299n 1.8
+    1751300n 0
+    1751599n 0
+    1751600n 1.8
+    1751699n 1.8
+    1751700n 0
+    1751999n 0
+    1752000n 1.8
+    1752099n 1.8
+    1752100n 0
+    1752399n 0
+    1752400n 1.8
+    1752499n 1.8
+    1752500n 0
+    1752799n 0
+    1752800n 1.8
+    1752899n 1.8
+    1752900n 0
+    1753199n 0
+    1753200n 1.8
+    1753299n 1.8
+    1753300n 0
+    1753599n 0
+    1753600n 1.8
+    1753699n 1.8
+    1753700n 0
+    1753999n 0
+    1754000n 1.8
+    1754099n 1.8
+    1754100n 0
+    1754399n 0
+    1754400n 1.8
+    1754499n 1.8
+    1754500n 0
+    1754799n 0
+    1754800n 1.8
+    1754899n 1.8
+    1754900n 0
+    1755199n 0
+    1755200n 1.8
+    1755299n 1.8
+    1755300n 0
+    1755599n 0
+    1755600n 1.8
+    1755699n 1.8
+    1755700n 0
+    1755999n 0
+    1756000n 1.8
+    1756099n 1.8
+    1756100n 0
+    1756399n 0
+    1756400n 1.8
+    1756499n 1.8
+    1756500n 0
+    1756799n 0
+    1756800n 1.8
+    1756899n 1.8
+    1756900n 0
+    1757199n 0
+    1757200n 1.8
+    1757299n 1.8
+    1757300n 0
+    1757599n 0
+    1757600n 1.8
+    1757699n 1.8
+    1757700n 0
+    1757999n 0
+    1758000n 1.8
+    1758099n 1.8
+    1758100n 0
+    1758399n 0
+    1758400n 1.8
+    1758499n 1.8
+    1758500n 0
+    1758799n 0
+    1758800n 1.8
+    1758899n 1.8
+    1758900n 0
+    1759199n 0
+    1759200n 1.8
+    1759299n 1.8
+    1759300n 0
+    1759599n 0
+    1759600n 1.8
+    1759699n 1.8
+    1759700n 0
+    1759999n 0
+    1760000n 1.8
+    1760099n 1.8
+    1760100n 0
+    1760399n 0
+    1760400n 1.8
+    1760499n 1.8
+    1760500n 0
+    1760799n 0
+    1760800n 1.8
+    1760899n 1.8
+    1760900n 0
+    1761199n 0
+    1761200n 1.8
+    1761299n 1.8
+    1761300n 0
+    1761599n 0
+    1761600n 1.8
+    1761699n 1.8
+    1761700n 0
+    1761999n 0
+    1762000n 1.8
+    1762099n 1.8
+    1762100n 0
+    1762399n 0
+    1762400n 1.8
+    1762499n 1.8
+    1762500n 0
+    1762799n 0
+    1762800n 1.8
+    1762899n 1.8
+    1762900n 0
+    1763199n 0
+    1763200n 1.8
+    1763299n 1.8
+    1763300n 0
+    1763599n 0
+    1763600n 1.8
+    1763699n 1.8
+    1763700n 0
+    1763999n 0
+    1764000n 1.8
+    1764099n 1.8
+    1764100n 0
+    1764399n 0
+    1764400n 1.8
+    1764499n 1.8
+    1764500n 0
+    1764799n 0
+    1764800n 1.8
+    1764899n 1.8
+    1764900n 0
+    1765199n 0
+    1765200n 1.8
+    1765299n 1.8
+    1765300n 0
+    1765599n 0
+    1765600n 1.8
+    1765699n 1.8
+    1765700n 0
+    1765999n 0
+    1766000n 1.8
+    1766099n 1.8
+    1766100n 0
+    1766399n 0
+    1766400n 1.8
+    1766499n 1.8
+    1766500n 0
+    1766799n 0
+    1766800n 1.8
+    1766899n 1.8
+    1766900n 0
+    1767199n 0
+    1767200n 1.8
+    1767299n 1.8
+    1767300n 0
+    1767599n 0
+    1767600n 1.8
+    1767699n 1.8
+    1767700n 0
+    1767999n 0
+    1768000n 1.8
+    1768099n 1.8
+    1768100n 0
+    1768399n 0
+    1768400n 1.8
+    1768499n 1.8
+    1768500n 0
+    1768799n 0
+    1768800n 1.8
+    1768899n 1.8
+    1768900n 0
+    1769199n 0
+    1769200n 1.8
+    1769299n 1.8
+    1769300n 0
+    1769599n 0
+    1769600n 1.8
+    1769699n 1.8
+    1769700n 0
+    1769999n 0
+    1770000n 1.8
+    1770099n 1.8
+    1770100n 0
+    1770399n 0
+    1770400n 1.8
+    1770499n 1.8
+    1770500n 0
+    1770799n 0
+    1770800n 1.8
+    1770899n 1.8
+    1770900n 0
+    1771199n 0
+    1771200n 1.8
+    1771299n 1.8
+    1771300n 0
+    1771599n 0
+    1771600n 1.8
+    1771699n 1.8
+    1771700n 0
+    1771999n 0
+    1772000n 1.8
+    1772099n 1.8
+    1772100n 0
+    1772399n 0
+    1772400n 1.8
+    1772499n 1.8
+    1772500n 0
+    1772799n 0
+    1772800n 1.8
+    1772899n 1.8
+    1772900n 0
+    1773199n 0
+    1773200n 1.8
+    1773299n 1.8
+    1773300n 0
+    1773599n 0
+    1773600n 1.8
+    1773699n 1.8
+    1773700n 0
+    1773999n 0
+    1774000n 1.8
+    1774099n 1.8
+    1774100n 0
+    1774399n 0
+    1774400n 1.8
+    1774499n 1.8
+    1774500n 0
+    1774799n 0
+    1774800n 1.8
+    1774899n 1.8
+    1774900n 0
+    1775199n 0
+    1775200n 1.8
+    1775299n 1.8
+    1775300n 0
+    1775599n 0
+    1775600n 1.8
+    1775699n 1.8
+    1775700n 0
+    1775999n 0
+    1776000n 1.8
+    1776099n 1.8
+    1776100n 0
+    1776399n 0
+    1776400n 1.8
+    1776499n 1.8
+    1776500n 0
+    1776799n 0
+    1776800n 1.8
+    1776899n 1.8
+    1776900n 0
+    1777199n 0
+    1777200n 1.8
+    1777299n 1.8
+    1777300n 0
+    1777599n 0
+    1777600n 1.8
+    1777699n 1.8
+    1777700n 0
+    1777999n 0
+    1778000n 1.8
+    1778099n 1.8
+    1778100n 0
+    1778399n 0
+    1778400n 1.8
+    1778499n 1.8
+    1778500n 0
+    1778799n 0
+    1778800n 1.8
+    1778899n 1.8
+    1778900n 0
+    1779199n 0
+    1779200n 1.8
+    1779299n 1.8
+    1779300n 0
+    1779599n 0
+    1779600n 1.8
+    1779699n 1.8
+    1779700n 0
+    1779999n 0
+    1780000n 1.8
+    1780099n 1.8
+    1780100n 0
+    1780399n 0
+    1780400n 1.8
+    1780499n 1.8
+    1780500n 0
+    1780799n 0
+    1780800n 1.8
+    1780899n 1.8
+    1780900n 0
+    1781199n 0
+    1781200n 1.8
+    1781299n 1.8
+    1781300n 0
+    1781599n 0
+    1781600n 1.8
+    1781699n 1.8
+    1781700n 0
+    1781999n 0
+    1782000n 1.8
+    1782099n 1.8
+    1782100n 0
+    1782399n 0
+    1782400n 1.8
+    1782499n 1.8
+    1782500n 0
+    1782799n 0
+    1782800n 1.8
+    1782899n 1.8
+    1782900n 0
+    1783199n 0
+    1783200n 1.8
+    1783299n 1.8
+    1783300n 0
+    1783599n 0
+    1783600n 1.8
+    1783699n 1.8
+    1783700n 0
+    1783999n 0
+    1784000n 1.8
+    1784099n 1.8
+    1784100n 0
+    1784399n 0
+    1784400n 1.8
+    1784499n 1.8
+    1784500n 0
+    1784799n 0
+    1784800n 1.8
+    1784899n 1.8
+    1784900n 0
+    1785199n 0
+    1785200n 1.8
+    1785299n 1.8
+    1785300n 0
+    1785599n 0
+    1785600n 1.8
+    1785699n 1.8
+    1785700n 0
+    1785999n 0
+    1786000n 1.8
+    1786099n 1.8
+    1786100n 0
+    1786399n 0
+    1786400n 1.8
+    1786499n 1.8
+    1786500n 0
+    1786799n 0
+    1786800n 1.8
+    1786899n 1.8
+    1786900n 0
+    1787199n 0
+    1787200n 1.8
+    1787299n 1.8
+    1787300n 0
+    1787599n 0
+    1787600n 1.8
+    1787699n 1.8
+    1787700n 0
+    1787999n 0
+    1788000n 1.8
+    1788099n 1.8
+    1788100n 0
+    1788399n 0
+    1788400n 1.8
+    1788499n 1.8
+    1788500n 0
+    1788799n 0
+    1788800n 1.8
+    1788899n 1.8
+    1788900n 0
+    1789199n 0
+    1789200n 1.8
+    1789299n 1.8
+    1789300n 0
+    1789599n 0
+    1789600n 1.8
+    1789699n 1.8
+    1789700n 0
+    1789999n 0
+    1790000n 1.8
+    1790099n 1.8
+    1790100n 0
+    1790399n 0
+    1790400n 1.8
+    1790499n 1.8
+    1790500n 0
+    1790799n 0
+    1790800n 1.8
+    1790899n 1.8
+    1790900n 0
+    1791199n 0
+    1791200n 1.8
+    1791299n 1.8
+    1791300n 0
+    1791599n 0
+    1791600n 1.8
+    1791699n 1.8
+    1791700n 0
+    1791999n 0
+    1792000n 1.8
+    1792099n 1.8
+    1792100n 0
+    1792399n 0
+    1792400n 1.8
+    1792499n 1.8
+    1792500n 0
+    1792799n 0
+    1792800n 1.8
+    1792899n 1.8
+    1792900n 0
+    1793199n 0
+    1793200n 1.8
+    1793299n 1.8
+    1793300n 0
+    1793599n 0
+    1793600n 1.8
+    1793699n 1.8
+    1793700n 0
+    1793999n 0
+    1794000n 1.8
+    1794099n 1.8
+    1794100n 0
+    1794399n 0
+    1794400n 1.8
+    1794499n 1.8
+    1794500n 0
+    1794799n 0
+    1794800n 1.8
+    1794899n 1.8
+    1794900n 0
+    1795199n 0
+    1795200n 1.8
+    1795299n 1.8
+    1795300n 0
+    1795599n 0
+    1795600n 1.8
+    1795699n 1.8
+    1795700n 0
+    1795999n 0
+    1796000n 1.8
+    1796099n 1.8
+    1796100n 0
+    1796399n 0
+    1796400n 1.8
+    1796499n 1.8
+    1796500n 0
+    1796799n 0
+    1796800n 1.8
+    1796899n 1.8
+    1796900n 0
+    1797199n 0
+    1797200n 1.8
+    1797299n 1.8
+    1797300n 0
+    1797599n 0
+    1797600n 1.8
+    1797699n 1.8
+    1797700n 0
+    1797999n 0
+    1798000n 1.8
+    1798099n 1.8
+    1798100n 0
+    1798399n 0
+    1798400n 1.8
+    1798499n 1.8
+    1798500n 0
+    1798799n 0
+    1798800n 1.8
+    1798899n 1.8
+    1798900n 0
+    1799199n 0
+    1799200n 1.8
+    1799299n 1.8
+    1799300n 0
+    1799599n 0
+    1799600n 1.8
+    1799699n 1.8
+    1799700n 0
+    1799999n 0
+    1800000n 1.8
+    1800099n 1.8
+    1800100n 0
+    1800399n 0
+    1800400n 1.8
+    1800499n 1.8
+    1800500n 0
+    1800799n 0
+    1800800n 1.8
+    1800899n 1.8
+    1800900n 0
+    1801199n 0
+    1801200n 1.8
+    1801299n 1.8
+    1801300n 0
+    1801599n 0
+    1801600n 1.8
+    1801699n 1.8
+    1801700n 0
+    1801999n 0
+    1802000n 1.8
+    1802099n 1.8
+    1802100n 0
+    1802399n 0
+    1802400n 1.8
+    1802499n 1.8
+    1802500n 0
+    1802799n 0
+    1802800n 1.8
+    1802899n 1.8
+    1802900n 0
+    1803199n 0
+    1803200n 1.8
+    1803299n 1.8
+    1803300n 0
+    1803599n 0
+    1803600n 1.8
+    1803699n 1.8
+    1803700n 0
+    1803999n 0
+    1804000n 1.8
+    1804099n 1.8
+    1804100n 0
+    1804399n 0
+    1804400n 1.8
+    1804499n 1.8
+    1804500n 0
+    1804799n 0
+    1804800n 1.8
+    1804899n 1.8
+    1804900n 0
+    1805199n 0
+    1805200n 1.8
+    1805299n 1.8
+    1805300n 0
+    1805599n 0
+    1805600n 1.8
+    1805699n 1.8
+    1805700n 0
+    1805999n 0
+    1806000n 1.8
+    1806099n 1.8
+    1806100n 0
+    1806399n 0
+    1806400n 1.8
+    1806499n 1.8
+    1806500n 0
+    1806799n 0
+    1806800n 1.8
+    1806899n 1.8
+    1806900n 0
+    1807199n 0
+    1807200n 1.8
+    1807299n 1.8
+    1807300n 0
+    1807599n 0
+    1807600n 1.8
+    1807699n 1.8
+    1807700n 0
+    1807999n 0
+    1808000n 1.8
+    1808099n 1.8
+    1808100n 0
+    1808399n 0
+    1808400n 1.8
+    1808499n 1.8
+    1808500n 0
+    1808799n 0
+    1808800n 1.8
+    1808899n 1.8
+    1808900n 0
+    1809199n 0
+    1809200n 1.8
+    1809299n 1.8
+    1809300n 0
+    1809599n 0
+    1809600n 1.8
+    1809699n 1.8
+    1809700n 0
+    1809999n 0
+    1810000n 1.8
+    1810099n 1.8
+    1810100n 0
+    1810399n 0
+    1810400n 1.8
+    1810499n 1.8
+    1810500n 0
+    1810799n 0
+    1810800n 1.8
+    1810899n 1.8
+    1810900n 0
+    1811199n 0
+    1811200n 1.8
+    1811299n 1.8
+    1811300n 0
+    1811599n 0
+    1811600n 1.8
+    1811699n 1.8
+    1811700n 0
+    1811999n 0
+    1812000n 1.8
+    1812099n 1.8
+    1812100n 0
+    1812399n 0
+    1812400n 1.8
+    1812499n 1.8
+    1812500n 0
+    1812799n 0
+    1812800n 1.8
+    1812899n 1.8
+    1812900n 0
+    1813199n 0
+    1813200n 1.8
+    1813299n 1.8
+    1813300n 0
+    1813599n 0
+    1813600n 1.8
+    1813699n 1.8
+    1813700n 0
+    1813999n 0
+    1814000n 1.8
+    1814099n 1.8
+    1814100n 0
+    1814399n 0
+    1814400n 1.8
+    1814499n 1.8
+    1814500n 0
+    1814799n 0
+    1814800n 1.8
+    1814899n 1.8
+    1814900n 0
+    1815199n 0
+    1815200n 1.8
+    1815299n 1.8
+    1815300n 0
+    1815599n 0
+    1815600n 1.8
+    1815699n 1.8
+    1815700n 0
+    1815999n 0
+    1816000n 1.8
+    1816099n 1.8
+    1816100n 0
+    1816399n 0
+    1816400n 1.8
+    1816499n 1.8
+    1816500n 0
+    1816799n 0
+    1816800n 1.8
+    1816899n 1.8
+    1816900n 0
+    1817199n 0
+    1817200n 1.8
+    1817299n 1.8
+    1817300n 0
+    1817599n 0
+    1817600n 1.8
+    1817699n 1.8
+    1817700n 0
+    1817999n 0
+    1818000n 1.8
+    1818099n 1.8
+    1818100n 0
+    1818399n 0
+    1818400n 1.8
+    1818499n 1.8
+    1818500n 0
+    1818799n 0
+    1818800n 1.8
+    1818899n 1.8
+    1818900n 0
+    1819199n 0
+    1819200n 1.8
+    1819299n 1.8
+    1819300n 0
+    1819599n 0
+    1819600n 1.8
+    1819699n 1.8
+    1819700n 0
+    1819999n 0
+    1820000n 1.8
+    1820099n 1.8
+    1820100n 0
+    1820399n 0
+    1820400n 1.8
+    1820499n 1.8
+    1820500n 0
+    1820799n 0
+    1820800n 1.8
+    1820899n 1.8
+    1820900n 0
+    1821199n 0
+    1821200n 1.8
+    1821299n 1.8
+    1821300n 0
+    1821599n 0
+    1821600n 1.8
+    1821699n 1.8
+    1821700n 0
+    1821999n 0
+    1822000n 1.8
+    1822099n 1.8
+    1822100n 0
+    1822399n 0
+    1822400n 1.8
+    1822499n 1.8
+    1822500n 0
+    1822799n 0
+    1822800n 1.8
+    1822899n 1.8
+    1822900n 0
+    1823199n 0
+    1823200n 1.8
+    1823299n 1.8
+    1823300n 0
+    1823599n 0
+    1823600n 1.8
+    1823699n 1.8
+    1823700n 0
+    1823999n 0
+    1824000n 1.8
+    1824099n 1.8
+    1824100n 0
+    1824399n 0
+    1824400n 1.8
+    1824499n 1.8
+    1824500n 0
+    1824799n 0
+    1824800n 1.8
+    1824899n 1.8
+    1824900n 0
+    1825199n 0
+    1825200n 1.8
+    1825299n 1.8
+    1825300n 0
+    1825599n 0
+    1825600n 1.8
+    1825699n 1.8
+    1825700n 0
+    1825999n 0
+    1826000n 1.8
+    1826099n 1.8
+    1826100n 0
+    1826399n 0
+    1826400n 1.8
+    1826499n 1.8
+    1826500n 0
+    1826799n 0
+    1826800n 1.8
+    1826899n 1.8
+    1826900n 0
+    1827199n 0
+    1827200n 1.8
+    1827299n 1.8
+    1827300n 0
+    1827599n 0
+    1827600n 1.8
+    1827699n 1.8
+    1827700n 0
+    1827999n 0
+    1828000n 1.8
+    1828099n 1.8
+    1828100n 0
+    1828399n 0
+    1828400n 1.8
+    1828499n 1.8
+    1828500n 0
+    1828799n 0
+    1828800n 1.8
+    1828899n 1.8
+    1828900n 0
+    1829199n 0
+    1829200n 1.8
+    1829299n 1.8
+    1829300n 0
+    1829599n 0
+    1829600n 1.8
+    1829699n 1.8
+    1829700n 0
+    1829999n 0
+    1830000n 1.8
+    1830099n 1.8
+    1830100n 0
+    1830399n 0
+    1830400n 1.8
+    1830499n 1.8
+    1830500n 0
+    1830799n 0
+    1830800n 1.8
+    1830899n 1.8
+    1830900n 0
+    1831199n 0
+    1831200n 1.8
+    1831299n 1.8
+    1831300n 0
+    1831599n 0
+    1831600n 1.8
+    1831699n 1.8
+    1831700n 0
+    1831999n 0
+    1832000n 1.8
+    1832099n 1.8
+    1832100n 0
+    1832399n 0
+    1832400n 1.8
+    1832499n 1.8
+    1832500n 0
+    1832799n 0
+    1832800n 1.8
+    1832899n 1.8
+    1832900n 0
+    1833199n 0
+    1833200n 1.8
+    1833299n 1.8
+    1833300n 0
+    1833599n 0
+    1833600n 1.8
+    1833699n 1.8
+    1833700n 0
+    1833999n 0
+    1834000n 1.8
+    1834099n 1.8
+    1834100n 0
+    1834399n 0
+    1834400n 1.8
+    1834499n 1.8
+    1834500n 0
+    1834799n 0
+    1834800n 1.8
+    1834899n 1.8
+    1834900n 0
+    1835199n 0
+    1835200n 1.8
+    1835299n 1.8
+    1835300n 0
+    1835599n 0
+    1835600n 1.8
+    1835699n 1.8
+    1835700n 0
+    1835999n 0
+    1836000n 1.8
+    1836099n 1.8
+    1836100n 0
+    1836399n 0
+    1836400n 1.8
+    1836499n 1.8
+    1836500n 0
+    1836799n 0
+    1836800n 1.8
+    1836899n 1.8
+    1836900n 0
+    1837199n 0
+    1837200n 1.8
+    1837299n 1.8
+    1837300n 0
+    1837599n 0
+    1837600n 1.8
+    1837699n 1.8
+    1837700n 0
+    1837999n 0
+    1838000n 1.8
+    1838099n 1.8
+    1838100n 0
+    1838399n 0
+    1838400n 1.8
+    1838499n 1.8
+    1838500n 0
+    1838799n 0
+    1838800n 1.8
+    1838899n 1.8
+    1838900n 0
+    1839199n 0
+    1839200n 1.8
+    1839299n 1.8
+    1839300n 0
+    1839599n 0
+    1839600n 1.8
+    1839699n 1.8
+    1839700n 0
+    1839999n 0
+    1840000n 1.8
+    1840099n 1.8
+    1840100n 0
+    1840399n 0
+    1840400n 1.8
+    1840499n 1.8
+    1840500n 0
+    1840799n 0
+    1840800n 1.8
+    1840899n 1.8
+    1840900n 0
+    1841199n 0
+    1841200n 1.8
+    1841299n 1.8
+    1841300n 0
+    1841599n 0
+    1841600n 1.8
+    1841699n 1.8
+    1841700n 0
+    1841999n 0
+    1842000n 1.8
+    1842099n 1.8
+    1842100n 0
+    1842399n 0
+    1842400n 1.8
+    1842499n 1.8
+    1842500n 0
+    1842799n 0
+    1842800n 1.8
+    1842899n 1.8
+    1842900n 0
+    1843199n 0
+    1843200n 1.8
+    1843299n 1.8
+    1843300n 0
+    1843599n 0
+    1843600n 1.8
+    1843699n 1.8
+    1843700n 0
+    1843999n 0
+    1844000n 1.8
+    1844099n 1.8
+    1844100n 0
+    1844399n 0
+    1844400n 1.8
+    1844499n 1.8
+    1844500n 0
+    1844799n 0
+    1844800n 1.8
+    1844899n 1.8
+    1844900n 0
+    1845199n 0
+    1845200n 1.8
+    1845299n 1.8
+    1845300n 0
+    1845599n 0
+    1845600n 1.8
+    1845699n 1.8
+    1845700n 0
+    1845999n 0
+    1846000n 1.8
+    1846099n 1.8
+    1846100n 0
+    1846399n 0
+    1846400n 1.8
+    1846499n 1.8
+    1846500n 0
+    1846799n 0
+    1846800n 1.8
+    1846899n 1.8
+    1846900n 0
+    1847199n 0
+    1847200n 1.8
+    1847299n 1.8
+    1847300n 0
+    1847599n 0
+    1847600n 1.8
+    1847699n 1.8
+    1847700n 0
+    1847999n 0
+    1848000n 1.8
+    1848099n 1.8
+    1848100n 0
+    1848399n 0
+    1848400n 1.8
+    1848499n 1.8
+    1848500n 0
+    1848799n 0
+    1848800n 1.8
+    1848899n 1.8
+    1848900n 0
+    1849199n 0
+    1849200n 1.8
+    1849299n 1.8
+    1849300n 0
+    1849599n 0
+    1849600n 1.8
+    1849699n 1.8
+    1849700n 0
+    1849999n 0
+    1850000n 1.8
+    1850099n 1.8
+    1850100n 0
+    1850399n 0
+    1850400n 1.8
+    1850499n 1.8
+    1850500n 0
+    1850799n 0
+    1850800n 1.8
+    1850899n 1.8
+    1850900n 0
+    1851199n 0
+    1851200n 1.8
+    1851299n 1.8
+    1851300n 0
+    1851599n 0
+    1851600n 1.8
+    1851699n 1.8
+    1851700n 0
+    1851999n 0
+    1852000n 1.8
+    1852099n 1.8
+    1852100n 0
+    1852399n 0
+    1852400n 1.8
+    1852499n 1.8
+    1852500n 0
+    1852799n 0
+    1852800n 1.8
+    1852899n 1.8
+    1852900n 0
+    1853199n 0
+    1853200n 1.8
+    1853299n 1.8
+    1853300n 0
+    1853599n 0
+    1853600n 1.8
+    1853699n 1.8
+    1853700n 0
+    1853999n 0
+    1854000n 1.8
+    1854099n 1.8
+    1854100n 0
+    1854399n 0
+    1854400n 1.8
+    1854499n 1.8
+    1854500n 0
+    1854799n 0
+    1854800n 1.8
+    1854899n 1.8
+    1854900n 0
+    1855199n 0
+    1855200n 1.8
+    1855299n 1.8
+    1855300n 0
+    1855599n 0
+    1855600n 1.8
+    1855699n 1.8
+    1855700n 0
+    1855999n 0
+    1856000n 1.8
+    1856099n 1.8
+    1856100n 0
+    1856399n 0
+    1856400n 1.8
+    1856499n 1.8
+    1856500n 0
+    1856799n 0
+    1856800n 1.8
+    1856899n 1.8
+    1856900n 0
+    1857199n 0
+    1857200n 1.8
+    1857299n 1.8
+    1857300n 0
+    1857599n 0
+    1857600n 1.8
+    1857699n 1.8
+    1857700n 0
+    1857999n 0
+    1858000n 1.8
+    1858099n 1.8
+    1858100n 0
+    1858399n 0
+    1858400n 1.8
+    1858499n 1.8
+    1858500n 0
+    1858799n 0
+    1858800n 1.8
+    1858899n 1.8
+    1858900n 0
+    1859199n 0
+    1859200n 1.8
+    1859299n 1.8
+    1859300n 0
+    1859599n 0
+    1859600n 1.8
+    1859699n 1.8
+    1859700n 0
+    1859999n 0
+    1860000n 1.8
+    1860099n 1.8
+    1860100n 0
+    1860399n 0
+    1860400n 1.8
+    1860499n 1.8
+    1860500n 0
+    1860799n 0
+    1860800n 1.8
+    1860899n 1.8
+    1860900n 0
+    1861199n 0
+    1861200n 1.8
+    1861299n 1.8
+    1861300n 0
+    1861599n 0
+    1861600n 1.8
+    1861699n 1.8
+    1861700n 0
+    1861999n 0
+    1862000n 1.8
+    1862099n 1.8
+    1862100n 0
+    1862399n 0
+    1862400n 1.8
+    1862499n 1.8
+    1862500n 0
+    1862799n 0
+    1862800n 1.8
+    1862899n 1.8
+    1862900n 0
+    1863199n 0
+    1863200n 1.8
+    1863299n 1.8
+    1863300n 0
+    1863599n 0
+    1863600n 1.8
+    1863699n 1.8
+    1863700n 0
+    1863999n 0
+    1864000n 1.8
+    1864099n 1.8
+    1864100n 0
+    1864399n 0
+    1864400n 1.8
+    1864499n 1.8
+    1864500n 0
+    1864799n 0
+    1864800n 1.8
+    1864899n 1.8
+    1864900n 0
+    1865199n 0
+    1865200n 1.8
+    1865299n 1.8
+    1865300n 0
+    1865599n 0
+    1865600n 1.8
+    1865699n 1.8
+    1865700n 0
+    1865999n 0
+    1866000n 1.8
+    1866099n 1.8
+    1866100n 0
+    1866399n 0
+    1866400n 1.8
+    1866499n 1.8
+    1866500n 0
+    1866799n 0
+    1866800n 1.8
+    1866899n 1.8
+    1866900n 0
+    1867199n 0
+    1867200n 1.8
+    1867299n 1.8
+    1867300n 0
+    1867599n 0
+    1867600n 1.8
+    1867699n 1.8
+    1867700n 0
+    1867999n 0
+    1868000n 1.8
+    1868099n 1.8
+    1868100n 0
+    1868399n 0
+    1868400n 1.8
+    1868499n 1.8
+    1868500n 0
+    1868799n 0
+    1868800n 1.8
+    1868899n 1.8
+    1868900n 0
+    1869199n 0
+    1869200n 1.8
+    1869299n 1.8
+    1869300n 0
+    1869599n 0
+    1869600n 1.8
+    1869699n 1.8
+    1869700n 0
+    1869999n 0
+    1870000n 1.8
+    1870099n 1.8
+    1870100n 0
+    1870399n 0
+    1870400n 1.8
+    1870499n 1.8
+    1870500n 0
+    1870799n 0
+    1870800n 1.8
+    1870899n 1.8
+    1870900n 0
+    1871199n 0
+    1871200n 1.8
+    1871299n 1.8
+    1871300n 0
+    1871599n 0
+    1871600n 1.8
+    1871699n 1.8
+    1871700n 0
+    1871999n 0
+    1872000n 1.8
+    1872099n 1.8
+    1872100n 0
+    1872399n 0
+    1872400n 1.8
+    1872499n 1.8
+    1872500n 0
+    1872799n 0
+    1872800n 1.8
+    1872899n 1.8
+    1872900n 0
+    1873199n 0
+    1873200n 1.8
+    1873299n 1.8
+    1873300n 0
+    1873599n 0
+    1873600n 1.8
+    1873699n 1.8
+    1873700n 0
+    1873999n 0
+    1874000n 1.8
+    1874099n 1.8
+    1874100n 0
+    1874399n 0
+    1874400n 1.8
+    1874499n 1.8
+    1874500n 0
+    1874799n 0
+    1874800n 1.8
+    1874899n 1.8
+    1874900n 0
+    1875199n 0
+    1875200n 1.8
+    1875299n 1.8
+    1875300n 0
+    1875599n 0
+    1875600n 1.8
+    1875699n 1.8
+    1875700n 0
+    1875999n 0
+    1876000n 1.8
+    1876099n 1.8
+    1876100n 0
+    1876399n 0
+    1876400n 1.8
+    1876499n 1.8
+    1876500n 0
+    1876799n 0
+    1876800n 1.8
+    1876899n 1.8
+    1876900n 0
+    1877199n 0
+    1877200n 1.8
+    1877299n 1.8
+    1877300n 0
+    1877599n 0
+    1877600n 1.8
+    1877699n 1.8
+    1877700n 0
+    1877999n 0
+    1878000n 1.8
+    1878099n 1.8
+    1878100n 0
+    1878399n 0
+    1878400n 1.8
+    1878499n 1.8
+    1878500n 0
+    1878799n 0
+    1878800n 1.8
+    1878899n 1.8
+    1878900n 0
+    1879199n 0
+    1879200n 1.8
+    1879299n 1.8
+    1879300n 0
+    1879599n 0
+    1879600n 1.8
+    1879699n 1.8
+    1879700n 0
+    1879999n 0
+    1880000n 1.8
+    1880099n 1.8
+    1880100n 0
+    1880399n 0
+    1880400n 1.8
+    1880499n 1.8
+    1880500n 0
+    1880799n 0
+    1880800n 1.8
+    1880899n 1.8
+    1880900n 0
+    1881199n 0
+    1881200n 1.8
+    1881299n 1.8
+    1881300n 0
+    1881599n 0
+    1881600n 1.8
+    1881699n 1.8
+    1881700n 0
+    1881999n 0
+    1882000n 1.8
+    1882099n 1.8
+    1882100n 0
+    1882399n 0
+    1882400n 1.8
+    1882499n 1.8
+    1882500n 0
+    1882799n 0
+    1882800n 1.8
+    1882899n 1.8
+    1882900n 0
+    1883199n 0
+    1883200n 1.8
+    1883299n 1.8
+    1883300n 0
+    1883599n 0
+    1883600n 1.8
+    1883699n 1.8
+    1883700n 0
+    1883999n 0
+    1884000n 1.8
+    1884099n 1.8
+    1884100n 0
+    1884399n 0
+    1884400n 1.8
+    1884499n 1.8
+    1884500n 0
+    1884799n 0
+    1884800n 1.8
+    1884899n 1.8
+    1884900n 0
+    1885199n 0
+    1885200n 1.8
+    1885299n 1.8
+    1885300n 0
+    1885599n 0
+    1885600n 1.8
+    1885699n 1.8
+    1885700n 0
+    1885999n 0
+    1886000n 1.8
+    1886099n 1.8
+    1886100n 0
+    1886399n 0
+    1886400n 1.8
+    1886499n 1.8
+    1886500n 0
+    1886799n 0
+    1886800n 1.8
+    1886899n 1.8
+    1886900n 0
+    1887199n 0
+    1887200n 1.8
+    1887299n 1.8
+    1887300n 0
+    1887599n 0
+    1887600n 1.8
+    1887699n 1.8
+    1887700n 0
+    1887999n 0
+    1888000n 1.8
+    1888099n 1.8
+    1888100n 0
+    1888399n 0
+    1888400n 1.8
+    1888499n 1.8
+    1888500n 0
+    1888799n 0
+    1888800n 1.8
+    1888899n 1.8
+    1888900n 0
+    1889199n 0
+    1889200n 1.8
+    1889299n 1.8
+    1889300n 0
+    1889599n 0
+    1889600n 1.8
+    1889699n 1.8
+    1889700n 0
+    1889999n 0
+    1890000n 1.8
+    1890099n 1.8
+    1890100n 0
+    1890399n 0
+    1890400n 1.8
+    1890499n 1.8
+    1890500n 0
+    1890799n 0
+    1890800n 1.8
+    1890899n 1.8
+    1890900n 0
+    1891199n 0
+    1891200n 1.8
+    1891299n 1.8
+    1891300n 0
+    1891599n 0
+    1891600n 1.8
+    1891699n 1.8
+    1891700n 0
+    1891999n 0
+    1892000n 1.8
+    1892099n 1.8
+    1892100n 0
+    1892399n 0
+    1892400n 1.8
+    1892499n 1.8
+    1892500n 0
+    1892799n 0
+    1892800n 1.8
+    1892899n 1.8
+    1892900n 0
+    1893199n 0
+    1893200n 1.8
+    1893299n 1.8
+    1893300n 0
+    1893599n 0
+    1893600n 1.8
+    1893699n 1.8
+    1893700n 0
+    1893999n 0
+    1894000n 1.8
+    1894099n 1.8
+    1894100n 0
+    1894399n 0
+    1894400n 1.8
+    1894499n 1.8
+    1894500n 0
+    1894799n 0
+    1894800n 1.8
+    1894899n 1.8
+    1894900n 0
+    1895199n 0
+    1895200n 1.8
+    1895299n 1.8
+    1895300n 0
+    1895599n 0
+    1895600n 1.8
+    1895699n 1.8
+    1895700n 0
+    1895999n 0
+    1896000n 1.8
+    1896099n 1.8
+    1896100n 0
+    1896399n 0
+    1896400n 1.8
+    1896499n 1.8
+    1896500n 0
+    1896799n 0
+    1896800n 1.8
+    1896899n 1.8
+    1896900n 0
+    1897199n 0
+    1897200n 1.8
+    1897299n 1.8
+    1897300n 0
+    1897599n 0
+    1897600n 1.8
+    1897699n 1.8
+    1897700n 0
+    1897999n 0
+    1898000n 1.8
+    1898099n 1.8
+    1898100n 0
+    1898399n 0
+    1898400n 1.8
+    1898499n 1.8
+    1898500n 0
+    1898799n 0
+    1898800n 1.8
+    1898899n 1.8
+    1898900n 0
+    1899199n 0
+    1899200n 1.8
+    1899299n 1.8
+    1899300n 0
+    1899599n 0
+    1899600n 1.8
+    1899699n 1.8
+    1899700n 0
+    1899999n 0
+    1900000n 1.8
+    1900099n 1.8
+    1900100n 0
+    1900399n 0
+    1900400n 1.8
+    1900499n 1.8
+    1900500n 0
+    1900799n 0
+    1900800n 1.8
+    1900899n 1.8
+    1900900n 0
+    1901199n 0
+    1901200n 1.8
+    1901299n 1.8
+    1901300n 0
+    1901599n 0
+    1901600n 1.8
+    1901699n 1.8
+    1901700n 0
+    1901999n 0
+    1902000n 1.8
+    1902099n 1.8
+    1902100n 0
+    1902399n 0
+    1902400n 1.8
+    1902499n 1.8
+    1902500n 0
+    1902799n 0
+    1902800n 1.8
+    1902899n 1.8
+    1902900n 0
+    1903199n 0
+    1903200n 1.8
+    1903299n 1.8
+    1903300n 0
+    1903599n 0
+    1903600n 1.8
+    1903699n 1.8
+    1903700n 0
+    1903999n 0
+    1904000n 1.8
+    1904099n 1.8
+    1904100n 0
+    1904399n 0
+    1904400n 1.8
+    1904499n 1.8
+    1904500n 0
+    1904799n 0
+    1904800n 1.8
+    1904899n 1.8
+    1904900n 0
+    1905199n 0
+    1905200n 1.8
+    1905299n 1.8
+    1905300n 0
+    1905599n 0
+    1905600n 1.8
+    1905699n 1.8
+    1905700n 0
+    1905999n 0
+    1906000n 1.8
+    1906099n 1.8
+    1906100n 0
+    1906399n 0
+    1906400n 1.8
+    1906499n 1.8
+    1906500n 0
+    1906799n 0
+    1906800n 1.8
+    1906899n 1.8
+    1906900n 0
+    1907199n 0
+    1907200n 1.8
+    1907299n 1.8
+    1907300n 0
+    1907599n 0
+    1907600n 1.8
+    1907699n 1.8
+    1907700n 0
+    1907999n 0
+    1908000n 1.8
+    1908099n 1.8
+    1908100n 0
+    1908399n 0
+    1908400n 1.8
+    1908499n 1.8
+    1908500n 0
+    1908799n 0
+    1908800n 1.8
+    1908899n 1.8
+    1908900n 0
+    1909199n 0
+    1909200n 1.8
+    1909299n 1.8
+    1909300n 0
+    1909599n 0
+    1909600n 1.8
+    1909699n 1.8
+    1909700n 0
+    1909999n 0
+    1910000n 1.8
+    1910099n 1.8
+    1910100n 0
+    1910399n 0
+    1910400n 1.8
+    1910499n 1.8
+    1910500n 0
+    1910799n 0
+    1910800n 1.8
+    1910899n 1.8
+    1910900n 0
+    1911199n 0
+    1911200n 1.8
+    1911299n 1.8
+    1911300n 0
+    1911599n 0
+    1911600n 1.8
+    1911699n 1.8
+    1911700n 0
+    1911999n 0
+    1912000n 1.8
+    1912099n 1.8
+    1912100n 0
+    1912399n 0
+    1912400n 1.8
+    1912499n 1.8
+    1912500n 0
+    1912799n 0
+    1912800n 1.8
+    1912899n 1.8
+    1912900n 0
+    1913199n 0
+    1913200n 1.8
+    1913299n 1.8
+    1913300n 0
+    1913599n 0
+    1913600n 1.8
+    1913699n 1.8
+    1913700n 0
+    1913999n 0
+    1914000n 1.8
+    1914099n 1.8
+    1914100n 0
+    1914399n 0
+    1914400n 1.8
+    1914499n 1.8
+    1914500n 0
+    1914799n 0
+    1914800n 1.8
+    1914899n 1.8
+    1914900n 0
+    1915199n 0
+    1915200n 1.8
+    1915299n 1.8
+    1915300n 0
+    1915599n 0
+    1915600n 1.8
+    1915699n 1.8
+    1915700n 0
+    1915999n 0
+    1916000n 1.8
+    1916099n 1.8
+    1916100n 0
+    1916399n 0
+    1916400n 1.8
+    1916499n 1.8
+    1916500n 0
+    1916799n 0
+    1916800n 1.8
+    1916899n 1.8
+    1916900n 0
+    1917199n 0
+    1917200n 1.8
+    1917299n 1.8
+    1917300n 0
+    1917599n 0
+    1917600n 1.8
+    1917699n 1.8
+    1917700n 0
+    1917999n 0
+    1918000n 1.8
+    1918099n 1.8
+    1918100n 0
+    1918399n 0
+    1918400n 1.8
+    1918499n 1.8
+    1918500n 0
+    1918799n 0
+    1918800n 1.8
+    1918899n 1.8
+    1918900n 0
+    1919199n 0
+    1919200n 1.8
+    1919299n 1.8
+    1919300n 0
+    1919599n 0
+    1919600n 1.8
+    1919699n 1.8
+    1919700n 0
+    1919999n 0
+    1920000n 1.8
+    1920099n 1.8
+    1920100n 0
+    1920399n 0
+    1920400n 1.8
+    1920499n 1.8
+    1920500n 0
+    1920799n 0
+    1920800n 1.8
+    1920899n 1.8
+    1920900n 0
+    1921199n 0
+    1921200n 1.8
+    1921299n 1.8
+    1921300n 0
+    1921599n 0
+    1921600n 1.8
+    1921699n 1.8
+    1921700n 0
+    1921999n 0
+    1922000n 1.8
+    1922099n 1.8
+    1922100n 0
+    1922399n 0
+    1922400n 1.8
+    1922499n 1.8
+    1922500n 0
+    1922799n 0
+    1922800n 1.8
+    1922899n 1.8
+    1922900n 0
+    1923199n 0
+    1923200n 1.8
+    1923299n 1.8
+    1923300n 0
+    1923599n 0
+    1923600n 1.8
+    1923699n 1.8
+    1923700n 0
+    1923999n 0
+    1924000n 1.8
+    1924099n 1.8
+    1924100n 0
+    1924399n 0
+    1924400n 1.8
+    1924499n 1.8
+    1924500n 0
+    1924799n 0
+    1924800n 1.8
+    1924899n 1.8
+    1924900n 0
+    1925199n 0
+    1925200n 1.8
+    1925299n 1.8
+    1925300n 0
+    1925599n 0
+    1925600n 1.8
+    1925699n 1.8
+    1925700n 0
+    1925999n 0
+    1926000n 1.8
+    1926099n 1.8
+    1926100n 0
+    1926399n 0
+    1926400n 1.8
+    1926499n 1.8
+    1926500n 0
+    1926799n 0
+    1926800n 1.8
+    1926899n 1.8
+    1926900n 0
+    1927199n 0
+    1927200n 1.8
+    1927299n 1.8
+    1927300n 0
+    1927599n 0
+    1927600n 1.8
+    1927699n 1.8
+    1927700n 0
+    1927999n 0
+    1928000n 1.8
+    1928099n 1.8
+    1928100n 0
+    1928399n 0
+    1928400n 1.8
+    1928499n 1.8
+    1928500n 0
+    1928799n 0
+    1928800n 1.8
+    1928899n 1.8
+    1928900n 0
+    1929199n 0
+    1929200n 1.8
+    1929299n 1.8
+    1929300n 0
+    1929599n 0
+    1929600n 1.8
+    1929699n 1.8
+    1929700n 0
+    1929999n 0
+    1930000n 1.8
+    1930099n 1.8
+    1930100n 0
+    1930399n 0
+    1930400n 1.8
+    1930499n 1.8
+    1930500n 0
+    1930799n 0
+    1930800n 1.8
+    1930899n 1.8
+    1930900n 0
+    1931199n 0
+    1931200n 1.8
+    1931299n 1.8
+    1931300n 0
+    1931599n 0
+    1931600n 1.8
+    1931699n 1.8
+    1931700n 0
+    1931999n 0
+    1932000n 1.8
+    1932099n 1.8
+    1932100n 0
+    1932399n 0
+    1932400n 1.8
+    1932499n 1.8
+    1932500n 0
+    1932799n 0
+    1932800n 1.8
+    1932899n 1.8
+    1932900n 0
+    1933199n 0
+    1933200n 1.8
+    1933299n 1.8
+    1933300n 0
+    1933599n 0
+    1933600n 1.8
+    1933699n 1.8
+    1933700n 0
+    1933999n 0
+    1934000n 1.8
+    1934099n 1.8
+    1934100n 0
+    1934399n 0
+    1934400n 1.8
+    1934499n 1.8
+    1934500n 0
+    1934799n 0
+    1934800n 1.8
+    1934899n 1.8
+    1934900n 0
+    1935199n 0
+    1935200n 1.8
+    1935299n 1.8
+    1935300n 0
+    1935599n 0
+    1935600n 1.8
+    1935699n 1.8
+    1935700n 0
+    1935999n 0
+    1936000n 1.8
+    1936099n 1.8
+    1936100n 0
+    1936399n 0
+    1936400n 1.8
+    1936499n 1.8
+    1936500n 0
+    1936799n 0
+    1936800n 1.8
+    1936899n 1.8
+    1936900n 0
+    1937199n 0
+    1937200n 1.8
+    1937299n 1.8
+    1937300n 0
+    1937599n 0
+    1937600n 1.8
+    1937699n 1.8
+    1937700n 0
+    1937999n 0
+    1938000n 1.8
+    1938099n 1.8
+    1938100n 0
+    1938399n 0
+    1938400n 1.8
+    1938499n 1.8
+    1938500n 0
+    1938799n 0
+    1938800n 1.8
+    1938899n 1.8
+    1938900n 0
+    1939199n 0
+    1939200n 1.8
+    1939299n 1.8
+    1939300n 0
+    1939599n 0
+    1939600n 1.8
+    1939699n 1.8
+    1939700n 0
+    1939999n 0
+    1940000n 1.8
+    1940099n 1.8
+    1940100n 0
+    1940399n 0
+    1940400n 1.8
+    1940499n 1.8
+    1940500n 0
+    1940799n 0
+    1940800n 1.8
+    1940899n 1.8
+    1940900n 0
+    1941199n 0
+    1941200n 1.8
+    1941299n 1.8
+    1941300n 0
+    1941599n 0
+    1941600n 1.8
+    1941699n 1.8
+    1941700n 0
+    1941999n 0
+    1942000n 1.8
+    1942099n 1.8
+    1942100n 0
+    1942399n 0
+    1942400n 1.8
+    1942499n 1.8
+    1942500n 0
+    1942799n 0
+    1942800n 1.8
+    1942899n 1.8
+    1942900n 0
+    1943199n 0
+    1943200n 1.8
+    1943299n 1.8
+    1943300n 0
+    1943599n 0
+    1943600n 1.8
+    1943699n 1.8
+    1943700n 0
+    1943999n 0
+    1944000n 1.8
+    1944099n 1.8
+    1944100n 0
+    1944399n 0
+    1944400n 1.8
+    1944499n 1.8
+    1944500n 0
+    1944799n 0
+    1944800n 1.8
+    1944899n 1.8
+    1944900n 0
+    1945199n 0
+    1945200n 1.8
+    1945299n 1.8
+    1945300n 0
+    1945599n 0
+    1945600n 1.8
+    1945699n 1.8
+    1945700n 0
+    1945999n 0
+    1946000n 1.8
+    1946099n 1.8
+    1946100n 0
+    1946399n 0
+    1946400n 1.8
+    1946499n 1.8
+    1946500n 0
+    1946799n 0
+    1946800n 1.8
+    1946899n 1.8
+    1946900n 0
+    1947199n 0
+    1947200n 1.8
+    1947299n 1.8
+    1947300n 0
+    1947599n 0
+    1947600n 1.8
+    1947699n 1.8
+    1947700n 0
+    1947999n 0
+    1948000n 1.8
+    1948099n 1.8
+    1948100n 0
+    1948399n 0
+    1948400n 1.8
+    1948499n 1.8
+    1948500n 0
+    1948799n 0
+    1948800n 1.8
+    1948899n 1.8
+    1948900n 0
+    1949199n 0
+    1949200n 1.8
+    1949299n 1.8
+    1949300n 0
+    1949599n 0
+    1949600n 1.8
+    1949699n 1.8
+    1949700n 0
+    1949999n 0
+    1950000n 1.8
+    1950099n 1.8
+    1950100n 0
+    1950399n 0
+    1950400n 1.8
+    1950499n 1.8
+    1950500n 0
+    1950799n 0
+    1950800n 1.8
+    1950899n 1.8
+    1950900n 0
+    1951199n 0
+    1951200n 1.8
+    1951299n 1.8
+    1951300n 0
+    1951599n 0
+    1951600n 1.8
+    1951699n 1.8
+    1951700n 0
+    1951999n 0
+    1952000n 1.8
+    1952099n 1.8
+    1952100n 0
+    1952399n 0
+    1952400n 1.8
+    1952499n 1.8
+    1952500n 0
+    1952799n 0
+    1952800n 1.8
+    1952899n 1.8
+    1952900n 0
+    1953199n 0
+    1953200n 1.8
+    1953299n 1.8
+    1953300n 0
+    1953599n 0
+    1953600n 1.8
+    1953699n 1.8
+    1953700n 0
+    1953999n 0
+    1954000n 1.8
+    1954099n 1.8
+    1954100n 0
+    1954399n 0
+    1954400n 1.8
+    1954499n 1.8
+    1954500n 0
+    1954799n 0
+    1954800n 1.8
+    1954899n 1.8
+    1954900n 0
+    1955199n 0
+    1955200n 1.8
+    1955299n 1.8
+    1955300n 0
+    1955599n 0
+    1955600n 1.8
+    1955699n 1.8
+    1955700n 0
+    1955999n 0
+    1956000n 1.8
+    1956099n 1.8
+    1956100n 0
+    1956399n 0
+    1956400n 1.8
+    1956499n 1.8
+    1956500n 0
+    1956799n 0
+    1956800n 1.8
+    1956899n 1.8
+    1956900n 0
+    1957199n 0
+    1957200n 1.8
+    1957299n 1.8
+    1957300n 0
+    1957599n 0
+    1957600n 1.8
+    1957699n 1.8
+    1957700n 0
+    1957999n 0
+    1958000n 1.8
+    1958099n 1.8
+    1958100n 0
+    1958399n 0
+    1958400n 1.8
+    1958499n 1.8
+    1958500n 0
+    1958799n 0
+    1958800n 1.8
+    1958899n 1.8
+    1958900n 0
+    1959199n 0
+    1959200n 1.8
+    1959299n 1.8
+    1959300n 0
+    1959599n 0
+    1959600n 1.8
+    1959699n 1.8
+    1959700n 0
+    1959999n 0
+    1960000n 1.8
+    1960099n 1.8
+    1960100n 0
+    1960399n 0
+    1960400n 1.8
+    1960499n 1.8
+    1960500n 0
+    1960799n 0
+    1960800n 1.8
+    1960899n 1.8
+    1960900n 0
+    1961199n 0
+    1961200n 1.8
+    1961299n 1.8
+    1961300n 0
+    1961599n 0
+    1961600n 1.8
+    1961699n 1.8
+    1961700n 0
+    1961999n 0
+    1962000n 1.8
+    1962099n 1.8
+    1962100n 0
+    1962399n 0
+    1962400n 1.8
+    1962499n 1.8
+    1962500n 0
+    1962799n 0
+    1962800n 1.8
+    1962899n 1.8
+    1962900n 0
+    1963199n 0
+    1963200n 1.8
+    1963299n 1.8
+    1963300n 0
+    1963599n 0
+    1963600n 1.8
+    1963699n 1.8
+    1963700n 0
+    1963999n 0
+    1964000n 1.8
+    1964099n 1.8
+    1964100n 0
+    1964399n 0
+    1964400n 1.8
+    1964499n 1.8
+    1964500n 0
+    1964799n 0
+    1964800n 1.8
+    1964899n 1.8
+    1964900n 0
+    1965199n 0
+    1965200n 1.8
+    1965299n 1.8
+    1965300n 0
+    1965599n 0
+    1965600n 1.8
+    1965699n 1.8
+    1965700n 0
+    1965999n 0
+    1966000n 1.8
+    1966099n 1.8
+    1966100n 0
+    1966399n 0
+    1966400n 1.8
+    1966499n 1.8
+    1966500n 0
+    1966799n 0
+    1966800n 1.8
+    1966899n 1.8
+    1966900n 0
+    1967199n 0
+    1967200n 1.8
+    1967299n 1.8
+    1967300n 0
+    1967599n 0
+    1967600n 1.8
+    1967699n 1.8
+    1967700n 0
+    1967999n 0
+    1968000n 1.8
+    1968099n 1.8
+    1968100n 0
+    1968399n 0
+    1968400n 1.8
+    1968499n 1.8
+    1968500n 0
+    1968799n 0
+    1968800n 1.8
+    1968899n 1.8
+    1968900n 0
+    1969199n 0
+    1969200n 1.8
+    1969299n 1.8
+    1969300n 0
+    1969599n 0
+    1969600n 1.8
+    1969699n 1.8
+    1969700n 0
+    1969999n 0
+    1970000n 1.8
+    1970099n 1.8
+    1970100n 0
+    1970399n 0
+    1970400n 1.8
+    1970499n 1.8
+    1970500n 0
+    1970799n 0
+    1970800n 1.8
+    1970899n 1.8
+    1970900n 0
+    1971199n 0
+    1971200n 1.8
+    1971299n 1.8
+    1971300n 0
+    1971599n 0
+    1971600n 1.8
+    1971699n 1.8
+    1971700n 0
+    1971999n 0
+    1972000n 1.8
+    1972099n 1.8
+    1972100n 0
+    1972399n 0
+    1972400n 1.8
+    1972499n 1.8
+    1972500n 0
+    1972799n 0
+    1972800n 1.8
+    1972899n 1.8
+    1972900n 0
+    1973199n 0
+    1973200n 1.8
+    1973299n 1.8
+    1973300n 0
+    1973599n 0
+    1973600n 1.8
+    1973699n 1.8
+    1973700n 0
+    1973999n 0
+    1974000n 1.8
+    1974099n 1.8
+    1974100n 0
+    1974399n 0
+    1974400n 1.8
+    1974499n 1.8
+    1974500n 0
+    1974799n 0
+    1974800n 1.8
+    1974899n 1.8
+    1974900n 0
+    1975199n 0
+    1975200n 1.8
+    1975299n 1.8
+    1975300n 0
+    1975599n 0
+    1975600n 1.8
+    1975699n 1.8
+    1975700n 0
+    1975999n 0
+    1976000n 1.8
+    1976099n 1.8
+    1976100n 0
+    1976399n 0
+    1976400n 1.8
+    1976499n 1.8
+    1976500n 0
+    1976799n 0
+    1976800n 1.8
+    1976899n 1.8
+    1976900n 0
+    1977199n 0
+    1977200n 1.8
+    1977299n 1.8
+    1977300n 0
+    1977599n 0
+    1977600n 1.8
+    1977699n 1.8
+    1977700n 0
+    1977999n 0
+    1978000n 1.8
+    1978099n 1.8
+    1978100n 0
+    1978399n 0
+    1978400n 1.8
+    1978499n 1.8
+    1978500n 0
+    1978799n 0
+    1978800n 1.8
+    1978899n 1.8
+    1978900n 0
+    1979199n 0
+    1979200n 1.8
+    1979299n 1.8
+    1979300n 0
+    1979599n 0
+    1979600n 1.8
+    1979699n 1.8
+    1979700n 0
+    1979999n 0
+    1980000n 1.8
+    1980099n 1.8
+    1980100n 0
+    1980399n 0
+    1980400n 1.8
+    1980499n 1.8
+    1980500n 0
+    1980799n 0
+    1980800n 1.8
+    1980899n 1.8
+    1980900n 0
+    1981199n 0
+    1981200n 1.8
+    1981299n 1.8
+    1981300n 0
+    1981599n 0
+    1981600n 1.8
+    1981699n 1.8
+    1981700n 0
+    1981999n 0
+    1982000n 1.8
+    1982099n 1.8
+    1982100n 0
+    1982399n 0
+    1982400n 1.8
+    1982499n 1.8
+    1982500n 0
+    1982799n 0
+    1982800n 1.8
+    1982899n 1.8
+    1982900n 0
+    1983199n 0
+    1983200n 1.8
+    1983299n 1.8
+    1983300n 0
+    1983599n 0
+    1983600n 1.8
+    1983699n 1.8
+    1983700n 0
+    1983999n 0
+    1984000n 1.8
+    1984099n 1.8
+    1984100n 0
+    1984399n 0
+    1984400n 1.8
+    1984499n 1.8
+    1984500n 0
+    1984799n 0
+    1984800n 1.8
+    1984899n 1.8
+    1984900n 0
+    1985199n 0
+    1985200n 1.8
+    1985299n 1.8
+    1985300n 0
+    1985599n 0
+    1985600n 1.8
+    1985699n 1.8
+    1985700n 0
+    1985999n 0
+    1986000n 1.8
+    1986099n 1.8
+    1986100n 0
+    1986399n 0
+    1986400n 1.8
+    1986499n 1.8
+    1986500n 0
+    1986799n 0
+    1986800n 1.8
+    1986899n 1.8
+    1986900n 0
+    1987199n 0
+    1987200n 1.8
+    1987299n 1.8
+    1987300n 0
+    1987599n 0
+    1987600n 1.8
+    1987699n 1.8
+    1987700n 0
+    1987999n 0
+    1988000n 1.8
+    1988099n 1.8
+    1988100n 0
+    1988399n 0
+    1988400n 1.8
+    1988499n 1.8
+    1988500n 0
+    1988799n 0
+    1988800n 1.8
+    1988899n 1.8
+    1988900n 0
+    1989199n 0
+    1989200n 1.8
+    1989299n 1.8
+    1989300n 0
+    1989599n 0
+    1989600n 1.8
+    1989699n 1.8
+    1989700n 0
+    1989999n 0
+    1990000n 1.8
+    1990099n 1.8
+    1990100n 0
+    1990399n 0
+    1990400n 1.8
+    1990499n 1.8
+    1990500n 0
+    1990799n 0
+    1990800n 1.8
+    1990899n 1.8
+    1990900n 0
+    1991199n 0
+    1991200n 1.8
+    1991299n 1.8
+    1991300n 0
+    1991599n 0
+    1991600n 1.8
+    1991699n 1.8
+    1991700n 0
+    1991999n 0
+    1992000n 1.8
+    1992099n 1.8
+    1992100n 0
+    1992399n 0
+    1992400n 1.8
+    1992499n 1.8
+    1992500n 0
+    1992799n 0
+    1992800n 1.8
+    1992899n 1.8
+    1992900n 0
+    1993199n 0
+    1993200n 1.8
+    1993299n 1.8
+    1993300n 0
+    1993599n 0
+    1993600n 1.8
+    1993699n 1.8
+    1993700n 0
+    1993999n 0
+    1994000n 1.8
+    1994099n 1.8
+    1994100n 0
+    1994399n 0
+    1994400n 1.8
+    1994499n 1.8
+    1994500n 0
+    1994799n 0
+    1994800n 1.8
+    1994899n 1.8
+    1994900n 0
+    1995199n 0
+    1995200n 1.8
+    1995299n 1.8
+    1995300n 0
+    1995599n 0
+    1995600n 1.8
+    1995699n 1.8
+    1995700n 0
+    1995999n 0
+    1996000n 1.8
+    1996099n 1.8
+    1996100n 0
+    1996399n 0
+    1996400n 1.8
+    1996499n 1.8
+    1996500n 0
+    1996799n 0
+    1996800n 1.8
+    1996899n 1.8
+    1996900n 0
+    1997199n 0
+    1997200n 1.8
+    1997299n 1.8
+    1997300n 0
+    1997599n 0
+    1997600n 1.8
+    1997699n 1.8
+    1997700n 0
+    1997999n 0
+    1998000n 1.8
+    1998099n 1.8
+    1998100n 0
+    1998399n 0
+    1998400n 1.8
+    1998499n 1.8
+    1998500n 0
+    1998799n 0
+    1998800n 1.8
+    1998899n 1.8
+    1998900n 0
+    1999199n 0
+    1999200n 1.8
+    1999299n 1.8
+    1999300n 0
+    1999599n 0
+    1999600n 1.8
+    1999699n 1.8
+    1999700n 0
+    1999999n 0
+    2000000n 1.8
+    )

* Pin: rst_n <- VCD: test.tb.rst_n
Vrst_n rst_n 0 pwl(
+    0n 0
+    99n 0
+    100n 1.8
+    )

* Pin: bdir <- VCD: test.tb.bdir
Vbdir bdir 0 pwl(
+    0n 0
+    149n 0
+    150n 1.8
+    349n 1.8
+    350n 0
+    449n 0
+    450n 1.8
+    649n 1.8
+    650n 0
+    749n 0
+    750n 1.8
+    949n 1.8
+    950n 0
+    1049n 0
+    1050n 1.8
+    1249n 1.8
+    1250n 0
+    1349n 0
+    1350n 1.8
+    1549n 1.8
+    1550n 0
+    1649n 0
+    1650n 1.8
+    1849n 1.8
+    1850n 0
+    1949n 0
+    1950n 1.8
+    2149n 1.8
+    2150n 0
+    2249n 0
+    2250n 1.8
+    2449n 1.8
+    2450n 0
+    2549n 0
+    2550n 1.8
+    2749n 1.8
+    2750n 0
+    2849n 0
+    2850n 1.8
+    3049n 1.8
+    3050n 0
+    3149n 0
+    3150n 1.8
+    3349n 1.8
+    3350n 0
+    3449n 0
+    3450n 1.8
+    3649n 1.8
+    3650n 0
+    3749n 0
+    3750n 1.8
+    3949n 1.8
+    3950n 0
+    4049n 0
+    4050n 1.8
+    4249n 1.8
+    4250n 0
+    4349n 0
+    4350n 1.8
+    4549n 1.8
+    4550n 0
+    4649n 0
+    4650n 1.8
+    4849n 1.8
+    4850n 0
+    )

* Pin: bc1 <- VCD: test.tb.bc1
Vbc1 bc1 0 pwl(
+    0n 0
+    149n 0
+    150n 1.8
+    249n 1.8
+    250n 0
+    449n 0
+    450n 1.8
+    549n 1.8
+    550n 0
+    749n 0
+    750n 1.8
+    849n 1.8
+    850n 0
+    1049n 0
+    1050n 1.8
+    1149n 1.8
+    1150n 0
+    1349n 0
+    1350n 1.8
+    1449n 1.8
+    1450n 0
+    1649n 0
+    1650n 1.8
+    1749n 1.8
+    1750n 0
+    1949n 0
+    1950n 1.8
+    2049n 1.8
+    2050n 0
+    2249n 0
+    2250n 1.8
+    2349n 1.8
+    2350n 0
+    2549n 0
+    2550n 1.8
+    2649n 1.8
+    2650n 0
+    2849n 0
+    2850n 1.8
+    2949n 1.8
+    2950n 0
+    3149n 0
+    3150n 1.8
+    3249n 1.8
+    3250n 0
+    3449n 0
+    3450n 1.8
+    3549n 1.8
+    3550n 0
+    3749n 0
+    3750n 1.8
+    3849n 1.8
+    3850n 0
+    4049n 0
+    4050n 1.8
+    4149n 1.8
+    4150n 0
+    4349n 0
+    4350n 1.8
+    4449n 1.8
+    4450n 0
+    4649n 0
+    4650n 1.8
+    4749n 1.8
+    4750n 0
+    )

* Pin: bc2 <- VCD: test.tb.bc2
Vbc2 bc2 0 pwl(
+    0n 0
+    49n 0
+    50n 1.8
+    )

* Pin: din[7] <- VCD: test.tb.din[7]
Vdin[7] din[7] 0 pwl(
+    0n 0
+    249n 0
+    250n 0
+    549n 0
+    550n 0
+    749n 0
+    750n 0
+    849n 0
+    850n 0
+    1049n 0
+    1050n 0
+    1149n 0
+    1150n 0
+    1349n 0
+    1350n 0
+    1449n 0
+    1450n 0
+    1649n 0
+    1650n 0
+    1749n 0
+    1750n 0
+    1949n 0
+    1950n 0
+    2049n 0
+    2050n 0
+    2249n 0
+    2250n 0
+    2549n 0
+    2550n 0
+    2649n 0
+    2650n 0
+    2849n 0
+    2850n 0
+    2949n 0
+    2950n 0
+    3149n 0
+    3150n 0
+    3249n 0
+    3250n 0
+    3449n 0
+    3450n 0
+    3549n 0
+    3550n 0
+    3749n 0
+    3750n 0
+    3849n 0
+    3850n 0
+    4049n 0
+    4050n 0
+    4149n 0
+    4150n 0
+    4349n 0
+    4350n 0
+    4449n 0
+    4450n 0
+    4649n 0
+    4650n 0
+    4749n 0
+    4750n 0
+    )

* Pin: din[6] <- VCD: test.tb.din[6]
Vdin[6] din[6] 0 pwl(
+    0n 0
+    249n 0
+    250n 0
+    549n 0
+    550n 0
+    749n 0
+    750n 0
+    849n 0
+    850n 0
+    1049n 0
+    1050n 0
+    1149n 0
+    1150n 0
+    1349n 0
+    1350n 0
+    1449n 0
+    1450n 0
+    1649n 0
+    1650n 0
+    1749n 0
+    1750n 0
+    1949n 0
+    1950n 0
+    2049n 0
+    2050n 0
+    2249n 0
+    2250n 0
+    2549n 0
+    2550n 0
+    2649n 0
+    2650n 0
+    2849n 0
+    2850n 0
+    2949n 0
+    2950n 0
+    3149n 0
+    3150n 0
+    3249n 0
+    3250n 0
+    3449n 0
+    3450n 0
+    3549n 0
+    3550n 0
+    3749n 0
+    3750n 0
+    3849n 0
+    3850n 0
+    4049n 0
+    4050n 0
+    4149n 0
+    4150n 0
+    4349n 0
+    4350n 0
+    4449n 0
+    4450n 0
+    4649n 0
+    4650n 0
+    4749n 0
+    4750n 0
+    )

* Pin: din[5] <- VCD: test.tb.din[5]
Vdin[5] din[5] 0 pwl(
+    0n 0
+    249n 0
+    250n 0
+    549n 0
+    550n 0
+    749n 0
+    750n 0
+    849n 0
+    850n 1.8
+    1049n 1.8
+    1050n 0
+    1149n 0
+    1150n 0
+    1349n 0
+    1350n 0
+    1449n 0
+    1450n 1.8
+    1649n 1.8
+    1650n 0
+    1749n 0
+    1750n 0
+    1949n 0
+    1950n 0
+    2049n 0
+    2050n 0
+    2249n 0
+    2250n 0
+    2549n 0
+    2550n 0
+    2649n 0
+    2650n 0
+    2849n 0
+    2850n 0
+    2949n 0
+    2950n 1.8
+    3149n 1.8
+    3150n 0
+    3249n 0
+    3250n 0
+    3449n 0
+    3450n 0
+    3549n 0
+    3550n 0
+    3749n 0
+    3750n 0
+    3849n 0
+    3850n 0
+    4049n 0
+    4050n 0
+    4149n 0
+    4150n 0
+    4349n 0
+    4350n 0
+    4449n 0
+    4450n 0
+    4649n 0
+    4650n 0
+    4749n 0
+    4750n 0
+    )

* Pin: din[4] <- VCD: test.tb.din[4]
Vdin[4] din[4] 0 pwl(
+    0n 0
+    249n 0
+    250n 0
+    549n 0
+    550n 0
+    749n 0
+    750n 0
+    849n 0
+    850n 0
+    1049n 0
+    1050n 0
+    1149n 0
+    1150n 0
+    1349n 0
+    1350n 0
+    1449n 0
+    1450n 0
+    1649n 0
+    1650n 0
+    1749n 0
+    1750n 0
+    1949n 0
+    1950n 0
+    2049n 0
+    2050n 0
+    2249n 0
+    2250n 0
+    2549n 0
+    2550n 0
+    2649n 0
+    2650n 0
+    2849n 0
+    2850n 0
+    2949n 0
+    2950n 1.8
+    3149n 1.8
+    3150n 0
+    3249n 0
+    3250n 0
+    3449n 0
+    3450n 0
+    3549n 0
+    3550n 0
+    3749n 0
+    3750n 0
+    3849n 0
+    3850n 0
+    4049n 0
+    4050n 0
+    4149n 0
+    4150n 0
+    4349n 0
+    4350n 0
+    4449n 0
+    4450n 0
+    4649n 0
+    4650n 0
+    4749n 0
+    4750n 1.8
+    )

* Pin: din[3] <- VCD: test.tb.din[3]
Vdin[3] din[3] 0 pwl(
+    0n 0
+    249n 0
+    250n 0
+    549n 0
+    550n 0
+    749n 0
+    750n 0
+    849n 0
+    850n 0
+    1049n 0
+    1050n 0
+    1149n 0
+    1150n 0
+    1349n 0
+    1350n 0
+    1449n 0
+    1450n 0
+    1649n 0
+    1650n 0
+    1749n 0
+    1750n 0
+    1949n 0
+    1950n 0
+    2049n 0
+    2050n 0
+    2249n 0
+    2250n 0
+    2549n 0
+    2550n 0
+    2649n 0
+    2650n 0
+    2849n 0
+    2850n 0
+    2949n 0
+    2950n 0
+    3149n 0
+    3150n 0
+    3249n 0
+    3250n 0
+    3449n 0
+    3450n 0
+    3549n 0
+    3550n 0
+    3749n 0
+    3750n 1.8
+    3849n 1.8
+    3850n 1.8
+    4049n 1.8
+    4050n 1.8
+    4149n 1.8
+    4150n 0
+    4349n 0
+    4350n 1.8
+    4449n 1.8
+    4450n 1.8
+    4649n 1.8
+    4650n 1.8
+    4749n 1.8
+    4750n 0
+    )

* Pin: din[2] <- VCD: test.tb.din[2]
Vdin[2] din[2] 0 pwl(
+    0n 0
+    249n 0
+    250n 0
+    549n 0
+    550n 0
+    749n 0
+    750n 0
+    849n 0
+    850n 0
+    1049n 0
+    1050n 0
+    1149n 0
+    1150n 0
+    1349n 0
+    1350n 1.8
+    1449n 1.8
+    1450n 0
+    1649n 0
+    1650n 1.8
+    1749n 1.8
+    1750n 0
+    1949n 0
+    1950n 1.8
+    2049n 1.8
+    2050n 0
+    2249n 0
+    2250n 0
+    2549n 0
+    2550n 0
+    2649n 0
+    2650n 0
+    2849n 0
+    2850n 1.8
+    2949n 1.8
+    2950n 0
+    3149n 0
+    3150n 1.8
+    3249n 1.8
+    3250n 0
+    3449n 0
+    3450n 1.8
+    3549n 1.8
+    3550n 0
+    3749n 0
+    3750n 1.8
+    3849n 1.8
+    3850n 1.8
+    4049n 1.8
+    4050n 1.8
+    4149n 1.8
+    4150n 0
+    4349n 0
+    4350n 0
+    4449n 0
+    4450n 0
+    4649n 0
+    4650n 0
+    4749n 0
+    4750n 0
+    )

* Pin: din[1] <- VCD: test.tb.din[1]
Vdin[1] din[1] 0 pwl(
+    0n 0
+    249n 0
+    250n 0
+    549n 0
+    550n 0
+    749n 0
+    750n 1.8
+    849n 1.8
+    850n 1.8
+    1049n 1.8
+    1050n 1.8
+    1149n 1.8
+    1150n 1.8
+    1349n 1.8
+    1350n 0
+    1449n 0
+    1450n 1.8
+    1649n 1.8
+    1650n 0
+    1749n 0
+    1750n 1.8
+    1949n 1.8
+    1950n 0
+    2049n 0
+    2050n 1.8
+    2249n 1.8
+    2250n 0
+    2549n 0
+    2550n 0
+    2649n 0
+    2650n 0
+    2849n 0
+    2850n 1.8
+    2949n 1.8
+    2950n 0
+    3149n 0
+    3150n 1.8
+    3249n 1.8
+    3250n 1.8
+    3449n 1.8
+    3450n 1.8
+    3549n 1.8
+    3550n 1.8
+    3749n 1.8
+    3750n 0
+    3849n 0
+    3850n 1.8
+    4049n 1.8
+    4050n 0
+    4149n 0
+    4150n 0
+    4349n 0
+    4350n 1.8
+    4449n 1.8
+    4450n 1.8
+    4649n 1.8
+    4650n 0
+    4749n 0
+    4750n 0
+    )

* Pin: din[0] <- VCD: test.tb.din[0]
Vdin[0] din[0] 0 pwl(
+    0n 0
+    249n 0
+    250n 1.8
+    549n 1.8
+    550n 0
+    749n 0
+    750n 0
+    849n 0
+    850n 0
+    1049n 0
+    1050n 1.8
+    1149n 1.8
+    1150n 0
+    1349n 0
+    1350n 0
+    1449n 0
+    1450n 1.8
+    1649n 1.8
+    1650n 1.8
+    1749n 1.8
+    1750n 1.8
+    1949n 1.8
+    1950n 1.8
+    2049n 1.8
+    2050n 1.8
+    2249n 1.8
+    2250n 0
+    2549n 0
+    2550n 1.8
+    2649n 1.8
+    2650n 0
+    2849n 0
+    2850n 1.8
+    2949n 1.8
+    2950n 1.8
+    3149n 1.8
+    3150n 0
+    3249n 0
+    3250n 1.8
+    3449n 1.8
+    3450n 0
+    3549n 0
+    3550n 0
+    3749n 0
+    3750n 1.8
+    3849n 1.8
+    3850n 0
+    4049n 0
+    4050n 0
+    4149n 0
+    4150n 0
+    4349n 0
+    4350n 1.8
+    4449n 1.8
+    4450n 0
+    4649n 0
+    4650n 0
+    4749n 0
+    4750n 0
+    )

.ends test_core
