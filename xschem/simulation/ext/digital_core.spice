* NGSPICE file created from digital_core.ext - technology: sky130A

.subckt sky130_fd_sc_hd__decap_3 VGND VNB VPB VPWR
X0 VPWR VGND VPWR VPB sky130_fd_pr__pfet_01v8_hvt ad=0.2262 pd=2.26 as=0.4524 ps=4.52 w=0.87 l=0.59
X1 VGND VPWR VGND VNB sky130_fd_pr__nfet_01v8 ad=0.143 pd=1.62 as=0.286 ps=3.24 w=0.55 l=0.59
.ends

.subckt sky130_ef_sc_hd__decap_12 VGND VPWR VPB VNB
X0 VPWR VGND VPWR VPB sky130_fd_pr__pfet_01v8_hvt ad=0.2262 pd=2.26 as=0.4524 ps=4.52 w=0.87 l=4.73
X1 VGND VPWR VGND VNB sky130_fd_pr__nfet_01v8 ad=0.143 pd=1.62 as=0.286 ps=3.24 w=0.55 l=4.73
.ends

.subckt sky130_fd_sc_hd__and3_1 A B C VGND VNB VPB VPWR X
X0 VPWR A a_27_47# VPB sky130_fd_pr__pfet_01v8_hvt ad=0.0567 pd=0.69 as=0.1092 ps=1.36 w=0.42 l=0.15
X1 VPWR C a_27_47# VPB sky130_fd_pr__pfet_01v8_hvt ad=0.14222 pd=1.335 as=0.06615 ps=0.735 w=0.42 l=0.15
X2 a_181_47# B a_109_47# VNB sky130_fd_pr__nfet_01v8 ad=0.0441 pd=0.63 as=0.0441 ps=0.63 w=0.42 l=0.15
X3 VGND C a_181_47# VNB sky130_fd_pr__nfet_01v8 ad=0.13165 pd=1.14 as=0.0441 ps=0.63 w=0.42 l=0.15
X4 a_27_47# B VPWR VPB sky130_fd_pr__pfet_01v8_hvt ad=0.06615 pd=0.735 as=0.0567 ps=0.69 w=0.42 l=0.15
X5 X a_27_47# VPWR VPB sky130_fd_pr__pfet_01v8_hvt ad=0.26 pd=2.52 as=0.14222 ps=1.335 w=1 l=0.15
X6 X a_27_47# VGND VNB sky130_fd_pr__nfet_01v8 ad=0.169 pd=1.82 as=0.13165 ps=1.14 w=0.65 l=0.15
X7 a_109_47# A a_27_47# VNB sky130_fd_pr__nfet_01v8 ad=0.0441 pd=0.63 as=0.1092 ps=1.36 w=0.42 l=0.15
.ends

.subckt sky130_fd_sc_hd__o221a_1 A1 A2 B1 B2 C1 VGND VNB VPB VPWR X
X0 a_240_47# A2 VGND VNB sky130_fd_pr__nfet_01v8 ad=0.08775 pd=0.92 as=0.169 ps=1.82 w=0.65 l=0.15
X1 X a_51_297# VGND VNB sky130_fd_pr__nfet_01v8 ad=0.182 pd=1.86 as=0.08775 ps=0.92 w=0.65 l=0.15
X2 VGND A1 a_240_47# VNB sky130_fd_pr__nfet_01v8 ad=0.08775 pd=0.92 as=0.08775 ps=0.92 w=0.65 l=0.15
X3 a_51_297# B2 a_245_297# VPB sky130_fd_pr__pfet_01v8_hvt ad=0.4125 pd=1.825 as=0.105 ps=1.21 w=1 l=0.15
X4 a_149_47# C1 a_51_297# VNB sky130_fd_pr__nfet_01v8 ad=0.09912 pd=0.955 as=0.2015 ps=1.92 w=0.65 l=0.15
X5 a_240_47# B1 a_149_47# VNB sky130_fd_pr__nfet_01v8 ad=0.08775 pd=0.92 as=0.09912 ps=0.955 w=0.65 l=0.15
X6 VPWR A1 a_512_297# VPB sky130_fd_pr__pfet_01v8_hvt ad=0.165 pd=1.33 as=0.105 ps=1.21 w=1 l=0.15
X7 X a_51_297# VPWR VPB sky130_fd_pr__pfet_01v8_hvt ad=0.28 pd=2.56 as=0.165 ps=1.33 w=1 l=0.15
X8 a_149_47# B2 a_240_47# VNB sky130_fd_pr__nfet_01v8 ad=0.169 pd=1.82 as=0.08775 ps=0.92 w=0.65 l=0.15
X9 a_245_297# B1 VPWR VPB sky130_fd_pr__pfet_01v8_hvt ad=0.105 pd=1.21 as=0.165 ps=1.33 w=1 l=0.15
X10 VPWR C1 a_51_297# VPB sky130_fd_pr__pfet_01v8_hvt ad=0.165 pd=1.33 as=0.34 ps=2.68 w=1 l=0.15
X11 a_512_297# A2 a_51_297# VPB sky130_fd_pr__pfet_01v8_hvt ad=0.105 pd=1.21 as=0.4125 ps=1.825 w=1 l=0.15
.ends

.subckt sky130_fd_sc_hd__dfrtp_1 CLK D RESET_B VGND VNB VPB VPWR Q
X0 a_805_47# a_761_289# a_639_47# VNB sky130_fd_pr__nfet_01v8 ad=0.0441 pd=0.63 as=0.1401 ps=1.1 w=0.42 l=0.15
X1 a_1217_47# a_27_47# a_1108_47# VNB sky130_fd_pr__special_nfet_01v8 ad=0.0669 pd=0.75 as=0.0711 ps=0.755 w=0.36 l=0.15
X2 a_1283_21# a_1108_47# a_1462_47# VNB sky130_fd_pr__nfet_01v8 ad=0.1092 pd=1.36 as=0.06405 ps=0.725 w=0.42 l=0.15
X3 a_651_413# a_27_47# a_543_47# VPB sky130_fd_pr__pfet_01v8_hvt ad=0.1155 pd=0.97 as=0.07245 ps=0.765 w=0.42 l=0.15
X4 a_1108_47# a_193_47# a_761_289# VNB sky130_fd_pr__special_nfet_01v8 ad=0.0711 pd=0.755 as=0.0999 ps=0.985 w=0.36 l=0.15
X5 VGND RESET_B a_805_47# VNB sky130_fd_pr__nfet_01v8 ad=0.1346 pd=1.15 as=0.0441 ps=0.63 w=0.42 l=0.15
X6 Q a_1283_21# VPWR VPB sky130_fd_pr__pfet_01v8_hvt ad=0.26 pd=2.52 as=0.3012 ps=2.66 w=1 l=0.15
X7 VPWR CLK a_27_47# VPB sky130_fd_pr__pfet_01v8_hvt ad=0.0864 pd=0.91 as=0.1664 ps=1.8 w=0.64 l=0.15
X8 a_448_47# D VPWR VPB sky130_fd_pr__pfet_01v8_hvt ad=0.0651 pd=0.73 as=0.1092 ps=1.36 w=0.42 l=0.15
X9 a_761_289# a_543_47# VGND VNB sky130_fd_pr__nfet_01v8 ad=0.0999 pd=0.985 as=0.1346 ps=1.15 w=0.64 l=0.15
X10 a_193_47# a_27_47# VGND VNB sky130_fd_pr__nfet_01v8 ad=0.1092 pd=1.36 as=0.0567 ps=0.69 w=0.42 l=0.15
X11 a_1108_47# a_27_47# a_761_289# VPB sky130_fd_pr__pfet_01v8_hvt ad=0.0588 pd=0.7 as=0.12915 ps=1.185 w=0.42 l=0.15
X12 a_1462_47# RESET_B VGND VNB sky130_fd_pr__nfet_01v8 ad=0.06405 pd=0.725 as=0.12495 ps=1.015 w=0.42 l=0.15
X13 a_543_47# a_27_47# a_448_47# VNB sky130_fd_pr__special_nfet_01v8 ad=0.0594 pd=0.69 as=0.066 ps=0.745 w=0.36 l=0.15
X14 a_543_47# a_193_47# a_448_47# VPB sky130_fd_pr__pfet_01v8_hvt ad=0.07245 pd=0.765 as=0.0651 ps=0.73 w=0.42 l=0.15
X15 a_448_47# D VGND VNB sky130_fd_pr__nfet_01v8 ad=0.066 pd=0.745 as=0.2205 ps=1.89 w=0.42 l=0.15
X16 VPWR a_1283_21# a_1270_413# VPB sky130_fd_pr__pfet_01v8_hvt ad=0.0819 pd=0.81 as=0.0567 ps=0.69 w=0.42 l=0.15
X17 VPWR a_1108_47# a_1283_21# VPB sky130_fd_pr__pfet_01v8_hvt ad=0.1134 pd=1.38 as=0.0567 ps=0.69 w=0.42 l=0.15
X18 a_1270_413# a_193_47# a_1108_47# VPB sky130_fd_pr__pfet_01v8_hvt ad=0.0567 pd=0.69 as=0.0588 ps=0.7 w=0.42 l=0.15
X19 a_193_47# a_27_47# VPWR VPB sky130_fd_pr__pfet_01v8_hvt ad=0.1664 pd=1.8 as=0.0864 ps=0.91 w=0.64 l=0.15
X20 a_1283_21# RESET_B VPWR VPB sky130_fd_pr__pfet_01v8_hvt ad=0.0567 pd=0.69 as=0.0819 ps=0.81 w=0.42 l=0.15
X21 VPWR a_761_289# a_651_413# VPB sky130_fd_pr__pfet_01v8_hvt ad=0.07035 pd=0.755 as=0.1155 ps=0.97 w=0.42 l=0.15
X22 Q a_1283_21# VGND VNB sky130_fd_pr__nfet_01v8 ad=0.169 pd=1.82 as=0.2087 ps=2.02 w=0.65 l=0.15
X23 a_639_47# a_193_47# a_543_47# VNB sky130_fd_pr__special_nfet_01v8 ad=0.1401 pd=1.1 as=0.0594 ps=0.69 w=0.36 l=0.15
X24 VGND a_1283_21# a_1217_47# VNB sky130_fd_pr__nfet_01v8 ad=0.12495 pd=1.015 as=0.0669 ps=0.75 w=0.42 l=0.15
X25 a_651_413# RESET_B VPWR VPB sky130_fd_pr__pfet_01v8_hvt ad=0.1092 pd=1.36 as=0.07035 ps=0.755 w=0.42 l=0.15
X26 VGND CLK a_27_47# VNB sky130_fd_pr__nfet_01v8 ad=0.0567 pd=0.69 as=0.1092 ps=1.36 w=0.42 l=0.15
X27 a_761_289# a_543_47# VPWR VPB sky130_fd_pr__pfet_01v8_hvt ad=0.12915 pd=1.185 as=0.2184 ps=2.2 w=0.84 l=0.15
.ends

.subckt sky130_fd_sc_hd__and2_2 A B VGND VNB VPB VPWR X
X0 X a_61_75# VPWR VPB sky130_fd_pr__pfet_01v8_hvt ad=0.195 pd=1.39 as=0.16655 ps=1.39 w=1 l=0.15
X1 VPWR a_61_75# X VPB sky130_fd_pr__pfet_01v8_hvt ad=0.38 pd=2.76 as=0.195 ps=1.39 w=1 l=0.15
X2 VPWR B a_61_75# VPB sky130_fd_pr__pfet_01v8_hvt ad=0.16655 pd=1.39 as=0.0567 ps=0.69 w=0.42 l=0.15
X3 VGND B a_147_75# VNB sky130_fd_pr__nfet_01v8 ad=0.1118 pd=1.04 as=0.0567 ps=0.69 w=0.42 l=0.15
X4 X a_61_75# VGND VNB sky130_fd_pr__nfet_01v8 ad=0.12675 pd=1.04 as=0.1118 ps=1.04 w=0.65 l=0.15
X5 VGND a_61_75# X VNB sky130_fd_pr__nfet_01v8 ad=0.247 pd=2.06 as=0.12675 ps=1.04 w=0.65 l=0.15
X6 a_61_75# A VPWR VPB sky130_fd_pr__pfet_01v8_hvt ad=0.0567 pd=0.69 as=0.1176 ps=1.4 w=0.42 l=0.15
X7 a_147_75# A a_61_75# VNB sky130_fd_pr__nfet_01v8 ad=0.0567 pd=0.69 as=0.1176 ps=1.4 w=0.42 l=0.15
.ends

.subckt sky130_fd_sc_hd__nand2b_1 A_N B VGND VNB VPB VPWR Y
X0 VGND A_N a_27_93# VNB sky130_fd_pr__nfet_01v8 ad=0.10025 pd=0.985 as=0.1092 ps=1.36 w=0.42 l=0.15
X1 Y a_27_93# a_206_47# VNB sky130_fd_pr__nfet_01v8 ad=0.169 pd=1.82 as=0.08775 ps=0.92 w=0.65 l=0.15
X2 a_206_47# B VGND VNB sky130_fd_pr__nfet_01v8 ad=0.08775 pd=0.92 as=0.10025 ps=0.985 w=0.65 l=0.15
X3 VPWR a_27_93# Y VPB sky130_fd_pr__pfet_01v8_hvt ad=0.265 pd=2.53 as=0.135 ps=1.27 w=1 l=0.15
X4 Y B VPWR VPB sky130_fd_pr__pfet_01v8_hvt ad=0.135 pd=1.27 as=0.14575 ps=1.335 w=1 l=0.15
X5 VPWR A_N a_27_93# VPB sky130_fd_pr__pfet_01v8_hvt ad=0.14575 pd=1.335 as=0.1092 ps=1.36 w=0.42 l=0.15
.ends

.subckt sky130_fd_sc_hd__mux2_1 A0 A1 S VGND VNB VPB VPWR X
X0 VPWR a_505_21# a_535_374# VPB sky130_fd_pr__pfet_01v8_hvt ad=0.0693 pd=0.75 as=0.0441 ps=0.63 w=0.42 l=0.15
X1 a_505_21# S VPWR VPB sky130_fd_pr__pfet_01v8_hvt ad=0.1176 pd=1.4 as=0.0693 ps=0.75 w=0.42 l=0.15
X2 a_218_374# S VPWR VPB sky130_fd_pr__pfet_01v8_hvt ad=0.07665 pd=0.785 as=0.15835 ps=1.395 w=0.42 l=0.15
X3 VGND a_505_21# a_439_47# VNB sky130_fd_pr__nfet_01v8 ad=0.1449 pd=1.11 as=0.0693 ps=0.75 w=0.42 l=0.15
X4 a_76_199# A0 a_218_374# VPB sky130_fd_pr__pfet_01v8_hvt ad=0.1932 pd=1.34 as=0.07665 ps=0.785 w=0.42 l=0.15
X5 a_505_21# S VGND VNB sky130_fd_pr__nfet_01v8 ad=0.1092 pd=1.36 as=0.1449 ps=1.11 w=0.42 l=0.15
X6 a_439_47# A0 a_76_199# VNB sky130_fd_pr__nfet_01v8 ad=0.0693 pd=0.75 as=0.09975 ps=0.895 w=0.42 l=0.15
X7 a_535_374# A1 a_76_199# VPB sky130_fd_pr__pfet_01v8_hvt ad=0.0441 pd=0.63 as=0.1932 ps=1.34 w=0.42 l=0.15
X8 a_76_199# A1 a_218_47# VNB sky130_fd_pr__nfet_01v8 ad=0.09975 pd=0.895 as=0.0693 ps=0.75 w=0.42 l=0.15
X9 a_218_47# S VGND VNB sky130_fd_pr__nfet_01v8 ad=0.0693 pd=0.75 as=0.11285 ps=1.045 w=0.42 l=0.15
X10 VPWR a_76_199# X VPB sky130_fd_pr__pfet_01v8_hvt ad=0.15835 pd=1.395 as=0.26 ps=2.52 w=1 l=0.15
X11 VGND a_76_199# X VNB sky130_fd_pr__nfet_01v8 ad=0.11285 pd=1.045 as=0.169 ps=1.82 w=0.65 l=0.15
.ends

.subckt sky130_fd_sc_hd__decap_8 VGND VNB VPB VPWR
X0 VPWR VGND VPWR VPB sky130_fd_pr__pfet_01v8_hvt ad=0.2262 pd=2.26 as=0.4524 ps=4.52 w=0.87 l=2.89
X1 VGND VPWR VGND VNB sky130_fd_pr__nfet_01v8 ad=0.143 pd=1.62 as=0.286 ps=3.24 w=0.55 l=2.89
.ends

.subckt sky130_fd_sc_hd__nor2_1 A B VGND VNB VPB VPWR Y
X0 VPWR A a_109_297# VPB sky130_fd_pr__pfet_01v8_hvt ad=0.26 pd=2.52 as=0.105 ps=1.21 w=1 l=0.15
X1 VGND A Y VNB sky130_fd_pr__nfet_01v8 ad=0.169 pd=1.82 as=0.08775 ps=0.92 w=0.65 l=0.15
X2 a_109_297# B Y VPB sky130_fd_pr__pfet_01v8_hvt ad=0.105 pd=1.21 as=0.26 ps=2.52 w=1 l=0.15
X3 Y B VGND VNB sky130_fd_pr__nfet_01v8 ad=0.08775 pd=0.92 as=0.169 ps=1.82 w=0.65 l=0.15
.ends

.subckt sky130_fd_sc_hd__or4_1 A B C D VGND VNB VPB VPWR X
X0 a_27_297# B VGND VNB sky130_fd_pr__nfet_01v8 ad=0.0567 pd=0.69 as=0.0567 ps=0.69 w=0.42 l=0.15
X1 a_27_297# D VGND VNB sky130_fd_pr__nfet_01v8 ad=0.0693 pd=0.75 as=0.1092 ps=1.36 w=0.42 l=0.15
X2 a_277_297# B a_205_297# VPB sky130_fd_pr__pfet_01v8_hvt ad=0.0693 pd=0.75 as=0.0441 ps=0.63 w=0.42 l=0.15
X3 VPWR A a_277_297# VPB sky130_fd_pr__pfet_01v8_hvt ad=0.14825 pd=1.34 as=0.0693 ps=0.75 w=0.42 l=0.15
X4 X a_27_297# VGND VNB sky130_fd_pr__nfet_01v8 ad=0.1755 pd=1.84 as=0.10187 ps=0.99 w=0.65 l=0.15
X5 a_205_297# C a_109_297# VPB sky130_fd_pr__pfet_01v8_hvt ad=0.0441 pd=0.63 as=0.0693 ps=0.75 w=0.42 l=0.15
X6 X a_27_297# VPWR VPB sky130_fd_pr__pfet_01v8_hvt ad=0.27 pd=2.54 as=0.14825 ps=1.34 w=1 l=0.15
X7 VGND C a_27_297# VNB sky130_fd_pr__nfet_01v8 ad=0.0567 pd=0.69 as=0.0693 ps=0.75 w=0.42 l=0.15
X8 a_109_297# D a_27_297# VPB sky130_fd_pr__pfet_01v8_hvt ad=0.0693 pd=0.75 as=0.1092 ps=1.36 w=0.42 l=0.15
X9 VGND A a_27_297# VNB sky130_fd_pr__nfet_01v8 ad=0.10187 pd=0.99 as=0.0567 ps=0.69 w=0.42 l=0.15
.ends

.subckt sky130_fd_sc_hd__a2111o_1 A1 A2 B1 C1 D1 VGND VNB VPB VPWR X
X0 VGND A2 a_660_47# VNB sky130_fd_pr__nfet_01v8 ad=0.1885 pd=1.88 as=0.08287 ps=0.905 w=0.65 l=0.15
X1 VGND C1 a_85_193# VNB sky130_fd_pr__nfet_01v8 ad=0.117 pd=1.01 as=0.10075 ps=0.96 w=0.65 l=0.15
X2 a_414_297# C1 a_334_297# VPB sky130_fd_pr__pfet_01v8_hvt ad=0.18 pd=1.36 as=0.125 ps=1.25 w=1 l=0.15
X3 VGND a_85_193# X VNB sky130_fd_pr__nfet_01v8 ad=0.27463 pd=1.495 as=0.2145 ps=1.96 w=0.65 l=0.15
X4 a_334_297# D1 a_85_193# VPB sky130_fd_pr__pfet_01v8_hvt ad=0.125 pd=1.25 as=0.385 ps=2.77 w=1 l=0.15
X5 a_516_297# B1 a_414_297# VPB sky130_fd_pr__pfet_01v8_hvt ad=0.28 pd=1.56 as=0.18 ps=1.36 w=1 l=0.15
X6 a_516_297# A2 VPWR VPB sky130_fd_pr__pfet_01v8_hvt ad=0.29 pd=2.58 as=0.135 ps=1.27 w=1 l=0.15
X7 a_660_47# A1 a_85_193# VNB sky130_fd_pr__nfet_01v8 ad=0.08287 pd=0.905 as=0.18525 ps=1.22 w=0.65 l=0.15
X8 a_85_193# D1 VGND VNB sky130_fd_pr__nfet_01v8 ad=0.10075 pd=0.96 as=0.27463 ps=1.495 w=0.65 l=0.15
X9 VPWR A1 a_516_297# VPB sky130_fd_pr__pfet_01v8_hvt ad=0.135 pd=1.27 as=0.28 ps=1.56 w=1 l=0.15
X10 a_85_193# B1 VGND VNB sky130_fd_pr__nfet_01v8 ad=0.18525 pd=1.22 as=0.117 ps=1.01 w=0.65 l=0.15
X11 VPWR a_85_193# X VPB sky130_fd_pr__pfet_01v8_hvt ad=0.265 pd=2.53 as=0.29 ps=2.58 w=1 l=0.15
.ends

.subckt sky130_fd_sc_hd__decap_4 VGND VNB VPB VPWR
X0 VPWR VGND VPWR VPB sky130_fd_pr__pfet_01v8_hvt ad=0.2262 pd=2.26 as=0.4524 ps=4.52 w=0.87 l=1.05
X1 VGND VPWR VGND VNB sky130_fd_pr__nfet_01v8 ad=0.143 pd=1.62 as=0.286 ps=3.24 w=0.55 l=1.05
.ends

.subckt sky130_fd_sc_hd__decap_6 VGND VNB VPB VPWR
X0 VPWR VGND VPWR VPB sky130_fd_pr__pfet_01v8_hvt ad=0.2262 pd=2.26 as=0.4524 ps=4.52 w=0.87 l=1.97
X1 VGND VPWR VGND VNB sky130_fd_pr__nfet_01v8 ad=0.143 pd=1.62 as=0.286 ps=3.24 w=0.55 l=1.97
.ends

.subckt sky130_fd_sc_hd__inv_2 A VGND VNB VPB VPWR Y
X0 Y A VPWR VPB sky130_fd_pr__pfet_01v8_hvt ad=0.135 pd=1.27 as=0.26 ps=2.52 w=1 l=0.15
X1 VGND A Y VNB sky130_fd_pr__nfet_01v8 ad=0.169 pd=1.82 as=0.08775 ps=0.92 w=0.65 l=0.15
X2 Y A VGND VNB sky130_fd_pr__nfet_01v8 ad=0.08775 pd=0.92 as=0.169 ps=1.82 w=0.65 l=0.15
X3 VPWR A Y VPB sky130_fd_pr__pfet_01v8_hvt ad=0.26 pd=2.52 as=0.135 ps=1.27 w=1 l=0.15
.ends

.subckt sky130_fd_sc_hd__o21a_1 A1 A2 B1 VGND VNB VPB VPWR X
X0 VPWR A1 a_382_297# VPB sky130_fd_pr__pfet_01v8_hvt ad=0.26 pd=2.52 as=0.1525 ps=1.305 w=1 l=0.15
X1 a_297_47# B1 a_79_21# VNB sky130_fd_pr__nfet_01v8 ad=0.10075 pd=0.96 as=0.169 ps=1.82 w=0.65 l=0.15
X2 a_297_47# A1 VGND VNB sky130_fd_pr__nfet_01v8 ad=0.169 pd=1.82 as=0.08775 ps=0.92 w=0.65 l=0.15
X3 VGND A2 a_297_47# VNB sky130_fd_pr__nfet_01v8 ad=0.08775 pd=0.92 as=0.10075 ps=0.96 w=0.65 l=0.15
X4 VPWR a_79_21# X VPB sky130_fd_pr__pfet_01v8_hvt ad=0.3275 pd=1.655 as=0.28 ps=2.56 w=1 l=0.15
X5 a_79_21# B1 VPWR VPB sky130_fd_pr__pfet_01v8_hvt ad=0.195 pd=1.39 as=0.3275 ps=1.655 w=1 l=0.15
X6 a_382_297# A2 a_79_21# VPB sky130_fd_pr__pfet_01v8_hvt ad=0.1525 pd=1.305 as=0.195 ps=1.39 w=1 l=0.15
X7 VGND a_79_21# X VNB sky130_fd_pr__nfet_01v8 ad=0.169 pd=1.82 as=0.169 ps=1.82 w=0.65 l=0.15
.ends

.subckt sky130_fd_sc_hd__a2bb2o_1 A1_N A2_N B1 B2 VGND VNB VPB VPWR X
X0 a_226_47# A2_N a_226_297# VPB sky130_fd_pr__pfet_01v8_hvt ad=0.1113 pd=1.37 as=0.0441 ps=0.63 w=0.42 l=0.15
X1 a_489_413# B1 VPWR VPB sky130_fd_pr__pfet_01v8_hvt ad=0.1092 pd=1.36 as=0.0567 ps=0.69 w=0.42 l=0.15
X2 a_226_297# A1_N VPWR VPB sky130_fd_pr__pfet_01v8_hvt ad=0.0441 pd=0.63 as=0.16675 ps=1.435 w=0.42 l=0.15
X3 VPWR B2 a_489_413# VPB sky130_fd_pr__pfet_01v8_hvt ad=0.0567 pd=0.69 as=0.0567 ps=0.69 w=0.42 l=0.15
X4 a_489_413# a_226_47# a_76_199# VPB sky130_fd_pr__pfet_01v8_hvt ad=0.0567 pd=0.69 as=0.1092 ps=1.36 w=0.42 l=0.15
X5 a_76_199# a_226_47# VGND VNB sky130_fd_pr__nfet_01v8 ad=0.0567 pd=0.69 as=0.1386 ps=1.08 w=0.42 l=0.15
X6 VGND B1 a_556_47# VNB sky130_fd_pr__nfet_01v8 ad=0.1092 pd=1.36 as=0.0567 ps=0.69 w=0.42 l=0.15
X7 a_556_47# B2 a_76_199# VNB sky130_fd_pr__nfet_01v8 ad=0.0567 pd=0.69 as=0.0567 ps=0.69 w=0.42 l=0.15
X8 VGND A2_N a_226_47# VNB sky130_fd_pr__nfet_01v8 ad=0.1386 pd=1.08 as=0.0567 ps=0.69 w=0.42 l=0.15
X9 a_226_47# A1_N VGND VNB sky130_fd_pr__nfet_01v8 ad=0.0567 pd=0.69 as=0.1201 ps=1.085 w=0.42 l=0.15
X10 VPWR a_76_199# X VPB sky130_fd_pr__pfet_01v8_hvt ad=0.16675 pd=1.435 as=0.26 ps=2.52 w=1 l=0.15
X11 VGND a_76_199# X VNB sky130_fd_pr__nfet_01v8 ad=0.1201 pd=1.085 as=0.169 ps=1.82 w=0.65 l=0.15
.ends

.subckt sky130_fd_sc_hd__and2_1 A B VGND VNB VPB VPWR X
X0 VPWR B a_59_75# VPB sky130_fd_pr__pfet_01v8_hvt ad=0.16655 pd=1.39 as=0.0567 ps=0.69 w=0.42 l=0.15
X1 X a_59_75# VPWR VPB sky130_fd_pr__pfet_01v8_hvt ad=0.475 pd=2.95 as=0.16655 ps=1.39 w=1 l=0.15
X2 VGND B a_145_75# VNB sky130_fd_pr__nfet_01v8 ad=0.1118 pd=1.04 as=0.0567 ps=0.69 w=0.42 l=0.15
X3 a_59_75# A VPWR VPB sky130_fd_pr__pfet_01v8_hvt ad=0.0567 pd=0.69 as=0.1176 ps=1.4 w=0.42 l=0.15
X4 X a_59_75# VGND VNB sky130_fd_pr__nfet_01v8 ad=0.182 pd=1.86 as=0.1118 ps=1.04 w=0.65 l=0.15
X5 a_145_75# A a_59_75# VNB sky130_fd_pr__nfet_01v8 ad=0.0567 pd=0.69 as=0.1176 ps=1.4 w=0.42 l=0.15
.ends

.subckt sky130_fd_sc_hd__o21ai_1 A1 A2 B1 VGND VNB VPB VPWR Y
X0 Y A2 a_109_297# VPB sky130_fd_pr__pfet_01v8_hvt ad=0.174 pd=1.39 as=0.105 ps=1.21 w=1 l=0.15
X1 VPWR B1 Y VPB sky130_fd_pr__pfet_01v8_hvt ad=0.182 pd=1.92 as=0.174 ps=1.39 w=0.7 l=0.15
X2 a_27_47# A2 VGND VNB sky130_fd_pr__nfet_01v8 ad=0.08775 pd=0.92 as=0.10725 ps=0.98 w=0.65 l=0.15
X3 Y B1 a_27_47# VNB sky130_fd_pr__nfet_01v8 ad=0.169 pd=1.82 as=0.08775 ps=0.92 w=0.65 l=0.15
X4 a_109_297# A1 VPWR VPB sky130_fd_pr__pfet_01v8_hvt ad=0.105 pd=1.21 as=0.26 ps=2.52 w=1 l=0.15
X5 VGND A1 a_27_47# VNB sky130_fd_pr__nfet_01v8 ad=0.10725 pd=0.98 as=0.169 ps=1.82 w=0.65 l=0.15
.ends

.subckt sky130_fd_sc_hd__a21o_1 A1 A2 B1 VGND VNB VPB VPWR X
X0 a_81_21# B1 VGND VNB sky130_fd_pr__nfet_01v8 ad=0.08937 pd=0.925 as=0.25675 ps=1.44 w=0.65 l=0.15
X1 a_299_297# B1 a_81_21# VPB sky130_fd_pr__pfet_01v8_hvt ad=0.1375 pd=1.275 as=0.26 ps=2.52 w=1 l=0.15
X2 VPWR a_81_21# X VPB sky130_fd_pr__pfet_01v8_hvt ad=0.26 pd=2.52 as=0.26 ps=2.52 w=1 l=0.15
X3 VPWR A1 a_299_297# VPB sky130_fd_pr__pfet_01v8_hvt ad=0.14 pd=1.28 as=0.1375 ps=1.275 w=1 l=0.15
X4 VGND a_81_21# X VNB sky130_fd_pr__nfet_01v8 ad=0.25675 pd=1.44 as=0.169 ps=1.82 w=0.65 l=0.15
X5 VGND A2 a_384_47# VNB sky130_fd_pr__nfet_01v8 ad=0.17225 pd=1.83 as=0.091 ps=0.93 w=0.65 l=0.15
X6 a_299_297# A2 VPWR VPB sky130_fd_pr__pfet_01v8_hvt ad=0.265 pd=2.53 as=0.14 ps=1.28 w=1 l=0.15
X7 a_384_47# A1 a_81_21# VNB sky130_fd_pr__nfet_01v8 ad=0.091 pd=0.93 as=0.08937 ps=0.925 w=0.65 l=0.15
.ends

.subckt sky130_fd_sc_hd__dfrtp_2 CLK D RESET_B VGND VNB VPB VPWR Q
X0 a_805_47# a_761_289# a_639_47# VNB sky130_fd_pr__nfet_01v8 ad=0.0441 pd=0.63 as=0.1401 ps=1.1 w=0.42 l=0.15
X1 a_1217_47# a_27_47# a_1108_47# VNB sky130_fd_pr__special_nfet_01v8 ad=0.0669 pd=0.75 as=0.0711 ps=0.755 w=0.36 l=0.15
X2 VGND a_1283_21# Q VNB sky130_fd_pr__nfet_01v8 ad=0.169 pd=1.82 as=0.08775 ps=0.92 w=0.65 l=0.15
X3 a_1283_21# a_1108_47# a_1462_47# VNB sky130_fd_pr__nfet_01v8 ad=0.1092 pd=1.36 as=0.06405 ps=0.725 w=0.42 l=0.15
X4 a_651_413# a_27_47# a_543_47# VPB sky130_fd_pr__pfet_01v8_hvt ad=0.1155 pd=0.97 as=0.07245 ps=0.765 w=0.42 l=0.15
X5 VPWR a_1283_21# Q VPB sky130_fd_pr__pfet_01v8_hvt ad=0.26 pd=2.52 as=0.135 ps=1.27 w=1 l=0.15
X6 a_1108_47# a_193_47# a_761_289# VNB sky130_fd_pr__special_nfet_01v8 ad=0.0711 pd=0.755 as=0.0999 ps=0.985 w=0.36 l=0.15
X7 VGND RESET_B a_805_47# VNB sky130_fd_pr__nfet_01v8 ad=0.1346 pd=1.15 as=0.0441 ps=0.63 w=0.42 l=0.15
X8 Q a_1283_21# VPWR VPB sky130_fd_pr__pfet_01v8_hvt ad=0.135 pd=1.27 as=0.3012 ps=2.66 w=1 l=0.15
X9 VPWR CLK a_27_47# VPB sky130_fd_pr__pfet_01v8_hvt ad=0.0864 pd=0.91 as=0.1664 ps=1.8 w=0.64 l=0.15
X10 a_448_47# D VPWR VPB sky130_fd_pr__pfet_01v8_hvt ad=0.0651 pd=0.73 as=0.1092 ps=1.36 w=0.42 l=0.15
X11 a_761_289# a_543_47# VGND VNB sky130_fd_pr__nfet_01v8 ad=0.0999 pd=0.985 as=0.1346 ps=1.15 w=0.64 l=0.15
X12 a_193_47# a_27_47# VGND VNB sky130_fd_pr__nfet_01v8 ad=0.1092 pd=1.36 as=0.0567 ps=0.69 w=0.42 l=0.15
X13 a_1108_47# a_27_47# a_761_289# VPB sky130_fd_pr__pfet_01v8_hvt ad=0.0588 pd=0.7 as=0.12915 ps=1.185 w=0.42 l=0.15
X14 a_1462_47# RESET_B VGND VNB sky130_fd_pr__nfet_01v8 ad=0.06405 pd=0.725 as=0.12495 ps=1.015 w=0.42 l=0.15
X15 a_543_47# a_27_47# a_448_47# VNB sky130_fd_pr__special_nfet_01v8 ad=0.0594 pd=0.69 as=0.066 ps=0.745 w=0.36 l=0.15
X16 a_543_47# a_193_47# a_448_47# VPB sky130_fd_pr__pfet_01v8_hvt ad=0.07245 pd=0.765 as=0.0651 ps=0.73 w=0.42 l=0.15
X17 a_448_47# D VGND VNB sky130_fd_pr__nfet_01v8 ad=0.066 pd=0.745 as=0.2205 ps=1.89 w=0.42 l=0.15
X18 VPWR a_1283_21# a_1270_413# VPB sky130_fd_pr__pfet_01v8_hvt ad=0.0819 pd=0.81 as=0.0567 ps=0.69 w=0.42 l=0.15
X19 VPWR a_1108_47# a_1283_21# VPB sky130_fd_pr__pfet_01v8_hvt ad=0.1134 pd=1.38 as=0.0567 ps=0.69 w=0.42 l=0.15
X20 a_1270_413# a_193_47# a_1108_47# VPB sky130_fd_pr__pfet_01v8_hvt ad=0.0567 pd=0.69 as=0.0588 ps=0.7 w=0.42 l=0.15
X21 a_193_47# a_27_47# VPWR VPB sky130_fd_pr__pfet_01v8_hvt ad=0.1664 pd=1.8 as=0.0864 ps=0.91 w=0.64 l=0.15
X22 a_1283_21# RESET_B VPWR VPB sky130_fd_pr__pfet_01v8_hvt ad=0.0567 pd=0.69 as=0.0819 ps=0.81 w=0.42 l=0.15
X23 VPWR a_761_289# a_651_413# VPB sky130_fd_pr__pfet_01v8_hvt ad=0.07035 pd=0.755 as=0.1155 ps=0.97 w=0.42 l=0.15
X24 Q a_1283_21# VGND VNB sky130_fd_pr__nfet_01v8 ad=0.08775 pd=0.92 as=0.2087 ps=2.02 w=0.65 l=0.15
X25 a_639_47# a_193_47# a_543_47# VNB sky130_fd_pr__special_nfet_01v8 ad=0.1401 pd=1.1 as=0.0594 ps=0.69 w=0.36 l=0.15
X26 VGND a_1283_21# a_1217_47# VNB sky130_fd_pr__nfet_01v8 ad=0.12495 pd=1.015 as=0.0669 ps=0.75 w=0.42 l=0.15
X27 a_651_413# RESET_B VPWR VPB sky130_fd_pr__pfet_01v8_hvt ad=0.1092 pd=1.36 as=0.07035 ps=0.755 w=0.42 l=0.15
X28 VGND CLK a_27_47# VNB sky130_fd_pr__nfet_01v8 ad=0.0567 pd=0.69 as=0.1092 ps=1.36 w=0.42 l=0.15
X29 a_761_289# a_543_47# VPWR VPB sky130_fd_pr__pfet_01v8_hvt ad=0.12915 pd=1.185 as=0.2184 ps=2.2 w=0.84 l=0.15
.ends

.subckt sky130_fd_sc_hd__dlygate4sd3_1 A VGND VNB VPB VPWR X
X0 VPWR A a_49_47# VPB sky130_fd_pr__pfet_01v8_hvt ad=0.0567 pd=0.69 as=0.1092 ps=1.36 w=0.42 l=0.15
X1 VGND a_285_47# a_391_47# VNB sky130_fd_pr__nfet_01v8 ad=0.097 pd=0.975 as=0.1092 ps=1.36 w=0.42 l=0.5
X2 X a_391_47# VPWR VPB sky130_fd_pr__pfet_01v8_hvt ad=0.26 pd=2.52 as=0.14075 ps=1.325 w=1 l=0.15
X3 VGND A a_49_47# VNB sky130_fd_pr__nfet_01v8 ad=0.0567 pd=0.69 as=0.1092 ps=1.36 w=0.42 l=0.15
X4 VPWR a_285_47# a_391_47# VPB sky130_fd_pr__pfet_01v8_hvt ad=0.14075 pd=1.325 as=0.1092 ps=1.36 w=0.42 l=0.5
X5 a_285_47# a_49_47# VGND VNB sky130_fd_pr__nfet_01v8 ad=0.1092 pd=1.36 as=0.0567 ps=0.69 w=0.42 l=0.5
X6 a_285_47# a_49_47# VPWR VPB sky130_fd_pr__pfet_01v8_hvt ad=0.1092 pd=1.36 as=0.0567 ps=0.69 w=0.42 l=0.5
X7 X a_391_47# VGND VNB sky130_fd_pr__nfet_01v8 ad=0.169 pd=1.82 as=0.097 ps=0.975 w=0.65 l=0.15
.ends

.subckt sky130_fd_sc_hd__dfxtp_1 CLK D VGND VNB VPB VPWR Q
X0 Q a_1059_315# VGND VNB sky130_fd_pr__nfet_01v8 ad=0.169 pd=1.82 as=0.08775 ps=0.92 w=0.65 l=0.15
X1 a_891_413# a_193_47# a_634_159# VNB sky130_fd_pr__special_nfet_01v8 ad=0.0684 pd=0.74 as=0.0989 ps=0.995 w=0.36 l=0.15
X2 a_561_413# a_27_47# a_466_413# VPB sky130_fd_pr__pfet_01v8_hvt ad=0.07665 pd=0.785 as=0.06825 ps=0.745 w=0.42 l=0.15
X3 VPWR CLK a_27_47# VPB sky130_fd_pr__pfet_01v8_hvt ad=0.0864 pd=0.91 as=0.1664 ps=1.8 w=0.64 l=0.15
X4 Q a_1059_315# VPWR VPB sky130_fd_pr__pfet_01v8_hvt ad=0.26 pd=2.52 as=0.135 ps=1.27 w=1 l=0.15
X5 a_381_47# D VPWR VPB sky130_fd_pr__pfet_01v8_hvt ad=0.05775 pd=0.695 as=0.1092 ps=1.36 w=0.42 l=0.15
X6 VGND a_634_159# a_592_47# VNB sky130_fd_pr__nfet_01v8 ad=0.12095 pd=1.085 as=0.0696 ps=0.765 w=0.42 l=0.15
X7 VPWR a_891_413# a_1059_315# VPB sky130_fd_pr__pfet_01v8_hvt ad=0.135 pd=1.27 as=0.27 ps=2.54 w=1 l=0.15
X8 a_466_413# a_193_47# a_381_47# VPB sky130_fd_pr__pfet_01v8_hvt ad=0.06825 pd=0.745 as=0.05775 ps=0.695 w=0.42 l=0.15
X9 VPWR a_634_159# a_561_413# VPB sky130_fd_pr__pfet_01v8_hvt ad=0.17887 pd=1.26 as=0.07665 ps=0.785 w=0.42 l=0.15
X10 a_634_159# a_466_413# VGND VNB sky130_fd_pr__nfet_01v8 ad=0.0989 pd=0.995 as=0.12095 ps=1.085 w=0.64 l=0.15
X11 a_634_159# a_466_413# VPWR VPB sky130_fd_pr__pfet_01v8_hvt ad=0.1095 pd=1.075 as=0.17887 ps=1.26 w=0.75 l=0.15
X12 a_975_413# a_193_47# a_891_413# VPB sky130_fd_pr__pfet_01v8_hvt ad=0.0882 pd=0.84 as=0.0567 ps=0.69 w=0.42 l=0.15
X13 VGND a_1059_315# a_1017_47# VNB sky130_fd_pr__nfet_01v8 ad=0.1092 pd=1.36 as=0.066 ps=0.745 w=0.42 l=0.15
X14 a_193_47# a_27_47# VGND VNB sky130_fd_pr__nfet_01v8 ad=0.1092 pd=1.36 as=0.0567 ps=0.69 w=0.42 l=0.15
X15 a_891_413# a_27_47# a_634_159# VPB sky130_fd_pr__pfet_01v8_hvt ad=0.0567 pd=0.69 as=0.1095 ps=1.075 w=0.42 l=0.15
X16 a_592_47# a_193_47# a_466_413# VNB sky130_fd_pr__special_nfet_01v8 ad=0.0696 pd=0.765 as=0.0621 ps=0.705 w=0.36 l=0.15
X17 VPWR a_1059_315# a_975_413# VPB sky130_fd_pr__pfet_01v8_hvt ad=0.1113 pd=1.37 as=0.0882 ps=0.84 w=0.42 l=0.15
X18 a_1017_47# a_27_47# a_891_413# VNB sky130_fd_pr__special_nfet_01v8 ad=0.066 pd=0.745 as=0.0684 ps=0.74 w=0.36 l=0.15
X19 a_193_47# a_27_47# VPWR VPB sky130_fd_pr__pfet_01v8_hvt ad=0.1664 pd=1.8 as=0.0864 ps=0.91 w=0.64 l=0.15
X20 a_466_413# a_27_47# a_381_47# VNB sky130_fd_pr__special_nfet_01v8 ad=0.0621 pd=0.705 as=0.0813 ps=0.83 w=0.36 l=0.15
X21 VGND a_891_413# a_1059_315# VNB sky130_fd_pr__nfet_01v8 ad=0.08775 pd=0.92 as=0.169 ps=1.82 w=0.65 l=0.15
X22 a_381_47# D VGND VNB sky130_fd_pr__nfet_01v8 ad=0.0813 pd=0.83 as=0.1092 ps=1.36 w=0.42 l=0.15
X23 VGND CLK a_27_47# VNB sky130_fd_pr__nfet_01v8 ad=0.0567 pd=0.69 as=0.1092 ps=1.36 w=0.42 l=0.15
.ends

.subckt sky130_fd_sc_hd__dfrtp_4 CLK D RESET_B VGND VNB VPB VPWR Q
X0 a_805_47# a_761_289# a_639_47# VNB sky130_fd_pr__nfet_01v8 ad=0.0441 pd=0.63 as=0.1401 ps=1.1 w=0.42 l=0.15
X1 a_1217_47# a_27_47# a_1108_47# VNB sky130_fd_pr__special_nfet_01v8 ad=0.0669 pd=0.75 as=0.0711 ps=0.755 w=0.36 l=0.15
X2 a_1283_21# a_1108_47# a_1462_47# VNB sky130_fd_pr__nfet_01v8 ad=0.1092 pd=1.36 as=0.06405 ps=0.725 w=0.42 l=0.15
X3 a_651_413# a_27_47# a_543_47# VPB sky130_fd_pr__pfet_01v8_hvt ad=0.1155 pd=0.97 as=0.07245 ps=0.765 w=0.42 l=0.15
X4 a_1108_47# a_193_47# a_761_289# VNB sky130_fd_pr__special_nfet_01v8 ad=0.0711 pd=0.755 as=0.0999 ps=0.985 w=0.36 l=0.15
X5 VGND RESET_B a_805_47# VNB sky130_fd_pr__nfet_01v8 ad=0.1346 pd=1.15 as=0.0441 ps=0.63 w=0.42 l=0.15
X6 VPWR a_1283_21# Q VPB sky130_fd_pr__pfet_01v8_hvt ad=0.305 pd=2.61 as=0.135 ps=1.27 w=1 l=0.15
X7 VPWR CLK a_27_47# VPB sky130_fd_pr__pfet_01v8_hvt ad=0.0864 pd=0.91 as=0.1664 ps=1.8 w=0.64 l=0.15
X8 a_448_47# D VPWR VPB sky130_fd_pr__pfet_01v8_hvt ad=0.0651 pd=0.73 as=0.1092 ps=1.36 w=0.42 l=0.15
X9 Q a_1283_21# VPWR VPB sky130_fd_pr__pfet_01v8_hvt ad=0.135 pd=1.27 as=0.135 ps=1.27 w=1 l=0.15
X10 VPWR a_1283_21# Q VPB sky130_fd_pr__pfet_01v8_hvt ad=0.135 pd=1.27 as=0.135 ps=1.27 w=1 l=0.15
X11 a_761_289# a_543_47# VGND VNB sky130_fd_pr__nfet_01v8 ad=0.0999 pd=0.985 as=0.1346 ps=1.15 w=0.64 l=0.15
X12 Q a_1283_21# VGND VNB sky130_fd_pr__nfet_01v8 ad=0.08775 pd=0.92 as=0.169 ps=1.82 w=0.65 l=0.15
X13 a_193_47# a_27_47# VGND VNB sky130_fd_pr__nfet_01v8 ad=0.1092 pd=1.36 as=0.0567 ps=0.69 w=0.42 l=0.15
X14 a_1108_47# a_27_47# a_761_289# VPB sky130_fd_pr__pfet_01v8_hvt ad=0.0588 pd=0.7 as=0.12915 ps=1.185 w=0.42 l=0.15
X15 a_1462_47# RESET_B VGND VNB sky130_fd_pr__nfet_01v8 ad=0.06405 pd=0.725 as=0.12495 ps=1.015 w=0.42 l=0.15
X16 a_543_47# a_27_47# a_448_47# VNB sky130_fd_pr__special_nfet_01v8 ad=0.0594 pd=0.69 as=0.066 ps=0.745 w=0.36 l=0.15
X17 a_543_47# a_193_47# a_448_47# VPB sky130_fd_pr__pfet_01v8_hvt ad=0.07245 pd=0.765 as=0.0651 ps=0.73 w=0.42 l=0.15
X18 a_448_47# D VGND VNB sky130_fd_pr__nfet_01v8 ad=0.066 pd=0.745 as=0.2205 ps=1.89 w=0.42 l=0.15
X19 VPWR a_1283_21# a_1270_413# VPB sky130_fd_pr__pfet_01v8_hvt ad=0.0819 pd=0.81 as=0.0567 ps=0.69 w=0.42 l=0.15
X20 VPWR a_1108_47# a_1283_21# VPB sky130_fd_pr__pfet_01v8_hvt ad=0.1134 pd=1.38 as=0.0567 ps=0.69 w=0.42 l=0.15
X21 Q a_1283_21# VPWR VPB sky130_fd_pr__pfet_01v8_hvt ad=0.135 pd=1.27 as=0.26 ps=2.52 w=1 l=0.15
X22 a_1270_413# a_193_47# a_1108_47# VPB sky130_fd_pr__pfet_01v8_hvt ad=0.0567 pd=0.69 as=0.0588 ps=0.7 w=0.42 l=0.15
X23 a_193_47# a_27_47# VPWR VPB sky130_fd_pr__pfet_01v8_hvt ad=0.1664 pd=1.8 as=0.0864 ps=0.91 w=0.64 l=0.15
X24 a_1283_21# RESET_B VPWR VPB sky130_fd_pr__pfet_01v8_hvt ad=0.0567 pd=0.69 as=0.0819 ps=0.81 w=0.42 l=0.15
X25 VGND a_1283_21# Q VNB sky130_fd_pr__nfet_01v8 ad=0.08775 pd=0.92 as=0.08775 ps=0.92 w=0.65 l=0.15
X26 VGND a_1283_21# Q VNB sky130_fd_pr__nfet_01v8 ad=0.182 pd=1.86 as=0.08775 ps=0.92 w=0.65 l=0.15
X27 VPWR a_761_289# a_651_413# VPB sky130_fd_pr__pfet_01v8_hvt ad=0.07035 pd=0.755 as=0.1155 ps=0.97 w=0.42 l=0.15
X28 a_639_47# a_193_47# a_543_47# VNB sky130_fd_pr__special_nfet_01v8 ad=0.1401 pd=1.1 as=0.0594 ps=0.69 w=0.36 l=0.15
X29 VGND a_1283_21# a_1217_47# VNB sky130_fd_pr__nfet_01v8 ad=0.12495 pd=1.015 as=0.0669 ps=0.75 w=0.42 l=0.15
X30 a_651_413# RESET_B VPWR VPB sky130_fd_pr__pfet_01v8_hvt ad=0.1092 pd=1.36 as=0.07035 ps=0.755 w=0.42 l=0.15
X31 VGND CLK a_27_47# VNB sky130_fd_pr__nfet_01v8 ad=0.0567 pd=0.69 as=0.1092 ps=1.36 w=0.42 l=0.15
X32 a_761_289# a_543_47# VPWR VPB sky130_fd_pr__pfet_01v8_hvt ad=0.12915 pd=1.185 as=0.2184 ps=2.2 w=0.84 l=0.15
X33 Q a_1283_21# VGND VNB sky130_fd_pr__nfet_01v8 ad=0.08775 pd=0.92 as=0.08775 ps=0.92 w=0.65 l=0.15
C0 VPB VNB 2.1109f
.ends

.subckt sky130_fd_sc_hd__dfxtp_2 CLK D VGND VNB VPB VPWR Q
X0 Q a_1059_315# VGND VNB sky130_fd_pr__nfet_01v8 ad=0.08775 pd=0.92 as=0.08775 ps=0.92 w=0.65 l=0.15
X1 VPWR a_1059_315# Q VPB sky130_fd_pr__pfet_01v8_hvt ad=0.26 pd=2.52 as=0.135 ps=1.27 w=1 l=0.15
X2 a_891_413# a_193_47# a_634_159# VNB sky130_fd_pr__special_nfet_01v8 ad=0.0684 pd=0.74 as=0.0989 ps=0.995 w=0.36 l=0.15
X3 a_561_413# a_27_47# a_466_413# VPB sky130_fd_pr__pfet_01v8_hvt ad=0.07665 pd=0.785 as=0.06825 ps=0.745 w=0.42 l=0.15
X4 VPWR CLK a_27_47# VPB sky130_fd_pr__pfet_01v8_hvt ad=0.0864 pd=0.91 as=0.1664 ps=1.8 w=0.64 l=0.15
X5 Q a_1059_315# VPWR VPB sky130_fd_pr__pfet_01v8_hvt ad=0.135 pd=1.27 as=0.135 ps=1.27 w=1 l=0.15
X6 a_381_47# D VPWR VPB sky130_fd_pr__pfet_01v8_hvt ad=0.05775 pd=0.695 as=0.1092 ps=1.36 w=0.42 l=0.15
X7 VGND a_634_159# a_592_47# VNB sky130_fd_pr__nfet_01v8 ad=0.12095 pd=1.085 as=0.0696 ps=0.765 w=0.42 l=0.15
X8 VGND a_1059_315# Q VNB sky130_fd_pr__nfet_01v8 ad=0.169 pd=1.82 as=0.08775 ps=0.92 w=0.65 l=0.15
X9 VPWR a_891_413# a_1059_315# VPB sky130_fd_pr__pfet_01v8_hvt ad=0.135 pd=1.27 as=0.27 ps=2.54 w=1 l=0.15
X10 a_466_413# a_193_47# a_381_47# VPB sky130_fd_pr__pfet_01v8_hvt ad=0.06825 pd=0.745 as=0.05775 ps=0.695 w=0.42 l=0.15
X11 VPWR a_634_159# a_561_413# VPB sky130_fd_pr__pfet_01v8_hvt ad=0.17887 pd=1.26 as=0.07665 ps=0.785 w=0.42 l=0.15
X12 a_634_159# a_466_413# VGND VNB sky130_fd_pr__nfet_01v8 ad=0.0989 pd=0.995 as=0.12095 ps=1.085 w=0.64 l=0.15
X13 a_634_159# a_466_413# VPWR VPB sky130_fd_pr__pfet_01v8_hvt ad=0.1095 pd=1.075 as=0.17887 ps=1.26 w=0.75 l=0.15
X14 a_975_413# a_193_47# a_891_413# VPB sky130_fd_pr__pfet_01v8_hvt ad=0.0882 pd=0.84 as=0.0567 ps=0.69 w=0.42 l=0.15
X15 VGND a_1059_315# a_1017_47# VNB sky130_fd_pr__nfet_01v8 ad=0.1092 pd=1.36 as=0.066 ps=0.745 w=0.42 l=0.15
X16 a_193_47# a_27_47# VGND VNB sky130_fd_pr__nfet_01v8 ad=0.1092 pd=1.36 as=0.0567 ps=0.69 w=0.42 l=0.15
X17 a_891_413# a_27_47# a_634_159# VPB sky130_fd_pr__pfet_01v8_hvt ad=0.0567 pd=0.69 as=0.1095 ps=1.075 w=0.42 l=0.15
X18 a_592_47# a_193_47# a_466_413# VNB sky130_fd_pr__special_nfet_01v8 ad=0.0696 pd=0.765 as=0.0621 ps=0.705 w=0.36 l=0.15
X19 VPWR a_1059_315# a_975_413# VPB sky130_fd_pr__pfet_01v8_hvt ad=0.1113 pd=1.37 as=0.0882 ps=0.84 w=0.42 l=0.15
X20 a_1017_47# a_27_47# a_891_413# VNB sky130_fd_pr__special_nfet_01v8 ad=0.066 pd=0.745 as=0.0684 ps=0.74 w=0.36 l=0.15
X21 a_193_47# a_27_47# VPWR VPB sky130_fd_pr__pfet_01v8_hvt ad=0.1664 pd=1.8 as=0.0864 ps=0.91 w=0.64 l=0.15
X22 a_466_413# a_27_47# a_381_47# VNB sky130_fd_pr__special_nfet_01v8 ad=0.0621 pd=0.705 as=0.0813 ps=0.83 w=0.36 l=0.15
X23 VGND a_891_413# a_1059_315# VNB sky130_fd_pr__nfet_01v8 ad=0.08775 pd=0.92 as=0.169 ps=1.82 w=0.65 l=0.15
X24 a_381_47# D VGND VNB sky130_fd_pr__nfet_01v8 ad=0.0813 pd=0.83 as=0.1092 ps=1.36 w=0.42 l=0.15
X25 VGND CLK a_27_47# VNB sky130_fd_pr__nfet_01v8 ad=0.0567 pd=0.69 as=0.1092 ps=1.36 w=0.42 l=0.15
.ends

.subckt sky130_fd_sc_hd__a22o_1 A1 A2 B1 B2 VGND VNB VPB VPWR X
X0 VPWR A2 a_109_297# VPB sky130_fd_pr__pfet_01v8_hvt ad=0.155 pd=1.31 as=0.16 ps=1.32 w=1 l=0.15
X1 a_27_297# B1 a_109_47# VNB sky130_fd_pr__nfet_01v8 ad=0.169 pd=1.82 as=0.07475 ps=0.88 w=0.65 l=0.15
X2 VGND A2 a_373_47# VNB sky130_fd_pr__nfet_01v8 ad=0.10075 pd=0.96 as=0.11375 ps=1 w=0.65 l=0.15
X3 X a_27_297# VPWR VPB sky130_fd_pr__pfet_01v8_hvt ad=0.26 pd=2.52 as=0.155 ps=1.31 w=1 l=0.15
X4 a_27_297# B1 a_109_297# VPB sky130_fd_pr__pfet_01v8_hvt ad=0.25285 pd=2.52 as=0.135 ps=1.27 w=1 l=0.15
X5 a_109_297# A1 VPWR VPB sky130_fd_pr__pfet_01v8_hvt ad=0.16 pd=1.32 as=0.2529 ps=2.52 w=1 l=0.15
X6 a_373_47# A1 a_27_297# VNB sky130_fd_pr__nfet_01v8 ad=0.11375 pd=1 as=0.169 ps=1.82 w=0.65 l=0.15
X7 X a_27_297# VGND VNB sky130_fd_pr__nfet_01v8 ad=0.169 pd=1.82 as=0.10075 ps=0.96 w=0.65 l=0.15
X8 a_109_297# B2 a_27_297# VPB sky130_fd_pr__pfet_01v8_hvt ad=0.135 pd=1.27 as=0.26 ps=2.52 w=1 l=0.15
X9 a_109_47# B2 VGND VNB sky130_fd_pr__nfet_01v8 ad=0.07475 pd=0.88 as=0.169 ps=1.82 w=0.65 l=0.15
.ends

.subckt sky130_fd_sc_hd__or2_1 A B VGND VNB VPB VPWR X
X0 VGND A a_68_297# VNB sky130_fd_pr__nfet_01v8 ad=0.10025 pd=0.985 as=0.0567 ps=0.69 w=0.42 l=0.15
X1 a_68_297# B VGND VNB sky130_fd_pr__nfet_01v8 ad=0.0567 pd=0.69 as=0.1092 ps=1.36 w=0.42 l=0.15
X2 X a_68_297# VGND VNB sky130_fd_pr__nfet_01v8 ad=0.169 pd=1.82 as=0.10025 ps=0.985 w=0.65 l=0.15
X3 VPWR A a_150_297# VPB sky130_fd_pr__pfet_01v8_hvt ad=0.14575 pd=1.335 as=0.0441 ps=0.63 w=0.42 l=0.15
X4 X a_68_297# VPWR VPB sky130_fd_pr__pfet_01v8_hvt ad=0.34 pd=2.68 as=0.14575 ps=1.335 w=1 l=0.15
X5 a_150_297# B a_68_297# VPB sky130_fd_pr__pfet_01v8_hvt ad=0.0441 pd=0.63 as=0.1092 ps=1.36 w=0.42 l=0.15
.ends

.subckt sky130_fd_sc_hd__a21oi_1 A1 A2 B1 VGND VNB VPB VPWR Y
X0 a_199_47# A1 Y VNB sky130_fd_pr__nfet_01v8 ad=0.09588 pd=0.945 as=0.091 ps=0.93 w=0.65 l=0.15
X1 a_113_297# A2 VPWR VPB sky130_fd_pr__pfet_01v8_hvt ad=0.265 pd=2.53 as=0.1475 ps=1.295 w=1 l=0.15
X2 Y B1 VGND VNB sky130_fd_pr__nfet_01v8 ad=0.091 pd=0.93 as=0.17225 ps=1.83 w=0.65 l=0.15
X3 VPWR A1 a_113_297# VPB sky130_fd_pr__pfet_01v8_hvt ad=0.1475 pd=1.295 as=0.14 ps=1.28 w=1 l=0.15
X4 a_113_297# B1 Y VPB sky130_fd_pr__pfet_01v8_hvt ad=0.14 pd=1.28 as=0.265 ps=2.53 w=1 l=0.15
X5 VGND A2 a_199_47# VNB sky130_fd_pr__nfet_01v8 ad=0.17225 pd=1.83 as=0.09588 ps=0.945 w=0.65 l=0.15
.ends

.subckt sky130_fd_sc_hd__a221o_1 A1 A2 B1 B2 C1 VGND VNB VPB VPWR X
X0 a_465_47# A1 a_27_47# VNB sky130_fd_pr__nfet_01v8 ad=0.10725 pd=0.98 as=0.169 ps=1.82 w=0.65 l=0.15
X1 X a_27_47# VPWR VPB sky130_fd_pr__pfet_01v8_hvt ad=0.26 pd=2.52 as=0.1575 ps=1.315 w=1 l=0.15
X2 a_109_297# B1 a_193_297# VPB sky130_fd_pr__pfet_01v8_hvt ad=0.26 pd=2.52 as=0.135 ps=1.27 w=1 l=0.15
X3 a_193_297# B2 a_109_297# VPB sky130_fd_pr__pfet_01v8_hvt ad=0.135 pd=1.27 as=0.135 ps=1.27 w=1 l=0.15
X4 X a_27_47# VGND VNB sky130_fd_pr__nfet_01v8 ad=0.169 pd=1.82 as=0.10238 ps=0.965 w=0.65 l=0.15
X5 a_205_47# B2 VGND VNB sky130_fd_pr__nfet_01v8 ad=0.06825 pd=0.86 as=0.10725 ps=0.98 w=0.65 l=0.15
X6 VPWR A2 a_193_297# VPB sky130_fd_pr__pfet_01v8_hvt ad=0.1575 pd=1.315 as=0.165 ps=1.33 w=1 l=0.15
X7 a_193_297# A1 VPWR VPB sky130_fd_pr__pfet_01v8_hvt ad=0.165 pd=1.33 as=0.26 ps=2.52 w=1 l=0.15
X8 a_27_47# B1 a_205_47# VNB sky130_fd_pr__nfet_01v8 ad=0.169 pd=1.82 as=0.06825 ps=0.86 w=0.65 l=0.15
X9 a_109_297# C1 a_27_47# VPB sky130_fd_pr__pfet_01v8_hvt ad=0.135 pd=1.27 as=0.26 ps=2.52 w=1 l=0.15
X10 VGND C1 a_27_47# VNB sky130_fd_pr__nfet_01v8 ad=0.10725 pd=0.98 as=0.169 ps=1.82 w=0.65 l=0.15
X11 VGND A2 a_465_47# VNB sky130_fd_pr__nfet_01v8 ad=0.10238 pd=0.965 as=0.10725 ps=0.98 w=0.65 l=0.15
.ends

.subckt sky130_fd_sc_hd__or3_1 A B C VGND VNB VPB VPWR X
X0 X a_29_53# VPWR VPB sky130_fd_pr__pfet_01v8_hvt ad=0.28 pd=2.56 as=0.14825 ps=1.34 w=1 l=0.15
X1 a_111_297# C a_29_53# VPB sky130_fd_pr__pfet_01v8_hvt ad=0.0441 pd=0.63 as=0.1092 ps=1.36 w=0.42 l=0.15
X2 X a_29_53# VGND VNB sky130_fd_pr__nfet_01v8 ad=0.182 pd=1.86 as=0.10187 ps=0.99 w=0.65 l=0.15
X3 a_183_297# B a_111_297# VPB sky130_fd_pr__pfet_01v8_hvt ad=0.0693 pd=0.75 as=0.0441 ps=0.63 w=0.42 l=0.15
X4 VPWR A a_183_297# VPB sky130_fd_pr__pfet_01v8_hvt ad=0.14825 pd=1.34 as=0.0693 ps=0.75 w=0.42 l=0.15
X5 a_29_53# B VGND VNB sky130_fd_pr__nfet_01v8 ad=0.0567 pd=0.69 as=0.0567 ps=0.69 w=0.42 l=0.15
X6 VGND C a_29_53# VNB sky130_fd_pr__nfet_01v8 ad=0.0567 pd=0.69 as=0.1092 ps=1.36 w=0.42 l=0.15
X7 VGND A a_29_53# VNB sky130_fd_pr__nfet_01v8 ad=0.10187 pd=0.99 as=0.0567 ps=0.69 w=0.42 l=0.15
.ends

.subckt sky130_fd_sc_hd__o22a_1 A1 A2 B1 B2 VGND VNB VPB VPWR X
X0 a_78_199# B1 a_215_47# VNB sky130_fd_pr__nfet_01v8 ad=0.08775 pd=0.92 as=0.169 ps=1.82 w=0.65 l=0.15
X1 VPWR A1 a_493_297# VPB sky130_fd_pr__pfet_01v8_hvt ad=0.26 pd=2.52 as=0.105 ps=1.21 w=1 l=0.15
X2 a_493_297# A2 a_78_199# VPB sky130_fd_pr__pfet_01v8_hvt ad=0.105 pd=1.21 as=0.235 ps=1.47 w=1 l=0.15
X3 VPWR a_78_199# X VPB sky130_fd_pr__pfet_01v8_hvt ad=0.3725 pd=1.745 as=0.28 ps=2.56 w=1 l=0.15
X4 VGND A2 a_215_47# VNB sky130_fd_pr__nfet_01v8 ad=0.08775 pd=0.92 as=0.11375 ps=1 w=0.65 l=0.15
X5 a_78_199# B2 a_292_297# VPB sky130_fd_pr__pfet_01v8_hvt ad=0.235 pd=1.47 as=0.1175 ps=1.235 w=1 l=0.15
X6 a_215_47# A1 VGND VNB sky130_fd_pr__nfet_01v8 ad=0.169 pd=1.82 as=0.08775 ps=0.92 w=0.65 l=0.15
X7 a_215_47# B2 a_78_199# VNB sky130_fd_pr__nfet_01v8 ad=0.11375 pd=1 as=0.08775 ps=0.92 w=0.65 l=0.15
X8 a_292_297# B1 VPWR VPB sky130_fd_pr__pfet_01v8_hvt ad=0.1175 pd=1.235 as=0.3725 ps=1.745 w=1 l=0.15
X9 VGND a_78_199# X VNB sky130_fd_pr__nfet_01v8 ad=0.169 pd=1.82 as=0.169 ps=1.82 w=0.65 l=0.15
.ends

.subckt sky130_fd_sc_hd__dfstp_1 CLK D SET_B VGND VNB VPB VPWR Q
X0 VGND a_652_21# a_586_47# VNB sky130_fd_pr__nfet_01v8 ad=0.0882 pd=0.84 as=0.06705 ps=0.75 w=0.42 l=0.15
X1 a_956_413# a_476_47# VPWR VPB sky130_fd_pr__pfet_01v8_hvt ad=0.0483 pd=0.65 as=0.0567 ps=0.69 w=0.42 l=0.15
X2 VPWR a_476_47# a_652_21# VPB sky130_fd_pr__pfet_01v8_hvt ad=0.0567 pd=0.69 as=0.0567 ps=0.69 w=0.42 l=0.15
X3 VPWR CLK a_27_47# VPB sky130_fd_pr__pfet_01v8_hvt ad=0.0864 pd=0.91 as=0.1664 ps=1.8 w=0.64 l=0.15
X4 a_586_47# a_193_47# a_476_47# VNB sky130_fd_pr__special_nfet_01v8 ad=0.06705 pd=0.75 as=0.072 ps=0.76 w=0.36 l=0.15
X5 a_1056_47# a_476_47# VGND VNB sky130_fd_pr__nfet_01v8 ad=0.0441 pd=0.63 as=0.1092 ps=1.36 w=0.42 l=0.15
X6 a_476_47# a_27_47# a_381_47# VNB sky130_fd_pr__special_nfet_01v8 ad=0.072 pd=0.76 as=0.0935 ps=0.965 w=0.36 l=0.15
X7 a_381_47# D VPWR VPB sky130_fd_pr__pfet_01v8_hvt ad=0.12495 pd=1.175 as=0.2184 ps=2.2 w=0.84 l=0.15
X8 a_652_21# SET_B VPWR VPB sky130_fd_pr__pfet_01v8_hvt ad=0.0567 pd=0.69 as=0.0798 ps=0.8 w=0.42 l=0.15
X9 a_1224_47# a_27_47# a_1032_413# VNB sky130_fd_pr__nfet_01v8 ad=0.0441 pd=0.63 as=0.0693 ps=0.75 w=0.42 l=0.15
X10 a_562_413# a_27_47# a_476_47# VPB sky130_fd_pr__pfet_01v8_hvt ad=0.0945 pd=0.87 as=0.0567 ps=0.69 w=0.42 l=0.15
X11 VGND a_1032_413# a_1602_47# VNB sky130_fd_pr__nfet_01v8 ad=0.097 pd=0.975 as=0.1092 ps=1.36 w=0.42 l=0.15
X12 VPWR a_1182_261# a_1140_413# VPB sky130_fd_pr__pfet_01v8_hvt ad=0.1092 pd=1.36 as=0.0441 ps=0.63 w=0.42 l=0.15
X13 Q a_1602_47# VPWR VPB sky130_fd_pr__pfet_01v8_hvt ad=0.26 pd=2.52 as=0.149 ps=1.325 w=1 l=0.15
X14 a_1032_413# a_193_47# a_1056_47# VNB sky130_fd_pr__nfet_01v8 ad=0.0693 pd=0.75 as=0.0441 ps=0.63 w=0.42 l=0.15
X15 a_476_47# a_193_47# a_381_47# VPB sky130_fd_pr__pfet_01v8_hvt ad=0.0567 pd=0.69 as=0.12495 ps=1.175 w=0.42 l=0.15
X16 a_1296_47# a_1182_261# a_1224_47# VNB sky130_fd_pr__nfet_01v8 ad=0.0483 pd=0.65 as=0.0441 ps=0.63 w=0.42 l=0.15
X17 a_193_47# a_27_47# VGND VNB sky130_fd_pr__nfet_01v8 ad=0.1092 pd=1.36 as=0.0567 ps=0.69 w=0.42 l=0.15
X18 VPWR a_652_21# a_562_413# VPB sky130_fd_pr__pfet_01v8_hvt ad=0.0798 pd=0.8 as=0.0945 ps=0.87 w=0.42 l=0.15
X19 VPWR SET_B a_1032_413# VPB sky130_fd_pr__pfet_01v8_hvt ad=0.12285 pd=1.17 as=0.1092 ps=1.36 w=0.42 l=0.15
X20 a_1032_413# a_27_47# a_956_413# VPB sky130_fd_pr__pfet_01v8_hvt ad=0.0819 pd=0.81 as=0.0483 ps=0.65 w=0.42 l=0.15
X21 a_1182_261# a_1032_413# VPWR VPB sky130_fd_pr__pfet_01v8_hvt ad=0.2184 pd=2.2 as=0.12285 ps=1.17 w=0.84 l=0.15
X22 Q a_1602_47# VGND VNB sky130_fd_pr__nfet_01v8 ad=0.169 pd=1.82 as=0.097 ps=0.975 w=0.65 l=0.15
X23 a_193_47# a_27_47# VPWR VPB sky130_fd_pr__pfet_01v8_hvt ad=0.1664 pd=1.8 as=0.0864 ps=0.91 w=0.64 l=0.15
X24 a_1140_413# a_193_47# a_1032_413# VPB sky130_fd_pr__pfet_01v8_hvt ad=0.0441 pd=0.63 as=0.0819 ps=0.81 w=0.42 l=0.15
X25 VPWR a_1032_413# a_1602_47# VPB sky130_fd_pr__pfet_01v8_hvt ad=0.149 pd=1.325 as=0.1664 ps=1.8 w=0.64 l=0.15
X26 a_796_47# SET_B VGND VNB sky130_fd_pr__nfet_01v8 ad=0.0441 pd=0.63 as=0.0882 ps=0.84 w=0.42 l=0.15
X27 a_381_47# D VGND VNB sky130_fd_pr__nfet_01v8 ad=0.0935 pd=0.965 as=0.1664 ps=1.8 w=0.64 l=0.15
X28 a_1182_261# a_1032_413# VGND VNB sky130_fd_pr__nfet_01v8 ad=0.1404 pd=1.6 as=0.1137 ps=1.01 w=0.54 l=0.15
X29 a_652_21# a_476_47# a_796_47# VNB sky130_fd_pr__nfet_01v8 ad=0.1092 pd=1.36 as=0.0441 ps=0.63 w=0.42 l=0.15
X30 VGND CLK a_27_47# VNB sky130_fd_pr__nfet_01v8 ad=0.0567 pd=0.69 as=0.1092 ps=1.36 w=0.42 l=0.15
X31 VGND SET_B a_1296_47# VNB sky130_fd_pr__nfet_01v8 ad=0.1137 pd=1.01 as=0.0483 ps=0.65 w=0.42 l=0.15
.ends

.subckt sky130_fd_sc_hd__nand2_1 A B VGND VNB VPB VPWR Y
X0 VPWR A Y VPB sky130_fd_pr__pfet_01v8_hvt ad=0.26 pd=2.52 as=0.135 ps=1.27 w=1 l=0.15
X1 Y A a_113_47# VNB sky130_fd_pr__nfet_01v8 ad=0.169 pd=1.82 as=0.08775 ps=0.92 w=0.65 l=0.15
X2 a_113_47# B VGND VNB sky130_fd_pr__nfet_01v8 ad=0.08775 pd=0.92 as=0.169 ps=1.82 w=0.65 l=0.15
X3 Y B VPWR VPB sky130_fd_pr__pfet_01v8_hvt ad=0.135 pd=1.27 as=0.26 ps=2.52 w=1 l=0.15
.ends

.subckt sky130_fd_sc_hd__nand3_4 A B C VGND VNB VPB VPWR Y
X0 a_27_47# B a_445_47# VNB sky130_fd_pr__nfet_01v8 ad=0.08775 pd=0.92 as=0.08775 ps=0.92 w=0.65 l=0.15
X1 a_27_47# B a_445_47# VNB sky130_fd_pr__nfet_01v8 ad=0.169 pd=1.82 as=0.08775 ps=0.92 w=0.65 l=0.15
X2 Y B VPWR VPB sky130_fd_pr__pfet_01v8_hvt ad=0.135 pd=1.27 as=0.135 ps=1.27 w=1 l=0.15
X3 VPWR C Y VPB sky130_fd_pr__pfet_01v8_hvt ad=0.135 pd=1.27 as=0.135 ps=1.27 w=1 l=0.15
X4 Y A a_445_47# VNB sky130_fd_pr__nfet_01v8 ad=0.08775 pd=0.92 as=0.08775 ps=0.92 w=0.65 l=0.15
X5 Y C VPWR VPB sky130_fd_pr__pfet_01v8_hvt ad=0.135 pd=1.27 as=0.135 ps=1.27 w=1 l=0.15
X6 Y A a_445_47# VNB sky130_fd_pr__nfet_01v8 ad=0.08775 pd=0.92 as=0.169 ps=1.82 w=0.65 l=0.15
X7 VPWR C Y VPB sky130_fd_pr__pfet_01v8_hvt ad=0.135 pd=1.27 as=0.135 ps=1.27 w=1 l=0.15
X8 a_27_47# C VGND VNB sky130_fd_pr__nfet_01v8 ad=0.08775 pd=0.92 as=0.08775 ps=0.92 w=0.65 l=0.15
X9 a_27_47# C VGND VNB sky130_fd_pr__nfet_01v8 ad=0.08775 pd=0.92 as=0.08775 ps=0.92 w=0.65 l=0.15
X10 a_445_47# A Y VNB sky130_fd_pr__nfet_01v8 ad=0.1755 pd=1.84 as=0.08775 ps=0.92 w=0.65 l=0.15
X11 VPWR B Y VPB sky130_fd_pr__pfet_01v8_hvt ad=0.26 pd=2.52 as=0.135 ps=1.27 w=1 l=0.15
X12 a_445_47# A Y VNB sky130_fd_pr__nfet_01v8 ad=0.08775 pd=0.92 as=0.08775 ps=0.92 w=0.65 l=0.15
X13 VGND C a_27_47# VNB sky130_fd_pr__nfet_01v8 ad=0.08775 pd=0.92 as=0.08775 ps=0.92 w=0.65 l=0.15
X14 a_445_47# B a_27_47# VNB sky130_fd_pr__nfet_01v8 ad=0.08775 pd=0.92 as=0.08775 ps=0.92 w=0.65 l=0.15
X15 Y B VPWR VPB sky130_fd_pr__pfet_01v8_hvt ad=0.135 pd=1.27 as=0.135 ps=1.27 w=1 l=0.15
X16 VPWR A Y VPB sky130_fd_pr__pfet_01v8_hvt ad=0.27 pd=2.54 as=0.135 ps=1.27 w=1 l=0.15
X17 a_445_47# B a_27_47# VNB sky130_fd_pr__nfet_01v8 ad=0.08775 pd=0.92 as=0.08775 ps=0.92 w=0.65 l=0.15
X18 VPWR B Y VPB sky130_fd_pr__pfet_01v8_hvt ad=0.135 pd=1.27 as=0.135 ps=1.27 w=1 l=0.15
X19 Y A VPWR VPB sky130_fd_pr__pfet_01v8_hvt ad=0.135 pd=1.27 as=0.135 ps=1.27 w=1 l=0.15
X20 VPWR A Y VPB sky130_fd_pr__pfet_01v8_hvt ad=0.135 pd=1.27 as=0.135 ps=1.27 w=1 l=0.15
X21 Y C VPWR VPB sky130_fd_pr__pfet_01v8_hvt ad=0.135 pd=1.27 as=0.26 ps=2.52 w=1 l=0.15
X22 Y A VPWR VPB sky130_fd_pr__pfet_01v8_hvt ad=0.135 pd=1.27 as=0.26 ps=2.52 w=1 l=0.15
X23 VGND C a_27_47# VNB sky130_fd_pr__nfet_01v8 ad=0.08775 pd=0.92 as=0.169 ps=1.82 w=0.65 l=0.15
.ends

.subckt sky130_fd_sc_hd__nor4_1 A B C D VGND VNB VPB VPWR Y
X0 Y B VGND VNB sky130_fd_pr__nfet_01v8 ad=0.08775 pd=0.92 as=0.08937 ps=0.925 w=0.65 l=0.15
X1 a_191_297# C a_109_297# VPB sky130_fd_pr__pfet_01v8_hvt ad=0.19 pd=1.38 as=0.13 ps=1.26 w=1 l=0.15
X2 VPWR A a_297_297# VPB sky130_fd_pr__pfet_01v8_hvt ad=0.26 pd=2.52 as=0.135 ps=1.27 w=1 l=0.15
X3 VGND C Y VNB sky130_fd_pr__nfet_01v8 ad=0.08937 pd=0.925 as=0.11863 ps=1.015 w=0.65 l=0.15
X4 VGND A Y VNB sky130_fd_pr__nfet_01v8 ad=0.169 pd=1.82 as=0.08775 ps=0.92 w=0.65 l=0.15
X5 a_297_297# B a_191_297# VPB sky130_fd_pr__pfet_01v8_hvt ad=0.135 pd=1.27 as=0.19 ps=1.38 w=1 l=0.15
X6 a_109_297# D Y VPB sky130_fd_pr__pfet_01v8_hvt ad=0.13 pd=1.26 as=0.26 ps=2.52 w=1 l=0.15
X7 Y D VGND VNB sky130_fd_pr__nfet_01v8 ad=0.11863 pd=1.015 as=0.169 ps=1.82 w=0.65 l=0.15
.ends

.subckt sky130_fd_sc_hd__xnor2_1 A B VGND VNB VPB VPWR Y
X0 a_377_297# A VPWR VPB sky130_fd_pr__pfet_01v8_hvt ad=0.105 pd=1.21 as=0.365 ps=1.73 w=1 l=0.15
X1 a_47_47# B VPWR VPB sky130_fd_pr__pfet_01v8_hvt ad=0.135 pd=1.27 as=0.3 ps=2.6 w=1 l=0.15
X2 a_129_47# B a_47_47# VNB sky130_fd_pr__nfet_01v8 ad=0.06825 pd=0.86 as=0.169 ps=1.82 w=0.65 l=0.15
X3 a_285_47# B VGND VNB sky130_fd_pr__nfet_01v8 ad=0.08775 pd=0.92 as=0.169 ps=1.82 w=0.65 l=0.15
X4 Y a_47_47# a_285_47# VNB sky130_fd_pr__nfet_01v8 ad=0.195 pd=1.9 as=0.08775 ps=0.92 w=0.65 l=0.15
X5 VGND A a_129_47# VNB sky130_fd_pr__nfet_01v8 ad=0.08775 pd=0.92 as=0.06825 ps=0.86 w=0.65 l=0.15
X6 VPWR A a_47_47# VPB sky130_fd_pr__pfet_01v8_hvt ad=0.365 pd=1.73 as=0.135 ps=1.27 w=1 l=0.15
X7 VPWR a_47_47# Y VPB sky130_fd_pr__pfet_01v8_hvt ad=0.36 pd=2.72 as=0.165 ps=1.33 w=1 l=0.15
X8 Y B a_377_297# VPB sky130_fd_pr__pfet_01v8_hvt ad=0.165 pd=1.33 as=0.105 ps=1.21 w=1 l=0.15
X9 a_285_47# A VGND VNB sky130_fd_pr__nfet_01v8 ad=0.169 pd=1.82 as=0.08775 ps=0.92 w=0.65 l=0.15
.ends

.subckt sky130_fd_sc_hd__nand2_4 A B VGND VNB VPB VPWR Y
X0 a_27_47# A Y VNB sky130_fd_pr__nfet_01v8 ad=0.08775 pd=0.92 as=0.08775 ps=0.92 w=0.65 l=0.15
X1 a_27_47# A Y VNB sky130_fd_pr__nfet_01v8 ad=0.169 pd=1.82 as=0.08775 ps=0.92 w=0.65 l=0.15
X2 Y A VPWR VPB sky130_fd_pr__pfet_01v8_hvt ad=0.135 pd=1.27 as=0.135 ps=1.27 w=1 l=0.15
X3 VPWR B Y VPB sky130_fd_pr__pfet_01v8_hvt ad=0.135 pd=1.27 as=0.135 ps=1.27 w=1 l=0.15
X4 Y B VPWR VPB sky130_fd_pr__pfet_01v8_hvt ad=0.135 pd=1.27 as=0.135 ps=1.27 w=1 l=0.15
X5 VPWR B Y VPB sky130_fd_pr__pfet_01v8_hvt ad=0.135 pd=1.27 as=0.135 ps=1.27 w=1 l=0.15
X6 a_27_47# B VGND VNB sky130_fd_pr__nfet_01v8 ad=0.08775 pd=0.92 as=0.08775 ps=0.92 w=0.65 l=0.15
X7 a_27_47# B VGND VNB sky130_fd_pr__nfet_01v8 ad=0.08775 pd=0.92 as=0.08775 ps=0.92 w=0.65 l=0.15
X8 VPWR A Y VPB sky130_fd_pr__pfet_01v8_hvt ad=0.26 pd=2.52 as=0.135 ps=1.27 w=1 l=0.15
X9 VGND B a_27_47# VNB sky130_fd_pr__nfet_01v8 ad=0.08775 pd=0.92 as=0.08775 ps=0.92 w=0.65 l=0.15
X10 Y A a_27_47# VNB sky130_fd_pr__nfet_01v8 ad=0.08775 pd=0.92 as=0.08775 ps=0.92 w=0.65 l=0.15
X11 Y A VPWR VPB sky130_fd_pr__pfet_01v8_hvt ad=0.135 pd=1.27 as=0.135 ps=1.27 w=1 l=0.15
X12 Y A a_27_47# VNB sky130_fd_pr__nfet_01v8 ad=0.08775 pd=0.92 as=0.08775 ps=0.92 w=0.65 l=0.15
X13 VPWR A Y VPB sky130_fd_pr__pfet_01v8_hvt ad=0.135 pd=1.27 as=0.135 ps=1.27 w=1 l=0.15
X14 Y B VPWR VPB sky130_fd_pr__pfet_01v8_hvt ad=0.135 pd=1.27 as=0.26 ps=2.52 w=1 l=0.15
X15 VGND B a_27_47# VNB sky130_fd_pr__nfet_01v8 ad=0.08775 pd=0.92 as=0.169 ps=1.82 w=0.65 l=0.15
.ends

.subckt sky130_fd_sc_hd__buf_2 A VGND VNB VPB VPWR X
X0 VPWR a_27_47# X VPB sky130_fd_pr__pfet_01v8_hvt ad=0.265 pd=2.53 as=0.135 ps=1.27 w=1 l=0.15
X1 X a_27_47# VPWR VPB sky130_fd_pr__pfet_01v8_hvt ad=0.135 pd=1.27 as=0.149 ps=1.325 w=1 l=0.15
X2 VPWR A a_27_47# VPB sky130_fd_pr__pfet_01v8_hvt ad=0.149 pd=1.325 as=0.1664 ps=1.8 w=0.64 l=0.15
X3 X a_27_47# VGND VNB sky130_fd_pr__nfet_01v8 ad=0.08775 pd=0.92 as=0.097 ps=0.975 w=0.65 l=0.15
X4 VGND a_27_47# X VNB sky130_fd_pr__nfet_01v8 ad=0.17225 pd=1.83 as=0.08775 ps=0.92 w=0.65 l=0.15
X5 VGND A a_27_47# VNB sky130_fd_pr__nfet_01v8 ad=0.097 pd=0.975 as=0.1092 ps=1.36 w=0.42 l=0.15
.ends

.subckt sky130_fd_sc_hd__and2b_1 A_N B VGND VNB VPB VPWR X
X0 VPWR B a_207_413# VPB sky130_fd_pr__pfet_01v8_hvt ad=0.2279 pd=1.74 as=0.0609 ps=0.71 w=0.42 l=0.15
X1 X a_207_413# VPWR VPB sky130_fd_pr__pfet_01v8_hvt ad=0.26 pd=2.52 as=0.2279 ps=1.74 w=1 l=0.15
X2 a_297_47# a_27_413# a_207_413# VNB sky130_fd_pr__nfet_01v8 ad=0.0504 pd=0.66 as=0.1092 ps=1.36 w=0.42 l=0.15
X3 X a_207_413# VGND VNB sky130_fd_pr__nfet_01v8 ad=0.169 pd=1.82 as=0.1013 ps=0.99 w=0.65 l=0.15
X4 a_207_413# a_27_413# VPWR VPB sky130_fd_pr__pfet_01v8_hvt ad=0.0609 pd=0.71 as=0.0714 ps=0.76 w=0.42 l=0.15
X5 VPWR A_N a_27_413# VPB sky130_fd_pr__pfet_01v8_hvt ad=0.0714 pd=0.76 as=0.1092 ps=1.36 w=0.42 l=0.15
X6 VGND B a_297_47# VNB sky130_fd_pr__nfet_01v8 ad=0.1013 pd=0.99 as=0.0504 ps=0.66 w=0.42 l=0.15
X7 a_27_413# A_N VGND VNB sky130_fd_pr__nfet_01v8 ad=0.1092 pd=1.36 as=0.1092 ps=1.36 w=0.42 l=0.15
.ends

.subckt sky130_fd_sc_hd__o31a_1 A1 A2 A3 B1 VGND VNB VPB VPWR X
X0 a_103_199# B1 a_253_47# VNB sky130_fd_pr__nfet_01v8 ad=0.2015 pd=1.92 as=0.10725 ps=0.98 w=0.65 l=0.15
X1 VPWR a_103_199# X VPB sky130_fd_pr__pfet_01v8_hvt ad=0.195 pd=1.39 as=0.36 ps=2.72 w=1 l=0.15
X2 a_337_297# A2 a_253_297# VPB sky130_fd_pr__pfet_01v8_hvt ad=0.165 pd=1.33 as=0.135 ps=1.27 w=1 l=0.15
X3 a_103_199# A3 a_337_297# VPB sky130_fd_pr__pfet_01v8_hvt ad=0.2125 pd=1.425 as=0.165 ps=1.33 w=1 l=0.15
X4 a_253_297# A1 VPWR VPB sky130_fd_pr__pfet_01v8_hvt ad=0.135 pd=1.27 as=0.195 ps=1.39 w=1 l=0.15
X5 VPWR B1 a_103_199# VPB sky130_fd_pr__pfet_01v8_hvt ad=0.345 pd=2.69 as=0.2125 ps=1.425 w=1 l=0.15
X6 VGND a_103_199# X VNB sky130_fd_pr__nfet_01v8 ad=0.12675 pd=1.04 as=0.234 ps=2.02 w=0.65 l=0.15
X7 a_253_47# A1 VGND VNB sky130_fd_pr__nfet_01v8 ad=0.08775 pd=0.92 as=0.12675 ps=1.04 w=0.65 l=0.15
X8 a_253_47# A3 VGND VNB sky130_fd_pr__nfet_01v8 ad=0.10725 pd=0.98 as=0.10725 ps=0.98 w=0.65 l=0.15
X9 VGND A2 a_253_47# VNB sky130_fd_pr__nfet_01v8 ad=0.10725 pd=0.98 as=0.08775 ps=0.92 w=0.65 l=0.15
.ends

.subckt sky130_fd_sc_hd__nor2_4 A B VGND VNB VPB VPWR Y
X0 VPWR A a_27_297# VPB sky130_fd_pr__pfet_01v8_hvt ad=0.135 pd=1.27 as=0.135 ps=1.27 w=1 l=0.15
X1 Y A VGND VNB sky130_fd_pr__nfet_01v8 ad=0.08775 pd=0.92 as=0.08775 ps=0.92 w=0.65 l=0.15
X2 a_27_297# A VPWR VPB sky130_fd_pr__pfet_01v8_hvt ad=0.135 pd=1.27 as=0.135 ps=1.27 w=1 l=0.15
X3 VGND A Y VNB sky130_fd_pr__nfet_01v8 ad=0.08775 pd=0.92 as=0.08775 ps=0.92 w=0.65 l=0.15
X4 a_27_297# B Y VPB sky130_fd_pr__pfet_01v8_hvt ad=0.27 pd=2.54 as=0.135 ps=1.27 w=1 l=0.15
X5 Y A VGND VNB sky130_fd_pr__nfet_01v8 ad=0.08775 pd=0.92 as=0.182 ps=1.86 w=0.65 l=0.15
X6 VGND A Y VNB sky130_fd_pr__nfet_01v8 ad=0.08775 pd=0.92 as=0.08775 ps=0.92 w=0.65 l=0.15
X7 VGND B Y VNB sky130_fd_pr__nfet_01v8 ad=0.08775 pd=0.92 as=0.08775 ps=0.92 w=0.65 l=0.15
X8 VGND B Y VNB sky130_fd_pr__nfet_01v8 ad=0.169 pd=1.82 as=0.08775 ps=0.92 w=0.65 l=0.15
X9 Y B a_27_297# VPB sky130_fd_pr__pfet_01v8_hvt ad=0.135 pd=1.27 as=0.135 ps=1.27 w=1 l=0.15
X10 VPWR A a_27_297# VPB sky130_fd_pr__pfet_01v8_hvt ad=0.135 pd=1.27 as=0.28 ps=2.56 w=1 l=0.15
X11 Y B VGND VNB sky130_fd_pr__nfet_01v8 ad=0.08775 pd=0.92 as=0.08775 ps=0.92 w=0.65 l=0.15
X12 Y B VGND VNB sky130_fd_pr__nfet_01v8 ad=0.08775 pd=0.92 as=0.08775 ps=0.92 w=0.65 l=0.15
X13 a_27_297# B Y VPB sky130_fd_pr__pfet_01v8_hvt ad=0.135 pd=1.27 as=0.135 ps=1.27 w=1 l=0.15
X14 Y B a_27_297# VPB sky130_fd_pr__pfet_01v8_hvt ad=0.135 pd=1.27 as=0.135 ps=1.27 w=1 l=0.15
X15 a_27_297# A VPWR VPB sky130_fd_pr__pfet_01v8_hvt ad=0.135 pd=1.27 as=0.135 ps=1.27 w=1 l=0.15
.ends

.subckt sky130_fd_sc_hd__clkbuf_8 A VGND VNB VPB VPWR X
X0 VPWR A a_110_47# VPB sky130_fd_pr__pfet_01v8_hvt ad=0.14 pd=1.28 as=0.14 ps=1.28 w=1 l=0.15
X1 VPWR a_110_47# X VPB sky130_fd_pr__pfet_01v8_hvt ad=0.14 pd=1.28 as=0.14 ps=1.28 w=1 l=0.15
X2 X a_110_47# VPWR VPB sky130_fd_pr__pfet_01v8_hvt ad=0.14 pd=1.28 as=0.14 ps=1.28 w=1 l=0.15
X3 a_110_47# A VPWR VPB sky130_fd_pr__pfet_01v8_hvt ad=0.14 pd=1.28 as=0.265 ps=2.53 w=1 l=0.15
X4 X a_110_47# VGND VNB sky130_fd_pr__nfet_01v8 ad=0.0588 pd=0.7 as=0.0588 ps=0.7 w=0.42 l=0.15
X5 X a_110_47# VPWR VPB sky130_fd_pr__pfet_01v8_hvt ad=0.14 pd=1.28 as=0.14 ps=1.28 w=1 l=0.15
X6 VGND a_110_47# X VNB sky130_fd_pr__nfet_01v8 ad=0.0588 pd=0.7 as=0.0588 ps=0.7 w=0.42 l=0.15
X7 VPWR a_110_47# X VPB sky130_fd_pr__pfet_01v8_hvt ad=0.14 pd=1.28 as=0.14 ps=1.28 w=1 l=0.15
X8 VGND A a_110_47# VNB sky130_fd_pr__nfet_01v8 ad=0.0588 pd=0.7 as=0.0588 ps=0.7 w=0.42 l=0.15
X9 VGND a_110_47# X VNB sky130_fd_pr__nfet_01v8 ad=0.1134 pd=1.38 as=0.0588 ps=0.7 w=0.42 l=0.15
X10 a_110_47# A VGND VNB sky130_fd_pr__nfet_01v8 ad=0.0588 pd=0.7 as=0.1113 ps=1.37 w=0.42 l=0.15
X11 VPWR a_110_47# X VPB sky130_fd_pr__pfet_01v8_hvt ad=0.14 pd=1.28 as=0.14 ps=1.28 w=1 l=0.15
X12 X a_110_47# VPWR VPB sky130_fd_pr__pfet_01v8_hvt ad=0.14 pd=1.28 as=0.14 ps=1.28 w=1 l=0.15
X13 VGND a_110_47# X VNB sky130_fd_pr__nfet_01v8 ad=0.0588 pd=0.7 as=0.0588 ps=0.7 w=0.42 l=0.15
X14 VGND a_110_47# X VNB sky130_fd_pr__nfet_01v8 ad=0.0588 pd=0.7 as=0.0588 ps=0.7 w=0.42 l=0.15
X15 X a_110_47# VPWR VPB sky130_fd_pr__pfet_01v8_hvt ad=0.14 pd=1.28 as=0.14 ps=1.28 w=1 l=0.15
X16 X a_110_47# VGND VNB sky130_fd_pr__nfet_01v8 ad=0.0588 pd=0.7 as=0.0588 ps=0.7 w=0.42 l=0.15
X17 VPWR a_110_47# X VPB sky130_fd_pr__pfet_01v8_hvt ad=0.265 pd=2.53 as=0.14 ps=1.28 w=1 l=0.15
X18 X a_110_47# VGND VNB sky130_fd_pr__nfet_01v8 ad=0.0588 pd=0.7 as=0.0588 ps=0.7 w=0.42 l=0.15
X19 X a_110_47# VGND VNB sky130_fd_pr__nfet_01v8 ad=0.0588 pd=0.7 as=0.0588 ps=0.7 w=0.42 l=0.15
.ends

.subckt sky130_fd_sc_hd__a211o_1 A1 A2 B1 C1 VGND VNB VPB VPWR X
X0 VPWR a_80_21# X VPB sky130_fd_pr__pfet_01v8_hvt ad=0.265 pd=2.53 as=0.265 ps=2.53 w=1 l=0.15
X1 a_80_21# C1 a_472_297# VPB sky130_fd_pr__pfet_01v8_hvt ad=0.265 pd=2.53 as=0.155 ps=1.31 w=1 l=0.15
X2 VPWR A2 a_217_297# VPB sky130_fd_pr__pfet_01v8_hvt ad=0.14 pd=1.28 as=0.265 ps=2.53 w=1 l=0.15
X3 VGND B1 a_80_21# VNB sky130_fd_pr__nfet_01v8 ad=0.10075 pd=0.96 as=0.091 ps=0.93 w=0.65 l=0.15
X4 VGND a_80_21# X VNB sky130_fd_pr__nfet_01v8 ad=0.26 pd=1.45 as=0.17225 ps=1.83 w=0.65 l=0.15
X5 a_300_47# A2 VGND VNB sky130_fd_pr__nfet_01v8 ad=0.091 pd=0.93 as=0.26 ps=1.45 w=0.65 l=0.15
X6 a_217_297# A1 VPWR VPB sky130_fd_pr__pfet_01v8_hvt ad=0.14 pd=1.28 as=0.14 ps=1.28 w=1 l=0.15
X7 a_80_21# A1 a_300_47# VNB sky130_fd_pr__nfet_01v8 ad=0.091 pd=0.93 as=0.091 ps=0.93 w=0.65 l=0.15
X8 a_472_297# B1 a_217_297# VPB sky130_fd_pr__pfet_01v8_hvt ad=0.155 pd=1.31 as=0.14 ps=1.28 w=1 l=0.15
X9 a_80_21# C1 VGND VNB sky130_fd_pr__nfet_01v8 ad=0.17225 pd=1.83 as=0.10075 ps=0.96 w=0.65 l=0.15
.ends

.subckt sky130_fd_sc_hd__clkbuf_4 A VGND VNB VPB VPWR X
X0 VPWR A a_27_47# VPB sky130_fd_pr__pfet_01v8_hvt ad=0.165 pd=1.33 as=0.265 ps=2.53 w=1 l=0.15
X1 VGND a_27_47# X VNB sky130_fd_pr__nfet_01v8 ad=0.1218 pd=1.42 as=0.0588 ps=0.7 w=0.42 l=0.15
X2 VGND a_27_47# X VNB sky130_fd_pr__nfet_01v8 ad=0.0588 pd=0.7 as=0.0588 ps=0.7 w=0.42 l=0.15
X3 X a_27_47# VPWR VPB sky130_fd_pr__pfet_01v8_hvt ad=0.14 pd=1.28 as=0.14 ps=1.28 w=1 l=0.15
X4 X a_27_47# VGND VNB sky130_fd_pr__nfet_01v8 ad=0.0588 pd=0.7 as=0.0588 ps=0.7 w=0.42 l=0.15
X5 VGND A a_27_47# VNB sky130_fd_pr__nfet_01v8 ad=0.07035 pd=0.755 as=0.1113 ps=1.37 w=0.42 l=0.15
X6 VPWR a_27_47# X VPB sky130_fd_pr__pfet_01v8_hvt ad=0.3 pd=2.6 as=0.14 ps=1.28 w=1 l=0.15
X7 X a_27_47# VGND VNB sky130_fd_pr__nfet_01v8 ad=0.0588 pd=0.7 as=0.07035 ps=0.755 w=0.42 l=0.15
X8 X a_27_47# VPWR VPB sky130_fd_pr__pfet_01v8_hvt ad=0.14 pd=1.28 as=0.165 ps=1.33 w=1 l=0.15
X9 VPWR a_27_47# X VPB sky130_fd_pr__pfet_01v8_hvt ad=0.14 pd=1.28 as=0.14 ps=1.28 w=1 l=0.15
.ends

.subckt sky130_fd_sc_hd__and4_1 A B C D VGND VNB VPB VPWR X
X0 a_27_47# C VPWR VPB sky130_fd_pr__pfet_01v8_hvt ad=0.0588 pd=0.7 as=0.0777 ps=0.79 w=0.42 l=0.15
X1 a_197_47# B a_109_47# VNB sky130_fd_pr__nfet_01v8 ad=0.0798 pd=0.8 as=0.0609 ps=0.71 w=0.42 l=0.15
X2 X a_27_47# VPWR VPB sky130_fd_pr__pfet_01v8_hvt ad=0.26 pd=2.52 as=0.31245 ps=1.68 w=1 l=0.15
X3 a_303_47# C a_197_47# VNB sky130_fd_pr__nfet_01v8 ad=0.0693 pd=0.75 as=0.0798 ps=0.8 w=0.42 l=0.15
X4 a_27_47# A VPWR VPB sky130_fd_pr__pfet_01v8_hvt ad=0.0735 pd=0.77 as=0.1092 ps=1.36 w=0.42 l=0.15
X5 VPWR D a_27_47# VPB sky130_fd_pr__pfet_01v8_hvt ad=0.31245 pd=1.68 as=0.0588 ps=0.7 w=0.42 l=0.15
X6 VGND D a_303_47# VNB sky130_fd_pr__nfet_01v8 ad=0.19627 pd=1.33 as=0.0693 ps=0.75 w=0.42 l=0.15
X7 VPWR B a_27_47# VPB sky130_fd_pr__pfet_01v8_hvt ad=0.0777 pd=0.79 as=0.0735 ps=0.77 w=0.42 l=0.15
X8 X a_27_47# VGND VNB sky130_fd_pr__nfet_01v8 ad=0.169 pd=1.82 as=0.19627 ps=1.33 w=0.65 l=0.15
X9 a_109_47# A a_27_47# VNB sky130_fd_pr__nfet_01v8 ad=0.0609 pd=0.71 as=0.1092 ps=1.36 w=0.42 l=0.15
.ends

.subckt sky130_fd_sc_hd__a21bo_1 A1 A2 B1_N VGND VNB VPB VPWR X
X0 a_298_297# a_27_413# a_215_297# VPB sky130_fd_pr__pfet_01v8_hvt ad=0.135 pd=1.27 as=0.265 ps=2.53 w=1 l=0.15
X1 a_215_297# a_27_413# VGND VNB sky130_fd_pr__nfet_01v8 ad=0.08775 pd=0.92 as=0.1359 ps=1.1 w=0.65 l=0.15
X2 a_298_297# A2 VPWR VPB sky130_fd_pr__pfet_01v8_hvt ad=0.265 pd=2.53 as=0.14 ps=1.28 w=1 l=0.15
X3 X a_215_297# VGND VNB sky130_fd_pr__nfet_01v8 ad=0.169 pd=1.82 as=0.25837 ps=1.445 w=0.65 l=0.15
X4 VPWR B1_N a_27_413# VPB sky130_fd_pr__pfet_01v8_hvt ad=0.1092 pd=1.36 as=0.1092 ps=1.36 w=0.42 l=0.15
X5 X a_215_297# VPWR VPB sky130_fd_pr__pfet_01v8_hvt ad=0.26 pd=2.52 as=0.26 ps=2.52 w=1 l=0.15
X6 a_382_47# A1 a_215_297# VNB sky130_fd_pr__nfet_01v8 ad=0.091 pd=0.93 as=0.08775 ps=0.92 w=0.65 l=0.15
X7 VGND B1_N a_27_413# VNB sky130_fd_pr__nfet_01v8 ad=0.1359 pd=1.1 as=0.1113 ps=1.37 w=0.42 l=0.15
X8 VPWR A1 a_298_297# VPB sky130_fd_pr__pfet_01v8_hvt ad=0.14 pd=1.28 as=0.135 ps=1.27 w=1 l=0.15
X9 VGND A2 a_382_47# VNB sky130_fd_pr__nfet_01v8 ad=0.25837 pd=1.445 as=0.091 ps=0.93 w=0.65 l=0.15
.ends

.subckt sky130_fd_sc_hd__bufinv_16 A VGND VNB VPB VPWR Y
X0 a_361_47# a_27_47# VGND VNB sky130_fd_pr__nfet_01v8 ad=0.08775 pd=0.92 as=0.08775 ps=0.92 w=0.65 l=0.15
X1 VPWR a_361_47# Y VPB sky130_fd_pr__pfet_01v8_hvt ad=0.135 pd=1.27 as=0.135 ps=1.27 w=1 l=0.15
X2 a_361_47# a_27_47# VGND VNB sky130_fd_pr__nfet_01v8 ad=0.08775 pd=0.92 as=0.08775 ps=0.92 w=0.65 l=0.15
X3 Y a_361_47# VGND VNB sky130_fd_pr__nfet_01v8 ad=0.08775 pd=0.92 as=0.08775 ps=0.92 w=0.65 l=0.15
X4 VPWR a_361_47# Y VPB sky130_fd_pr__pfet_01v8_hvt ad=0.135 pd=1.27 as=0.135 ps=1.27 w=1 l=0.15
X5 Y a_361_47# VGND VNB sky130_fd_pr__nfet_01v8 ad=0.08775 pd=0.92 as=0.08775 ps=0.92 w=0.65 l=0.15
X6 Y a_361_47# VPWR VPB sky130_fd_pr__pfet_01v8_hvt ad=0.135 pd=1.27 as=0.135 ps=1.27 w=1 l=0.15
X7 VPWR a_27_47# a_361_47# VPB sky130_fd_pr__pfet_01v8_hvt ad=0.135 pd=1.27 as=0.135 ps=1.27 w=1 l=0.15
X8 VPWR a_361_47# Y VPB sky130_fd_pr__pfet_01v8_hvt ad=0.26 pd=2.52 as=0.135 ps=1.27 w=1 l=0.15
X9 VPWR a_361_47# Y VPB sky130_fd_pr__pfet_01v8_hvt ad=0.135 pd=1.27 as=0.135 ps=1.27 w=1 l=0.15
X10 VGND a_361_47# Y VNB sky130_fd_pr__nfet_01v8 ad=0.169 pd=1.82 as=0.08775 ps=0.92 w=0.65 l=0.15
X11 a_361_47# a_27_47# VPWR VPB sky130_fd_pr__pfet_01v8_hvt ad=0.135 pd=1.27 as=0.135 ps=1.27 w=1 l=0.15
X12 VGND a_361_47# Y VNB sky130_fd_pr__nfet_01v8 ad=0.08775 pd=0.92 as=0.08775 ps=0.92 w=0.65 l=0.15
X13 VGND a_361_47# Y VNB sky130_fd_pr__nfet_01v8 ad=0.08775 pd=0.92 as=0.08775 ps=0.92 w=0.65 l=0.15
X14 VGND a_361_47# Y VNB sky130_fd_pr__nfet_01v8 ad=0.08775 pd=0.92 as=0.08775 ps=0.92 w=0.65 l=0.15
X15 VGND a_361_47# Y VNB sky130_fd_pr__nfet_01v8 ad=0.08775 pd=0.92 as=0.08775 ps=0.92 w=0.65 l=0.15
X16 VPWR A a_27_47# VPB sky130_fd_pr__pfet_01v8_hvt ad=0.135 pd=1.27 as=0.135 ps=1.27 w=1 l=0.15
X17 Y a_361_47# VPWR VPB sky130_fd_pr__pfet_01v8_hvt ad=0.135 pd=1.27 as=0.135 ps=1.27 w=1 l=0.15
X18 VGND a_361_47# Y VNB sky130_fd_pr__nfet_01v8 ad=0.08775 pd=0.92 as=0.08775 ps=0.92 w=0.65 l=0.15
X19 VPWR a_361_47# Y VPB sky130_fd_pr__pfet_01v8_hvt ad=0.135 pd=1.27 as=0.135 ps=1.27 w=1 l=0.15
X20 a_27_47# A VPWR VPB sky130_fd_pr__pfet_01v8_hvt ad=0.135 pd=1.27 as=0.135 ps=1.27 w=1 l=0.15
X21 Y a_361_47# VPWR VPB sky130_fd_pr__pfet_01v8_hvt ad=0.135 pd=1.27 as=0.135 ps=1.27 w=1 l=0.15
X22 a_27_47# A VGND VNB sky130_fd_pr__nfet_01v8 ad=0.08775 pd=0.92 as=0.08775 ps=0.92 w=0.65 l=0.15
X23 a_361_47# a_27_47# VGND VNB sky130_fd_pr__nfet_01v8 ad=0.08775 pd=0.92 as=0.08775 ps=0.92 w=0.65 l=0.15
X24 Y a_361_47# VPWR VPB sky130_fd_pr__pfet_01v8_hvt ad=0.135 pd=1.27 as=0.135 ps=1.27 w=1 l=0.15
X25 Y a_361_47# VGND VNB sky130_fd_pr__nfet_01v8 ad=0.08775 pd=0.92 as=0.08775 ps=0.92 w=0.65 l=0.15
X26 VPWR a_27_47# a_361_47# VPB sky130_fd_pr__pfet_01v8_hvt ad=0.135 pd=1.27 as=0.135 ps=1.27 w=1 l=0.15
X27 Y a_361_47# VGND VNB sky130_fd_pr__nfet_01v8 ad=0.08775 pd=0.92 as=0.08775 ps=0.92 w=0.65 l=0.15
X28 Y a_361_47# VPWR VPB sky130_fd_pr__pfet_01v8_hvt ad=0.135 pd=1.27 as=0.135 ps=1.27 w=1 l=0.15
X29 Y a_361_47# VGND VNB sky130_fd_pr__nfet_01v8 ad=0.08775 pd=0.92 as=0.08775 ps=0.92 w=0.65 l=0.15
X30 a_361_47# a_27_47# VPWR VPB sky130_fd_pr__pfet_01v8_hvt ad=0.135 pd=1.27 as=0.135 ps=1.27 w=1 l=0.15
X31 VPWR a_361_47# Y VPB sky130_fd_pr__pfet_01v8_hvt ad=0.135 pd=1.27 as=0.135 ps=1.27 w=1 l=0.15
X32 Y a_361_47# VGND VNB sky130_fd_pr__nfet_01v8 ad=0.08775 pd=0.92 as=0.08775 ps=0.92 w=0.65 l=0.15
X33 VGND A a_27_47# VNB sky130_fd_pr__nfet_01v8 ad=0.08775 pd=0.92 as=0.08775 ps=0.92 w=0.65 l=0.15
X34 VGND a_27_47# a_361_47# VNB sky130_fd_pr__nfet_01v8 ad=0.08775 pd=0.92 as=0.08775 ps=0.92 w=0.65 l=0.15
X35 VPWR a_27_47# a_361_47# VPB sky130_fd_pr__pfet_01v8_hvt ad=0.135 pd=1.27 as=0.135 ps=1.27 w=1 l=0.15
X36 Y a_361_47# VPWR VPB sky130_fd_pr__pfet_01v8_hvt ad=0.135 pd=1.27 as=0.135 ps=1.27 w=1 l=0.15
X37 VGND a_27_47# a_361_47# VNB sky130_fd_pr__nfet_01v8 ad=0.08775 pd=0.92 as=0.08775 ps=0.92 w=0.65 l=0.15
X38 VGND a_27_47# a_361_47# VNB sky130_fd_pr__nfet_01v8 ad=0.08775 pd=0.92 as=0.08775 ps=0.92 w=0.65 l=0.15
X39 a_361_47# a_27_47# VPWR VPB sky130_fd_pr__pfet_01v8_hvt ad=0.135 pd=1.27 as=0.135 ps=1.27 w=1 l=0.15
X40 VPWR a_361_47# Y VPB sky130_fd_pr__pfet_01v8_hvt ad=0.135 pd=1.27 as=0.135 ps=1.27 w=1 l=0.15
X41 VPWR a_361_47# Y VPB sky130_fd_pr__pfet_01v8_hvt ad=0.135 pd=1.27 as=0.135 ps=1.27 w=1 l=0.15
X42 VGND a_361_47# Y VNB sky130_fd_pr__nfet_01v8 ad=0.08775 pd=0.92 as=0.08775 ps=0.92 w=0.65 l=0.15
X43 VGND a_361_47# Y VNB sky130_fd_pr__nfet_01v8 ad=0.08775 pd=0.92 as=0.08775 ps=0.92 w=0.65 l=0.15
X44 VPWR A a_27_47# VPB sky130_fd_pr__pfet_01v8_hvt ad=0.135 pd=1.27 as=0.26 ps=2.52 w=1 l=0.15
X45 Y a_361_47# VPWR VPB sky130_fd_pr__pfet_01v8_hvt ad=0.135 pd=1.27 as=0.135 ps=1.27 w=1 l=0.15
X46 Y a_361_47# VGND VNB sky130_fd_pr__nfet_01v8 ad=0.08775 pd=0.92 as=0.08775 ps=0.92 w=0.65 l=0.15
X47 Y a_361_47# VPWR VPB sky130_fd_pr__pfet_01v8_hvt ad=0.135 pd=1.27 as=0.135 ps=1.27 w=1 l=0.15
X48 VGND A a_27_47# VNB sky130_fd_pr__nfet_01v8 ad=0.08775 pd=0.92 as=0.169 ps=1.82 w=0.65 l=0.15
X49 Y a_361_47# VGND VNB sky130_fd_pr__nfet_01v8 ad=0.08775 pd=0.92 as=0.08775 ps=0.92 w=0.65 l=0.15
C0 VPB VNB 2.19949f
.ends

.subckt sky130_fd_sc_hd__clkbuf_2 A VGND VNB VPB VPWR X
X0 VPWR A a_27_47# VPB sky130_fd_pr__pfet_01v8_hvt ad=0.1625 pd=1.325 as=0.265 ps=2.53 w=1 l=0.15
X1 VPWR a_27_47# X VPB sky130_fd_pr__pfet_01v8_hvt ad=0.26 pd=2.52 as=0.135 ps=1.27 w=1 l=0.15
X2 VGND A a_27_47# VNB sky130_fd_pr__nfet_01v8 ad=0.06825 pd=0.745 as=0.1113 ps=1.37 w=0.42 l=0.15
X3 X a_27_47# VPWR VPB sky130_fd_pr__pfet_01v8_hvt ad=0.135 pd=1.27 as=0.1625 ps=1.325 w=1 l=0.15
X4 X a_27_47# VGND VNB sky130_fd_pr__nfet_01v8 ad=0.0567 pd=0.69 as=0.06825 ps=0.745 w=0.42 l=0.15
X5 VGND a_27_47# X VNB sky130_fd_pr__nfet_01v8 ad=0.1092 pd=1.36 as=0.0567 ps=0.69 w=0.42 l=0.15
.ends

.subckt sky130_fd_sc_hd__nand2b_2 A_N B VGND VNB VPB VPWR Y
X0 Y B VPWR VPB sky130_fd_pr__pfet_01v8_hvt ad=0.135 pd=1.27 as=0.335 ps=1.67 w=1 l=0.15
X1 VGND A_N a_27_93# VNB sky130_fd_pr__nfet_01v8 ad=0.194 pd=1.95 as=0.1092 ps=1.36 w=0.42 l=0.15
X2 VGND B a_229_47# VNB sky130_fd_pr__nfet_01v8 ad=0.08775 pd=0.92 as=0.08775 ps=0.92 w=0.65 l=0.15
X3 Y a_27_93# a_229_47# VNB sky130_fd_pr__nfet_01v8 ad=0.08775 pd=0.92 as=0.169 ps=1.82 w=0.65 l=0.15
X4 a_229_47# a_27_93# Y VNB sky130_fd_pr__nfet_01v8 ad=0.08775 pd=0.92 as=0.08775 ps=0.92 w=0.65 l=0.15
X5 Y a_27_93# VPWR VPB sky130_fd_pr__pfet_01v8_hvt ad=0.165 pd=1.33 as=0.1468 ps=1.34 w=1 l=0.15
X6 VPWR a_27_93# Y VPB sky130_fd_pr__pfet_01v8_hvt ad=0.335 pd=1.67 as=0.165 ps=1.33 w=1 l=0.15
X7 VPWR B Y VPB sky130_fd_pr__pfet_01v8_hvt ad=0.275 pd=2.55 as=0.135 ps=1.27 w=1 l=0.15
X8 a_229_47# B VGND VNB sky130_fd_pr__nfet_01v8 ad=0.169 pd=1.82 as=0.08775 ps=0.92 w=0.65 l=0.15
X9 VPWR A_N a_27_93# VPB sky130_fd_pr__pfet_01v8_hvt ad=0.1468 pd=1.34 as=0.1092 ps=1.36 w=0.42 l=0.15
.ends

.subckt sky130_fd_sc_hd__xor2_1 A B VGND VNB VPB VPWR X
X0 X a_35_297# a_285_297# VPB sky130_fd_pr__pfet_01v8_hvt ad=0.3 pd=2.6 as=0.26 ps=2.52 w=1 l=0.15
X1 X B a_285_47# VNB sky130_fd_pr__nfet_01v8 ad=0.25025 pd=1.42 as=0.08775 ps=0.92 w=0.65 l=0.15
X2 a_35_297# B VGND VNB sky130_fd_pr__nfet_01v8 ad=0.08775 pd=0.92 as=0.169 ps=1.82 w=0.65 l=0.15
X3 a_117_297# B a_35_297# VPB sky130_fd_pr__pfet_01v8_hvt ad=0.135 pd=1.27 as=0.26 ps=2.52 w=1 l=0.15
X4 VPWR B a_285_297# VPB sky130_fd_pr__pfet_01v8_hvt ad=0.26 pd=2.52 as=0.135 ps=1.27 w=1 l=0.15
X5 VGND A a_35_297# VNB sky130_fd_pr__nfet_01v8 ad=0.08775 pd=0.92 as=0.08775 ps=0.92 w=0.65 l=0.15
X6 VGND a_35_297# X VNB sky130_fd_pr__nfet_01v8 ad=0.208 pd=1.94 as=0.25025 ps=1.42 w=0.65 l=0.15
X7 a_285_297# A VPWR VPB sky130_fd_pr__pfet_01v8_hvt ad=0.135 pd=1.27 as=0.135 ps=1.27 w=1 l=0.15
X8 VPWR A a_117_297# VPB sky130_fd_pr__pfet_01v8_hvt ad=0.135 pd=1.27 as=0.135 ps=1.27 w=1 l=0.15
X9 a_285_47# A VGND VNB sky130_fd_pr__nfet_01v8 ad=0.08775 pd=0.92 as=0.08775 ps=0.92 w=0.65 l=0.15
.ends

.subckt sky130_fd_sc_hd__inv_4 A VGND VNB VPB VPWR Y
X0 VPWR A Y VPB sky130_fd_pr__pfet_01v8_hvt ad=0.26 pd=2.52 as=0.135 ps=1.27 w=1 l=0.15
X1 Y A VPWR VPB sky130_fd_pr__pfet_01v8_hvt ad=0.135 pd=1.27 as=0.135 ps=1.27 w=1 l=0.15
X2 Y A VGND VNB sky130_fd_pr__nfet_01v8 ad=0.08775 pd=0.92 as=0.169 ps=1.82 w=0.65 l=0.15
X3 VPWR A Y VPB sky130_fd_pr__pfet_01v8_hvt ad=0.135 pd=1.27 as=0.135 ps=1.27 w=1 l=0.15
X4 VGND A Y VNB sky130_fd_pr__nfet_01v8 ad=0.08775 pd=0.92 as=0.08775 ps=0.92 w=0.65 l=0.15
X5 Y A VPWR VPB sky130_fd_pr__pfet_01v8_hvt ad=0.135 pd=1.27 as=0.26 ps=2.52 w=1 l=0.15
X6 VGND A Y VNB sky130_fd_pr__nfet_01v8 ad=0.169 pd=1.82 as=0.08775 ps=0.92 w=0.65 l=0.15
X7 Y A VGND VNB sky130_fd_pr__nfet_01v8 ad=0.08775 pd=0.92 as=0.08775 ps=0.92 w=0.65 l=0.15
.ends

.subckt sky130_fd_sc_hd__a32o_1 A1 A2 A3 B1 B2 VGND VNB VPB VPWR X
X0 a_93_21# A1 a_346_47# VNB sky130_fd_pr__nfet_01v8 ad=0.143 pd=1.09 as=0.14625 ps=1.1 w=0.65 l=0.15
X1 a_93_21# B1 a_250_297# VPB sky130_fd_pr__pfet_01v8_hvt ad=0.14 pd=1.28 as=0.185 ps=1.37 w=1 l=0.15
X2 a_584_47# B1 a_93_21# VNB sky130_fd_pr__nfet_01v8 ad=0.06825 pd=0.86 as=0.143 ps=1.09 w=0.65 l=0.15
X3 VPWR a_93_21# X VPB sky130_fd_pr__pfet_01v8_hvt ad=0.2425 pd=1.485 as=0.33 ps=2.66 w=1 l=0.15
X4 VGND B2 a_584_47# VNB sky130_fd_pr__nfet_01v8 ad=0.17225 pd=1.83 as=0.06825 ps=0.86 w=0.65 l=0.15
X5 a_256_47# A3 VGND VNB sky130_fd_pr__nfet_01v8 ad=0.0975 pd=0.95 as=0.16737 ps=1.165 w=0.65 l=0.15
X6 a_250_297# B2 a_93_21# VPB sky130_fd_pr__pfet_01v8_hvt ad=0.265 pd=2.53 as=0.14 ps=1.28 w=1 l=0.15
X7 VGND a_93_21# X VNB sky130_fd_pr__nfet_01v8 ad=0.16737 pd=1.165 as=0.2145 ps=1.96 w=0.65 l=0.15
X8 a_250_297# A3 VPWR VPB sky130_fd_pr__pfet_01v8_hvt ad=0.165 pd=1.33 as=0.2425 ps=1.485 w=1 l=0.15
X9 VPWR A2 a_250_297# VPB sky130_fd_pr__pfet_01v8_hvt ad=0.225 pd=1.45 as=0.165 ps=1.33 w=1 l=0.15
X10 a_250_297# A1 VPWR VPB sky130_fd_pr__pfet_01v8_hvt ad=0.185 pd=1.37 as=0.225 ps=1.45 w=1 l=0.15
X11 a_346_47# A2 a_256_47# VNB sky130_fd_pr__nfet_01v8 ad=0.14625 pd=1.1 as=0.0975 ps=0.95 w=0.65 l=0.15
.ends

.subckt sky130_fd_sc_hd__clkinv_1 A VGND VNB VPB VPWR Y
X0 Y A VPWR VPB sky130_fd_pr__pfet_01v8_hvt ad=0.1134 pd=1.11 as=0.2184 ps=2.2 w=0.84 l=0.15
X1 VGND A Y VNB sky130_fd_pr__nfet_01v8 ad=0.1197 pd=1.41 as=0.1092 ps=1.36 w=0.42 l=0.15
X2 VPWR A Y VPB sky130_fd_pr__pfet_01v8_hvt ad=0.2352 pd=2.24 as=0.1134 ps=1.11 w=0.84 l=0.15
.ends

.subckt sky130_fd_sc_hd__clkbuf_16 A VGND VNB VPB VPWR X
X0 VPWR A a_110_47# VPB sky130_fd_pr__pfet_01v8_hvt ad=0.14 pd=1.28 as=0.14 ps=1.28 w=1 l=0.15
X1 VPWR a_110_47# X VPB sky130_fd_pr__pfet_01v8_hvt ad=0.14 pd=1.28 as=0.14 ps=1.28 w=1 l=0.15
X2 X a_110_47# VPWR VPB sky130_fd_pr__pfet_01v8_hvt ad=0.14 pd=1.28 as=0.14 ps=1.28 w=1 l=0.15
X3 X a_110_47# VPWR VPB sky130_fd_pr__pfet_01v8_hvt ad=0.14 pd=1.28 as=0.14 ps=1.28 w=1 l=0.15
X4 VPWR a_110_47# X VPB sky130_fd_pr__pfet_01v8_hvt ad=0.14 pd=1.28 as=0.14 ps=1.28 w=1 l=0.15
X5 VPWR a_110_47# X VPB sky130_fd_pr__pfet_01v8_hvt ad=0.265 pd=2.53 as=0.14 ps=1.28 w=1 l=0.15
X6 a_110_47# A VPWR VPB sky130_fd_pr__pfet_01v8_hvt ad=0.14 pd=1.28 as=0.265 ps=2.53 w=1 l=0.15
X7 a_110_47# A VGND VNB sky130_fd_pr__nfet_01v8 ad=0.0588 pd=0.7 as=0.0588 ps=0.7 w=0.42 l=0.15
X8 VGND a_110_47# X VNB sky130_fd_pr__nfet_01v8 ad=0.0588 pd=0.7 as=0.0588 ps=0.7 w=0.42 l=0.15
X9 X a_110_47# VGND VNB sky130_fd_pr__nfet_01v8 ad=0.0588 pd=0.7 as=0.0588 ps=0.7 w=0.42 l=0.15
X10 VGND a_110_47# X VNB sky130_fd_pr__nfet_01v8 ad=0.0588 pd=0.7 as=0.0588 ps=0.7 w=0.42 l=0.15
X11 a_110_47# A VPWR VPB sky130_fd_pr__pfet_01v8_hvt ad=0.14 pd=1.28 as=0.14 ps=1.28 w=1 l=0.15
X12 VGND A a_110_47# VNB sky130_fd_pr__nfet_01v8 ad=0.0588 pd=0.7 as=0.0588 ps=0.7 w=0.42 l=0.15
X13 VGND a_110_47# X VNB sky130_fd_pr__nfet_01v8 ad=0.05775 pd=0.695 as=0.0588 ps=0.7 w=0.42 l=0.15
X14 VPWR a_110_47# X VPB sky130_fd_pr__pfet_01v8_hvt ad=0.14 pd=1.28 as=0.14 ps=1.28 w=1 l=0.15
X15 X a_110_47# VPWR VPB sky130_fd_pr__pfet_01v8_hvt ad=0.14 pd=1.28 as=0.14 ps=1.28 w=1 l=0.15
X16 VGND A a_110_47# VNB sky130_fd_pr__nfet_01v8 ad=0.0588 pd=0.7 as=0.0588 ps=0.7 w=0.42 l=0.15
X17 VGND a_110_47# X VNB sky130_fd_pr__nfet_01v8 ad=0.1113 pd=1.37 as=0.0588 ps=0.7 w=0.42 l=0.15
X18 VPWR a_110_47# X VPB sky130_fd_pr__pfet_01v8_hvt ad=0.1375 pd=1.275 as=0.14 ps=1.28 w=1 l=0.15
X19 VGND a_110_47# X VNB sky130_fd_pr__nfet_01v8 ad=0.0588 pd=0.7 as=0.0588 ps=0.7 w=0.42 l=0.15
X20 X a_110_47# VPWR VPB sky130_fd_pr__pfet_01v8_hvt ad=0.14 pd=1.28 as=0.1375 ps=1.275 w=1 l=0.15
X21 a_110_47# A VGND VNB sky130_fd_pr__nfet_01v8 ad=0.0588 pd=0.7 as=0.1113 ps=1.37 w=0.42 l=0.15
X22 VPWR A a_110_47# VPB sky130_fd_pr__pfet_01v8_hvt ad=0.14 pd=1.28 as=0.14 ps=1.28 w=1 l=0.15
X23 VPWR a_110_47# X VPB sky130_fd_pr__pfet_01v8_hvt ad=0.14 pd=1.28 as=0.14 ps=1.28 w=1 l=0.15
X24 VPWR a_110_47# X VPB sky130_fd_pr__pfet_01v8_hvt ad=0.14 pd=1.28 as=0.14 ps=1.28 w=1 l=0.15
X25 VGND a_110_47# X VNB sky130_fd_pr__nfet_01v8 ad=0.0588 pd=0.7 as=0.0588 ps=0.7 w=0.42 l=0.15
X26 X a_110_47# VPWR VPB sky130_fd_pr__pfet_01v8_hvt ad=0.14 pd=1.28 as=0.14 ps=1.28 w=1 l=0.15
X27 VGND a_110_47# X VNB sky130_fd_pr__nfet_01v8 ad=0.0588 pd=0.7 as=0.0588 ps=0.7 w=0.42 l=0.15
X28 VGND a_110_47# X VNB sky130_fd_pr__nfet_01v8 ad=0.0588 pd=0.7 as=0.0588 ps=0.7 w=0.42 l=0.15
X29 X a_110_47# VGND VNB sky130_fd_pr__nfet_01v8 ad=0.0588 pd=0.7 as=0.0588 ps=0.7 w=0.42 l=0.15
X30 X a_110_47# VPWR VPB sky130_fd_pr__pfet_01v8_hvt ad=0.14 pd=1.28 as=0.14 ps=1.28 w=1 l=0.15
X31 X a_110_47# VPWR VPB sky130_fd_pr__pfet_01v8_hvt ad=0.14 pd=1.28 as=0.14 ps=1.28 w=1 l=0.15
X32 X a_110_47# VGND VNB sky130_fd_pr__nfet_01v8 ad=0.0588 pd=0.7 as=0.0588 ps=0.7 w=0.42 l=0.15
X33 VPWR a_110_47# X VPB sky130_fd_pr__pfet_01v8_hvt ad=0.14 pd=1.28 as=0.14 ps=1.28 w=1 l=0.15
X34 X a_110_47# VPWR VPB sky130_fd_pr__pfet_01v8_hvt ad=0.14 pd=1.28 as=0.14 ps=1.28 w=1 l=0.15
X35 X a_110_47# VGND VNB sky130_fd_pr__nfet_01v8 ad=0.0588 pd=0.7 as=0.0588 ps=0.7 w=0.42 l=0.15
X36 X a_110_47# VGND VNB sky130_fd_pr__nfet_01v8 ad=0.0588 pd=0.7 as=0.0588 ps=0.7 w=0.42 l=0.15
X37 X a_110_47# VGND VNB sky130_fd_pr__nfet_01v8 ad=0.0588 pd=0.7 as=0.0588 ps=0.7 w=0.42 l=0.15
X38 X a_110_47# VGND VNB sky130_fd_pr__nfet_01v8 ad=0.0588 pd=0.7 as=0.0588 ps=0.7 w=0.42 l=0.15
X39 X a_110_47# VGND VNB sky130_fd_pr__nfet_01v8 ad=0.0588 pd=0.7 as=0.05775 ps=0.695 w=0.42 l=0.15
.ends

.subckt sky130_fd_sc_hd__o2111a_1 A1 A2 B1 C1 D1 VGND VNB VPB VPWR X
X0 a_676_297# A2 a_79_21# VPB sky130_fd_pr__pfet_01v8_hvt ad=0.105 pd=1.21 as=0.2125 ps=1.425 w=1 l=0.15
X1 a_512_47# B1 a_409_47# VNB sky130_fd_pr__nfet_01v8 ad=0.19825 pd=1.26 as=0.11863 ps=1.015 w=0.65 l=0.15
X2 a_306_47# D1 a_79_21# VNB sky130_fd_pr__nfet_01v8 ad=0.11863 pd=1.015 as=0.19825 ps=1.91 w=0.65 l=0.15
X3 VGND A2 a_512_47# VNB sky130_fd_pr__nfet_01v8 ad=0.08775 pd=0.92 as=0.19825 ps=1.26 w=0.65 l=0.15
X4 VPWR C1 a_79_21# VPB sky130_fd_pr__pfet_01v8_hvt ad=0.305 pd=1.61 as=0.2175 ps=1.435 w=1 l=0.15
X5 a_79_21# B1 VPWR VPB sky130_fd_pr__pfet_01v8_hvt ad=0.2125 pd=1.425 as=0.305 ps=1.61 w=1 l=0.15
X6 VPWR A1 a_676_297# VPB sky130_fd_pr__pfet_01v8_hvt ad=0.265 pd=2.53 as=0.105 ps=1.21 w=1 l=0.15
X7 a_512_47# A1 VGND VNB sky130_fd_pr__nfet_01v8 ad=0.17225 pd=1.83 as=0.08775 ps=0.92 w=0.65 l=0.15
X8 a_409_47# C1 a_306_47# VNB sky130_fd_pr__nfet_01v8 ad=0.11863 pd=1.015 as=0.11863 ps=1.015 w=0.65 l=0.15
X9 VPWR a_79_21# X VPB sky130_fd_pr__pfet_01v8_hvt ad=0.3825 pd=1.765 as=0.26 ps=2.52 w=1 l=0.15
X10 a_79_21# D1 VPWR VPB sky130_fd_pr__pfet_01v8_hvt ad=0.2175 pd=1.435 as=0.3825 ps=1.765 w=1 l=0.15
X11 VGND a_79_21# X VNB sky130_fd_pr__nfet_01v8 ad=0.169 pd=1.82 as=0.169 ps=1.82 w=0.65 l=0.15
.ends

.subckt sky130_fd_sc_hd__inv_6 A VGND VNB VPB VPWR Y
X0 VPWR A Y VPB sky130_fd_pr__pfet_01v8_hvt ad=0.27 pd=2.54 as=0.135 ps=1.27 w=1 l=0.15
X1 Y A VPWR VPB sky130_fd_pr__pfet_01v8_hvt ad=0.135 pd=1.27 as=0.135 ps=1.27 w=1 l=0.15
X2 Y A VGND VNB sky130_fd_pr__nfet_01v8 ad=0.08775 pd=0.92 as=0.08775 ps=0.92 w=0.65 l=0.15
X3 VPWR A Y VPB sky130_fd_pr__pfet_01v8_hvt ad=0.135 pd=1.27 as=0.135 ps=1.27 w=1 l=0.15
X4 Y A VPWR VPB sky130_fd_pr__pfet_01v8_hvt ad=0.135 pd=1.27 as=0.135 ps=1.27 w=1 l=0.15
X5 VPWR A Y VPB sky130_fd_pr__pfet_01v8_hvt ad=0.135 pd=1.27 as=0.135 ps=1.27 w=1 l=0.15
X6 Y A VGND VNB sky130_fd_pr__nfet_01v8 ad=0.08775 pd=0.92 as=0.247 ps=2.06 w=0.65 l=0.15
X7 Y A VGND VNB sky130_fd_pr__nfet_01v8 ad=0.08775 pd=0.92 as=0.08775 ps=0.92 w=0.65 l=0.15
X8 Y A VPWR VPB sky130_fd_pr__pfet_01v8_hvt ad=0.135 pd=1.27 as=0.43 ps=2.86 w=1 l=0.15
X9 VGND A Y VNB sky130_fd_pr__nfet_01v8 ad=0.08775 pd=0.92 as=0.08775 ps=0.92 w=0.65 l=0.15
X10 VGND A Y VNB sky130_fd_pr__nfet_01v8 ad=0.08775 pd=0.92 as=0.08775 ps=0.92 w=0.65 l=0.15
X11 VGND A Y VNB sky130_fd_pr__nfet_01v8 ad=0.1755 pd=1.84 as=0.08775 ps=0.92 w=0.65 l=0.15
.ends

.subckt sky130_fd_sc_hd__clkinvlp_4 A VGND VNB VPB VPWR Y
X0 Y A VPWR VPB sky130_fd_pr__pfet_01v8_hvt ad=0.14 pd=1.28 as=0.265 ps=2.53 w=1 l=0.25
X1 VGND A a_268_47# VNB sky130_fd_pr__nfet_01v8 ad=0.14575 pd=1.63 as=0.05775 ps=0.76 w=0.55 l=0.15
X2 Y A VPWR VPB sky130_fd_pr__pfet_01v8_hvt ad=0.14 pd=1.28 as=0.14 ps=1.28 w=1 l=0.25
X3 Y A a_110_47# VNB sky130_fd_pr__nfet_01v8 ad=0.077 pd=0.83 as=0.05775 ps=0.76 w=0.55 l=0.15
X4 VPWR A Y VPB sky130_fd_pr__pfet_01v8_hvt ad=0.14 pd=1.28 as=0.14 ps=1.28 w=1 l=0.25
X5 a_110_47# A VGND VNB sky130_fd_pr__nfet_01v8 ad=0.05775 pd=0.76 as=0.14575 ps=1.63 w=0.55 l=0.15
X6 a_268_47# A Y VNB sky130_fd_pr__nfet_01v8 ad=0.05775 pd=0.76 as=0.077 ps=0.83 w=0.55 l=0.15
X7 VPWR A Y VPB sky130_fd_pr__pfet_01v8_hvt ad=0.265 pd=2.53 as=0.14 ps=1.28 w=1 l=0.25
.ends

.subckt sky130_fd_sc_hd__clkinv_8 A VGND VNB VPB VPWR Y
X0 Y A VGND VNB sky130_fd_pr__nfet_01v8 ad=0.0588 pd=0.7 as=0.1113 ps=1.37 w=0.42 l=0.15
X1 VPWR A Y VPB sky130_fd_pr__pfet_01v8_hvt ad=0.135 pd=1.27 as=0.135 ps=1.27 w=1 l=0.15
X2 Y A VGND VNB sky130_fd_pr__nfet_01v8 ad=0.0588 pd=0.7 as=0.0588 ps=0.7 w=0.42 l=0.15
X3 Y A VGND VNB sky130_fd_pr__nfet_01v8 ad=0.0588 pd=0.7 as=0.0588 ps=0.7 w=0.42 l=0.15
X4 Y A VPWR VPB sky130_fd_pr__pfet_01v8_hvt ad=0.135 pd=1.27 as=0.135 ps=1.27 w=1 l=0.15
X5 VPWR A Y VPB sky130_fd_pr__pfet_01v8_hvt ad=0.1375 pd=1.275 as=0.135 ps=1.27 w=1 l=0.15
X6 VPWR A Y VPB sky130_fd_pr__pfet_01v8_hvt ad=0.135 pd=1.27 as=0.135 ps=1.27 w=1 l=0.15
X7 Y A VGND VNB sky130_fd_pr__nfet_01v8 ad=0.0588 pd=0.7 as=0.0588 ps=0.7 w=0.42 l=0.15
X8 Y A VPWR VPB sky130_fd_pr__pfet_01v8_hvt ad=0.135 pd=1.27 as=0.135 ps=1.27 w=1 l=0.15
X9 VGND A Y VNB sky130_fd_pr__nfet_01v8 ad=0.0588 pd=0.7 as=0.0588 ps=0.7 w=0.42 l=0.15
X10 Y A VPWR VPB sky130_fd_pr__pfet_01v8_hvt ad=0.135 pd=1.27 as=0.1375 ps=1.275 w=1 l=0.15
X11 VPWR A Y VPB sky130_fd_pr__pfet_01v8_hvt ad=0.26 pd=2.52 as=0.135 ps=1.27 w=1 l=0.15
X12 VGND A Y VNB sky130_fd_pr__nfet_01v8 ad=0.0588 pd=0.7 as=0.0588 ps=0.7 w=0.42 l=0.15
X13 VPWR A Y VPB sky130_fd_pr__pfet_01v8_hvt ad=0.135 pd=1.27 as=0.135 ps=1.27 w=1 l=0.15
X14 Y A VPWR VPB sky130_fd_pr__pfet_01v8_hvt ad=0.135 pd=1.27 as=0.135 ps=1.27 w=1 l=0.15
X15 VGND A Y VNB sky130_fd_pr__nfet_01v8 ad=0.0588 pd=0.7 as=0.0588 ps=0.7 w=0.42 l=0.15
X16 VPWR A Y VPB sky130_fd_pr__pfet_01v8_hvt ad=0.135 pd=1.27 as=0.135 ps=1.27 w=1 l=0.15
X17 Y A VPWR VPB sky130_fd_pr__pfet_01v8_hvt ad=0.135 pd=1.27 as=0.135 ps=1.27 w=1 l=0.15
X18 Y A VPWR VPB sky130_fd_pr__pfet_01v8_hvt ad=0.135 pd=1.27 as=0.26 ps=2.52 w=1 l=0.15
X19 VGND A Y VNB sky130_fd_pr__nfet_01v8 ad=0.1113 pd=1.37 as=0.0588 ps=0.7 w=0.42 l=0.15
.ends

.subckt sky130_fd_sc_hd__clkinv_2 A VGND VNB VPB VPWR Y
X0 Y A VGND VNB sky130_fd_pr__nfet_01v8 ad=0.0588 pd=0.7 as=0.1113 ps=1.37 w=0.42 l=0.15
X1 Y A VPWR VPB sky130_fd_pr__pfet_01v8_hvt ad=0.14 pd=1.28 as=0.14 ps=1.28 w=1 l=0.15
X2 VPWR A Y VPB sky130_fd_pr__pfet_01v8_hvt ad=0.14 pd=1.28 as=0.265 ps=2.53 w=1 l=0.15
X3 VGND A Y VNB sky130_fd_pr__nfet_01v8 ad=0.1092 pd=1.36 as=0.0588 ps=0.7 w=0.42 l=0.15
X4 VPWR A Y VPB sky130_fd_pr__pfet_01v8_hvt ad=0.265 pd=2.53 as=0.14 ps=1.28 w=1 l=0.15
.ends

.subckt sky130_fd_sc_hd__nand2b_4 A_N B VGND VNB VPB VPWR Y
X0 VGND B a_215_47# VNB sky130_fd_pr__nfet_01v8 ad=0.08775 pd=0.92 as=0.09262 ps=0.935 w=0.65 l=0.15
X1 Y B VPWR VPB sky130_fd_pr__pfet_01v8_hvt ad=0.135 pd=1.27 as=0.1425 ps=1.285 w=1 l=0.15
X2 Y a_27_47# a_215_47# VNB sky130_fd_pr__nfet_01v8 ad=0.08775 pd=0.92 as=0.169 ps=1.82 w=0.65 l=0.15
X3 VGND B a_215_47# VNB sky130_fd_pr__nfet_01v8 ad=0.08775 pd=0.92 as=0.08775 ps=0.92 w=0.65 l=0.15
X4 Y a_27_47# a_215_47# VNB sky130_fd_pr__nfet_01v8 ad=0.08775 pd=0.92 as=0.08775 ps=0.92 w=0.65 l=0.15
X5 a_215_47# a_27_47# Y VNB sky130_fd_pr__nfet_01v8 ad=0.09262 pd=0.935 as=0.08775 ps=0.92 w=0.65 l=0.15
X6 a_215_47# B VGND VNB sky130_fd_pr__nfet_01v8 ad=0.2535 pd=2.08 as=0.08775 ps=0.92 w=0.65 l=0.15
X7 VPWR B Y VPB sky130_fd_pr__pfet_01v8_hvt ad=0.39 pd=2.78 as=0.135 ps=1.27 w=1 l=0.15
X8 VPWR a_27_47# Y VPB sky130_fd_pr__pfet_01v8_hvt ad=0.1425 pd=1.285 as=0.135 ps=1.27 w=1 l=0.15
X9 Y B VPWR VPB sky130_fd_pr__pfet_01v8_hvt ad=0.135 pd=1.27 as=0.135 ps=1.27 w=1 l=0.15
X10 VPWR B Y VPB sky130_fd_pr__pfet_01v8_hvt ad=0.135 pd=1.27 as=0.135 ps=1.27 w=1 l=0.15
X11 Y a_27_47# VPWR VPB sky130_fd_pr__pfet_01v8_hvt ad=0.135 pd=1.27 as=0.135 ps=1.27 w=1 l=0.15
X12 VPWR a_27_47# Y VPB sky130_fd_pr__pfet_01v8_hvt ad=0.135 pd=1.27 as=0.135 ps=1.27 w=1 l=0.15
X13 a_215_47# B VGND VNB sky130_fd_pr__nfet_01v8 ad=0.08775 pd=0.92 as=0.08775 ps=0.92 w=0.65 l=0.15
X14 a_215_47# a_27_47# Y VNB sky130_fd_pr__nfet_01v8 ad=0.08775 pd=0.92 as=0.08775 ps=0.92 w=0.65 l=0.15
X15 Y a_27_47# VPWR VPB sky130_fd_pr__pfet_01v8_hvt ad=0.135 pd=1.27 as=0.26 ps=2.52 w=1 l=0.15
X16 VPWR A_N a_27_47# VPB sky130_fd_pr__pfet_01v8_hvt ad=0.26 pd=2.52 as=0.26 ps=2.52 w=1 l=0.15
X17 VGND A_N a_27_47# VNB sky130_fd_pr__nfet_01v8 ad=0.169 pd=1.82 as=0.169 ps=1.82 w=0.65 l=0.15
.ends

.subckt sky130_fd_sc_hd__nand3_1 A B C VGND VNB VPB VPWR Y
X0 VPWR B Y VPB sky130_fd_pr__pfet_01v8_hvt ad=0.165 pd=1.33 as=0.135 ps=1.27 w=1 l=0.15
X1 Y A VPWR VPB sky130_fd_pr__pfet_01v8_hvt ad=0.26 pd=2.52 as=0.165 ps=1.33 w=1 l=0.15
X2 a_193_47# B a_109_47# VNB sky130_fd_pr__nfet_01v8 ad=0.10725 pd=0.98 as=0.08775 ps=0.92 w=0.65 l=0.15
X3 Y A a_193_47# VNB sky130_fd_pr__nfet_01v8 ad=0.169 pd=1.82 as=0.10725 ps=0.98 w=0.65 l=0.15
X4 Y C VPWR VPB sky130_fd_pr__pfet_01v8_hvt ad=0.135 pd=1.27 as=0.26 ps=2.52 w=1 l=0.15
X5 a_109_47# C VGND VNB sky130_fd_pr__nfet_01v8 ad=0.08775 pd=0.92 as=0.169 ps=1.82 w=0.65 l=0.15
.ends

.subckt sky130_fd_sc_hd__buf_1 A VGND VNB VPB VPWR X
X0 VPWR A a_27_47# VPB sky130_fd_pr__pfet_01v8_hvt ad=0.11455 pd=1.08 as=0.2054 ps=2.1 w=0.79 l=0.15
X1 X a_27_47# VGND VNB sky130_fd_pr__nfet_01v8 ad=0.1352 pd=1.56 as=0.0754 ps=0.81 w=0.52 l=0.15
X2 X a_27_47# VPWR VPB sky130_fd_pr__pfet_01v8_hvt ad=0.2054 pd=2.1 as=0.11455 ps=1.08 w=0.79 l=0.15
X3 VGND A a_27_47# VNB sky130_fd_pr__nfet_01v8 ad=0.0754 pd=0.81 as=0.1352 ps=1.56 w=0.52 l=0.15
.ends

.subckt sky130_fd_sc_hd__clkinv_4 A VGND VNB VPB VPWR Y
X0 Y A VPWR VPB sky130_fd_pr__pfet_01v8_hvt ad=0.14 pd=1.28 as=0.14 ps=1.28 w=1 l=0.15
X1 VGND A Y VNB sky130_fd_pr__nfet_01v8 ad=0.1659 pd=1.63 as=0.0588 ps=0.7 w=0.42 l=0.15
X2 VGND A Y VNB sky130_fd_pr__nfet_01v8 ad=0.0588 pd=0.7 as=0.0588 ps=0.7 w=0.42 l=0.15
X3 VPWR A Y VPB sky130_fd_pr__pfet_01v8_hvt ad=0.14 pd=1.28 as=0.14 ps=1.28 w=1 l=0.15
X4 VPWR A Y VPB sky130_fd_pr__pfet_01v8_hvt ad=0.345 pd=2.69 as=0.14 ps=1.28 w=1 l=0.15
X5 Y A VGND VNB sky130_fd_pr__nfet_01v8 ad=0.0588 pd=0.7 as=0.0588 ps=0.7 w=0.42 l=0.15
X6 Y A VPWR VPB sky130_fd_pr__pfet_01v8_hvt ad=0.14 pd=1.28 as=0.305 ps=2.61 w=1 l=0.15
X7 Y A VGND VNB sky130_fd_pr__nfet_01v8 ad=0.0588 pd=0.7 as=0.1386 ps=1.5 w=0.42 l=0.15
X8 Y A VPWR VPB sky130_fd_pr__pfet_01v8_hvt ad=0.14 pd=1.28 as=0.14 ps=1.28 w=1 l=0.15
X9 VPWR A Y VPB sky130_fd_pr__pfet_01v8_hvt ad=0.14 pd=1.28 as=0.14 ps=1.28 w=1 l=0.15
.ends

.subckt sky130_fd_sc_hd__a31o_1 A1 A2 A3 B1 VGND VNB VPB VPWR X
X0 VPWR a_80_21# X VPB sky130_fd_pr__pfet_01v8_hvt ad=0.1725 pd=1.345 as=0.265 ps=2.53 w=1 l=0.15
X1 a_209_297# A3 VPWR VPB sky130_fd_pr__pfet_01v8_hvt ad=0.16 pd=1.32 as=0.1725 ps=1.345 w=1 l=0.15
X2 a_303_47# A2 a_209_47# VNB sky130_fd_pr__nfet_01v8 ad=0.10725 pd=0.98 as=0.104 ps=0.97 w=0.65 l=0.15
X3 a_209_47# A3 VGND VNB sky130_fd_pr__nfet_01v8 ad=0.104 pd=0.97 as=0.11213 ps=0.995 w=0.65 l=0.15
X4 VGND a_80_21# X VNB sky130_fd_pr__nfet_01v8 ad=0.11213 pd=0.995 as=0.17225 ps=1.83 w=0.65 l=0.15
X5 VGND B1 a_80_21# VNB sky130_fd_pr__nfet_01v8 ad=0.208 pd=1.94 as=0.10725 ps=0.98 w=0.65 l=0.15
X6 a_80_21# A1 a_303_47# VNB sky130_fd_pr__nfet_01v8 ad=0.10725 pd=0.98 as=0.10725 ps=0.98 w=0.65 l=0.15
X7 VPWR A2 a_209_297# VPB sky130_fd_pr__pfet_01v8_hvt ad=0.165 pd=1.33 as=0.16 ps=1.32 w=1 l=0.15
X8 a_80_21# B1 a_209_297# VPB sky130_fd_pr__pfet_01v8_hvt ad=0.32 pd=2.64 as=0.165 ps=1.33 w=1 l=0.15
X9 a_209_297# A1 VPWR VPB sky130_fd_pr__pfet_01v8_hvt ad=0.165 pd=1.33 as=0.165 ps=1.33 w=1 l=0.15
.ends

.subckt sky130_fd_sc_hd__or2_2 A B VGND VNB VPB VPWR X
X0 a_121_297# B a_39_297# VPB sky130_fd_pr__pfet_01v8_hvt ad=0.0441 pd=0.63 as=0.1092 ps=1.36 w=0.42 l=0.15
X1 X a_39_297# VGND VNB sky130_fd_pr__nfet_01v8 ad=0.08775 pd=0.92 as=0.10675 ps=1.005 w=0.65 l=0.15
X2 VPWR a_39_297# X VPB sky130_fd_pr__pfet_01v8_hvt ad=0.26 pd=2.52 as=0.135 ps=1.27 w=1 l=0.15
X3 X a_39_297# VPWR VPB sky130_fd_pr__pfet_01v8_hvt ad=0.135 pd=1.27 as=0.15575 ps=1.355 w=1 l=0.15
X4 VGND a_39_297# X VNB sky130_fd_pr__nfet_01v8 ad=0.169 pd=1.82 as=0.08775 ps=0.92 w=0.65 l=0.15
X5 VPWR A a_121_297# VPB sky130_fd_pr__pfet_01v8_hvt ad=0.15575 pd=1.355 as=0.0441 ps=0.63 w=0.42 l=0.15
X6 VGND A a_39_297# VNB sky130_fd_pr__nfet_01v8 ad=0.10675 pd=1.005 as=0.0567 ps=0.69 w=0.42 l=0.15
X7 a_39_297# B VGND VNB sky130_fd_pr__nfet_01v8 ad=0.0567 pd=0.69 as=0.1092 ps=1.36 w=0.42 l=0.15
.ends

.subckt sky130_fd_sc_hd__inv_8 A VGND VNB VPB VPWR Y
X0 VPWR A Y VPB sky130_fd_pr__pfet_01v8_hvt ad=0.135 pd=1.27 as=0.135 ps=1.27 w=1 l=0.15
X1 Y A VPWR VPB sky130_fd_pr__pfet_01v8_hvt ad=0.135 pd=1.27 as=0.135 ps=1.27 w=1 l=0.15
X2 Y A VGND VNB sky130_fd_pr__nfet_01v8 ad=0.08775 pd=0.92 as=0.08775 ps=0.92 w=0.65 l=0.15
X3 Y A VGND VNB sky130_fd_pr__nfet_01v8 ad=0.08775 pd=0.92 as=0.08775 ps=0.92 w=0.65 l=0.15
X4 VPWR A Y VPB sky130_fd_pr__pfet_01v8_hvt ad=0.135 pd=1.27 as=0.135 ps=1.27 w=1 l=0.15
X5 Y A VPWR VPB sky130_fd_pr__pfet_01v8_hvt ad=0.135 pd=1.27 as=0.26 ps=2.52 w=1 l=0.15
X6 Y A VGND VNB sky130_fd_pr__nfet_01v8 ad=0.08775 pd=0.92 as=0.169 ps=1.82 w=0.65 l=0.15
X7 VPWR A Y VPB sky130_fd_pr__pfet_01v8_hvt ad=0.26 pd=2.52 as=0.135 ps=1.27 w=1 l=0.15
X8 Y A VGND VNB sky130_fd_pr__nfet_01v8 ad=0.08775 pd=0.92 as=0.08775 ps=0.92 w=0.65 l=0.15
X9 Y A VPWR VPB sky130_fd_pr__pfet_01v8_hvt ad=0.135 pd=1.27 as=0.135 ps=1.27 w=1 l=0.15
X10 VPWR A Y VPB sky130_fd_pr__pfet_01v8_hvt ad=0.135 pd=1.27 as=0.135 ps=1.27 w=1 l=0.15
X11 VGND A Y VNB sky130_fd_pr__nfet_01v8 ad=0.08775 pd=0.92 as=0.08775 ps=0.92 w=0.65 l=0.15
X12 VGND A Y VNB sky130_fd_pr__nfet_01v8 ad=0.08775 pd=0.92 as=0.08775 ps=0.92 w=0.65 l=0.15
X13 VGND A Y VNB sky130_fd_pr__nfet_01v8 ad=0.08775 pd=0.92 as=0.08775 ps=0.92 w=0.65 l=0.15
X14 Y A VPWR VPB sky130_fd_pr__pfet_01v8_hvt ad=0.135 pd=1.27 as=0.135 ps=1.27 w=1 l=0.15
X15 VGND A Y VNB sky130_fd_pr__nfet_01v8 ad=0.169 pd=1.82 as=0.08775 ps=0.92 w=0.65 l=0.15
.ends

.subckt sky130_fd_sc_hd__o21ba_1 A1 A2 B1_N VGND VNB VPB VPWR X
X0 a_222_93# B1_N VGND VNB sky130_fd_pr__nfet_01v8 ad=0.1092 pd=1.36 as=0.10025 ps=0.985 w=0.42 l=0.15
X1 VPWR A1 a_544_297# VPB sky130_fd_pr__pfet_01v8_hvt ad=0.28 pd=2.56 as=0.105 ps=1.21 w=1 l=0.15
X2 VGND a_79_199# X VNB sky130_fd_pr__nfet_01v8 ad=0.10025 pd=0.985 as=0.169 ps=1.82 w=0.65 l=0.15
X3 a_222_93# B1_N VPWR VPB sky130_fd_pr__pfet_01v8_hvt ad=0.1176 pd=1.4 as=0.18575 ps=1.415 w=0.42 l=0.15
X4 VGND A2 a_448_47# VNB sky130_fd_pr__nfet_01v8 ad=0.08775 pd=0.92 as=0.10725 ps=0.98 w=0.65 l=0.15
X5 a_448_47# a_222_93# a_79_199# VNB sky130_fd_pr__nfet_01v8 ad=0.10725 pd=0.98 as=0.169 ps=1.82 w=0.65 l=0.15
X6 a_79_199# a_222_93# VPWR VPB sky130_fd_pr__pfet_01v8_hvt ad=0.165 pd=1.33 as=0.3 ps=2.6 w=1 l=0.15
X7 a_544_297# A2 a_79_199# VPB sky130_fd_pr__pfet_01v8_hvt ad=0.105 pd=1.21 as=0.165 ps=1.33 w=1 l=0.15
X8 a_448_47# A1 VGND VNB sky130_fd_pr__nfet_01v8 ad=0.17225 pd=1.83 as=0.08775 ps=0.92 w=0.65 l=0.15
X9 VPWR a_79_199# X VPB sky130_fd_pr__pfet_01v8_hvt ad=0.18575 pd=1.415 as=0.26 ps=2.52 w=1 l=0.15
.ends

.subckt sky130_fd_sc_hd__and3b_1 A_N B C VGND VNB VPB VPWR X
X0 a_109_93# A_N VGND VNB sky130_fd_pr__nfet_01v8 ad=0.10785 pd=1.36 as=0.1092 ps=1.36 w=0.42 l=0.15
X1 X a_209_311# VPWR VPB sky130_fd_pr__pfet_01v8_hvt ad=0.26 pd=2.52 as=0.14222 ps=1.335 w=1 l=0.15
X2 a_109_93# A_N VPWR VPB sky130_fd_pr__pfet_01v8_hvt ad=0.1087 pd=1.36 as=0.1092 ps=1.36 w=0.42 l=0.15
X3 a_296_53# a_109_93# a_209_311# VNB sky130_fd_pr__nfet_01v8 ad=0.0441 pd=0.63 as=0.10783 ps=1.36 w=0.42 l=0.15
X4 VPWR C a_209_311# VPB sky130_fd_pr__pfet_01v8_hvt ad=0.14222 pd=1.335 as=0.07438 ps=0.815 w=0.42 l=0.15
X5 a_368_53# B a_296_53# VNB sky130_fd_pr__nfet_01v8 ad=0.05355 pd=0.675 as=0.0441 ps=0.63 w=0.42 l=0.15
X6 X a_209_311# VGND VNB sky130_fd_pr__nfet_01v8 ad=0.169 pd=1.82 as=0.12228 ps=1.08 w=0.65 l=0.15
X7 a_209_311# B VPWR VPB sky130_fd_pr__pfet_01v8_hvt ad=0.07438 pd=0.815 as=0.0567 ps=0.69 w=0.42 l=0.15
X8 VPWR a_109_93# a_209_311# VPB sky130_fd_pr__pfet_01v8_hvt ad=0.0567 pd=0.69 as=0.1085 ps=1.36 w=0.42 l=0.15
X9 VGND C a_368_53# VNB sky130_fd_pr__nfet_01v8 ad=0.12228 pd=1.08 as=0.05355 ps=0.675 w=0.42 l=0.15
.ends

.subckt sky130_fd_sc_hd__a21boi_1 A1 A2 B1_N VGND VNB VPB VPWR Y
X0 a_300_297# a_27_413# Y VPB sky130_fd_pr__pfet_01v8_hvt ad=0.14 pd=1.28 as=0.265 ps=2.53 w=1 l=0.15
X1 VGND A2 a_384_47# VNB sky130_fd_pr__nfet_01v8 ad=0.17225 pd=1.83 as=0.091 ps=0.93 w=0.65 l=0.15
X2 VPWR B1_N a_27_413# VPB sky130_fd_pr__pfet_01v8_hvt ad=0.1113 pd=1.37 as=0.1113 ps=1.37 w=0.42 l=0.15
X3 Y a_27_413# VGND VNB sky130_fd_pr__nfet_01v8 ad=0.143 pd=1.09 as=0.10187 ps=0.99 w=0.65 l=0.15
X4 VPWR A1 a_300_297# VPB sky130_fd_pr__pfet_01v8_hvt ad=0.14 pd=1.28 as=0.14 ps=1.28 w=1 l=0.15
X5 a_384_47# A1 Y VNB sky130_fd_pr__nfet_01v8 ad=0.091 pd=0.93 as=0.143 ps=1.09 w=0.65 l=0.15
X6 VGND B1_N a_27_413# VNB sky130_fd_pr__nfet_01v8 ad=0.10187 pd=0.99 as=0.1113 ps=1.37 w=0.42 l=0.15
X7 a_300_297# A2 VPWR VPB sky130_fd_pr__pfet_01v8_hvt ad=0.265 pd=2.53 as=0.14 ps=1.28 w=1 l=0.15
.ends

.subckt sky130_fd_sc_hd__a22oi_2 A1 A2 B1 B2 VGND VNB VPB VPWR Y
X0 a_109_297# A2 VPWR VPB sky130_fd_pr__pfet_01v8_hvt ad=0.26 pd=2.52 as=0.135 ps=1.27 w=1 l=0.15
X1 a_467_47# A1 Y VNB sky130_fd_pr__nfet_01v8 ad=0.08775 pd=0.92 as=0.08775 ps=0.92 w=0.65 l=0.15
X2 VPWR A2 a_109_297# VPB sky130_fd_pr__pfet_01v8_hvt ad=0.135 pd=1.27 as=0.135 ps=1.27 w=1 l=0.15
X3 a_467_47# A2 VGND VNB sky130_fd_pr__nfet_01v8 ad=0.169 pd=1.82 as=0.08775 ps=0.92 w=0.65 l=0.15
X4 Y B1 a_109_297# VPB sky130_fd_pr__pfet_01v8_hvt ad=0.26 pd=2.52 as=0.135 ps=1.27 w=1 l=0.15
X5 Y A1 a_467_47# VNB sky130_fd_pr__nfet_01v8 ad=0.08775 pd=0.92 as=0.169 ps=1.82 w=0.65 l=0.15
X6 a_109_297# B1 Y VPB sky130_fd_pr__pfet_01v8_hvt ad=0.135 pd=1.27 as=0.135 ps=1.27 w=1 l=0.15
X7 VGND A2 a_467_47# VNB sky130_fd_pr__nfet_01v8 ad=0.08775 pd=0.92 as=0.08775 ps=0.92 w=0.65 l=0.15
X8 Y B2 a_109_297# VPB sky130_fd_pr__pfet_01v8_hvt ad=0.135 pd=1.27 as=0.135 ps=1.27 w=1 l=0.15
X9 a_27_47# B2 VGND VNB sky130_fd_pr__nfet_01v8 ad=0.08775 pd=0.92 as=0.08775 ps=0.92 w=0.65 l=0.15
X10 a_27_47# B1 Y VNB sky130_fd_pr__nfet_01v8 ad=0.169 pd=1.82 as=0.08775 ps=0.92 w=0.65 l=0.15
X11 a_109_297# A1 VPWR VPB sky130_fd_pr__pfet_01v8_hvt ad=0.135 pd=1.27 as=0.135 ps=1.27 w=1 l=0.15
X12 VPWR A1 a_109_297# VPB sky130_fd_pr__pfet_01v8_hvt ad=0.135 pd=1.27 as=0.26 ps=2.52 w=1 l=0.15
X13 Y B1 a_27_47# VNB sky130_fd_pr__nfet_01v8 ad=0.08775 pd=0.92 as=0.08775 ps=0.92 w=0.65 l=0.15
X14 a_109_297# B2 Y VPB sky130_fd_pr__pfet_01v8_hvt ad=0.135 pd=1.27 as=0.26 ps=2.52 w=1 l=0.15
X15 VGND B2 a_27_47# VNB sky130_fd_pr__nfet_01v8 ad=0.08775 pd=0.92 as=0.169 ps=1.82 w=0.65 l=0.15
.ends

.subckt sky130_fd_sc_hd__o211a_1 A1 A2 B1 C1 VGND VNB VPB VPWR X
X0 VGND A1 a_215_47# VNB sky130_fd_pr__nfet_01v8 ad=0.10563 pd=0.975 as=0.169 ps=1.82 w=0.65 l=0.15
X1 a_510_47# B1 a_215_47# VNB sky130_fd_pr__nfet_01v8 ad=0.11375 pd=1 as=0.143 ps=1.09 w=0.65 l=0.15
X2 a_79_21# C1 VPWR VPB sky130_fd_pr__pfet_01v8_hvt ad=0.3 pd=2.6 as=0.175 ps=1.35 w=1 l=0.15
X3 VPWR B1 a_79_21# VPB sky130_fd_pr__pfet_01v8_hvt ad=0.175 pd=1.35 as=0.22 ps=1.44 w=1 l=0.15
X4 a_79_21# A2 a_297_297# VPB sky130_fd_pr__pfet_01v8_hvt ad=0.22 pd=1.44 as=0.1625 ps=1.325 w=1 l=0.15
X5 a_297_297# A1 VPWR VPB sky130_fd_pr__pfet_01v8_hvt ad=0.1625 pd=1.325 as=0.26 ps=2.52 w=1 l=0.15
X6 a_79_21# C1 a_510_47# VNB sky130_fd_pr__nfet_01v8 ad=0.195 pd=1.9 as=0.11375 ps=1 w=0.65 l=0.15
X7 VPWR a_79_21# X VPB sky130_fd_pr__pfet_01v8_hvt ad=0.26 pd=2.52 as=0.26 ps=2.52 w=1 l=0.15
X8 VGND a_79_21# X VNB sky130_fd_pr__nfet_01v8 ad=0.169 pd=1.82 as=0.169 ps=1.82 w=0.65 l=0.15
X9 a_215_47# A2 VGND VNB sky130_fd_pr__nfet_01v8 ad=0.143 pd=1.09 as=0.10563 ps=0.975 w=0.65 l=0.15
.ends

.subckt sky130_fd_sc_hd__o21ai_4 A1 A2 B1 VGND VNB VPB VPWR Y
X0 VPWR B1 Y VPB sky130_fd_pr__pfet_01v8_hvt ad=0.14 pd=1.28 as=0.14 ps=1.28 w=1 l=0.15
X1 a_115_297# A1 VPWR VPB sky130_fd_pr__pfet_01v8_hvt ad=0.14 pd=1.28 as=0.14 ps=1.28 w=1 l=0.15
X2 a_115_297# A2 Y VPB sky130_fd_pr__pfet_01v8_hvt ad=0.14 pd=1.28 as=0.14 ps=1.28 w=1 l=0.15
X3 VPWR A1 a_115_297# VPB sky130_fd_pr__pfet_01v8_hvt ad=0.16 pd=1.32 as=0.14 ps=1.28 w=1 l=0.15
X4 VGND A2 a_32_47# VNB sky130_fd_pr__nfet_01v8 ad=0.104 pd=0.97 as=0.091 ps=0.93 w=0.65 l=0.15
X5 Y B1 a_32_47# VNB sky130_fd_pr__nfet_01v8 ad=0.091 pd=0.93 as=0.091 ps=0.93 w=0.65 l=0.15
X6 VGND A1 a_32_47# VNB sky130_fd_pr__nfet_01v8 ad=0.091 pd=0.93 as=0.17225 ps=1.83 w=0.65 l=0.15
X7 Y B1 VPWR VPB sky130_fd_pr__pfet_01v8_hvt ad=0.14 pd=1.28 as=0.14 ps=1.28 w=1 l=0.15
X8 a_32_47# B1 Y VNB sky130_fd_pr__nfet_01v8 ad=0.18525 pd=1.87 as=0.091 ps=0.93 w=0.65 l=0.15
X9 Y B1 a_32_47# VNB sky130_fd_pr__nfet_01v8 ad=0.091 pd=0.93 as=0.091 ps=0.93 w=0.65 l=0.15
X10 Y A2 a_115_297# VPB sky130_fd_pr__pfet_01v8_hvt ad=0.14 pd=1.28 as=0.14 ps=1.28 w=1 l=0.15
X11 a_32_47# A2 VGND VNB sky130_fd_pr__nfet_01v8 ad=0.091 pd=0.93 as=0.091 ps=0.93 w=0.65 l=0.15
X12 a_32_47# B1 Y VNB sky130_fd_pr__nfet_01v8 ad=0.091 pd=0.93 as=0.091 ps=0.93 w=0.65 l=0.15
X13 a_32_47# A2 VGND VNB sky130_fd_pr__nfet_01v8 ad=0.091 pd=0.93 as=0.091 ps=0.93 w=0.65 l=0.15
X14 a_115_297# A2 Y VPB sky130_fd_pr__pfet_01v8_hvt ad=0.14 pd=1.28 as=0.14 ps=1.28 w=1 l=0.15
X15 a_32_47# A1 VGND VNB sky130_fd_pr__nfet_01v8 ad=0.091 pd=0.93 as=0.104 ps=0.97 w=0.65 l=0.15
X16 VPWR B1 Y VPB sky130_fd_pr__pfet_01v8_hvt ad=0.265 pd=2.53 as=0.14 ps=1.28 w=1 l=0.15
X17 a_32_47# A1 VGND VNB sky130_fd_pr__nfet_01v8 ad=0.091 pd=0.93 as=0.091 ps=0.93 w=0.65 l=0.15
X18 VGND A2 a_32_47# VNB sky130_fd_pr__nfet_01v8 ad=0.091 pd=0.93 as=0.091 ps=0.93 w=0.65 l=0.15
X19 Y B1 VPWR VPB sky130_fd_pr__pfet_01v8_hvt ad=0.14 pd=1.28 as=0.16 ps=1.32 w=1 l=0.15
X20 VPWR A1 a_115_297# VPB sky130_fd_pr__pfet_01v8_hvt ad=0.14 pd=1.28 as=0.14 ps=1.28 w=1 l=0.15
X21 Y A2 a_115_297# VPB sky130_fd_pr__pfet_01v8_hvt ad=0.14 pd=1.28 as=0.14 ps=1.28 w=1 l=0.15
X22 VGND A1 a_32_47# VNB sky130_fd_pr__nfet_01v8 ad=0.091 pd=0.93 as=0.091 ps=0.93 w=0.65 l=0.15
X23 a_115_297# A1 VPWR VPB sky130_fd_pr__pfet_01v8_hvt ad=0.14 pd=1.28 as=0.265 ps=2.53 w=1 l=0.15
.ends

.subckt sky130_fd_sc_hd__or3b_1 A B C_N VGND VNB VPB VPWR X
X0 a_109_93# C_N VGND VNB sky130_fd_pr__nfet_01v8 ad=0.1092 pd=1.36 as=0.1092 ps=1.36 w=0.42 l=0.15
X1 a_215_53# B VGND VNB sky130_fd_pr__nfet_01v8 ad=0.0567 pd=0.69 as=0.0567 ps=0.69 w=0.42 l=0.15
X2 VGND a_109_93# a_215_53# VNB sky130_fd_pr__nfet_01v8 ad=0.0567 pd=0.69 as=0.1092 ps=1.36 w=0.42 l=0.15
X3 VGND A a_215_53# VNB sky130_fd_pr__nfet_01v8 ad=0.10025 pd=0.985 as=0.0567 ps=0.69 w=0.42 l=0.15
X4 VPWR A a_369_297# VPB sky130_fd_pr__pfet_01v8_hvt ad=0.14825 pd=1.34 as=0.06825 ps=0.745 w=0.42 l=0.15
X5 a_369_297# B a_297_297# VPB sky130_fd_pr__pfet_01v8_hvt ad=0.06825 pd=0.745 as=0.0441 ps=0.63 w=0.42 l=0.15
X6 X a_215_53# VPWR VPB sky130_fd_pr__pfet_01v8_hvt ad=0.275 pd=2.55 as=0.14825 ps=1.34 w=1 l=0.15
X7 a_297_297# a_109_93# a_215_53# VPB sky130_fd_pr__pfet_01v8_hvt ad=0.0441 pd=0.63 as=0.1092 ps=1.36 w=0.42 l=0.15
X8 a_109_93# C_N VPWR VPB sky130_fd_pr__pfet_01v8_hvt ad=0.1092 pd=1.36 as=0.1092 ps=1.36 w=0.42 l=0.15
X9 X a_215_53# VGND VNB sky130_fd_pr__nfet_01v8 ad=0.17875 pd=1.85 as=0.10025 ps=0.985 w=0.65 l=0.15
.ends

.subckt sky130_fd_sc_hd__o2111ai_1 A1 A2 B1 C1 D1 VGND VNB VPB VPWR Y
X0 VPWR C1 Y VPB sky130_fd_pr__pfet_01v8_hvt ad=0.195 pd=1.39 as=0.14 ps=1.28 w=1 l=0.15
X1 a_235_47# C1 a_163_47# VNB sky130_fd_pr__nfet_01v8 ad=0.12675 pd=1.04 as=0.06825 ps=0.86 w=0.65 l=0.15
X2 a_343_47# B1 a_235_47# VNB sky130_fd_pr__nfet_01v8 ad=0.13162 pd=1.055 as=0.12675 ps=1.04 w=0.65 l=0.15
X3 Y B1 VPWR VPB sky130_fd_pr__pfet_01v8_hvt ad=0.2025 pd=1.405 as=0.195 ps=1.39 w=1 l=0.15
X4 a_454_297# A2 Y VPB sky130_fd_pr__pfet_01v8_hvt ad=0.195 pd=1.39 as=0.2025 ps=1.405 w=1 l=0.15
X5 Y D1 VPWR VPB sky130_fd_pr__pfet_01v8_hvt ad=0.14 pd=1.28 as=0.265 ps=2.53 w=1 l=0.15
X6 VPWR A1 a_454_297# VPB sky130_fd_pr__pfet_01v8_hvt ad=0.265 pd=2.53 as=0.195 ps=1.39 w=1 l=0.15
X7 a_163_47# D1 Y VNB sky130_fd_pr__nfet_01v8 ad=0.06825 pd=0.86 as=0.17225 ps=1.83 w=0.65 l=0.15
X8 VGND A2 a_343_47# VNB sky130_fd_pr__nfet_01v8 ad=0.12675 pd=1.04 as=0.13162 ps=1.055 w=0.65 l=0.15
X9 a_343_47# A1 VGND VNB sky130_fd_pr__nfet_01v8 ad=0.17225 pd=1.83 as=0.12675 ps=1.04 w=0.65 l=0.15
.ends

.subckt sky130_fd_sc_hd__clkbuf_1 A VGND VNB VPB VPWR X
X0 VPWR a_75_212# X VPB sky130_fd_pr__pfet_01v8_hvt ad=0.11455 pd=1.08 as=0.2054 ps=2.1 w=0.79 l=0.15
X1 a_75_212# A VGND VNB sky130_fd_pr__nfet_01v8 ad=0.1352 pd=1.56 as=0.0754 ps=0.81 w=0.52 l=0.15
X2 a_75_212# A VPWR VPB sky130_fd_pr__pfet_01v8_hvt ad=0.2054 pd=2.1 as=0.11455 ps=1.08 w=0.79 l=0.15
X3 VGND a_75_212# X VNB sky130_fd_pr__nfet_01v8 ad=0.0754 pd=0.81 as=0.1352 ps=1.56 w=0.52 l=0.15
.ends

.subckt sky130_fd_sc_hd__buf_4 A VGND VNB VPB VPWR X
X0 VPWR a_27_47# X VPB sky130_fd_pr__pfet_01v8_hvt ad=0.26 pd=2.52 as=0.135 ps=1.27 w=1 l=0.15
X1 X a_27_47# VPWR VPB sky130_fd_pr__pfet_01v8_hvt ad=0.135 pd=1.27 as=0.135 ps=1.27 w=1 l=0.15
X2 VPWR a_27_47# X VPB sky130_fd_pr__pfet_01v8_hvt ad=0.135 pd=1.27 as=0.135 ps=1.27 w=1 l=0.15
X3 X a_27_47# VPWR VPB sky130_fd_pr__pfet_01v8_hvt ad=0.135 pd=1.27 as=0.135 ps=1.27 w=1 l=0.15
X4 X a_27_47# VGND VNB sky130_fd_pr__nfet_01v8 ad=0.08775 pd=0.92 as=0.08775 ps=0.92 w=0.65 l=0.15
X5 X a_27_47# VGND VNB sky130_fd_pr__nfet_01v8 ad=0.08775 pd=0.92 as=0.08775 ps=0.92 w=0.65 l=0.15
X6 VGND a_27_47# X VNB sky130_fd_pr__nfet_01v8 ad=0.08775 pd=0.92 as=0.08775 ps=0.92 w=0.65 l=0.15
X7 VGND a_27_47# X VNB sky130_fd_pr__nfet_01v8 ad=0.169 pd=1.82 as=0.08775 ps=0.92 w=0.65 l=0.15
X8 VPWR A a_27_47# VPB sky130_fd_pr__pfet_01v8_hvt ad=0.135 pd=1.27 as=0.26 ps=2.52 w=1 l=0.15
X9 VGND A a_27_47# VNB sky130_fd_pr__nfet_01v8 ad=0.08775 pd=0.92 as=0.169 ps=1.82 w=0.65 l=0.15
.ends

.subckt sky130_fd_sc_hd__o2bb2a_1 A1_N A2_N B1 B2 VGND VNB VPB VPWR X
X0 a_206_369# A1_N VPWR VPB sky130_fd_pr__pfet_01v8_hvt ad=0.129 pd=1.18 as=0.14575 ps=1.335 w=0.42 l=0.15
X1 a_206_369# A2_N a_205_47# VNB sky130_fd_pr__nfet_01v8 ad=0.1092 pd=1.36 as=0.06615 ps=0.735 w=0.42 l=0.15
X2 VGND B2 a_489_47# VNB sky130_fd_pr__nfet_01v8 ad=0.0567 pd=0.69 as=0.0567 ps=0.69 w=0.42 l=0.15
X3 a_585_369# B2 a_76_199# VPB sky130_fd_pr__pfet_01v8_hvt ad=0.0441 pd=0.63 as=0.0672 ps=0.74 w=0.42 l=0.15
X4 a_489_47# a_206_369# a_76_199# VNB sky130_fd_pr__nfet_01v8 ad=0.0567 pd=0.69 as=0.1092 ps=1.36 w=0.42 l=0.15
X5 a_489_47# B1 VGND VNB sky130_fd_pr__nfet_01v8 ad=0.1092 pd=1.36 as=0.0567 ps=0.69 w=0.42 l=0.15
X6 VPWR A2_N a_206_369# VPB sky130_fd_pr__pfet_01v8_hvt ad=0.20925 pd=1.345 as=0.129 ps=1.18 w=0.42 l=0.15
X7 a_76_199# a_206_369# VPWR VPB sky130_fd_pr__pfet_01v8_hvt ad=0.0672 pd=0.74 as=0.20925 ps=1.345 w=0.42 l=0.15
X8 a_205_47# A1_N VGND VNB sky130_fd_pr__nfet_01v8 ad=0.06615 pd=0.735 as=0.09862 ps=0.98 w=0.42 l=0.15
X9 VPWR a_76_199# X VPB sky130_fd_pr__pfet_01v8_hvt ad=0.14575 pd=1.335 as=0.26 ps=2.52 w=1 l=0.15
X10 VPWR B1 a_585_369# VPB sky130_fd_pr__pfet_01v8_hvt ad=0.1092 pd=1.36 as=0.0441 ps=0.63 w=0.42 l=0.15
X11 VGND a_76_199# X VNB sky130_fd_pr__nfet_01v8 ad=0.09862 pd=0.98 as=0.169 ps=1.82 w=0.65 l=0.15
.ends

.subckt sky130_fd_sc_hd__dlymetal6s2s_1 A VGND VNB VPB VPWR X
X0 a_558_47# a_381_47# VPWR VPB sky130_fd_pr__pfet_01v8_hvt ad=0.26 pd=2.52 as=0.14075 ps=1.325 w=1 l=0.15
X1 VGND X a_381_47# VNB sky130_fd_pr__nfet_01v8 ad=0.097 pd=0.975 as=0.1092 ps=1.36 w=0.42 l=0.15
X2 a_841_47# a_664_47# VPWR VPB sky130_fd_pr__pfet_01v8_hvt ad=0.26 pd=2.52 as=0.14075 ps=1.325 w=1 l=0.15
X3 VPWR A a_62_47# VPB sky130_fd_pr__pfet_01v8_hvt ad=0.14075 pd=1.325 as=0.1092 ps=1.36 w=0.42 l=0.15
X4 VGND A a_62_47# VNB sky130_fd_pr__nfet_01v8 ad=0.097 pd=0.975 as=0.1092 ps=1.36 w=0.42 l=0.15
X5 a_558_47# a_381_47# VGND VNB sky130_fd_pr__nfet_01v8 ad=0.169 pd=1.82 as=0.097 ps=0.975 w=0.65 l=0.15
X6 X a_62_47# VPWR VPB sky130_fd_pr__pfet_01v8_hvt ad=0.26 pd=2.52 as=0.14075 ps=1.325 w=1 l=0.15
X7 VPWR X a_381_47# VPB sky130_fd_pr__pfet_01v8_hvt ad=0.14075 pd=1.325 as=0.1092 ps=1.36 w=0.42 l=0.15
X8 a_841_47# a_664_47# VGND VNB sky130_fd_pr__nfet_01v8 ad=0.169 pd=1.82 as=0.097 ps=0.975 w=0.65 l=0.15
X9 X a_62_47# VGND VNB sky130_fd_pr__nfet_01v8 ad=0.169 pd=1.82 as=0.097 ps=0.975 w=0.65 l=0.15
X10 VPWR a_558_47# a_664_47# VPB sky130_fd_pr__pfet_01v8_hvt ad=0.14075 pd=1.325 as=0.1092 ps=1.36 w=0.42 l=0.15
X11 VGND a_558_47# a_664_47# VNB sky130_fd_pr__nfet_01v8 ad=0.097 pd=0.975 as=0.1092 ps=1.36 w=0.42 l=0.15
.ends

.subckt sky130_fd_sc_hd__and4b_4 A_N B C D VGND VNB VPB VPWR X
X0 VPWR a_174_21# X VPB sky130_fd_pr__pfet_01v8_hvt ad=0.3275 pd=1.655 as=0.135 ps=1.27 w=1 l=0.15
X1 X a_174_21# VPWR VPB sky130_fd_pr__pfet_01v8_hvt ad=0.135 pd=1.27 as=0.135 ps=1.27 w=1 l=0.15
X2 a_815_47# B a_701_47# VNB sky130_fd_pr__nfet_01v8 ad=0.143 pd=1.09 as=0.1365 ps=1.07 w=0.65 l=0.15
X3 VPWR a_174_21# X VPB sky130_fd_pr__pfet_01v8_hvt ad=0.135 pd=1.27 as=0.135 ps=1.27 w=1 l=0.15
X4 VPWR C a_174_21# VPB sky130_fd_pr__pfet_01v8_hvt ad=0.21 pd=1.42 as=0.135 ps=1.27 w=1 l=0.15
X5 a_174_21# a_27_47# a_815_47# VNB sky130_fd_pr__nfet_01v8 ad=0.169 pd=1.82 as=0.143 ps=1.09 w=0.65 l=0.15
X6 X a_174_21# VPWR VPB sky130_fd_pr__pfet_01v8_hvt ad=0.135 pd=1.27 as=0.14075 ps=1.325 w=1 l=0.15
X7 VPWR A_N a_27_47# VPB sky130_fd_pr__pfet_01v8_hvt ad=0.14075 pd=1.325 as=0.1092 ps=1.36 w=0.42 l=0.15
X8 a_701_47# C a_617_47# VNB sky130_fd_pr__nfet_01v8 ad=0.1365 pd=1.07 as=0.08775 ps=0.92 w=0.65 l=0.15
X9 a_174_21# D VPWR VPB sky130_fd_pr__pfet_01v8_hvt ad=0.135 pd=1.27 as=0.3275 ps=1.655 w=1 l=0.15
X10 a_174_21# B VPWR VPB sky130_fd_pr__pfet_01v8_hvt ad=0.22 pd=1.44 as=0.21 ps=1.42 w=1 l=0.15
X11 VPWR a_27_47# a_174_21# VPB sky130_fd_pr__pfet_01v8_hvt ad=0.26 pd=2.52 as=0.22 ps=1.44 w=1 l=0.15
X12 X a_174_21# VGND VNB sky130_fd_pr__nfet_01v8 ad=0.08775 pd=0.92 as=0.097 ps=0.975 w=0.65 l=0.15
X13 X a_174_21# VGND VNB sky130_fd_pr__nfet_01v8 ad=0.08775 pd=0.92 as=0.08775 ps=0.92 w=0.65 l=0.15
X14 a_617_47# D VGND VNB sky130_fd_pr__nfet_01v8 ad=0.08775 pd=0.92 as=0.21287 ps=1.305 w=0.65 l=0.15
X15 VGND a_174_21# X VNB sky130_fd_pr__nfet_01v8 ad=0.08775 pd=0.92 as=0.08775 ps=0.92 w=0.65 l=0.15
X16 VGND a_174_21# X VNB sky130_fd_pr__nfet_01v8 ad=0.21287 pd=1.305 as=0.08775 ps=0.92 w=0.65 l=0.15
X17 VGND A_N a_27_47# VNB sky130_fd_pr__nfet_01v8 ad=0.097 pd=0.975 as=0.1092 ps=1.36 w=0.42 l=0.15
.ends

.subckt sky130_fd_sc_hd__o22ai_1 A1 A2 B1 B2 VGND VNB VPB VPWR Y
X0 VGND A2 a_27_47# VNB sky130_fd_pr__nfet_01v8 ad=0.08775 pd=0.92 as=0.11537 ps=1.005 w=0.65 l=0.15
X1 a_27_47# B2 Y VNB sky130_fd_pr__nfet_01v8 ad=0.11537 pd=1.005 as=0.09262 ps=0.935 w=0.65 l=0.15
X2 VPWR A1 a_307_297# VPB sky130_fd_pr__pfet_01v8_hvt ad=0.27 pd=2.54 as=0.105 ps=1.21 w=1 l=0.15
X3 a_307_297# A2 Y VPB sky130_fd_pr__pfet_01v8_hvt ad=0.105 pd=1.21 as=0.2325 ps=1.465 w=1 l=0.15
X4 a_27_47# A1 VGND VNB sky130_fd_pr__nfet_01v8 ad=0.169 pd=1.82 as=0.08775 ps=0.92 w=0.65 l=0.15
X5 Y B2 a_109_297# VPB sky130_fd_pr__pfet_01v8_hvt ad=0.2325 pd=1.465 as=0.1125 ps=1.225 w=1 l=0.15
X6 a_109_297# B1 VPWR VPB sky130_fd_pr__pfet_01v8_hvt ad=0.1125 pd=1.225 as=0.26 ps=2.52 w=1 l=0.15
X7 Y B1 a_27_47# VNB sky130_fd_pr__nfet_01v8 ad=0.09262 pd=0.935 as=0.169 ps=1.82 w=0.65 l=0.15
.ends

.subckt sky130_fd_sc_hd__nor3_1 A B C VGND VNB VPB VPWR Y
X0 VPWR A a_193_297# VPB sky130_fd_pr__pfet_01v8_hvt ad=0.26 pd=2.52 as=0.135 ps=1.27 w=1 l=0.15
X1 a_193_297# B a_109_297# VPB sky130_fd_pr__pfet_01v8_hvt ad=0.135 pd=1.27 as=0.135 ps=1.27 w=1 l=0.15
X2 Y B VGND VNB sky130_fd_pr__nfet_01v8 ad=0.08775 pd=0.92 as=0.08775 ps=0.92 w=0.65 l=0.15
X3 VGND A Y VNB sky130_fd_pr__nfet_01v8 ad=0.169 pd=1.82 as=0.08775 ps=0.92 w=0.65 l=0.15
X4 a_109_297# C Y VPB sky130_fd_pr__pfet_01v8_hvt ad=0.135 pd=1.27 as=0.26 ps=2.52 w=1 l=0.15
X5 VGND C Y VNB sky130_fd_pr__nfet_01v8 ad=0.08775 pd=0.92 as=0.169 ps=1.82 w=0.65 l=0.15
.ends

.subckt sky130_fd_sc_hd__a311o_1 A1 A2 A3 B1 C1 VGND VNB VPB VPWR X
X0 a_75_199# C1 VGND VNB sky130_fd_pr__nfet_01v8 ad=0.169 pd=1.82 as=0.13487 ps=1.065 w=0.65 l=0.15
X1 a_208_47# A3 VGND VNB sky130_fd_pr__nfet_01v8 ad=0.12513 pd=1.035 as=0.11213 ps=0.995 w=0.65 l=0.15
X2 a_315_47# A2 a_208_47# VNB sky130_fd_pr__nfet_01v8 ad=0.169 pd=1.17 as=0.12513 ps=1.035 w=0.65 l=0.15
X3 VGND B1 a_75_199# VNB sky130_fd_pr__nfet_01v8 ad=0.13487 pd=1.065 as=0.10563 ps=0.975 w=0.65 l=0.15
X4 a_75_199# A1 a_315_47# VNB sky130_fd_pr__nfet_01v8 ad=0.10563 pd=0.975 as=0.169 ps=1.17 w=0.65 l=0.15
X5 a_75_199# C1 a_544_297# VPB sky130_fd_pr__pfet_01v8_hvt ad=0.26 pd=2.52 as=0.2075 ps=1.415 w=1 l=0.15
X6 a_544_297# B1 a_201_297# VPB sky130_fd_pr__pfet_01v8_hvt ad=0.2075 pd=1.415 as=0.1625 ps=1.325 w=1 l=0.15
X7 VPWR a_75_199# X VPB sky130_fd_pr__pfet_01v8_hvt ad=0.1425 pd=1.285 as=0.285 ps=2.57 w=1 l=0.15
X8 a_201_297# A3 VPWR VPB sky130_fd_pr__pfet_01v8_hvt ad=0.165 pd=1.33 as=0.1425 ps=1.285 w=1 l=0.15
X9 VPWR A2 a_201_297# VPB sky130_fd_pr__pfet_01v8_hvt ad=0.305 pd=1.61 as=0.165 ps=1.33 w=1 l=0.15
X10 a_201_297# A1 VPWR VPB sky130_fd_pr__pfet_01v8_hvt ad=0.1625 pd=1.325 as=0.305 ps=1.61 w=1 l=0.15
X11 VGND a_75_199# X VNB sky130_fd_pr__nfet_01v8 ad=0.11213 pd=0.995 as=0.169 ps=1.82 w=0.65 l=0.15
.ends

.subckt sky130_fd_sc_hd__nor2_2 A B VGND VNB VPB VPWR Y
X0 Y B a_27_297# VPB sky130_fd_pr__pfet_01v8_hvt ad=0.135 pd=1.27 as=0.135 ps=1.27 w=1 l=0.15
X1 Y B VGND VNB sky130_fd_pr__nfet_01v8 ad=0.08775 pd=0.92 as=0.08775 ps=0.92 w=0.65 l=0.15
X2 a_27_297# A VPWR VPB sky130_fd_pr__pfet_01v8_hvt ad=0.135 pd=1.27 as=0.135 ps=1.27 w=1 l=0.15
X3 VGND A Y VNB sky130_fd_pr__nfet_01v8 ad=0.08775 pd=0.92 as=0.08775 ps=0.92 w=0.65 l=0.15
X4 Y A VGND VNB sky130_fd_pr__nfet_01v8 ad=0.08775 pd=0.92 as=0.182 ps=1.86 w=0.65 l=0.15
X5 VGND B Y VNB sky130_fd_pr__nfet_01v8 ad=0.169 pd=1.82 as=0.08775 ps=0.92 w=0.65 l=0.15
X6 VPWR A a_27_297# VPB sky130_fd_pr__pfet_01v8_hvt ad=0.135 pd=1.27 as=0.28 ps=2.56 w=1 l=0.15
X7 a_27_297# B Y VPB sky130_fd_pr__pfet_01v8_hvt ad=0.26 pd=2.52 as=0.135 ps=1.27 w=1 l=0.15
.ends

.subckt sky130_fd_sc_hd__and4bb_2 A_N B_N C D VGND VNB VPB VPWR X
X0 a_174_21# C VPWR VPB sky130_fd_pr__pfet_01v8_hvt ad=0.0567 pd=0.69 as=0.0588 ps=0.7 w=0.42 l=0.15
X1 a_174_21# a_27_47# VPWR VPB sky130_fd_pr__pfet_01v8_hvt ad=0.0672 pd=0.74 as=0.33075 ps=1.705 w=0.42 l=0.15
X2 a_476_47# a_27_47# a_174_21# VNB sky130_fd_pr__nfet_01v8 ad=0.0441 pd=0.63 as=0.1092 ps=1.36 w=0.42 l=0.15
X3 VPWR a_174_21# X VPB sky130_fd_pr__pfet_01v8_hvt ad=0.33075 pd=1.705 as=0.135 ps=1.27 w=1 l=0.15
X4 X a_174_21# VPWR VPB sky130_fd_pr__pfet_01v8_hvt ad=0.135 pd=1.27 as=0.14075 ps=1.325 w=1 l=0.15
X5 a_548_47# a_505_280# a_476_47# VNB sky130_fd_pr__nfet_01v8 ad=0.06405 pd=0.725 as=0.0441 ps=0.63 w=0.42 l=0.15
X6 VPWR A_N a_27_47# VPB sky130_fd_pr__pfet_01v8_hvt ad=0.14075 pd=1.325 as=0.1092 ps=1.36 w=0.42 l=0.15
X7 X a_174_21# VGND VNB sky130_fd_pr__nfet_01v8 ad=0.08775 pd=0.92 as=0.097 ps=0.975 w=0.65 l=0.15
X8 VPWR D a_174_21# VPB sky130_fd_pr__pfet_01v8_hvt ad=0.0924 pd=0.86 as=0.0567 ps=0.69 w=0.42 l=0.15
X9 VGND D a_639_47# VNB sky130_fd_pr__nfet_01v8 ad=0.0924 pd=0.86 as=0.0567 ps=0.69 w=0.42 l=0.15
X10 VPWR a_505_280# a_174_21# VPB sky130_fd_pr__pfet_01v8_hvt ad=0.0588 pd=0.7 as=0.0672 ps=0.74 w=0.42 l=0.15
X11 a_505_280# B_N VPWR VPB sky130_fd_pr__pfet_01v8_hvt ad=0.1092 pd=1.36 as=0.0924 ps=0.86 w=0.42 l=0.15
X12 VGND a_174_21# X VNB sky130_fd_pr__nfet_01v8 ad=0.169 pd=1.82 as=0.08775 ps=0.92 w=0.65 l=0.15
X13 a_505_280# B_N VGND VNB sky130_fd_pr__nfet_01v8 ad=0.1092 pd=1.36 as=0.0924 ps=0.86 w=0.42 l=0.15
X14 a_639_47# C a_548_47# VNB sky130_fd_pr__nfet_01v8 ad=0.0567 pd=0.69 as=0.06405 ps=0.725 w=0.42 l=0.15
X15 VGND A_N a_27_47# VNB sky130_fd_pr__nfet_01v8 ad=0.097 pd=0.975 as=0.1092 ps=1.36 w=0.42 l=0.15
.ends

.subckt sky130_fd_sc_hd__and4bb_4 A_N B_N C D VGND VNB VPB VPWR X
X0 VPWR a_174_21# X VPB sky130_fd_pr__pfet_01v8_hvt ad=0.175 pd=1.35 as=0.135 ps=1.27 w=1 l=0.15
X1 a_174_21# a_832_21# a_766_47# VNB sky130_fd_pr__nfet_01v8 ad=0.169 pd=1.82 as=0.10725 ps=0.98 w=0.65 l=0.15
X2 X a_174_21# VPWR VPB sky130_fd_pr__pfet_01v8_hvt ad=0.135 pd=1.27 as=0.135 ps=1.27 w=1 l=0.15
X3 a_832_21# A_N VGND VNB sky130_fd_pr__nfet_01v8 ad=0.1092 pd=1.36 as=0.1764 ps=1.68 w=0.42 l=0.15
X4 a_766_47# a_27_47# a_652_47# VNB sky130_fd_pr__nfet_01v8 ad=0.10725 pd=0.98 as=0.1365 ps=1.07 w=0.65 l=0.15
X5 VPWR a_174_21# X VPB sky130_fd_pr__pfet_01v8_hvt ad=0.135 pd=1.27 as=0.135 ps=1.27 w=1 l=0.15
X6 X a_174_21# VPWR VPB sky130_fd_pr__pfet_01v8_hvt ad=0.135 pd=1.27 as=0.14075 ps=1.325 w=1 l=0.15
X7 VPWR B_N a_27_47# VPB sky130_fd_pr__pfet_01v8_hvt ad=0.14075 pd=1.325 as=0.1092 ps=1.36 w=0.42 l=0.15
X8 a_652_47# C a_556_47# VNB sky130_fd_pr__nfet_01v8 ad=0.1365 pd=1.07 as=0.10725 ps=0.98 w=0.65 l=0.15
X9 a_832_21# A_N VPWR VPB sky130_fd_pr__pfet_01v8_hvt ad=0.1092 pd=1.36 as=0.31165 ps=2.125 w=0.42 l=0.15
X10 X a_174_21# VGND VNB sky130_fd_pr__nfet_01v8 ad=0.08775 pd=0.92 as=0.097 ps=0.975 w=0.65 l=0.15
X11 X a_174_21# VGND VNB sky130_fd_pr__nfet_01v8 ad=0.08775 pd=0.92 as=0.08775 ps=0.92 w=0.65 l=0.15
X12 a_556_47# D VGND VNB sky130_fd_pr__nfet_01v8 ad=0.10725 pd=0.98 as=0.11375 ps=1 w=0.65 l=0.15
X13 a_174_21# D VPWR VPB sky130_fd_pr__pfet_01v8_hvt ad=0.165 pd=1.33 as=0.175 ps=1.35 w=1 l=0.15
X14 VPWR C a_174_21# VPB sky130_fd_pr__pfet_01v8_hvt ad=0.21 pd=1.42 as=0.165 ps=1.33 w=1 l=0.15
X15 VGND a_174_21# X VNB sky130_fd_pr__nfet_01v8 ad=0.08775 pd=0.92 as=0.08775 ps=0.92 w=0.65 l=0.15
X16 VGND a_174_21# X VNB sky130_fd_pr__nfet_01v8 ad=0.11375 pd=1 as=0.08775 ps=0.92 w=0.65 l=0.15
X17 VPWR a_832_21# a_174_21# VPB sky130_fd_pr__pfet_01v8_hvt ad=0.31165 pd=2.125 as=0.165 ps=1.33 w=1 l=0.15
X18 a_174_21# a_27_47# VPWR VPB sky130_fd_pr__pfet_01v8_hvt ad=0.165 pd=1.33 as=0.21 ps=1.42 w=1 l=0.15
X19 VGND B_N a_27_47# VNB sky130_fd_pr__nfet_01v8 ad=0.097 pd=0.975 as=0.1092 ps=1.36 w=0.42 l=0.15
.ends

.subckt sky130_fd_sc_hd__o311a_1 A1 A2 A3 B1 C1 VGND VNB VPB VPWR X
X0 a_585_47# B1 a_266_47# VNB sky130_fd_pr__nfet_01v8 ad=0.06825 pd=0.86 as=0.11863 ps=1.015 w=0.65 l=0.15
X1 VGND A2 a_266_47# VNB sky130_fd_pr__nfet_01v8 ad=0.1365 pd=1.07 as=0.117 ps=1.01 w=0.65 l=0.15
X2 VPWR a_81_21# X VPB sky130_fd_pr__pfet_01v8_hvt ad=0.3125 pd=1.625 as=0.26 ps=2.52 w=1 l=0.15
X3 a_81_21# C1 a_585_47# VNB sky130_fd_pr__nfet_01v8 ad=0.169 pd=1.82 as=0.06825 ps=0.86 w=0.65 l=0.15
X4 VGND a_81_21# X VNB sky130_fd_pr__nfet_01v8 ad=0.20312 pd=1.275 as=0.169 ps=1.82 w=0.65 l=0.15
X5 a_266_297# A1 VPWR VPB sky130_fd_pr__pfet_01v8_hvt ad=0.18 pd=1.36 as=0.3125 ps=1.625 w=1 l=0.15
X6 a_368_297# A2 a_266_297# VPB sky130_fd_pr__pfet_01v8_hvt ad=0.21 pd=1.42 as=0.18 ps=1.36 w=1 l=0.15
X7 a_266_47# A3 VGND VNB sky130_fd_pr__nfet_01v8 ad=0.11863 pd=1.015 as=0.1365 ps=1.07 w=0.65 l=0.15
X8 a_266_47# A1 VGND VNB sky130_fd_pr__nfet_01v8 ad=0.117 pd=1.01 as=0.20312 ps=1.275 w=0.65 l=0.15
X9 a_81_21# A3 a_368_297# VPB sky130_fd_pr__pfet_01v8_hvt ad=0.1375 pd=1.275 as=0.21 ps=1.42 w=1 l=0.15
X10 a_81_21# C1 VPWR VPB sky130_fd_pr__pfet_01v8_hvt ad=0.26 pd=2.52 as=0.15 ps=1.3 w=1 l=0.15
X11 VPWR B1 a_81_21# VPB sky130_fd_pr__pfet_01v8_hvt ad=0.15 pd=1.3 as=0.1375 ps=1.275 w=1 l=0.15
.ends

.subckt sky130_fd_sc_hd__xor2_2 A B VGND VNB VPB VPWR X
X0 a_27_297# A VPWR VPB sky130_fd_pr__pfet_01v8_hvt ad=0.135 pd=1.27 as=0.135 ps=1.27 w=1 l=0.15
X1 a_470_47# A VGND VNB sky130_fd_pr__nfet_01v8 ad=0.08775 pd=0.92 as=0.08775 ps=0.92 w=0.65 l=0.15
X2 a_470_297# A VPWR VPB sky130_fd_pr__pfet_01v8_hvt ad=0.135 pd=1.27 as=0.135 ps=1.27 w=1 l=0.15
X3 VPWR A a_470_297# VPB sky130_fd_pr__pfet_01v8_hvt ad=0.135 pd=1.27 as=0.26 ps=2.52 w=1 l=0.15
X4 a_112_47# B VGND VNB sky130_fd_pr__nfet_01v8 ad=0.08775 pd=0.92 as=0.08775 ps=0.92 w=0.65 l=0.15
X5 a_470_47# B X VNB sky130_fd_pr__nfet_01v8 ad=0.169 pd=1.82 as=0.10563 ps=0.975 w=0.65 l=0.15
X6 VGND A a_112_47# VNB sky130_fd_pr__nfet_01v8 ad=0.08775 pd=0.92 as=0.08775 ps=0.92 w=0.65 l=0.15
X7 a_112_47# A VGND VNB sky130_fd_pr__nfet_01v8 ad=0.08775 pd=0.92 as=0.17875 ps=1.85 w=0.65 l=0.15
X8 VGND B a_112_47# VNB sky130_fd_pr__nfet_01v8 ad=0.169 pd=1.82 as=0.08775 ps=0.92 w=0.65 l=0.15
X9 VPWR A a_27_297# VPB sky130_fd_pr__pfet_01v8_hvt ad=0.135 pd=1.27 as=0.275 ps=2.55 w=1 l=0.15
X10 a_470_297# B VPWR VPB sky130_fd_pr__pfet_01v8_hvt ad=0.26 pd=2.52 as=0.1625 ps=1.325 w=1 l=0.15
X11 X a_112_47# VGND VNB sky130_fd_pr__nfet_01v8 ad=0.08775 pd=0.92 as=0.169 ps=1.82 w=0.65 l=0.15
X12 VPWR B a_470_297# VPB sky130_fd_pr__pfet_01v8_hvt ad=0.1625 pd=1.325 as=0.135 ps=1.27 w=1 l=0.15
X13 VGND a_112_47# X VNB sky130_fd_pr__nfet_01v8 ad=0.169 pd=1.82 as=0.08775 ps=0.92 w=0.65 l=0.15
X14 VGND A a_470_47# VNB sky130_fd_pr__nfet_01v8 ad=0.08775 pd=0.92 as=0.169 ps=1.82 w=0.65 l=0.15
X15 a_27_297# B a_112_47# VPB sky130_fd_pr__pfet_01v8_hvt ad=0.26 pd=2.52 as=0.135 ps=1.27 w=1 l=0.15
X16 X a_112_47# a_470_297# VPB sky130_fd_pr__pfet_01v8_hvt ad=0.135 pd=1.27 as=0.26 ps=2.52 w=1 l=0.15
X17 a_470_297# a_112_47# X VPB sky130_fd_pr__pfet_01v8_hvt ad=0.28 pd=2.56 as=0.135 ps=1.27 w=1 l=0.15
X18 X B a_470_47# VNB sky130_fd_pr__nfet_01v8 ad=0.10563 pd=0.975 as=0.08775 ps=0.92 w=0.65 l=0.15
X19 a_112_47# B a_27_297# VPB sky130_fd_pr__pfet_01v8_hvt ad=0.135 pd=1.27 as=0.135 ps=1.27 w=1 l=0.15
.ends

.subckt sky130_fd_sc_hd__o32a_1 A1 A2 A3 B1 B2 VGND VNB VPB VPWR X
X0 a_77_199# B2 a_227_47# VNB sky130_fd_pr__nfet_01v8 ad=0.13325 pd=1.06 as=0.12675 ps=1.04 w=0.65 l=0.15
X1 a_323_297# A2 a_227_297# VPB sky130_fd_pr__pfet_01v8_hvt ad=0.195 pd=1.39 as=0.165 ps=1.33 w=1 l=0.15
X2 a_227_297# A1 VPWR VPB sky130_fd_pr__pfet_01v8_hvt ad=0.165 pd=1.33 as=0.135 ps=1.27 w=1 l=0.15
X3 a_227_47# B1 a_77_199# VNB sky130_fd_pr__nfet_01v8 ad=0.1885 pd=1.88 as=0.13325 ps=1.06 w=0.65 l=0.15
X4 VGND a_77_199# X VNB sky130_fd_pr__nfet_01v8 ad=0.08775 pd=0.92 as=0.169 ps=1.82 w=0.65 l=0.15
X5 VPWR B1 a_539_297# VPB sky130_fd_pr__pfet_01v8_hvt ad=0.29 pd=2.58 as=0.205 ps=1.41 w=1 l=0.15
X6 a_227_47# A3 VGND VNB sky130_fd_pr__nfet_01v8 ad=0.12675 pd=1.04 as=0.12675 ps=1.04 w=0.65 l=0.15
X7 VPWR a_77_199# X VPB sky130_fd_pr__pfet_01v8_hvt ad=0.135 pd=1.27 as=0.335 ps=2.67 w=1 l=0.15
X8 a_77_199# A3 a_323_297# VPB sky130_fd_pr__pfet_01v8_hvt ad=0.195 pd=1.39 as=0.195 ps=1.39 w=1 l=0.15
X9 VGND A2 a_227_47# VNB sky130_fd_pr__nfet_01v8 ad=0.12675 pd=1.04 as=0.10725 ps=0.98 w=0.65 l=0.15
X10 a_227_47# A1 VGND VNB sky130_fd_pr__nfet_01v8 ad=0.10725 pd=0.98 as=0.08775 ps=0.92 w=0.65 l=0.15
X11 a_539_297# B2 a_77_199# VPB sky130_fd_pr__pfet_01v8_hvt ad=0.205 pd=1.41 as=0.195 ps=1.39 w=1 l=0.15
.ends

.subckt sky130_fd_sc_hd__diode_2 DIODE VGND VNB VPB VPWR
X0 VNB DIODE sky130_fd_pr__diode_pw2nd_05v5 perim=2.64e+06 area=4.347e+11
.ends

.subckt sky130_fd_sc_hd__o31a_2 A1 A2 A3 B1 VGND VNB VPB VPWR X
X0 a_108_21# B1 a_346_47# VNB sky130_fd_pr__nfet_01v8 ad=0.2015 pd=1.92 as=0.10725 ps=0.98 w=0.65 l=0.15
X1 a_346_47# A3 VGND VNB sky130_fd_pr__nfet_01v8 ad=0.10725 pd=0.98 as=0.10725 ps=0.98 w=0.65 l=0.15
X2 X a_108_21# VGND VNB sky130_fd_pr__nfet_01v8 ad=0.11375 pd=1 as=0.26325 ps=2.11 w=0.65 l=0.15
X3 a_108_21# A3 a_430_297# VPB sky130_fd_pr__pfet_01v8_hvt ad=0.2125 pd=1.425 as=0.165 ps=1.33 w=1 l=0.15
X4 a_430_297# A2 a_346_297# VPB sky130_fd_pr__pfet_01v8_hvt ad=0.165 pd=1.33 as=0.135 ps=1.27 w=1 l=0.15
X5 VPWR a_108_21# X VPB sky130_fd_pr__pfet_01v8_hvt ad=0.195 pd=1.39 as=0.175 ps=1.35 w=1 l=0.15
X6 a_346_297# A1 VPWR VPB sky130_fd_pr__pfet_01v8_hvt ad=0.135 pd=1.27 as=0.195 ps=1.39 w=1 l=0.15
X7 VGND A2 a_346_47# VNB sky130_fd_pr__nfet_01v8 ad=0.10725 pd=0.98 as=0.08775 ps=0.92 w=0.65 l=0.15
X8 X a_108_21# VPWR VPB sky130_fd_pr__pfet_01v8_hvt ad=0.175 pd=1.35 as=0.405 ps=2.81 w=1 l=0.15
X9 VPWR B1 a_108_21# VPB sky130_fd_pr__pfet_01v8_hvt ad=0.34 pd=2.68 as=0.2125 ps=1.425 w=1 l=0.15
X10 VGND a_108_21# X VNB sky130_fd_pr__nfet_01v8 ad=0.12675 pd=1.04 as=0.11375 ps=1 w=0.65 l=0.15
X11 a_346_47# A1 VGND VNB sky130_fd_pr__nfet_01v8 ad=0.08775 pd=0.92 as=0.12675 ps=1.04 w=0.65 l=0.15
.ends

.subckt sky130_fd_sc_hd__nand4_1 A B C D VGND VNB VPB VPWR Y
X0 Y B VPWR VPB sky130_fd_pr__pfet_01v8_hvt ad=0.165 pd=1.33 as=0.135 ps=1.27 w=1 l=0.15
X1 VPWR A Y VPB sky130_fd_pr__pfet_01v8_hvt ad=0.3 pd=2.6 as=0.165 ps=1.33 w=1 l=0.15
X2 VPWR C Y VPB sky130_fd_pr__pfet_01v8_hvt ad=0.135 pd=1.27 as=0.135 ps=1.27 w=1 l=0.15
X3 a_193_47# C a_109_47# VNB sky130_fd_pr__nfet_01v8 ad=0.08775 pd=0.92 as=0.08775 ps=0.92 w=0.65 l=0.15
X4 Y A a_277_47# VNB sky130_fd_pr__nfet_01v8 ad=0.195 pd=1.9 as=0.10725 ps=0.98 w=0.65 l=0.15
X5 a_277_47# B a_193_47# VNB sky130_fd_pr__nfet_01v8 ad=0.10725 pd=0.98 as=0.08775 ps=0.92 w=0.65 l=0.15
X6 Y D VPWR VPB sky130_fd_pr__pfet_01v8_hvt ad=0.135 pd=1.27 as=0.26 ps=2.52 w=1 l=0.15
X7 a_109_47# D VGND VNB sky130_fd_pr__nfet_01v8 ad=0.08775 pd=0.92 as=0.169 ps=1.82 w=0.65 l=0.15
.ends

.subckt sky130_fd_sc_hd__o2bb2a_2 A1_N A2_N B1 B2 VGND VNB VPB VPWR X
X0 a_294_47# A1_N VGND VNB sky130_fd_pr__nfet_01v8 ad=0.06615 pd=0.735 as=0.09862 ps=0.98 w=0.42 l=0.15
X1 VPWR A2_N a_295_369# VPB sky130_fd_pr__pfet_01v8_hvt ad=0.2272 pd=1.35 as=0.173 ps=1.4 w=0.64 l=0.15
X2 VPWR B1 a_665_369# VPB sky130_fd_pr__pfet_01v8_hvt ad=0.1664 pd=1.8 as=0.0864 ps=0.91 w=0.64 l=0.15
X3 VGND a_84_21# X VNB sky130_fd_pr__nfet_01v8 ad=0.09862 pd=0.98 as=0.08775 ps=0.92 w=0.65 l=0.15
X4 X a_84_21# VGND VNB sky130_fd_pr__nfet_01v8 ad=0.08775 pd=0.92 as=0.18525 ps=1.87 w=0.65 l=0.15
X5 a_581_47# a_295_369# a_84_21# VNB sky130_fd_pr__nfet_01v8 ad=0.0567 pd=0.69 as=0.1092 ps=1.36 w=0.42 l=0.15
X6 VPWR a_84_21# X VPB sky130_fd_pr__pfet_01v8_hvt ad=0.154 pd=1.335 as=0.135 ps=1.27 w=1 l=0.15
X7 a_665_369# B2 a_84_21# VPB sky130_fd_pr__pfet_01v8_hvt ad=0.0864 pd=0.91 as=0.0928 ps=0.93 w=0.64 l=0.15
X8 VGND B2 a_581_47# VNB sky130_fd_pr__nfet_01v8 ad=0.0567 pd=0.69 as=0.0567 ps=0.69 w=0.42 l=0.15
X9 a_295_369# A2_N a_294_47# VNB sky130_fd_pr__nfet_01v8 ad=0.1092 pd=1.36 as=0.06615 ps=0.735 w=0.42 l=0.15
X10 X a_84_21# VPWR VPB sky130_fd_pr__pfet_01v8_hvt ad=0.135 pd=1.27 as=0.285 ps=2.57 w=1 l=0.15
X11 a_84_21# a_295_369# VPWR VPB sky130_fd_pr__pfet_01v8_hvt ad=0.0928 pd=0.93 as=0.2272 ps=1.35 w=0.64 l=0.15
X12 a_295_369# A1_N VPWR VPB sky130_fd_pr__pfet_01v8_hvt ad=0.173 pd=1.4 as=0.154 ps=1.335 w=0.64 l=0.15
X13 a_581_47# B1 VGND VNB sky130_fd_pr__nfet_01v8 ad=0.1092 pd=1.36 as=0.0567 ps=0.69 w=0.42 l=0.15
.ends

.subckt digital_core A8 A[0] A[1] A[2] A[3] B[0] B[1] B[2] B[3] C[0] C[1] C[2] C[3]
+ IOA_in[0] IOA_in[1] IOA_in[2] IOA_in[3] IOA_in[4] IOA_in[5] IOA_in[6] IOA_in[7]
+ IOA_oe IOA_out[0] IOA_out[1] IOA_out[2] IOA_out[3] IOA_out[4] IOA_out[5] IOA_out[6]
+ IOA_out[7] IOB_in[0] IOB_in[1] IOB_in[2] IOB_in[3] IOB_in[4] IOB_in[5] IOB_in[6]
+ IOB_in[7] IOB_oe IOB_out[0] IOB_out[1] IOB_out[2] IOB_out[3] IOB_out[4] IOB_out[5]
+ IOB_out[6] IOB_out[7] VGND VPWR bc1 bc2 bdir clk clk_en din[0] din[1] din[2] din[3]
+ din[4] din[5] din[6] din[7] dout[0] dout[1] dout[2] dout[3] dout[4] dout[5] dout[6]
+ dout[7] nA9 rst_n
XFILLER_54_225 VGND VGND VPWR VPWR sky130_fd_sc_hd__decap_3
XFILLER_39_277 VGND VGND VPWR VPWR sky130_fd_sc_hd__decap_3
XFILLER_52_29 VGND VPWR VPWR VGND sky130_ef_sc_hd__decap_12
X_1270_ net43 u_jt49.u_chB.count\[4\] _0313_ VGND VGND VPWR VPWR _0315_ sky130_fd_sc_hd__and3_1
X_0985_ u_jt49.regarray\[6\]\[2\] _0467_ _0468_ u_jt49.regarray\[6\]\[1\] _0613_ VGND
+ VGND VPWR VPWR _0614_ sky130_fd_sc_hd__o221a_1
X_1606_ clknet_leaf_20_clk _0053_ net87 VGND VGND VPWR VPWR u_jt49.u_envdiv.count\[2\]
+ sky130_fd_sc_hd__dfrtp_1
XFILLER_59_317 VGND VPWR VPWR VGND sky130_ef_sc_hd__decap_12
X_1468_ net37 _0535_ VGND VGND VPWR VPWR _0407_ sky130_fd_sc_hd__and2_2
X_1537_ u_jt49.envelope\[1\] u_jt49.regarray\[9\]\[4\] VGND VGND VPWR VPWR _0422_
+ sky130_fd_sc_hd__nand2b_1
X_1399_ net59 u_jt49.eg_period\[2\] _0399_ VGND VGND VPWR VPWR _0135_ sky130_fd_sc_hd__mux2_1
XFILLER_27_225 VGND VGND VPWR VPWR sky130_fd_sc_hd__decap_3
XPHY_EDGE_ROW_19_Left_83 VGND VGND VPWR VPWR sky130_fd_sc_hd__decap_3
XFILLER_37_40 VGND VPWR VPWR VGND sky130_ef_sc_hd__decap_12
XFILLER_5_173 VGND VGND VPWR VPWR sky130_fd_sc_hd__decap_8
X_1253_ u_jt49.u_chB.count\[10\] _0472_ VGND VGND VPWR VPWR _0302_ sky130_fd_sc_hd__nor2_1
X_1322_ _0341_ _0343_ _0345_ _0356_ VGND VGND VPWR VPWR _0358_ sky130_fd_sc_hd__or4_1
XFILLER_49_361 VGND VPWR VPWR VGND sky130_ef_sc_hd__decap_12
X_1184_ net31 _0766_ _0767_ VGND VGND VPWR VPWR _0061_ sky130_fd_sc_hd__and3_1
X_0968_ u_jt49.regarray\[9\]\[7\] _0524_ _0543_ _0607_ _0517_ VGND VGND VPWR VPWR
+ _0608_ sky130_fd_sc_hd__a2111o_1
XFILLER_32_261 VGND VGND VPWR VPWR sky130_fd_sc_hd__decap_3
X_0899_ net48 _0543_ VGND VGND VPWR VPWR _0546_ sky130_fd_sc_hd__and2_2
XFILLER_59_169 VGND VPWR VPWR VGND sky130_ef_sc_hd__decap_12
XFILLER_59_125 VGND VPWR VPWR VGND sky130_ef_sc_hd__decap_12
XFILLER_55_331 VGND VGND VPWR VPWR sky130_fd_sc_hd__decap_4
XFILLER_55_364 VGND VGND VPWR VPWR sky130_fd_sc_hd__decap_3
XPHY_EDGE_ROW_4_Left_68 VGND VGND VPWR VPWR sky130_fd_sc_hd__decap_3
XFILLER_23_75 VGND VGND VPWR VPWR sky130_fd_sc_hd__decap_6
XFILLER_38_309 VGND VGND VPWR VPWR sky130_fd_sc_hd__decap_6
XFILLER_2_121 VGND VPWR VPWR VGND sky130_ef_sc_hd__decap_12
XFILLER_58_180 VGND VGND VPWR VPWR sky130_fd_sc_hd__decap_6
XFILLER_58_191 VGND VGND VPWR VPWR sky130_fd_sc_hd__decap_4
X_0822_ u_jt49.u_chB.count\[6\] VGND VGND VPWR VPWR _0476_ sky130_fd_sc_hd__inv_2
XFILLER_50_3 VGND VPWR VPWR VGND sky130_ef_sc_hd__decap_12
X_1236_ _0478_ u_jt49.periodB\[4\] _0284_ VGND VGND VPWR VPWR _0285_ sky130_fd_sc_hd__o21a_1
X_1305_ _0482_ u_jt49.periodA\[11\] u_jt49.u_chA.count\[10\] _0484_ VGND VGND VPWR
+ VPWR _0341_ sky130_fd_sc_hd__a2bb2o_1
X_1167_ u_jt49.u_envdiv.count\[6\] _0752_ VGND VGND VPWR VPWR _0755_ sky130_fd_sc_hd__and2_1
X_1098_ _0443_ net33 _0631_ VGND VGND VPWR VPWR _0700_ sky130_fd_sc_hd__o21ai_1
XFILLER_60_29 VGND VPWR VPWR VGND sky130_ef_sc_hd__decap_12
XFILLER_20_253 VGND VGND VPWR VPWR sky130_fd_sc_hd__decap_6
XFILLER_62_109 VGND VPWR VPWR VGND sky130_ef_sc_hd__decap_12
XFILLER_55_194 VGND VPWR VPWR VGND sky130_ef_sc_hd__decap_12
XFILLER_34_85 VGND VGND VPWR VPWR sky130_fd_sc_hd__decap_4
XFILLER_34_74 VGND VGND VPWR VPWR sky130_fd_sc_hd__decap_8
XFILLER_34_41 VGND VGND VPWR VPWR sky130_fd_sc_hd__decap_4
XFILLER_59_93 VGND VPWR VPWR VGND sky130_ef_sc_hd__decap_12
XFILLER_38_117 VGND VPWR VPWR VGND sky130_ef_sc_hd__decap_12
X_1021_ _0640_ _0641_ _0636_ VGND VGND VPWR VPWR _0642_ sky130_fd_sc_hd__a21o_1
X_0805_ u_jt49.u_envdiv.count\[13\] VGND VGND VPWR VPWR _0459_ sky130_fd_sc_hd__inv_2
X_1785_ clknet_leaf_3_clk _0228_ net75 VGND VGND VPWR VPWR u_jt49.periodB\[6\] sky130_fd_sc_hd__dfrtp_2
X_1219_ u_jt49.u_ng.poly17\[1\] u_jt49.u_ng.poly17\[2\] u_jt49.u_ng.poly17\[5\] u_jt49.u_ng.poly17\[4\]
+ VGND VGND VPWR VPWR _0272_ sky130_fd_sc_hd__or4_1
XFILLER_40_326 VGND VGND VPWR VPWR sky130_fd_sc_hd__decap_8
XFILLER_20_21 VGND VGND VPWR VPWR sky130_fd_sc_hd__decap_6
XFILLER_20_76 VGND VGND VPWR VPWR sky130_fd_sc_hd__decap_4
Xhold41 u_jt49.regarray\[3\]\[7\] VGND VGND VPWR VPWR net138 sky130_fd_sc_hd__dlygate4sd3_1
Xhold30 u_jt49.regarray\[5\]\[5\] VGND VGND VPWR VPWR net127 sky130_fd_sc_hd__dlygate4sd3_1
Xhold52 u_jt49.regarray\[13\]\[7\] VGND VGND VPWR VPWR net149 sky130_fd_sc_hd__dlygate4sd3_1
Xhold63 u_jt49.u_ng.poly17\[11\] VGND VGND VPWR VPWR net160 sky130_fd_sc_hd__dlygate4sd3_1
Xhold74 u_jt49.u_ng.poly17\[10\] VGND VGND VPWR VPWR net171 sky130_fd_sc_hd__dlygate4sd3_1
Xhold85 u_jt49.regarray\[7\]\[5\] VGND VGND VPWR VPWR net182 sky130_fd_sc_hd__dlygate4sd3_1
Xhold96 u_jt49.u_env.gain\[4\] VGND VGND VPWR VPWR net193 sky130_fd_sc_hd__dlygate4sd3_1
XFILLER_16_301 VGND VGND VPWR VPWR sky130_fd_sc_hd__decap_6
XPHY_EDGE_ROW_7_Left_71 VGND VGND VPWR VPWR sky130_fd_sc_hd__decap_3
X_1570_ clknet_leaf_7_clk _0017_ VGND VGND VPWR VPWR addr\[0\] sky130_fd_sc_hd__dfxtp_1
X_1004_ net26 net25 net28 net27 VGND VGND VPWR VPWR _0628_ sky130_fd_sc_hd__or4_1
X_1768_ clknet_leaf_6_clk _0211_ net76 VGND VGND VPWR VPWR IOB_out[6] sky130_fd_sc_hd__dfrtp_4
X_1837_ clknet_leaf_22_clk net109 VGND VGND VPWR VPWR C[3] sky130_fd_sc_hd__dfxtp_2
X_1699_ clknet_leaf_18_clk _0142_ net83 VGND VGND VPWR VPWR u_jt49.regarray\[10\]\[1\]
+ sky130_fd_sc_hd__dfrtp_1
XPHY_EDGE_ROW_33_Left_97 VGND VGND VPWR VPWR sky130_fd_sc_hd__decap_3
XFILLER_48_278 VGND VPWR VPWR VGND sky130_ef_sc_hd__decap_12
XFILLER_16_197 VGND VGND VPWR VPWR sky130_fd_sc_hd__decap_8
X_1622_ clknet_leaf_4_clk _0069_ net74 VGND VGND VPWR VPWR u_jt49.u_ng.poly17\[2\]
+ sky130_fd_sc_hd__dfrtp_1
X_1484_ net52 IOB_out[6] _0408_ VGND VGND VPWR VPWR _0211_ sky130_fd_sc_hd__mux2_1
X_1553_ net66 net108 _0427_ _0430_ VGND VGND VPWR VPWR _0258_ sky130_fd_sc_hd__a22o_1
XFILLER_42_85 VGND VPWR VPWR VGND sky130_ef_sc_hd__decap_12
XFILLER_13_178 VGND VGND VPWR VPWR sky130_fd_sc_hd__decap_8
XFILLER_3_57 VGND VPWR VPWR VGND sky130_ef_sc_hd__decap_12
X_0984_ u_jt49.regarray\[6\]\[1\] _0468_ _0469_ u_jt49.regarray\[6\]\[0\] VGND VGND
+ VPWR VPWR _0613_ sky130_fd_sc_hd__a22o_1
XFILLER_8_171 VGND VPWR VPWR VGND sky130_ef_sc_hd__decap_12
X_1536_ u_jt49.regarray\[9\]\[0\] u_jt49.regarray\[9\]\[4\] VGND VGND VPWR VPWR _0421_
+ sky130_fd_sc_hd__or2_1
X_1605_ clknet_leaf_20_clk _0052_ net86 VGND VGND VPWR VPWR u_jt49.u_envdiv.count\[1\]
+ sky130_fd_sc_hd__dfrtp_1
XFILLER_59_329 VGND VGND VPWR VPWR sky130_fd_sc_hd__decap_6
X_1467_ net136 net50 _0406_ VGND VGND VPWR VPWR _0196_ sky130_fd_sc_hd__mux2_1
X_1398_ net62 u_jt49.eg_period\[1\] _0399_ VGND VGND VPWR VPWR _0134_ sky130_fd_sc_hd__mux2_1
XFILLER_63_29 VGND VPWR VPWR VGND sky130_ef_sc_hd__decap_12
XFILLER_6_108 VGND VPWR VPWR VGND sky130_ef_sc_hd__decap_12
XFILLER_37_52 VGND VGND VPWR VPWR sky130_fd_sc_hd__decap_4
XFILLER_53_73 VGND VPWR VPWR VGND sky130_ef_sc_hd__decap_12
XFILLER_53_51 VGND VGND VPWR VPWR sky130_fd_sc_hd__decap_4
XFILLER_49_373 VGND VGND VPWR VPWR sky130_fd_sc_hd__decap_6
X_1252_ _0473_ u_jt49.periodB\[9\] _0474_ u_jt49.periodB\[8\] _0300_ VGND VGND VPWR
+ VPWR _0301_ sky130_fd_sc_hd__o221a_1
X_1321_ _0344_ _0345_ _0341_ VGND VGND VPWR VPWR _0357_ sky130_fd_sc_hd__a21oi_1
X_1183_ u_jt49.u_envdiv.count\[10\] _0763_ VGND VGND VPWR VPWR _0767_ sky130_fd_sc_hd__or2_1
XFILLER_17_281 VGND VPWR VPWR VGND sky130_ef_sc_hd__decap_12
XPHY_EDGE_ROW_20_Left_84 VGND VGND VPWR VPWR sky130_fd_sc_hd__decap_3
X_0967_ u_jt49.regarray\[10\]\[7\] _0526_ _0527_ u_jt49.periodB\[7\] _0606_ VGND VGND
+ VPWR VPWR _0607_ sky130_fd_sc_hd__a221o_1
XFILLER_59_137 VGND VPWR VPWR VGND sky130_ef_sc_hd__decap_12
XFILLER_58_29 VGND VPWR VPWR VGND sky130_ef_sc_hd__decap_12
XFILLER_58_18 VGND VGND VPWR VPWR sky130_fd_sc_hd__decap_8
X_1519_ u_jt49.Amix net20 VGND VGND VPWR VPWR _0416_ sky130_fd_sc_hd__and2_1
XPHY_EDGE_ROW_12_Right_12 VGND VGND VPWR VPWR sky130_fd_sc_hd__decap_3
X_0898_ u_jt49.periodA\[0\] _0518_ _0539_ _0542_ _0544_ VGND VGND VPWR VPWR _0545_
+ sky130_fd_sc_hd__o221a_1
XPHY_EDGE_ROW_21_Right_21 VGND VGND VPWR VPWR sky130_fd_sc_hd__decap_3
XFILLER_23_240 VGND VGND VPWR VPWR sky130_fd_sc_hd__decap_6
XPHY_EDGE_ROW_30_Right_30 VGND VGND VPWR VPWR sky130_fd_sc_hd__decap_3
XFILLER_2_133 VGND VGND VPWR VPWR sky130_fd_sc_hd__decap_6
XFILLER_46_365 VGND VGND VPWR VPWR sky130_fd_sc_hd__decap_3
X_0821_ u_jt49.u_chB.count\[7\] VGND VGND VPWR VPWR _0475_ sky130_fd_sc_hd__inv_2
XFILLER_43_3 VGND VGND VPWR VPWR sky130_fd_sc_hd__decap_6
X_1235_ u_jt49.periodB\[5\] u_jt49.u_chB.count\[5\] VGND VGND VPWR VPWR _0284_ sky130_fd_sc_hd__nand2b_1
X_1166_ net30 _0753_ _0754_ VGND VGND VPWR VPWR _0056_ sky130_fd_sc_hd__and3_1
X_1304_ _0482_ u_jt49.periodA\[11\] VGND VGND VPWR VPWR _0340_ sky130_fd_sc_hd__and2_1
XFILLER_52_368 VGND VPWR VPWR VGND sky130_ef_sc_hd__decap_12
X_1097_ _0630_ _0698_ _0699_ VGND VGND VPWR VPWR _0042_ sky130_fd_sc_hd__or3_1
XFILLER_20_232 VGND VPWR VPWR VGND sky130_ef_sc_hd__decap_12
XFILLER_43_302 VGND VGND VPWR VPWR sky130_fd_sc_hd__decap_4
XFILLER_28_365 VGND VGND VPWR VPWR sky130_fd_sc_hd__decap_3
XFILLER_50_41 VGND VGND VPWR VPWR sky130_fd_sc_hd__decap_6
XFILLER_7_225 VGND VGND VPWR VPWR sky130_fd_sc_hd__decap_3
XFILLER_59_50 VGND VGND VPWR VPWR sky130_fd_sc_hd__decap_6
XFILLER_50_85 VGND VGND VPWR VPWR sky130_fd_sc_hd__decap_6
X_1020_ u_jt49.u_chC.count\[4\] _0451_ u_jt49.u_chC.count\[3\] _0452_ VGND VGND VPWR
+ VPWR _0641_ sky130_fd_sc_hd__o22a_1
XFILLER_38_129 VGND VGND VPWR VPWR sky130_fd_sc_hd__decap_8
X_0804_ u_jt49.u_envdiv.count\[14\] VGND VGND VPWR VPWR _0458_ sky130_fd_sc_hd__inv_2
X_1784_ clknet_leaf_3_clk _0227_ net75 VGND VGND VPWR VPWR u_jt49.periodB\[5\] sky130_fd_sc_hd__dfrtp_1
XFILLER_37_195 VGND VGND VPWR VPWR sky130_fd_sc_hd__decap_4
XFILLER_37_162 VGND VGND VPWR VPWR sky130_fd_sc_hd__decap_6
X_1218_ u_jt49.u_ng.poly17\[7\] u_jt49.u_ng.poly17\[6\] u_jt49.u_ng.poly17\[9\] u_jt49.u_ng.poly17\[8\]
+ VGND VGND VPWR VPWR _0271_ sky130_fd_sc_hd__or4_1
X_1149_ _0741_ VGND VGND VPWR VPWR _0742_ sky130_fd_sc_hd__inv_2
XPHY_EDGE_ROW_42_Left_106 VGND VGND VPWR VPWR sky130_fd_sc_hd__decap_3
Xhold31 u_jt49.regarray\[9\]\[5\] VGND VGND VPWR VPWR net128 sky130_fd_sc_hd__dlygate4sd3_1
Xhold53 u_jt49.regarray\[3\]\[6\] VGND VGND VPWR VPWR net150 sky130_fd_sc_hd__dlygate4sd3_1
Xhold86 u_jt49.regarray\[7\]\[1\] VGND VGND VPWR VPWR net183 sky130_fd_sc_hd__dlygate4sd3_1
Xhold42 u_jt49.regarray\[8\]\[7\] VGND VGND VPWR VPWR net139 sky130_fd_sc_hd__dlygate4sd3_1
Xhold20 u_jt49.regarray\[8\]\[0\] VGND VGND VPWR VPWR net117 sky130_fd_sc_hd__dlygate4sd3_1
Xhold97 u_jt49.regarray\[9\]\[2\] VGND VGND VPWR VPWR net194 sky130_fd_sc_hd__dlygate4sd3_1
Xhold64 _0077_ VGND VGND VPWR VPWR net161 sky130_fd_sc_hd__dlygate4sd3_1
Xhold75 _0076_ VGND VGND VPWR VPWR net172 sky130_fd_sc_hd__dlygate4sd3_1
XPHY_EDGE_ROW_51_Left_115 VGND VGND VPWR VPWR sky130_fd_sc_hd__decap_3
XPHY_EDGE_ROW_60_Left_124 VGND VGND VPWR VPWR sky130_fd_sc_hd__decap_3
XFILLER_3_261 VGND VGND VPWR VPWR sky130_fd_sc_hd__decap_3
X_1003_ _0619_ _0627_ VGND VGND VPWR VPWR _0016_ sky130_fd_sc_hd__and2_1
X_1767_ clknet_leaf_6_clk _0210_ net76 VGND VGND VPWR VPWR IOB_out[5] sky130_fd_sc_hd__dfrtp_4
X_1836_ clknet_leaf_22_clk net108 VGND VGND VPWR VPWR C[2] sky130_fd_sc_hd__dfxtp_2
XPHY_EDGE_ROW_6_Right_6 VGND VGND VPWR VPWR sky130_fd_sc_hd__decap_3
X_1698_ clknet_leaf_18_clk _0141_ net84 VGND VGND VPWR VPWR u_jt49.regarray\[10\]\[0\]
+ sky130_fd_sc_hd__dfrtp_1
XFILLER_13_305 VGND VGND VPWR VPWR sky130_fd_sc_hd__decap_4
XFILLER_31_98 VGND VPWR VPWR VGND sky130_ef_sc_hd__decap_12
XFILLER_0_253 VGND VPWR VPWR VGND sky130_ef_sc_hd__decap_12
XPHY_EDGE_ROW_59_Right_59 VGND VGND VPWR VPWR sky130_fd_sc_hd__decap_3
X_1621_ clknet_leaf_4_clk net163 net74 VGND VGND VPWR VPWR u_jt49.u_ng.poly17\[1\]
+ sky130_fd_sc_hd__dfrtp_1
X_1552_ u_jt49.regarray\[10\]\[2\] u_jt49.envelope\[3\] u_jt49.regarray\[10\]\[4\]
+ VGND VGND VPWR VPWR _0430_ sky130_fd_sc_hd__mux2_1
X_1483_ net53 IOB_out[5] _0408_ VGND VGND VPWR VPWR _0210_ sky130_fd_sc_hd__mux2_1
X_1819_ clknet_leaf_28_clk net99 VGND VGND VPWR VPWR A[1] sky130_fd_sc_hd__dfxtp_2
XFILLER_26_76 VGND VGND VPWR VPWR sky130_fd_sc_hd__decap_8
XFILLER_42_97 VGND VGND VPWR VPWR sky130_fd_sc_hd__decap_6
XFILLER_3_69 VGND VPWR VPWR VGND sky130_ef_sc_hd__decap_12
X_0983_ net50 net28 _0612_ VGND VGND VPWR VPWR _0011_ sky130_fd_sc_hd__mux2_1
X_1535_ u_jt49.periodA\[7\] net49 _0420_ VGND VGND VPWR VPWR _0250_ sky130_fd_sc_hd__mux2_1
XFILLER_8_183 VGND VPWR VPWR VGND sky130_ef_sc_hd__decap_12
X_1604_ clknet_leaf_19_clk _0051_ net86 VGND VGND VPWR VPWR u_jt49.u_envdiv.count\[0\]
+ sky130_fd_sc_hd__dfstp_1
X_1466_ net134 net51 _0406_ VGND VGND VPWR VPWR _0195_ sky130_fd_sc_hd__mux2_1
X_1397_ net64 u_jt49.eg_period\[0\] _0399_ VGND VGND VPWR VPWR _0133_ sky130_fd_sc_hd__mux2_1
XFILLER_12_56 VGND VGND VPWR VPWR sky130_fd_sc_hd__decap_4
XFILLER_53_85 VGND VGND VPWR VPWR sky130_fd_sc_hd__decap_6
XFILLER_41_252 VGND VGND VPWR VPWR sky130_fd_sc_hd__decap_4
X_1320_ u_jt49.u_chA.count\[8\] _0486_ _0487_ u_jt49.periodA\[7\] VGND VGND VPWR VPWR
+ _0356_ sky130_fd_sc_hd__a2bb2o_1
X_1251_ _0295_ _0298_ _0299_ VGND VGND VPWR VPWR _0300_ sky130_fd_sc_hd__a21o_1
X_1182_ u_jt49.u_envdiv.count\[10\] _0763_ VGND VGND VPWR VPWR _0766_ sky130_fd_sc_hd__nand2_1
XFILLER_17_293 VGND VPWR VPWR VGND sky130_ef_sc_hd__decap_12
X_0966_ u_jt49.regarray\[3\]\[7\] _0515_ _0532_ IOB_oe VGND VGND VPWR VPWR _0606_
+ sky130_fd_sc_hd__a22o_1
X_0897_ net45 net46 net47 VGND VGND VPWR VPWR _0544_ sky130_fd_sc_hd__nand3_4
XFILLER_59_149 VGND VPWR VPWR VGND sky130_ef_sc_hd__decap_12
XFILLER_59_105 VGND VGND VPWR VPWR sky130_fd_sc_hd__decap_6
X_1449_ net49 IOB_oe _0404_ VGND VGND VPWR VPWR _0180_ sky130_fd_sc_hd__mux2_1
X_1518_ u_jt49.envelope\[1\] u_jt49.regarray\[8\]\[4\] VGND VGND VPWR VPWR _0415_
+ sky130_fd_sc_hd__nand2b_1
XFILLER_23_274 VGND VGND VPWR VPWR sky130_fd_sc_hd__decap_6
XFILLER_3_3 VGND VPWR VPWR VGND sky130_ef_sc_hd__decap_12
XFILLER_46_377 VGND VGND VPWR VPWR sky130_fd_sc_hd__decap_3
XFILLER_14_230 VGND VGND VPWR VPWR sky130_fd_sc_hd__decap_4
X_0820_ u_jt49.u_chB.count\[8\] VGND VGND VPWR VPWR _0474_ sky130_fd_sc_hd__inv_2
XFILLER_9_57 VGND VPWR VPWR VGND sky130_ef_sc_hd__decap_12
XFILLER_14_296 VGND VGND VPWR VPWR sky130_fd_sc_hd__decap_3
X_1303_ _0339_ u_jt49.bitB _0307_ VGND VGND VPWR VPWR _0099_ sky130_fd_sc_hd__mux2_1
X_1234_ _0476_ u_jt49.periodB\[6\] _0282_ VGND VGND VPWR VPWR _0283_ sky130_fd_sc_hd__a21o_1
X_1165_ u_jt49.u_envdiv.count\[5\] _0749_ VGND VGND VPWR VPWR _0754_ sky130_fd_sc_hd__or2_1
X_1096_ u_jt49.u_env.gain\[0\] u_jt49.u_env.gain\[1\] u_jt49.u_env.gain\[2\] _0694_
+ VGND VGND VPWR VPWR _0699_ sky130_fd_sc_hd__nor4_1
XFILLER_20_244 VGND VGND VPWR VPWR sky130_fd_sc_hd__decap_8
X_0949_ _0586_ _0587_ _0590_ VGND VGND VPWR VPWR _0591_ sky130_fd_sc_hd__or3_1
XFILLER_20_288 VGND VPWR VPWR VGND sky130_ef_sc_hd__decap_12
XFILLER_34_54 VGND VGND VPWR VPWR sky130_fd_sc_hd__decap_8
XFILLER_46_141 VGND VGND VPWR VPWR sky130_fd_sc_hd__decap_6
XFILLER_19_377 VGND VGND VPWR VPWR sky130_fd_sc_hd__decap_3
X_0803_ net180 VGND VGND VPWR VPWR _0457_ sky130_fd_sc_hd__inv_2
X_1783_ clknet_leaf_3_clk _0226_ net75 VGND VGND VPWR VPWR u_jt49.periodB\[4\] sky130_fd_sc_hd__dfrtp_2
XFILLER_29_108 VGND VGND VPWR VPWR sky130_fd_sc_hd__decap_4
X_1217_ u_jt49.u_ng.poly17\[15\] u_jt49.u_ng.poly17\[14\] u_jt49.u_ng.poly17\[16\]
+ _0269_ VGND VGND VPWR VPWR _0270_ sky130_fd_sc_hd__or4_1
X_1079_ u_jt49.regarray\[13\]\[2\] u_jt49.regarray\[13\]\[1\] u_jt49.regarray\[13\]\[3\]
+ VGND VGND VPWR VPWR _0687_ sky130_fd_sc_hd__mux2_1
X_1148_ net40 u_jt49.u_envdiv.count\[1\] u_jt49.u_envdiv.count\[0\] VGND VGND VPWR
+ VPWR _0741_ sky130_fd_sc_hd__and3_1
XFILLER_4_218 VGND VGND VPWR VPWR sky130_fd_sc_hd__decap_3
Xhold32 u_jt49.regarray\[10\]\[6\] VGND VGND VPWR VPWR net129 sky130_fd_sc_hd__dlygate4sd3_1
Xhold43 u_jt49.regarray\[3\]\[5\] VGND VGND VPWR VPWR net140 sky130_fd_sc_hd__dlygate4sd3_1
Xhold65 u_jt49.u_ng.poly17\[1\] VGND VGND VPWR VPWR net162 sky130_fd_sc_hd__dlygate4sd3_1
XFILLER_29_32 VGND VGND VPWR VPWR sky130_fd_sc_hd__decap_4
Xhold10 u_jt49.logB\[4\] VGND VGND VPWR VPWR net107 sky130_fd_sc_hd__dlygate4sd3_1
Xhold54 u_jt49.u_env.stop VGND VGND VPWR VPWR net151 sky130_fd_sc_hd__dlygate4sd3_1
Xhold21 u_jt49.u_env.last_step VGND VGND VPWR VPWR net118 sky130_fd_sc_hd__dlygate4sd3_1
Xhold98 u_jt49.regarray\[9\]\[1\] VGND VGND VPWR VPWR net195 sky130_fd_sc_hd__dlygate4sd3_1
Xhold76 u_jt49.u_ng.poly17\[15\] VGND VGND VPWR VPWR net173 sky130_fd_sc_hd__dlygate4sd3_1
Xhold87 u_jt49.regarray\[9\]\[3\] VGND VGND VPWR VPWR net184 sky130_fd_sc_hd__dlygate4sd3_1
XFILLER_43_133 VGND VGND VPWR VPWR sky130_fd_sc_hd__decap_4
XFILLER_20_6 VGND VGND VPWR VPWR sky130_fd_sc_hd__decap_6
X_1002_ u_jt49.u_ng.u_div.count\[4\] _0625_ VGND VGND VPWR VPWR _0627_ sky130_fd_sc_hd__xnor2_1
X_1835_ clknet_leaf_22_clk net105 VGND VGND VPWR VPWR C[1] sky130_fd_sc_hd__dfxtp_2
X_1766_ clknet_leaf_5_clk _0209_ net76 VGND VGND VPWR VPWR IOB_out[4] sky130_fd_sc_hd__dfrtp_4
X_1697_ clknet_leaf_17_clk _0140_ net86 VGND VGND VPWR VPWR u_jt49.eg_period\[7\]
+ sky130_fd_sc_hd__dfrtp_1
XFILLER_40_136 VGND VGND VPWR VPWR sky130_fd_sc_hd__decap_4
XFILLER_0_221 VGND VGND VPWR VPWR sky130_fd_sc_hd__decap_3
XFILLER_0_232 VGND VPWR VPWR VGND sky130_ef_sc_hd__decap_12
XFILLER_0_265 VGND VPWR VPWR VGND sky130_ef_sc_hd__decap_12
XFILLER_56_85 VGND VPWR VPWR VGND sky130_ef_sc_hd__decap_12
XFILLER_56_41 VGND VPWR VPWR VGND sky130_ef_sc_hd__decap_12
XFILLER_31_169 VGND VGND VPWR VPWR sky130_fd_sc_hd__decap_8
XFILLER_8_321 VGND VPWR VPWR VGND sky130_ef_sc_hd__decap_12
X_1482_ net56 IOB_out[4] _0408_ VGND VGND VPWR VPWR _0209_ sky130_fd_sc_hd__mux2_1
X_1551_ net66 net105 _0427_ _0429_ VGND VGND VPWR VPWR _0257_ sky130_fd_sc_hd__a22o_1
XFILLER_8_365 VGND VPWR VPWR VGND sky130_ef_sc_hd__decap_12
X_1620_ clknet_leaf_0_clk _0067_ net68 VGND VGND VPWR VPWR u_jt49.u_ng.poly17\[0\]
+ sky130_fd_sc_hd__dfrtp_1
XFILLER_54_217 VGND VGND VPWR VPWR sky130_fd_sc_hd__decap_8
XFILLER_39_269 VGND VGND VPWR VPWR sky130_fd_sc_hd__decap_8
X_1818_ clknet_leaf_28_clk net103 VGND VGND VPWR VPWR A[0] sky130_fd_sc_hd__dfxtp_2
X_1749_ clknet_leaf_17_clk _0192_ net90 VGND VGND VPWR VPWR u_jt49.periodC\[11\] sky130_fd_sc_hd__dfrtp_2
XFILLER_60_209 VGND VPWR VPWR VGND sky130_ef_sc_hd__decap_12
XFILLER_36_217 VGND VPWR VPWR VGND sky130_ef_sc_hd__decap_12
XFILLER_3_15 VGND VPWR VPWR VGND sky130_ef_sc_hd__decap_12
X_0982_ net52 net27 _0612_ VGND VGND VPWR VPWR _0010_ sky130_fd_sc_hd__mux2_1
X_1465_ net127 net54 _0406_ VGND VGND VPWR VPWR _0194_ sky130_fd_sc_hd__mux2_1
X_1534_ u_jt49.periodA\[6\] net52 _0420_ VGND VGND VPWR VPWR _0249_ sky130_fd_sc_hd__mux2_1
X_1603_ clknet_leaf_31_clk net121 VGND VGND VPWR VPWR u_jt49.u_ng.last_en sky130_fd_sc_hd__dfxtp_1
X_1396_ net37 _0530_ VGND VGND VPWR VPWR _0399_ sky130_fd_sc_hd__nand2_4
XFILLER_50_253 VGND VGND VPWR VPWR sky130_fd_sc_hd__decap_6
X_1250_ _0474_ u_jt49.periodB\[8\] _0475_ u_jt49.periodB\[7\] VGND VGND VPWR VPWR
+ _0299_ sky130_fd_sc_hd__a22o_1
X_1181_ net30 _0764_ _0765_ VGND VGND VPWR VPWR _0060_ sky130_fd_sc_hd__and3_1
XFILLER_32_253 VGND VGND VPWR VPWR sky130_fd_sc_hd__decap_8
X_0896_ net45 net46 net47 VGND VGND VPWR VPWR _0543_ sky130_fd_sc_hd__and3_1
X_0965_ u_jt49.regarray\[6\]\[7\] _0521_ _0533_ u_jt49.regarray\[8\]\[7\] _0603_ VGND
+ VGND VPWR VPWR _0605_ sky130_fd_sc_hd__a221o_1
X_1448_ net51 IOA_oe _0404_ VGND VGND VPWR VPWR _0179_ sky130_fd_sc_hd__mux2_1
X_1517_ u_jt49.regarray\[8\]\[0\] u_jt49.regarray\[8\]\[4\] VGND VGND VPWR VPWR _0414_
+ sky130_fd_sc_hd__or2_1
X_1379_ net64 u_jt49.regarray\[13\]\[0\] _0397_ VGND VGND VPWR VPWR _0117_ sky130_fd_sc_hd__mux2_1
XFILLER_23_45 VGND VGND VPWR VPWR sky130_fd_sc_hd__decap_6
XFILLER_23_253 VGND VPWR VPWR VGND sky130_ef_sc_hd__decap_12
XFILLER_46_356 VGND VGND VPWR VPWR sky130_fd_sc_hd__decap_8
XFILLER_61_337 VGND VPWR VPWR VGND sky130_ef_sc_hd__decap_12
XFILLER_9_69 VGND VPWR VPWR VGND sky130_ef_sc_hd__decap_12
XFILLER_14_253 VGND VGND VPWR VPWR sky130_fd_sc_hd__decap_4
Xfanout90 net96 VGND VGND VPWR VPWR net90 sky130_fd_sc_hd__buf_2
XFILLER_56_109 VGND VPWR VPWR VGND sky130_ef_sc_hd__decap_12
X_1233_ u_jt49.u_chB.count\[5\] u_jt49.periodB\[5\] VGND VGND VPWR VPWR _0282_ sky130_fd_sc_hd__and2b_1
X_1302_ _0336_ _0337_ _0338_ _0497_ VGND VGND VPWR VPWR _0339_ sky130_fd_sc_hd__o31a_1
XFILLER_37_345 VGND VPWR VPWR VGND sky130_ef_sc_hd__decap_12
X_1164_ _0752_ VGND VGND VPWR VPWR _0753_ sky130_fd_sc_hd__inv_2
X_1095_ u_jt49.u_env.gain\[1\] _0695_ u_jt49.u_env.gain\[2\] VGND VGND VPWR VPWR _0698_
+ sky130_fd_sc_hd__o21a_1
X_0948_ u_jt49.regarray\[3\]\[5\] _0515_ _0521_ u_jt49.regarray\[6\]\[5\] _0589_ VGND
+ VGND VPWR VPWR _0590_ sky130_fd_sc_hd__a221o_1
X_0879_ _0519_ _0522_ VGND VGND VPWR VPWR _0526_ sky130_fd_sc_hd__nor2_4
XFILLER_18_23 VGND VGND VPWR VPWR sky130_fd_sc_hd__decap_4
XFILLER_55_175 VGND VPWR VPWR VGND sky130_ef_sc_hd__decap_12
XFILLER_11_234 VGND VGND VPWR VPWR sky130_fd_sc_hd__decap_4
XFILLER_19_345 VGND VPWR VPWR VGND sky130_ef_sc_hd__decap_12
X_0802_ net43 VGND VGND VPWR VPWR _0456_ sky130_fd_sc_hd__inv_2
X_1782_ clknet_leaf_3_clk _0225_ net74 VGND VGND VPWR VPWR u_jt49.periodB\[3\] sky130_fd_sc_hd__dfrtp_2
X_1216_ u_jt49.u_ng.poly17\[11\] u_jt49.u_ng.poly17\[10\] u_jt49.u_ng.poly17\[13\]
+ u_jt49.u_ng.poly17\[12\] VGND VGND VPWR VPWR _0269_ sky130_fd_sc_hd__or4_1
X_1078_ u_jt49.u_env.gain\[0\] u_jt49.u_env.gain\[1\] u_jt49.u_env.gain\[3\] u_jt49.u_env.gain\[2\]
+ VGND VGND VPWR VPWR _0686_ sky130_fd_sc_hd__or4_1
X_1147_ _0731_ _0740_ _0739_ VGND VGND VPWR VPWR _0051_ sky130_fd_sc_hd__o21a_1
XFILLER_25_337 VGND VGND VPWR VPWR sky130_fd_sc_hd__decap_3
XFILLER_29_44 VGND VGND VPWR VPWR sky130_fd_sc_hd__decap_3
Xhold11 u_jt49.logC\[3\] VGND VGND VPWR VPWR net108 sky130_fd_sc_hd__dlygate4sd3_1
Xhold22 _0038_ VGND VGND VPWR VPWR net119 sky130_fd_sc_hd__dlygate4sd3_1
Xhold33 u_jt49.regarray\[10\]\[5\] VGND VGND VPWR VPWR net130 sky130_fd_sc_hd__dlygate4sd3_1
Xhold99 u_jt49.u_chB.count\[0\] VGND VGND VPWR VPWR net196 sky130_fd_sc_hd__dlygate4sd3_1
Xhold55 u_jt49.regarray\[1\]\[5\] VGND VGND VPWR VPWR net152 sky130_fd_sc_hd__dlygate4sd3_1
Xhold66 _0068_ VGND VGND VPWR VPWR net163 sky130_fd_sc_hd__dlygate4sd3_1
Xhold44 u_jt49.regarray\[1\]\[7\] VGND VGND VPWR VPWR net141 sky130_fd_sc_hd__dlygate4sd3_1
XFILLER_28_197 VGND VGND VPWR VPWR sky130_fd_sc_hd__decap_3
Xhold88 u_jt49.regarray\[7\]\[4\] VGND VGND VPWR VPWR net185 sky130_fd_sc_hd__dlygate4sd3_1
Xhold77 u_jt49.u_ng.poly17\[0\] VGND VGND VPWR VPWR net174 sky130_fd_sc_hd__dlygate4sd3_1
XFILLER_61_31 VGND VPWR VPWR VGND sky130_ef_sc_hd__decap_12
XFILLER_16_359 VGND VGND VPWR VPWR sky130_fd_sc_hd__decap_4
XFILLER_6_15 VGND VPWR VPWR VGND sky130_ef_sc_hd__decap_12
X_1001_ _0619_ _0625_ _0626_ VGND VGND VPWR VPWR _0015_ sky130_fd_sc_hd__and3_1
XFILLER_15_370 VGND VGND VPWR VPWR sky130_fd_sc_hd__decap_8
X_1765_ clknet_leaf_4_clk _0208_ net75 VGND VGND VPWR VPWR IOB_out[3] sky130_fd_sc_hd__dfrtp_4
X_1834_ clknet_leaf_22_clk net106 VGND VGND VPWR VPWR C[0] sky130_fd_sc_hd__dfxtp_2
X_1696_ clknet_leaf_17_clk _0139_ net94 VGND VGND VPWR VPWR u_jt49.eg_period\[6\]
+ sky130_fd_sc_hd__dfrtp_1
XFILLER_25_156 VGND VGND VPWR VPWR sky130_fd_sc_hd__decap_4
XFILLER_0_244 VGND VGND VPWR VPWR sky130_fd_sc_hd__decap_8
XFILLER_0_277 VGND VGND VPWR VPWR sky130_fd_sc_hd__decap_3
XFILLER_56_97 VGND VPWR VPWR VGND sky130_ef_sc_hd__decap_12
XFILLER_56_53 VGND VPWR VPWR VGND sky130_ef_sc_hd__decap_12
XFILLER_8_333 VGND VPWR VPWR VGND sky130_ef_sc_hd__decap_12
XFILLER_12_340 VGND VPWR VPWR VGND sky130_ef_sc_hd__decap_12
X_1481_ net57 IOB_out[3] _0408_ VGND VGND VPWR VPWR _0208_ sky130_fd_sc_hd__mux2_1
X_1550_ u_jt49.regarray\[10\]\[1\] u_jt49.envelope\[2\] u_jt49.regarray\[10\]\[4\]
+ VGND VGND VPWR VPWR _0429_ sky130_fd_sc_hd__mux2_1
XFILLER_47_281 VGND VPWR VPWR VGND sky130_ef_sc_hd__decap_12
XFILLER_11_3 VGND VGND VPWR VPWR sky130_fd_sc_hd__decap_6
X_1748_ clknet_leaf_13_clk _0191_ net92 VGND VGND VPWR VPWR u_jt49.periodC\[10\] sky130_fd_sc_hd__dfrtp_1
X_1817_ clknet_leaf_19_clk net37 net86 VGND VGND VPWR VPWR u_jt49.last_write sky130_fd_sc_hd__dfrtp_1
X_1679_ clknet_leaf_17_clk _0122_ net89 VGND VGND VPWR VPWR u_jt49.regarray\[13\]\[5\]
+ sky130_fd_sc_hd__dfrtp_1
XPHY_EDGE_ROW_39_Left_103 VGND VGND VPWR VPWR sky130_fd_sc_hd__decap_3
XFILLER_3_27 VGND VPWR VPWR VGND sky130_ef_sc_hd__decap_12
XPHY_EDGE_ROW_48_Left_112 VGND VGND VPWR VPWR sky130_fd_sc_hd__decap_3
XFILLER_36_229 VGND VGND VPWR VPWR sky130_fd_sc_hd__decap_6
XFILLER_29_281 VGND VGND VPWR VPWR sky130_fd_sc_hd__decap_6
X_0981_ net54 net26 _0612_ VGND VGND VPWR VPWR _0009_ sky130_fd_sc_hd__mux2_1
XFILLER_44_262 VGND VPWR VPWR VGND sky130_ef_sc_hd__decap_12
XPHY_EDGE_ROW_57_Left_121 VGND VGND VPWR VPWR sky130_fd_sc_hd__decap_3
XFILLER_8_141 VGND VPWR VPWR VGND sky130_ef_sc_hd__decap_12
X_1602_ clknet_leaf_25_clk _0049_ VGND VGND VPWR VPWR u_jt49.envelope\[4\] sky130_fd_sc_hd__dfxtp_1
X_1395_ u_jt49.eg_period\[15\] net50 _0398_ VGND VGND VPWR VPWR _0132_ sky130_fd_sc_hd__mux2_1
X_1464_ net137 net55 _0406_ VGND VGND VPWR VPWR _0193_ sky130_fd_sc_hd__mux2_1
X_1533_ u_jt49.periodA\[5\] net53 _0420_ VGND VGND VPWR VPWR _0248_ sky130_fd_sc_hd__mux2_1
Xclkbuf_leaf_30_clk clknet_2_0__leaf_clk VGND VGND VPWR VPWR clknet_leaf_30_clk sky130_fd_sc_hd__clkbuf_8
XFILLER_10_118 VGND VPWR VPWR VGND sky130_ef_sc_hd__decap_12
XFILLER_53_65 VGND VGND VPWR VPWR sky130_fd_sc_hd__decap_3
XFILLER_41_221 VGND VGND VPWR VPWR sky130_fd_sc_hd__decap_3
XFILLER_26_295 VGND VPWR VPWR VGND sky130_ef_sc_hd__decap_12
Xclkbuf_leaf_21_clk clknet_2_2__leaf_clk VGND VGND VPWR VPWR clknet_leaf_21_clk sky130_fd_sc_hd__clkbuf_8
XFILLER_1_361 VGND VPWR VPWR VGND sky130_ef_sc_hd__decap_12
X_1180_ u_jt49.u_envdiv.count\[9\] _0760_ VGND VGND VPWR VPWR _0765_ sky130_fd_sc_hd__or2_1
Xclkbuf_leaf_12_clk clknet_2_3__leaf_clk VGND VGND VPWR VPWR clknet_leaf_12_clk sky130_fd_sc_hd__clkbuf_8
X_0964_ u_jt49.regarray\[13\]\[7\] _0529_ _0530_ u_jt49.eg_period\[7\] _0602_ VGND
+ VGND VPWR VPWR _0604_ sky130_fd_sc_hd__a221o_1
X_1516_ net141 net49 _0413_ VGND VGND VPWR VPWR _0238_ sky130_fd_sc_hd__mux2_1
X_0895_ u_jt49.regarray\[10\]\[0\] _0526_ _0541_ _0517_ VGND VGND VPWR VPWR _0542_
+ sky130_fd_sc_hd__a211o_1
X_1447_ net53 net182 _0404_ VGND VGND VPWR VPWR _0178_ sky130_fd_sc_hd__mux2_1
X_1378_ net37 _0529_ VGND VGND VPWR VPWR _0397_ sky130_fd_sc_hd__nand2_4
XFILLER_61_305 VGND VPWR VPWR VGND sky130_ef_sc_hd__decap_12
XFILLER_61_349 VGND VPWR VPWR VGND sky130_ef_sc_hd__decap_12
Xfanout91 net96 VGND VGND VPWR VPWR net91 sky130_fd_sc_hd__clkbuf_4
Xfanout80 net81 VGND VGND VPWR VPWR net80 sky130_fd_sc_hd__buf_2
XFILLER_9_15 VGND VPWR VPWR VGND sky130_ef_sc_hd__decap_12
XPHY_EDGE_ROW_24_Left_88 VGND VGND VPWR VPWR sky130_fd_sc_hd__decap_3
X_1232_ u_jt49.u_chB.count\[11\] _0471_ u_jt49.u_chB.count\[10\] _0472_ VGND VGND
+ VPWR VPWR _0281_ sky130_fd_sc_hd__a22o_1
X_1301_ u_jt49.periodB\[11\] u_jt49.periodB\[10\] u_jt49.periodB\[9\] u_jt49.periodB\[8\]
+ VGND VGND VPWR VPWR _0338_ sky130_fd_sc_hd__or4_1
XFILLER_37_324 VGND VPWR VPWR VGND sky130_ef_sc_hd__decap_12
Xclkbuf_leaf_1_clk clknet_2_0__leaf_clk VGND VGND VPWR VPWR clknet_leaf_1_clk sky130_fd_sc_hd__clkbuf_8
X_1163_ u_jt49.u_envdiv.count\[5\] u_jt49.u_envdiv.count\[4\] u_jt49.u_envdiv.count\[3\]
+ _0745_ VGND VGND VPWR VPWR _0752_ sky130_fd_sc_hd__and4_1
X_1094_ u_jt49.u_env.gain\[1\] _0695_ _0697_ VGND VGND VPWR VPWR _0041_ sky130_fd_sc_hd__a21bo_1
X_0947_ u_jt49.eg_period\[13\] _0531_ _0534_ u_jt49.regarray\[5\]\[5\] _0588_ VGND
+ VGND VPWR VPWR _0589_ sky130_fd_sc_hd__a221o_1
X_0878_ u_jt49.regarray\[6\]\[0\] _0521_ _0524_ u_jt49.regarray\[9\]\[0\] VGND VGND
+ VPWR VPWR _0525_ sky130_fd_sc_hd__a22o_1
XFILLER_55_187 VGND VGND VPWR VPWR sky130_fd_sc_hd__decap_3
XFILLER_11_213 VGND VGND VPWR VPWR sky130_fd_sc_hd__decap_6
Xclkload0 clknet_leaf_1_clk VGND VGND VPWR VPWR clkload0/Y sky130_fd_sc_hd__bufinv_16
XFILLER_61_113 VGND VPWR VPWR VGND sky130_ef_sc_hd__decap_12
XFILLER_19_357 VGND VPWR VPWR VGND sky130_ef_sc_hd__decap_12
X_0801_ u_jt49.periodC\[0\] VGND VGND VPWR VPWR _0455_ sky130_fd_sc_hd__inv_2
X_1781_ clknet_leaf_5_clk _0224_ net75 VGND VGND VPWR VPWR u_jt49.periodB\[2\] sky130_fd_sc_hd__dfrtp_1
XFILLER_41_3 VGND VPWR VPWR VGND sky130_ef_sc_hd__decap_12
X_1215_ net173 net177 net34 VGND VGND VPWR VPWR _0082_ sky130_fd_sc_hd__mux2_1
X_1146_ net40 u_jt49.u_envdiv.count\[0\] VGND VGND VPWR VPWR _0740_ sky130_fd_sc_hd__nand2_1
XFILLER_25_316 VGND VPWR VPWR VGND sky130_ef_sc_hd__decap_12
X_1077_ u_jt49.u_env.stop _0684_ _0631_ VGND VGND VPWR VPWR _0685_ sky130_fd_sc_hd__o21a_1
Xhold34 u_jt49.regarray\[9\]\[6\] VGND VGND VPWR VPWR net131 sky130_fd_sc_hd__dlygate4sd3_1
Xhold12 u_jt49.logC\[4\] VGND VGND VPWR VPWR net109 sky130_fd_sc_hd__dlygate4sd3_1
Xhold45 u_jt49.u_ng.poly17\[12\] VGND VGND VPWR VPWR net142 sky130_fd_sc_hd__dlygate4sd3_1
Xhold23 u_jt49.u_ng.last_en VGND VGND VPWR VPWR net120 sky130_fd_sc_hd__dlygate4sd3_1
Xhold56 u_jt49.last_write VGND VGND VPWR VPWR net153 sky130_fd_sc_hd__dlygate4sd3_1
Xhold89 u_jt49.regarray\[7\]\[2\] VGND VGND VPWR VPWR net186 sky130_fd_sc_hd__dlygate4sd3_1
XFILLER_28_176 VGND VGND VPWR VPWR sky130_fd_sc_hd__decap_4
Xhold78 u_jt49.u_chA.count\[7\] VGND VGND VPWR VPWR net175 sky130_fd_sc_hd__dlygate4sd3_1
Xhold67 u_jt49.u_ng.poly17\[7\] VGND VGND VPWR VPWR net164 sky130_fd_sc_hd__dlygate4sd3_1
XFILLER_61_43 VGND VPWR VPWR VGND sky130_ef_sc_hd__decap_12
XFILLER_3_297 VGND VGND VPWR VPWR sky130_fd_sc_hd__decap_8
X_1000_ u_jt49.u_ng.u_div.count\[3\] _0623_ VGND VGND VPWR VPWR _0626_ sky130_fd_sc_hd__or2_1
XFILLER_30_330 VGND VGND VPWR VPWR sky130_fd_sc_hd__decap_3
X_1764_ clknet_leaf_4_clk _0207_ net75 VGND VGND VPWR VPWR IOB_out[2] sky130_fd_sc_hd__dfrtp_4
X_1833_ clknet_leaf_28_clk _0268_ net73 VGND VGND VPWR VPWR dout[7] sky130_fd_sc_hd__dfrtp_4
X_1695_ clknet_leaf_17_clk _0138_ net83 VGND VGND VPWR VPWR u_jt49.eg_period\[5\]
+ sky130_fd_sc_hd__dfrtp_1
XPHY_EDGE_ROW_27_Left_91 VGND VGND VPWR VPWR sky130_fd_sc_hd__decap_3
X_1129_ _0441_ u_jt49.u_envdiv.count\[8\] u_jt49.u_envdiv.count\[7\] _0439_ _0712_
+ VGND VGND VPWR VPWR _0729_ sky130_fd_sc_hd__o221a_1
XPHY_EDGE_ROW_11_Left_75 VGND VGND VPWR VPWR sky130_fd_sc_hd__decap_3
XFILLER_40_149 VGND VGND VPWR VPWR sky130_fd_sc_hd__decap_4
XFILLER_31_57 VGND VPWR VPWR VGND sky130_ef_sc_hd__decap_12
XFILLER_56_65 VGND VPWR VPWR VGND sky130_ef_sc_hd__decap_12
XFILLER_16_102 VGND VGND VPWR VPWR sky130_fd_sc_hd__decap_3
XPHY_EDGE_ROW_19_Right_19 VGND VGND VPWR VPWR sky130_fd_sc_hd__decap_3
XFILLER_8_345 VGND VPWR VPWR VGND sky130_ef_sc_hd__decap_12
XFILLER_12_352 VGND VPWR VPWR VGND sky130_ef_sc_hd__decap_12
X_1480_ net59 IOB_out[2] _0408_ VGND VGND VPWR VPWR _0207_ sky130_fd_sc_hd__mux2_1
XPHY_EDGE_ROW_28_Right_28 VGND VGND VPWR VPWR sky130_fd_sc_hd__decap_3
XFILLER_47_293 VGND VPWR VPWR VGND sky130_ef_sc_hd__decap_12
XPHY_EDGE_ROW_37_Right_37 VGND VGND VPWR VPWR sky130_fd_sc_hd__decap_3
XPHY_EDGE_ROW_46_Right_46 VGND VGND VPWR VPWR sky130_fd_sc_hd__decap_3
X_1747_ clknet_leaf_11_clk _0190_ net92 VGND VGND VPWR VPWR u_jt49.periodC\[9\] sky130_fd_sc_hd__dfrtp_2
X_1678_ clknet_leaf_18_clk _0121_ net84 VGND VGND VPWR VPWR u_jt49.regarray\[13\]\[4\]
+ sky130_fd_sc_hd__dfrtp_1
XFILLER_7_81 VGND VPWR VPWR VGND sky130_ef_sc_hd__decap_12
X_1816_ clknet_leaf_23_clk _0259_ VGND VGND VPWR VPWR u_jt49.logC\[4\] sky130_fd_sc_hd__dfxtp_1
XPHY_EDGE_ROW_55_Right_55 VGND VGND VPWR VPWR sky130_fd_sc_hd__decap_3
XFILLER_42_56 VGND VPWR VPWR VGND sky130_ef_sc_hd__decap_12
XFILLER_5_337 VGND VPWR VPWR VGND sky130_ef_sc_hd__decap_12
XFILLER_3_39 VGND VPWR VPWR VGND sky130_ef_sc_hd__decap_12
X_0980_ net56 net25 _0612_ VGND VGND VPWR VPWR _0008_ sky130_fd_sc_hd__mux2_1
XFILLER_44_274 VGND VPWR VPWR VGND sky130_ef_sc_hd__decap_12
X_1532_ u_jt49.periodA\[4\] net56 _0420_ VGND VGND VPWR VPWR _0247_ sky130_fd_sc_hd__mux2_1
XFILLER_8_131 VGND VGND VPWR VPWR sky130_fd_sc_hd__decap_8
X_1601_ clknet_leaf_23_clk _0048_ VGND VGND VPWR VPWR u_jt49.envelope\[3\] sky130_fd_sc_hd__dfxtp_1
X_1394_ u_jt49.eg_period\[14\] net51 _0398_ VGND VGND VPWR VPWR _0131_ sky130_fd_sc_hd__mux2_1
X_1463_ u_jt49.periodC\[11\] net58 _0406_ VGND VGND VPWR VPWR _0192_ sky130_fd_sc_hd__mux2_1
XFILLER_35_274 VGND VGND VPWR VPWR sky130_fd_sc_hd__decap_6
XFILLER_35_241 VGND VPWR VPWR VGND sky130_ef_sc_hd__decap_12
XFILLER_12_37 VGND VGND VPWR VPWR sky130_fd_sc_hd__decap_4
XFILLER_58_377 VGND VGND VPWR VPWR sky130_fd_sc_hd__decap_3
XFILLER_41_277 VGND VGND VPWR VPWR sky130_fd_sc_hd__decap_3
XFILLER_1_373 VGND VGND VPWR VPWR sky130_fd_sc_hd__decap_6
X_0894_ u_jt49.periodB\[0\] _0527_ _0535_ u_jt49.periodC\[0\] _0540_ VGND VGND VPWR
+ VPWR _0541_ sky130_fd_sc_hd__a221o_1
X_0963_ u_jt49.regarray\[1\]\[7\] _0528_ _0531_ u_jt49.eg_period\[15\] VGND VGND VPWR
+ VPWR _0603_ sky130_fd_sc_hd__a22o_1
X_1515_ net156 net52 _0413_ VGND VGND VPWR VPWR _0237_ sky130_fd_sc_hd__mux2_1
X_1446_ net55 net185 _0404_ VGND VGND VPWR VPWR _0177_ sky130_fd_sc_hd__mux2_1
X_1377_ net112 net65 _0396_ VGND VGND VPWR VPWR _0116_ sky130_fd_sc_hd__a21o_1
XFILLER_23_14 VGND VGND VPWR VPWR sky130_fd_sc_hd__decap_3
XFILLER_58_141 VGND VPWR VPWR VGND sky130_ef_sc_hd__decap_12
XFILLER_61_317 VGND VPWR VPWR VGND sky130_ef_sc_hd__decap_12
XFILLER_48_88 VGND VPWR VPWR VGND sky130_ef_sc_hd__decap_12
XFILLER_0_29 VGND VPWR VPWR VGND sky130_ef_sc_hd__decap_12
Xfanout81 net82 VGND VGND VPWR VPWR net81 sky130_fd_sc_hd__buf_2
Xfanout92 net96 VGND VGND VPWR VPWR net92 sky130_fd_sc_hd__clkbuf_2
Xfanout70 net82 VGND VGND VPWR VPWR net70 sky130_fd_sc_hd__buf_2
XFILLER_9_27 VGND VPWR VPWR VGND sky130_ef_sc_hd__decap_12
X_1231_ _0280_ net210 net32 VGND VGND VPWR VPWR _0086_ sky130_fd_sc_hd__mux2_1
X_1300_ u_jt49.periodB\[7\] u_jt49.periodB\[6\] u_jt49.periodB\[5\] u_jt49.periodB\[4\]
+ VGND VGND VPWR VPWR _0337_ sky130_fd_sc_hd__or4_1
X_1162_ net30 _0750_ _0751_ VGND VGND VPWR VPWR _0055_ sky130_fd_sc_hd__and3_1
X_1093_ u_jt49.u_env.gain\[1\] _0695_ _0631_ VGND VGND VPWR VPWR _0697_ sky130_fd_sc_hd__o21a_1
X_0877_ _0522_ _0523_ VGND VGND VPWR VPWR _0524_ sky130_fd_sc_hd__nor2_4
X_0946_ u_jt49.regarray\[13\]\[5\] _0529_ _0530_ u_jt49.eg_period\[5\] VGND VGND VPWR
+ VPWR _0588_ sky130_fd_sc_hd__a22o_1
XFILLER_9_281 VGND VPWR VPWR VGND sky130_ef_sc_hd__decap_12
X_1429_ net54 IOA_out[5] _0402_ VGND VGND VPWR VPWR _0162_ sky130_fd_sc_hd__mux2_1
Xclkload1 clknet_leaf_26_clk VGND VGND VPWR VPWR clkload1/X sky130_fd_sc_hd__clkbuf_4
XFILLER_61_169 VGND VPWR VPWR VGND sky130_ef_sc_hd__decap_12
XFILLER_61_125 VGND VPWR VPWR VGND sky130_ef_sc_hd__decap_12
XFILLER_42_361 VGND VGND VPWR VPWR sky130_fd_sc_hd__decap_3
XFILLER_19_369 VGND VGND VPWR VPWR sky130_fd_sc_hd__decap_8
X_0800_ u_jt49.periodC\[1\] VGND VGND VPWR VPWR _0454_ sky130_fd_sc_hd__inv_2
X_1780_ clknet_leaf_3_clk _0223_ net75 VGND VGND VPWR VPWR u_jt49.periodB\[1\] sky130_fd_sc_hd__dfrtp_1
XFILLER_34_3 VGND VPWR VPWR VGND sky130_ef_sc_hd__decap_12
X_1214_ net166 net173 net34 VGND VGND VPWR VPWR _0081_ sky130_fd_sc_hd__mux2_1
X_1145_ net41 u_jt49.u_envdiv.count\[0\] VGND VGND VPWR VPWR _0739_ sky130_fd_sc_hd__or2_1
XFILLER_25_328 VGND VGND VPWR VPWR sky130_fd_sc_hd__decap_8
XFILLER_40_309 VGND VPWR VPWR VGND sky130_ef_sc_hd__decap_12
X_1076_ _0682_ _0683_ net40 VGND VGND VPWR VPWR _0684_ sky130_fd_sc_hd__o21ai_1
X_0929_ _0568_ _0570_ _0572_ VGND VGND VPWR VPWR _0573_ sky130_fd_sc_hd__or3_1
Xhold13 addr_ok VGND VGND VPWR VPWR net110 sky130_fd_sc_hd__dlygate4sd3_1
Xhold35 u_jt49.regarray\[6\]\[5\] VGND VGND VPWR VPWR net132 sky130_fd_sc_hd__dlygate4sd3_1
Xhold57 u_jt49.regarray\[13\]\[6\] VGND VGND VPWR VPWR net154 sky130_fd_sc_hd__dlygate4sd3_1
XFILLER_29_57 VGND VGND VPWR VPWR sky130_fd_sc_hd__decap_6
Xhold79 u_jt49.u_ng.poly17\[2\] VGND VGND VPWR VPWR net176 sky130_fd_sc_hd__dlygate4sd3_1
Xhold24 _0050_ VGND VGND VPWR VPWR net121 sky130_fd_sc_hd__dlygate4sd3_1
Xhold46 _0078_ VGND VGND VPWR VPWR net143 sky130_fd_sc_hd__dlygate4sd3_1
Xhold68 _0074_ VGND VGND VPWR VPWR net165 sky130_fd_sc_hd__dlygate4sd3_1
XFILLER_45_78 VGND VGND VPWR VPWR sky130_fd_sc_hd__decap_3
XFILLER_43_169 VGND VGND VPWR VPWR sky130_fd_sc_hd__decap_6
XFILLER_51_180 VGND VGND VPWR VPWR sky130_fd_sc_hd__decap_8
XFILLER_19_122 VGND VGND VPWR VPWR sky130_fd_sc_hd__decap_6
XFILLER_34_147 VGND VGND VPWR VPWR sky130_fd_sc_hd__decap_3
X_1832_ clknet_leaf_29_clk _0267_ net73 VGND VGND VPWR VPWR dout[6] sky130_fd_sc_hd__dfrtp_4
X_1763_ clknet_leaf_4_clk _0206_ net74 VGND VGND VPWR VPWR IOB_out[1] sky130_fd_sc_hd__dfrtp_4
X_1694_ clknet_leaf_18_clk _0137_ net83 VGND VGND VPWR VPWR u_jt49.eg_period\[4\]
+ sky130_fd_sc_hd__dfrtp_1
X_1059_ _0671_ VGND VGND VPWR VPWR _0672_ sky130_fd_sc_hd__inv_2
X_1128_ _0725_ _0726_ _0727_ VGND VGND VPWR VPWR _0728_ sky130_fd_sc_hd__a21o_1
XFILLER_25_169 VGND VGND VPWR VPWR sky130_fd_sc_hd__decap_6
XFILLER_63_209 VGND VPWR VPWR VGND sky130_ef_sc_hd__decap_12
XFILLER_56_77 VGND VGND VPWR VPWR sky130_fd_sc_hd__decap_6
XFILLER_8_357 VGND VGND VPWR VPWR sky130_fd_sc_hd__decap_6
XFILLER_62_253 VGND VPWR VPWR VGND sky130_ef_sc_hd__decap_12
XFILLER_47_250 VGND VGND VPWR VPWR sky130_fd_sc_hd__decap_4
X_1815_ clknet_leaf_23_clk _0258_ VGND VGND VPWR VPWR u_jt49.logC\[3\] sky130_fd_sc_hd__dfxtp_1
X_1746_ clknet_leaf_11_clk _0189_ net92 VGND VGND VPWR VPWR u_jt49.periodC\[8\] sky130_fd_sc_hd__dfrtp_2
XFILLER_7_93 VGND VPWR VPWR VGND sky130_ef_sc_hd__decap_12
X_1677_ clknet_leaf_19_clk _0120_ net83 VGND VGND VPWR VPWR u_jt49.regarray\[13\]\[3\]
+ sky130_fd_sc_hd__dfrtp_1
XFILLER_53_220 VGND VGND VPWR VPWR sky130_fd_sc_hd__decap_4
XFILLER_42_68 VGND VPWR VPWR VGND sky130_ef_sc_hd__decap_12
XFILLER_5_349 VGND VPWR VPWR VGND sky130_ef_sc_hd__decap_12
XFILLER_5_305 VGND VPWR VPWR VGND sky130_ef_sc_hd__decap_12
XFILLER_12_183 VGND VGND VPWR VPWR sky130_fd_sc_hd__decap_8
X_1462_ u_jt49.periodC\[10\] net60 _0406_ VGND VGND VPWR VPWR _0191_ sky130_fd_sc_hd__mux2_1
X_1600_ clknet_leaf_23_clk _0047_ VGND VGND VPWR VPWR u_jt49.envelope\[2\] sky130_fd_sc_hd__dfxtp_1
X_1531_ u_jt49.periodA\[3\] net57 _0420_ VGND VGND VPWR VPWR _0246_ sky130_fd_sc_hd__mux2_1
X_1393_ u_jt49.eg_period\[13\] net53 _0398_ VGND VGND VPWR VPWR _0130_ sky130_fd_sc_hd__mux2_1
Xhold110 u_jt49.regarray\[10\]\[0\] VGND VGND VPWR VPWR net207 sky130_fd_sc_hd__dlygate4sd3_1
X_1729_ clknet_leaf_2_clk _0172_ net72 VGND VGND VPWR VPWR u_jt49.regarray\[8\]\[7\]
+ sky130_fd_sc_hd__dfrtp_1
XFILLER_2_319 VGND VGND VPWR VPWR sky130_fd_sc_hd__decap_8
XFILLER_37_57 VGND VGND VPWR VPWR sky130_fd_sc_hd__decap_4
XFILLER_26_264 VGND VGND VPWR VPWR sky130_fd_sc_hd__decap_3
XFILLER_26_242 VGND VGND VPWR VPWR sky130_fd_sc_hd__decap_8
XFILLER_5_113 VGND VPWR VPWR VGND sky130_ef_sc_hd__decap_12
X_0962_ u_jt49.regarray\[5\]\[7\] _0534_ _0535_ u_jt49.periodC\[7\] VGND VGND VPWR
+ VPWR _0602_ sky130_fd_sc_hd__a22o_1
X_0893_ u_jt49.regarray\[13\]\[0\] _0529_ _0531_ u_jt49.eg_period\[8\] VGND VGND VPWR
+ VPWR _0540_ sky130_fd_sc_hd__a22o_1
X_1514_ net152 net53 _0413_ VGND VGND VPWR VPWR _0236_ sky130_fd_sc_hd__mux2_1
X_1445_ net57 net197 _0404_ VGND VGND VPWR VPWR _0176_ sky130_fd_sc_hd__mux2_1
XFILLER_55_337 VGND VGND VPWR VPWR sky130_fd_sc_hd__decap_6
X_1376_ u_jt49.bitC u_jt49.regarray\[7\]\[2\] u_jt49.regarray\[7\]\[5\] u_jt49.noise
+ net20 VGND VGND VPWR VPWR _0396_ sky130_fd_sc_hd__o221a_1
XFILLER_23_212 VGND VPWR VPWR VGND sky130_ef_sc_hd__decap_12
XFILLER_61_329 VGND VGND VPWR VPWR sky130_fd_sc_hd__decap_6
Xfanout82 net97 VGND VGND VPWR VPWR net82 sky130_fd_sc_hd__buf_2
Xfanout60 din_latch\[2\] VGND VGND VPWR VPWR net60 sky130_fd_sc_hd__buf_2
Xfanout93 net94 VGND VGND VPWR VPWR net93 sky130_fd_sc_hd__clkbuf_4
Xfanout71 net82 VGND VGND VPWR VPWR net71 sky130_fd_sc_hd__clkbuf_4
XFILLER_9_39 VGND VPWR VPWR VGND sky130_ef_sc_hd__decap_12
X_1230_ _0277_ _0278_ _0279_ _0496_ VGND VGND VPWR VPWR _0280_ sky130_fd_sc_hd__o31a_1
X_1161_ u_jt49.u_envdiv.count\[3\] _0745_ u_jt49.u_envdiv.count\[4\] VGND VGND VPWR
+ VPWR _0751_ sky130_fd_sc_hd__a21o_1
X_1092_ _0695_ _0696_ VGND VGND VPWR VPWR _0040_ sky130_fd_sc_hd__nand2_1
X_0945_ u_jt49.regarray\[9\]\[5\] _0524_ _0535_ u_jt49.periodC\[5\] _0584_ VGND VGND
+ VPWR VPWR _0587_ sky130_fd_sc_hd__a221o_1
X_0876_ net47 net48 VGND VGND VPWR VPWR _0523_ sky130_fd_sc_hd__nand2b_2
XFILLER_9_293 VGND VGND VPWR VPWR sky130_fd_sc_hd__decap_4
X_1428_ net55 IOA_out[4] _0402_ VGND VGND VPWR VPWR _0161_ sky130_fd_sc_hd__mux2_1
X_1359_ u_jt49.u_chA.count\[9\] _0381_ u_jt49.u_chA.count\[10\] VGND VGND VPWR VPWR
+ _0385_ sky130_fd_sc_hd__a21o_1
Xclkload2 clknet_leaf_27_clk VGND VGND VPWR VPWR clkload2/Y sky130_fd_sc_hd__bufinv_16
XFILLER_50_68 VGND VPWR VPWR VGND sky130_ef_sc_hd__decap_12
XFILLER_46_134 VGND VGND VPWR VPWR sky130_fd_sc_hd__decap_6
XFILLER_61_137 VGND VPWR VPWR VGND sky130_ef_sc_hd__decap_12
X_1213_ net159 net166 net34 VGND VGND VPWR VPWR _0080_ sky130_fd_sc_hd__mux2_1
X_1144_ u_jt49.u_ng.noise_en net120 _0738_ VGND VGND VPWR VPWR _0050_ sky130_fd_sc_hd__mux2_1
X_1075_ u_jt49.u_env.last_step u_jt49.eg_step VGND VGND VPWR VPWR _0683_ sky130_fd_sc_hd__and2b_1
XFILLER_25_307 VGND VGND VPWR VPWR sky130_fd_sc_hd__decap_3
X_0859_ _0508_ _0019_ VGND VGND VPWR VPWR _0509_ sky130_fd_sc_hd__nand2_1
X_0928_ u_jt49.periodB\[3\] _0527_ _0531_ u_jt49.eg_period\[11\] _0571_ VGND VGND
+ VPWR VPWR _0572_ sky130_fd_sc_hd__a221o_1
Xhold36 u_jt49.regarray\[6\]\[6\] VGND VGND VPWR VPWR net133 sky130_fd_sc_hd__dlygate4sd3_1
Xhold47 u_jt49.regarray\[6\]\[7\] VGND VGND VPWR VPWR net144 sky130_fd_sc_hd__dlygate4sd3_1
Xhold58 u_jt49.regarray\[13\]\[4\] VGND VGND VPWR VPWR net155 sky130_fd_sc_hd__dlygate4sd3_1
Xhold14 u_jt49.Bmix VGND VGND VPWR VPWR net111 sky130_fd_sc_hd__dlygate4sd3_1
Xhold25 u_jt49.u_cen.cencnt\[2\] VGND VGND VPWR VPWR net122 sky130_fd_sc_hd__dlygate4sd3_1
Xhold69 u_jt49.u_ng.poly17\[14\] VGND VGND VPWR VPWR net166 sky130_fd_sc_hd__dlygate4sd3_1
XFILLER_45_57 VGND VGND VPWR VPWR sky130_fd_sc_hd__decap_3
XFILLER_6_29 VGND VPWR VPWR VGND sky130_ef_sc_hd__decap_12
XFILLER_10_93 VGND VPWR VPWR VGND sky130_ef_sc_hd__decap_12
XFILLER_59_281 VGND VPWR VPWR VGND sky130_ef_sc_hd__decap_12
XFILLER_59_270 VGND VGND VPWR VPWR sky130_fd_sc_hd__decap_8
XFILLER_30_365 VGND VGND VPWR VPWR sky130_fd_sc_hd__decap_4
X_1831_ clknet_leaf_29_clk _0266_ net70 VGND VGND VPWR VPWR dout[5] sky130_fd_sc_hd__dfrtp_4
X_1762_ clknet_leaf_4_clk _0205_ net74 VGND VGND VPWR VPWR IOB_out[0] sky130_fd_sc_hd__dfrtp_4
X_1693_ clknet_leaf_19_clk _0136_ net86 VGND VGND VPWR VPWR u_jt49.eg_period\[3\]
+ sky130_fd_sc_hd__dfrtp_1
X_1058_ _0447_ _0669_ VGND VGND VPWR VPWR _0671_ sky130_fd_sc_hd__nor2_1
X_1127_ _0439_ u_jt49.u_envdiv.count\[7\] u_jt49.u_envdiv.count\[6\] _0440_ VGND VGND
+ VPWR VPWR _0727_ sky130_fd_sc_hd__a22o_1
XPHY_EDGE_ROW_1_Right_1 VGND VGND VPWR VPWR sky130_fd_sc_hd__decap_3
XFILLER_56_240 VGND VPWR VPWR VGND sky130_ef_sc_hd__decap_12
XFILLER_16_137 VGND VGND VPWR VPWR sky130_fd_sc_hd__decap_3
XFILLER_8_303 VGND VGND VPWR VPWR sky130_fd_sc_hd__decap_4
XFILLER_12_365 VGND VPWR VPWR VGND sky130_ef_sc_hd__decap_12
XFILLER_62_265 VGND VPWR VPWR VGND sky130_ef_sc_hd__decap_12
XFILLER_62_221 VGND VPWR VPWR VGND sky130_ef_sc_hd__decap_12
X_1745_ clknet_leaf_18_clk _0188_ net72 VGND VGND VPWR VPWR u_jt49.regarray\[6\]\[7\]
+ sky130_fd_sc_hd__dfrtp_1
X_1814_ clknet_leaf_22_clk _0257_ VGND VGND VPWR VPWR u_jt49.logC\[2\] sky130_fd_sc_hd__dfxtp_1
XFILLER_15_181 VGND VGND VPWR VPWR sky130_fd_sc_hd__decap_4
X_1676_ clknet_leaf_25_clk _0119_ net83 VGND VGND VPWR VPWR u_jt49.regarray\[13\]\[2\]
+ sky130_fd_sc_hd__dfrtp_1
XFILLER_5_317 VGND VPWR VPWR VGND sky130_ef_sc_hd__decap_12
Xclkbuf_leaf_24_clk clknet_2_2__leaf_clk VGND VGND VPWR VPWR clknet_leaf_24_clk sky130_fd_sc_hd__clkbuf_8
X_1461_ u_jt49.periodC\[9\] net62 _0406_ VGND VGND VPWR VPWR _0190_ sky130_fd_sc_hd__mux2_1
X_1392_ u_jt49.eg_period\[12\] net55 _0398_ VGND VGND VPWR VPWR _0129_ sky130_fd_sc_hd__mux2_1
X_1530_ u_jt49.periodA\[2\] net59 _0420_ VGND VGND VPWR VPWR _0245_ sky130_fd_sc_hd__mux2_1
Xclkbuf_leaf_15_clk clknet_2_3__leaf_clk VGND VGND VPWR VPWR clknet_leaf_15_clk sky130_fd_sc_hd__clkbuf_8
X_1728_ clknet_leaf_2_clk _0171_ net77 VGND VGND VPWR VPWR u_jt49.regarray\[8\]\[6\]
+ sky130_fd_sc_hd__dfrtp_1
Xhold111 u_jt49.regarray\[13\]\[2\] VGND VGND VPWR VPWR net208 sky130_fd_sc_hd__dlygate4sd3_1
Xhold100 u_jt49.regarray\[7\]\[3\] VGND VGND VPWR VPWR net197 sky130_fd_sc_hd__dlygate4sd3_1
X_1659_ clknet_leaf_29_clk _0104_ net70 VGND VGND VPWR VPWR u_jt49.u_chA.count\[4\]
+ sky130_fd_sc_hd__dfrtp_1
XFILLER_26_276 VGND VGND VPWR VPWR sky130_fd_sc_hd__decap_8
XFILLER_53_57 VGND VGND VPWR VPWR sky130_fd_sc_hd__decap_8
XFILLER_5_125 VGND VPWR VPWR VGND sky130_ef_sc_hd__decap_12
XFILLER_32_202 VGND VGND VPWR VPWR sky130_fd_sc_hd__decap_8
X_0961_ net15 _0546_ _0547_ net7 _0601_ VGND VGND VPWR VPWR _0267_ sky130_fd_sc_hd__a221o_1
XFILLER_40_290 VGND VGND VPWR VPWR sky130_fd_sc_hd__decap_3
X_0892_ _0525_ _0536_ _0537_ _0538_ VGND VGND VPWR VPWR _0539_ sky130_fd_sc_hd__or4_1
X_1444_ net60 net186 _0404_ VGND VGND VPWR VPWR _0175_ sky130_fd_sc_hd__mux2_1
X_1513_ net145 net56 _0413_ VGND VGND VPWR VPWR _0235_ sky130_fd_sc_hd__mux2_1
Xclkbuf_leaf_4_clk clknet_2_1__leaf_clk VGND VGND VPWR VPWR clknet_leaf_4_clk sky130_fd_sc_hd__clkbuf_8
XFILLER_4_40 VGND VPWR VPWR VGND sky130_ef_sc_hd__decap_12
X_1375_ net122 _0394_ VGND VGND VPWR VPWR _0115_ sky130_fd_sc_hd__xor2_1
XFILLER_58_121 VGND VPWR VPWR VGND sky130_ef_sc_hd__decap_12
Xfanout50 din_latch\[7\] VGND VGND VPWR VPWR net50 sky130_fd_sc_hd__buf_2
Xfanout61 din_latch\[1\] VGND VGND VPWR VPWR net61 sky130_fd_sc_hd__clkbuf_4
Xfanout94 net96 VGND VGND VPWR VPWR net94 sky130_fd_sc_hd__clkbuf_4
Xfanout83 net84 VGND VGND VPWR VPWR net83 sky130_fd_sc_hd__clkbuf_4
Xfanout72 net82 VGND VGND VPWR VPWR net72 sky130_fd_sc_hd__buf_2
XFILLER_49_154 VGND VPWR VPWR VGND sky130_ef_sc_hd__decap_12
XFILLER_45_360 VGND VPWR VPWR VGND sky130_ef_sc_hd__decap_12
X_1160_ _0749_ VGND VGND VPWR VPWR _0750_ sky130_fd_sc_hd__inv_2
X_1091_ u_jt49.u_env.gain\[0\] _0694_ _0630_ VGND VGND VPWR VPWR _0696_ sky130_fd_sc_hd__a21oi_1
X_0944_ u_jt49.regarray\[1\]\[5\] _0528_ _0533_ u_jt49.regarray\[8\]\[5\] _0585_ VGND
+ VGND VPWR VPWR _0586_ sky130_fd_sc_hd__a221o_1
X_0875_ net46 net45 VGND VGND VPWR VPWR _0522_ sky130_fd_sc_hd__nand2b_2
Xclkload20 clknet_leaf_25_clk VGND VGND VPWR VPWR clkload20/Y sky130_fd_sc_hd__inv_4
XFILLER_55_113 VGND VPWR VPWR VGND sky130_ef_sc_hd__decap_12
X_1427_ net58 IOA_out[3] _0402_ VGND VGND VPWR VPWR _0160_ sky130_fd_sc_hd__mux2_1
XFILLER_28_305 VGND VGND VPWR VPWR sky130_fd_sc_hd__decap_3
XFILLER_18_38 VGND VGND VPWR VPWR sky130_fd_sc_hd__decap_6
X_1358_ _0360_ _0383_ _0384_ u_jt49.u_chA.count\[9\] net38 VGND VGND VPWR VPWR _0109_
+ sky130_fd_sc_hd__a32o_1
XFILLER_51_374 VGND VGND VPWR VPWR sky130_fd_sc_hd__decap_6
X_1289_ u_jt49.u_chB.count\[9\] _0327_ VGND VGND VPWR VPWR _0329_ sky130_fd_sc_hd__or2_1
XFILLER_34_15 VGND VPWR VPWR VGND sky130_ef_sc_hd__decap_12
Xclkload3 clknet_leaf_28_clk VGND VGND VPWR VPWR clkload3/Y sky130_fd_sc_hd__clkinv_1
XFILLER_61_105 VGND VGND VPWR VPWR sky130_fd_sc_hd__decap_6
XFILLER_61_149 VGND VPWR VPWR VGND sky130_ef_sc_hd__decap_12
XFILLER_6_253 VGND VPWR VPWR VGND sky130_ef_sc_hd__decap_12
XFILLER_6_286 VGND VPWR VPWR VGND sky130_ef_sc_hd__decap_12
X_1212_ net142 net159 net34 VGND VGND VPWR VPWR _0079_ sky130_fd_sc_hd__mux2_1
XFILLER_37_146 VGND VGND VPWR VPWR sky130_fd_sc_hd__decap_3
X_1074_ _0679_ _0681_ VGND VGND VPWR VPWR _0682_ sky130_fd_sc_hd__nor2_1
X_1143_ net42 net67 VGND VGND VPWR VPWR _0738_ sky130_fd_sc_hd__nand2_1
X_0927_ u_jt49.periodA\[11\] _0528_ _0533_ u_jt49.regarray\[8\]\[3\] VGND VGND VPWR
+ VPWR _0571_ sky130_fd_sc_hd__a22o_1
X_0858_ net78 _0508_ VGND VGND VPWR VPWR _0018_ sky130_fd_sc_hd__and2_1
X_0789_ u_jt49.u_env.gain\[3\] VGND VGND VPWR VPWR _0443_ sky130_fd_sc_hd__inv_2
Xhold37 u_jt49.regarray\[5\]\[6\] VGND VGND VPWR VPWR net134 sky130_fd_sc_hd__dlygate4sd3_1
Xhold48 u_jt49.regarray\[1\]\[4\] VGND VGND VPWR VPWR net145 sky130_fd_sc_hd__dlygate4sd3_1
Xhold26 u_jt49.regarray\[8\]\[5\] VGND VGND VPWR VPWR net123 sky130_fd_sc_hd__dlygate4sd3_1
Xhold59 u_jt49.regarray\[1\]\[6\] VGND VGND VPWR VPWR net156 sky130_fd_sc_hd__dlygate4sd3_1
Xhold15 u_jt49.Cmix VGND VGND VPWR VPWR net112 sky130_fd_sc_hd__dlygate4sd3_1
XFILLER_61_57 VGND VPWR VPWR VGND sky130_ef_sc_hd__decap_12
XFILLER_59_293 VGND VPWR VPWR VGND sky130_ef_sc_hd__decap_12
XFILLER_19_81 VGND VGND VPWR VPWR sky130_fd_sc_hd__decap_3
X_1761_ clknet_leaf_11_clk _0204_ net92 VGND VGND VPWR VPWR u_jt49.periodC\[7\] sky130_fd_sc_hd__dfrtp_1
X_1830_ clknet_leaf_29_clk _0265_ net70 VGND VGND VPWR VPWR dout[4] sky130_fd_sc_hd__dfrtp_4
X_1692_ clknet_leaf_19_clk _0135_ net86 VGND VGND VPWR VPWR u_jt49.eg_period\[2\]
+ sky130_fd_sc_hd__dfrtp_1
X_1126_ _0440_ u_jt49.u_envdiv.count\[6\] u_jt49.u_envdiv.count\[5\] _0437_ VGND VGND
+ VPWR VPWR _0726_ sky130_fd_sc_hd__o22a_1
X_1057_ u_jt49.u_chC.count\[8\] _0668_ VGND VGND VPWR VPWR _0670_ sky130_fd_sc_hd__or2_1
XFILLER_31_49 VGND VGND VPWR VPWR sky130_fd_sc_hd__decap_6
XFILLER_21_377 VGND VGND VPWR VPWR sky130_fd_sc_hd__decap_3
XFILLER_56_296 VGND VGND VPWR VPWR sky130_fd_sc_hd__decap_3
XFILLER_12_377 VGND VGND VPWR VPWR sky130_fd_sc_hd__decap_3
XFILLER_62_277 VGND VPWR VPWR VGND sky130_ef_sc_hd__decap_12
XFILLER_62_233 VGND VPWR VPWR VGND sky130_ef_sc_hd__decap_12
Xclkbuf_0_clk clk VGND VGND VPWR VPWR clknet_0_clk sky130_fd_sc_hd__clkbuf_16
X_1744_ clknet_leaf_10_clk _0187_ net89 VGND VGND VPWR VPWR u_jt49.regarray\[6\]\[6\]
+ sky130_fd_sc_hd__dfrtp_1
XFILLER_7_51 VGND VGND VPWR VPWR sky130_fd_sc_hd__decap_4
X_1813_ clknet_leaf_23_clk _0256_ VGND VGND VPWR VPWR u_jt49.logC\[1\] sky130_fd_sc_hd__dfxtp_1
XPHY_EDGE_ROW_15_Left_79 VGND VGND VPWR VPWR sky130_fd_sc_hd__decap_3
XPHY_EDGE_ROW_15_Right_15 VGND VGND VPWR VPWR sky130_fd_sc_hd__decap_3
X_1675_ clknet_leaf_25_clk _0118_ net83 VGND VGND VPWR VPWR u_jt49.regarray\[13\]\[1\]
+ sky130_fd_sc_hd__dfrtp_1
XFILLER_53_266 VGND VGND VPWR VPWR sky130_fd_sc_hd__decap_6
X_1109_ _0702_ _0703_ _0706_ _0708_ VGND VGND VPWR VPWR _0709_ sky130_fd_sc_hd__and4_1
XPHY_EDGE_ROW_24_Right_24 VGND VGND VPWR VPWR sky130_fd_sc_hd__decap_3
XFILLER_42_15 VGND VPWR VPWR VGND sky130_ef_sc_hd__decap_12
XPHY_EDGE_ROW_33_Right_33 VGND VGND VPWR VPWR sky130_fd_sc_hd__decap_3
XFILLER_5_329 VGND VGND VPWR VPWR sky130_fd_sc_hd__decap_6
XPHY_EDGE_ROW_42_Right_42 VGND VGND VPWR VPWR sky130_fd_sc_hd__decap_3
XFILLER_29_296 VGND VGND VPWR VPWR sky130_fd_sc_hd__decap_3
XPHY_EDGE_ROW_51_Right_51 VGND VGND VPWR VPWR sky130_fd_sc_hd__decap_3
XFILLER_12_141 VGND VGND VPWR VPWR sky130_fd_sc_hd__decap_6
X_1460_ u_jt49.periodC\[8\] net64 _0406_ VGND VGND VPWR VPWR _0189_ sky130_fd_sc_hd__mux2_1
X_1391_ u_jt49.eg_period\[11\] net58 _0398_ VGND VGND VPWR VPWR _0128_ sky130_fd_sc_hd__mux2_1
XPHY_EDGE_ROW_60_Right_60 VGND VGND VPWR VPWR sky130_fd_sc_hd__decap_3
Xhold112 u_jt49.u_chB.count\[9\] VGND VGND VPWR VPWR net209 sky130_fd_sc_hd__dlygate4sd3_1
X_1727_ clknet_leaf_2_clk _0170_ net77 VGND VGND VPWR VPWR u_jt49.regarray\[8\]\[5\]
+ sky130_fd_sc_hd__dfrtp_1
X_1658_ clknet_leaf_29_clk _0103_ net67 VGND VGND VPWR VPWR u_jt49.u_chA.count\[3\]
+ sky130_fd_sc_hd__dfrtp_1
Xhold101 u_jt49.regarray\[8\]\[1\] VGND VGND VPWR VPWR net198 sky130_fd_sc_hd__dlygate4sd3_1
XFILLER_58_369 VGND VGND VPWR VPWR sky130_fd_sc_hd__decap_8
X_1589_ clknet_leaf_21_clk net116 VGND VGND VPWR VPWR u_jt49.u_env.rst_latch sky130_fd_sc_hd__dfxtp_1
XFILLER_41_225 VGND VGND VPWR VPWR sky130_fd_sc_hd__decap_4
XFILLER_5_137 VGND VPWR VPWR VGND sky130_ef_sc_hd__decap_12
XFILLER_1_332 VGND VGND VPWR VPWR sky130_fd_sc_hd__decap_4
XFILLER_17_255 VGND VGND VPWR VPWR sky130_fd_sc_hd__decap_4
X_0960_ u_jt49.periodA\[6\] _0518_ _0544_ _0600_ u_jt49.read_mask\[5\] VGND VGND VPWR
+ VPWR _0601_ sky130_fd_sc_hd__o2111a_1
X_0891_ u_jt49.periodB\[8\] _0515_ _0534_ u_jt49.periodC\[8\] VGND VGND VPWR VPWR
+ _0538_ sky130_fd_sc_hd__a22o_1
X_1512_ u_jt49.periodA\[11\] net57 _0413_ VGND VGND VPWR VPWR _0234_ sky130_fd_sc_hd__mux2_1
X_1443_ net61 net183 _0404_ VGND VGND VPWR VPWR _0174_ sky130_fd_sc_hd__mux2_1
X_1374_ _0394_ net189 VGND VGND VPWR VPWR _0114_ sky130_fd_sc_hd__nor2_1
XFILLER_4_85 VGND VPWR VPWR VGND sky130_ef_sc_hd__decap_12
XFILLER_4_52 VGND VPWR VPWR VGND sky130_ef_sc_hd__decap_12
XPHY_EDGE_ROW_18_Left_82 VGND VGND VPWR VPWR sky130_fd_sc_hd__decap_3
XFILLER_58_133 VGND VGND VPWR VPWR sky130_fd_sc_hd__decap_6
XPHY_EDGE_ROW_45_Left_109 VGND VGND VPWR VPWR sky130_fd_sc_hd__decap_3
XPHY_EDGE_ROW_54_Left_118 VGND VGND VPWR VPWR sky130_fd_sc_hd__decap_3
Xfanout62 din_latch\[1\] VGND VGND VPWR VPWR net62 sky130_fd_sc_hd__clkbuf_2
Xfanout51 net52 VGND VGND VPWR VPWR net51 sky130_fd_sc_hd__buf_2
Xfanout40 net41 VGND VGND VPWR VPWR net40 sky130_fd_sc_hd__buf_2
Xfanout73 net82 VGND VGND VPWR VPWR net73 sky130_fd_sc_hd__clkbuf_4
Xfanout95 net96 VGND VGND VPWR VPWR net95 sky130_fd_sc_hd__clkbuf_4
Xfanout84 net85 VGND VGND VPWR VPWR net84 sky130_fd_sc_hd__clkbuf_4
XPHY_EDGE_ROW_63_Left_127 VGND VGND VPWR VPWR sky130_fd_sc_hd__decap_3
XFILLER_52_309 VGND VPWR VPWR VGND sky130_ef_sc_hd__decap_12
X_1090_ u_jt49.u_env.gain\[0\] _0694_ VGND VGND VPWR VPWR _0695_ sky130_fd_sc_hd__or2_1
Xclkload10 clknet_leaf_5_clk VGND VGND VPWR VPWR clkload10/Y sky130_fd_sc_hd__inv_6
X_0874_ _0519_ _0520_ VGND VGND VPWR VPWR _0521_ sky130_fd_sc_hd__nor2_4
X_0943_ u_jt49.periodB\[5\] _0527_ _0543_ _0517_ VGND VGND VPWR VPWR _0585_ sky130_fd_sc_hd__a211o_1
Xclkload21 clknet_leaf_10_clk VGND VGND VPWR VPWR clkload21/X sky130_fd_sc_hd__clkbuf_8
XFILLER_55_147 VGND VPWR VPWR VGND sky130_ef_sc_hd__decap_12
XFILLER_55_125 VGND VPWR VPWR VGND sky130_ef_sc_hd__decap_12
X_1288_ _0307_ _0326_ _0328_ VGND VGND VPWR VPWR _0095_ sky130_fd_sc_hd__and3_1
X_1426_ net60 IOA_out[2] _0402_ VGND VGND VPWR VPWR _0159_ sky130_fd_sc_hd__mux2_1
X_1357_ u_jt49.u_chA.count\[9\] _0381_ VGND VGND VPWR VPWR _0384_ sky130_fd_sc_hd__or2_1
XFILLER_50_15 VGND VPWR VPWR VGND sky130_ef_sc_hd__decap_12
Xclkload4 clknet_leaf_29_clk VGND VGND VPWR VPWR clkload4/Y sky130_fd_sc_hd__clkinvlp_4
XFILLER_59_57 VGND VPWR VPWR VGND sky130_ef_sc_hd__decap_12
XPHY_EDGE_ROW_3_Left_67 VGND VGND VPWR VPWR sky130_fd_sc_hd__decap_3
XFILLER_1_6 VGND VPWR VPWR VGND sky130_ef_sc_hd__decap_12
XFILLER_34_309 VGND VGND VPWR VPWR sky130_fd_sc_hd__decap_4
XFILLER_42_353 VGND VGND VPWR VPWR sky130_fd_sc_hd__decap_8
XFILLER_6_265 VGND VGND VPWR VPWR sky130_fd_sc_hd__decap_4
XFILLER_6_298 VGND VGND VPWR VPWR sky130_fd_sc_hd__decap_8
XFILLER_1_53 VGND VGND VPWR VPWR sky130_fd_sc_hd__decap_3
X_1211_ u_jt49.u_ng.poly17\[11\] net142 net34 VGND VGND VPWR VPWR _0078_ sky130_fd_sc_hd__mux2_1
X_1142_ net181 _0737_ net40 VGND VGND VPWR VPWR _0049_ sky130_fd_sc_hd__mux2_1
XFILLER_33_342 VGND VPWR VPWR VGND sky130_ef_sc_hd__decap_12
X_1073_ _0677_ _0678_ _0680_ VGND VGND VPWR VPWR _0681_ sky130_fd_sc_hd__or3_1
X_0857_ net78 _0505_ VGND VGND VPWR VPWR _0019_ sky130_fd_sc_hd__and2_1
X_0926_ u_jt49.regarray\[13\]\[3\] _0529_ _0532_ u_jt49.regarray\[7\]\[3\] _0569_
+ VGND VGND VPWR VPWR _0570_ sky130_fd_sc_hd__a221o_1
Xhold38 u_jt49.regarray\[10\]\[7\] VGND VGND VPWR VPWR net135 sky130_fd_sc_hd__dlygate4sd3_1
Xhold27 u_jt49.regarray\[8\]\[6\] VGND VGND VPWR VPWR net124 sky130_fd_sc_hd__dlygate4sd3_1
Xhold16 u_jt49.Amix VGND VGND VPWR VPWR net113 sky130_fd_sc_hd__dlygate4sd3_1
X_0788_ u_jt49.regarray\[13\]\[0\] VGND VGND VPWR VPWR _0442_ sky130_fd_sc_hd__inv_2
X_1409_ net213 net58 _0400_ VGND VGND VPWR VPWR _0144_ sky130_fd_sc_hd__mux2_1
Xhold49 u_jt49.regarray\[13\]\[5\] VGND VGND VPWR VPWR net146 sky130_fd_sc_hd__dlygate4sd3_1
XFILLER_28_147 VGND VPWR VPWR VGND sky130_ef_sc_hd__decap_12
XFILLER_61_69 VGND VPWR VPWR VGND sky130_ef_sc_hd__decap_12
X_1760_ clknet_leaf_11_clk _0203_ net92 VGND VGND VPWR VPWR u_jt49.periodC\[6\] sky130_fd_sc_hd__dfrtp_1
X_1691_ clknet_leaf_18_clk _0134_ net83 VGND VGND VPWR VPWR u_jt49.eg_period\[1\]
+ sky130_fd_sc_hd__dfrtp_1
XFILLER_32_3 VGND VGND VPWR VPWR sky130_fd_sc_hd__decap_6
X_1125_ _0722_ _0723_ _0724_ VGND VGND VPWR VPWR _0725_ sky130_fd_sc_hd__a21o_1
X_1056_ net32 _0667_ _0669_ VGND VGND VPWR VPWR _0031_ sky130_fd_sc_hd__and3_1
XFILLER_18_191 VGND VGND VPWR VPWR sky130_fd_sc_hd__decap_4
X_0909_ _0552_ _0554_ VGND VGND VPWR VPWR _0555_ sky130_fd_sc_hd__or2_1
XFILLER_47_275 VGND VGND VPWR VPWR sky130_fd_sc_hd__decap_4
XPHY_EDGE_ROW_6_Left_70 VGND VGND VPWR VPWR sky130_fd_sc_hd__decap_3
XFILLER_62_289 VGND VPWR VPWR VGND sky130_ef_sc_hd__decap_12
XFILLER_62_245 VGND VGND VPWR VPWR sky130_fd_sc_hd__decap_6
X_1743_ clknet_leaf_9_clk _0186_ net80 VGND VGND VPWR VPWR u_jt49.regarray\[6\]\[5\]
+ sky130_fd_sc_hd__dfrtp_1
XFILLER_30_197 VGND VGND VPWR VPWR sky130_fd_sc_hd__decap_8
X_1674_ clknet_leaf_19_clk _0117_ net83 VGND VGND VPWR VPWR u_jt49.regarray\[13\]\[0\]
+ sky130_fd_sc_hd__dfrtp_1
X_1812_ clknet_leaf_20_clk _0255_ net86 VGND VGND VPWR VPWR u_jt49.eg_restart sky130_fd_sc_hd__dfrtp_1
X_1039_ u_jt49.u_chC.count\[3\] _0654_ VGND VGND VPWR VPWR _0657_ sky130_fd_sc_hd__nand2_1
X_1108_ u_jt49.eg_period\[12\] _0460_ _0705_ VGND VGND VPWR VPWR _0708_ sky130_fd_sc_hd__a21oi_1
XFILLER_38_253 VGND VGND VPWR VPWR sky130_fd_sc_hd__decap_4
XPHY_EDGE_ROW_32_Left_96 VGND VGND VPWR VPWR sky130_fd_sc_hd__decap_3
XFILLER_12_175 VGND VGND VPWR VPWR sky130_fd_sc_hd__decap_4
X_1390_ u_jt49.eg_period\[10\] net59 _0398_ VGND VGND VPWR VPWR _0127_ sky130_fd_sc_hd__mux2_1
Xhold113 u_jt49.bitC VGND VGND VPWR VPWR net210 sky130_fd_sc_hd__dlygate4sd3_1
X_1588_ clknet_leaf_13_clk _0035_ net95 VGND VGND VPWR VPWR u_jt49.u_chC.count\[11\]
+ sky130_fd_sc_hd__dfrtp_1
X_1657_ clknet_leaf_27_clk _0102_ net73 VGND VGND VPWR VPWR u_jt49.u_chA.count\[2\]
+ sky130_fd_sc_hd__dfrtp_1
Xhold102 u_jt49.envelope\[3\] VGND VGND VPWR VPWR net199 sky130_fd_sc_hd__dlygate4sd3_1
X_1726_ clknet_leaf_26_clk _0169_ net72 VGND VGND VPWR VPWR u_jt49.regarray\[8\]\[4\]
+ sky130_fd_sc_hd__dfrtp_4
XFILLER_53_15 VGND VPWR VPWR VGND sky130_ef_sc_hd__decap_12
XFILLER_5_105 VGND VGND VPWR VPWR sky130_fd_sc_hd__decap_6
XFILLER_49_337 VGND VPWR VPWR VGND sky130_ef_sc_hd__decap_12
Xclkbuf_2_0__f_clk clknet_0_clk VGND VGND VPWR VPWR clknet_2_0__leaf_clk sky130_fd_sc_hd__clkbuf_16
XFILLER_43_81 VGND VPWR VPWR VGND sky130_ef_sc_hd__decap_12
X_0890_ u_jt49.eg_period\[0\] _0530_ _0533_ u_jt49.regarray\[8\]\[0\] VGND VGND VPWR
+ VPWR _0537_ sky130_fd_sc_hd__a22o_1
X_1442_ net63 net179 _0404_ VGND VGND VPWR VPWR _0173_ sky130_fd_sc_hd__mux2_1
X_1511_ u_jt49.periodA\[10\] net59 _0413_ VGND VGND VPWR VPWR _0233_ sky130_fd_sc_hd__mux2_1
XFILLER_55_307 VGND VPWR VPWR VGND sky130_ef_sc_hd__decap_12
X_1373_ u_jt49.u_cen.cencnt\[0\] net20 net125 VGND VGND VPWR VPWR _0395_ sky130_fd_sc_hd__a21oi_1
XFILLER_4_97 VGND VPWR VPWR VGND sky130_ef_sc_hd__decap_12
XFILLER_4_64 VGND VPWR VPWR VGND sky130_ef_sc_hd__decap_12
X_1709_ clknet_leaf_25_clk _0152_ net84 VGND VGND VPWR VPWR u_jt49.regarray\[9\]\[3\]
+ sky130_fd_sc_hd__dfrtp_1
Xfanout52 din_latch\[6\] VGND VGND VPWR VPWR net52 sky130_fd_sc_hd__clkbuf_4
Xfanout96 net97 VGND VGND VPWR VPWR net96 sky130_fd_sc_hd__buf_2
Xfanout63 din_latch\[0\] VGND VGND VPWR VPWR net63 sky130_fd_sc_hd__clkbuf_4
Xfanout74 net75 VGND VGND VPWR VPWR net74 sky130_fd_sc_hd__clkbuf_4
Xfanout30 _0732_ VGND VGND VPWR VPWR net30 sky130_fd_sc_hd__clkbuf_2
Xfanout85 net97 VGND VGND VPWR VPWR net85 sky130_fd_sc_hd__clkbuf_4
Xfanout41 u_jt49.u_env.cen VGND VGND VPWR VPWR net41 sky130_fd_sc_hd__clkbuf_2
XFILLER_49_178 VGND VGND VPWR VPWR sky130_fd_sc_hd__decap_4
XFILLER_60_365 VGND VPWR VPWR VGND sky130_ef_sc_hd__decap_12
XFILLER_60_321 VGND VPWR VPWR VGND sky130_ef_sc_hd__decap_12
XFILLER_62_3 VGND VPWR VPWR VGND sky130_ef_sc_hd__decap_12
Xclkload11 clknet_leaf_6_clk VGND VGND VPWR VPWR clkload11/Y sky130_fd_sc_hd__clkinv_8
Xclkload22 clknet_leaf_11_clk VGND VGND VPWR VPWR clkload22/Y sky130_fd_sc_hd__clkinv_2
X_0942_ u_jt49.regarray\[10\]\[5\] _0526_ _0532_ u_jt49.regarray\[7\]\[5\] VGND VGND
+ VPWR VPWR _0584_ sky130_fd_sc_hd__a22o_1
X_0873_ net45 net46 VGND VGND VPWR VPWR _0520_ sky130_fd_sc_hd__nand2b_4
XFILLER_13_281 VGND VPWR VPWR VGND sky130_ef_sc_hd__decap_12
XFILLER_20_218 VGND VGND VPWR VPWR sky130_fd_sc_hd__decap_8
X_1425_ net62 IOA_out[1] _0402_ VGND VGND VPWR VPWR _0158_ sky130_fd_sc_hd__mux2_1
XFILLER_55_159 VGND VGND VPWR VPWR sky130_fd_sc_hd__decap_8
XFILLER_55_137 VGND VGND VPWR VPWR sky130_fd_sc_hd__decap_6
X_1287_ _0327_ VGND VGND VPWR VPWR _0328_ sky130_fd_sc_hd__inv_2
XFILLER_18_29 VGND VGND VPWR VPWR sky130_fd_sc_hd__decap_3
X_1356_ u_jt49.u_chA.count\[9\] u_jt49.u_chA.count\[8\] _0377_ VGND VGND VPWR VPWR
+ _0383_ sky130_fd_sc_hd__nand3_1
XFILLER_63_181 VGND VGND VPWR VPWR sky130_fd_sc_hd__decap_8
Xclkload5 clknet_leaf_30_clk VGND VGND VPWR VPWR clkload5/Y sky130_fd_sc_hd__inv_6
XFILLER_59_69 VGND VPWR VPWR VGND sky130_ef_sc_hd__decap_12
XFILLER_42_365 VGND VPWR VPWR VGND sky130_ef_sc_hd__decap_12
XFILLER_49_91 VGND VGND VPWR VPWR sky130_fd_sc_hd__decap_8
X_1072_ u_jt49.eg_period\[13\] u_jt49.eg_period\[12\] u_jt49.eg_period\[15\] u_jt49.eg_period\[14\]
+ VGND VGND VPWR VPWR _0680_ sky130_fd_sc_hd__or4_1
X_1141_ u_jt49.u_env.gain\[4\] u_jt49.u_env.inv VGND VGND VPWR VPWR _0737_ sky130_fd_sc_hd__xor2_1
X_1210_ u_jt49.u_ng.poly17\[10\] net160 net34 VGND VGND VPWR VPWR _0077_ sky130_fd_sc_hd__mux2_1
XFILLER_18_340 VGND VPWR VPWR VGND sky130_ef_sc_hd__decap_12
XFILLER_33_354 VGND VGND VPWR VPWR sky130_fd_sc_hd__decap_3
X_0856_ net22 addr\[1\] _0504_ VGND VGND VPWR VPWR _0508_ sky130_fd_sc_hd__mux2_1
X_0787_ u_jt49.eg_period\[8\] VGND VGND VPWR VPWR _0441_ sky130_fd_sc_hd__inv_2
X_0925_ u_jt49.eg_period\[3\] _0530_ _0535_ u_jt49.periodC\[3\] VGND VGND VPWR VPWR
+ _0569_ sky130_fd_sc_hd__a22o_1
Xhold39 u_jt49.regarray\[5\]\[7\] VGND VGND VPWR VPWR net136 sky130_fd_sc_hd__dlygate4sd3_1
X_1408_ net212 net60 _0400_ VGND VGND VPWR VPWR _0143_ sky130_fd_sc_hd__mux2_1
Xhold28 u_jt49.u_cen.cencnt\[1\] VGND VGND VPWR VPWR net125 sky130_fd_sc_hd__dlygate4sd3_1
Xhold17 u_jt49.regarray\[9\]\[0\] VGND VGND VPWR VPWR net114 sky130_fd_sc_hd__dlygate4sd3_1
XFILLER_45_49 VGND VGND VPWR VPWR sky130_fd_sc_hd__decap_6
XFILLER_28_137 VGND VGND VPWR VPWR sky130_fd_sc_hd__decap_3
X_1339_ _0370_ VGND VGND VPWR VPWR _0371_ sky130_fd_sc_hd__inv_2
XFILLER_51_140 VGND VGND VPWR VPWR sky130_fd_sc_hd__decap_3
XFILLER_24_365 VGND VGND VPWR VPWR sky130_fd_sc_hd__decap_4
XFILLER_10_52 VGND VPWR VPWR VGND sky130_ef_sc_hd__decap_12
XFILLER_10_85 VGND VGND VPWR VPWR sky130_fd_sc_hd__decap_4
XFILLER_19_50 VGND VGND VPWR VPWR sky130_fd_sc_hd__decap_6
XFILLER_19_148 VGND VGND VPWR VPWR sky130_fd_sc_hd__decap_8
XFILLER_27_181 VGND VPWR VPWR VGND sky130_ef_sc_hd__decap_12
X_1690_ clknet_leaf_19_clk _0133_ net86 VGND VGND VPWR VPWR u_jt49.eg_period\[0\]
+ sky130_fd_sc_hd__dfrtp_1
X_1055_ _0668_ VGND VGND VPWR VPWR _0669_ sky130_fd_sc_hd__inv_2
X_1124_ _0437_ u_jt49.u_envdiv.count\[5\] u_jt49.u_envdiv.count\[4\] _0438_ VGND VGND
+ VPWR VPWR _0724_ sky130_fd_sc_hd__a22o_1
XFILLER_21_357 VGND VPWR VPWR VGND sky130_ef_sc_hd__decap_12
X_0908_ u_jt49.periodA\[9\] _0528_ _0531_ u_jt49.eg_period\[9\] _0553_ VGND VGND VPWR
+ VPWR _0554_ sky130_fd_sc_hd__a221o_1
X_0839_ u_jt49.periodA\[1\] VGND VGND VPWR VPWR _0493_ sky130_fd_sc_hd__inv_2
XFILLER_24_173 VGND VPWR VPWR VGND sky130_ef_sc_hd__decap_12
XFILLER_47_210 VGND VGND VPWR VPWR sky130_fd_sc_hd__decap_8
Xclkbuf_leaf_27_clk clknet_2_0__leaf_clk VGND VGND VPWR VPWR clknet_leaf_27_clk sky130_fd_sc_hd__clkbuf_8
X_1811_ clknet_leaf_23_clk _0254_ VGND VGND VPWR VPWR u_jt49.logB\[4\] sky130_fd_sc_hd__dfxtp_1
X_1673_ clknet_leaf_24_clk _0116_ VGND VGND VPWR VPWR u_jt49.Cmix sky130_fd_sc_hd__dfxtp_1
XFILLER_7_361 VGND VPWR VPWR VGND sky130_ef_sc_hd__decap_12
X_1742_ clknet_leaf_26_clk _0185_ net84 VGND VGND VPWR VPWR u_jt49.regarray\[6\]\[4\]
+ sky130_fd_sc_hd__dfrtp_1
X_1038_ net32 _0655_ _0656_ VGND VGND VPWR VPWR _0026_ sky130_fd_sc_hd__and3_1
X_1107_ _0704_ _0706_ _0702_ VGND VGND VPWR VPWR _0707_ sky130_fd_sc_hd__o21a_1
Xclkbuf_leaf_18_clk clknet_2_2__leaf_clk VGND VGND VPWR VPWR clknet_leaf_18_clk sky130_fd_sc_hd__clkbuf_8
XPHY_EDGE_ROW_5_Right_5 VGND VGND VPWR VPWR sky130_fd_sc_hd__decap_3
XFILLER_44_235 VGND VPWR VPWR VGND sky130_ef_sc_hd__decap_12
XFILLER_4_320 VGND VPWR VPWR VGND sky130_ef_sc_hd__decap_12
XFILLER_50_227 VGND VGND VPWR VPWR sky130_fd_sc_hd__decap_4
X_1725_ clknet_leaf_26_clk _0168_ net72 VGND VGND VPWR VPWR u_jt49.regarray\[8\]\[3\]
+ sky130_fd_sc_hd__dfrtp_1
XFILLER_58_305 VGND VGND VPWR VPWR sky130_fd_sc_hd__decap_3
Xclkbuf_leaf_7_clk clknet_2_1__leaf_clk VGND VGND VPWR VPWR clknet_leaf_7_clk sky130_fd_sc_hd__clkbuf_8
X_1587_ clknet_leaf_13_clk _0034_ net95 VGND VGND VPWR VPWR u_jt49.u_chC.count\[10\]
+ sky130_fd_sc_hd__dfrtp_1
Xhold114 u_jt49.u_chB.count\[7\] VGND VGND VPWR VPWR net211 sky130_fd_sc_hd__dlygate4sd3_1
X_1656_ clknet_leaf_27_clk _0101_ net73 VGND VGND VPWR VPWR u_jt49.u_chA.count\[1\]
+ sky130_fd_sc_hd__dfrtp_1
Xhold103 u_jt49.regarray\[10\]\[1\] VGND VGND VPWR VPWR net200 sky130_fd_sc_hd__dlygate4sd3_1
XFILLER_58_327 VGND VGND VPWR VPWR sky130_fd_sc_hd__decap_8
XFILLER_37_28 VGND VPWR VPWR VGND sky130_ef_sc_hd__decap_12
XFILLER_53_27 VGND VPWR VPWR VGND sky130_ef_sc_hd__decap_12
XFILLER_49_349 VGND VPWR VPWR VGND sky130_ef_sc_hd__decap_12
XFILLER_49_305 VGND VPWR VPWR VGND sky130_ef_sc_hd__decap_12
XFILLER_17_268 VGND VPWR VPWR VGND sky130_ef_sc_hd__decap_12
X_1441_ net36 _0532_ VGND VGND VPWR VPWR _0404_ sky130_fd_sc_hd__nand2_4
X_1510_ u_jt49.periodA\[9\] net61 _0413_ VGND VGND VPWR VPWR _0232_ sky130_fd_sc_hd__mux2_1
XFILLER_4_76 VGND VGND VPWR VPWR sky130_fd_sc_hd__decap_8
XFILLER_55_319 VGND VPWR VPWR VGND sky130_ef_sc_hd__decap_12
X_1372_ u_jt49.u_cen.cencnt\[0\] u_jt49.u_cen.cencnt\[1\] net20 VGND VGND VPWR VPWR
+ _0394_ sky130_fd_sc_hd__and3_1
XFILLER_2_109 VGND VPWR VPWR VGND sky130_ef_sc_hd__decap_12
X_1708_ clknet_leaf_25_clk _0151_ net85 VGND VGND VPWR VPWR u_jt49.regarray\[9\]\[2\]
+ sky130_fd_sc_hd__dfrtp_1
X_1639_ clknet_leaf_8_clk _0000_ VGND VGND VPWR VPWR u_jt49.read_mask\[4\] sky130_fd_sc_hd__dfxtp_1
XFILLER_58_168 VGND VPWR VPWR VGND sky130_ef_sc_hd__decap_12
Xfanout97 net29 VGND VGND VPWR VPWR net97 sky130_fd_sc_hd__buf_2
Xfanout64 din_latch\[0\] VGND VGND VPWR VPWR net64 sky130_fd_sc_hd__buf_2
Xfanout75 net81 VGND VGND VPWR VPWR net75 sky130_fd_sc_hd__clkbuf_4
Xfanout53 din_latch\[5\] VGND VGND VPWR VPWR net53 sky130_fd_sc_hd__clkbuf_4
Xfanout31 _0732_ VGND VGND VPWR VPWR net31 sky130_fd_sc_hd__buf_1
Xfanout86 net88 VGND VGND VPWR VPWR net86 sky130_fd_sc_hd__clkbuf_4
Xfanout42 net44 VGND VGND VPWR VPWR net42 sky130_fd_sc_hd__buf_2
XFILLER_49_102 VGND VGND VPWR VPWR sky130_fd_sc_hd__decap_3
XFILLER_60_377 VGND VGND VPWR VPWR sky130_fd_sc_hd__decap_3
XFILLER_60_333 VGND VPWR VPWR VGND sky130_ef_sc_hd__decap_12
X_0941_ net13 _0546_ _0547_ net5 _0583_ VGND VGND VPWR VPWR _0265_ sky130_fd_sc_hd__a221o_1
Xclkload23 clknet_leaf_12_clk VGND VGND VPWR VPWR clkload23/Y sky130_fd_sc_hd__inv_6
Xclkload12 clknet_leaf_7_clk VGND VGND VPWR VPWR clkload12/Y sky130_fd_sc_hd__clkinv_4
X_0872_ net48 net47 VGND VGND VPWR VPWR _0519_ sky130_fd_sc_hd__nand2b_2
XFILLER_9_242 VGND VGND VPWR VPWR sky130_fd_sc_hd__decap_8
XFILLER_13_293 VGND VPWR VPWR VGND sky130_ef_sc_hd__decap_12
X_1355_ _0362_ _0380_ _0382_ VGND VGND VPWR VPWR _0108_ sky130_fd_sc_hd__and3_1
X_1424_ net64 IOA_out[0] _0402_ VGND VGND VPWR VPWR _0157_ sky130_fd_sc_hd__mux2_1
X_1286_ net43 u_jt49.u_chB.count\[8\] _0325_ VGND VGND VPWR VPWR _0327_ sky130_fd_sc_hd__and3_1
XFILLER_28_319 VGND VGND VPWR VPWR sky130_fd_sc_hd__decap_6
XFILLER_34_29 VGND VPWR VPWR VGND sky130_ef_sc_hd__decap_12
Xclkload6 clknet_leaf_31_clk VGND VGND VPWR VPWR clkload6/X sky130_fd_sc_hd__clkbuf_4
XFILLER_59_26 VGND VPWR VPWR VGND sky130_ef_sc_hd__decap_12
XFILLER_54_193 VGND VGND VPWR VPWR sky130_fd_sc_hd__decap_3
XFILLER_42_377 VGND VGND VPWR VPWR sky130_fd_sc_hd__decap_3
X_1071_ u_jt49.eg_period\[9\] u_jt49.eg_period\[8\] u_jt49.eg_period\[11\] u_jt49.eg_period\[10\]
+ VGND VGND VPWR VPWR _0679_ sky130_fd_sc_hd__or4_1
X_1140_ net199 _0736_ net40 VGND VGND VPWR VPWR _0048_ sky130_fd_sc_hd__mux2_1
XFILLER_18_352 VGND VPWR VPWR VGND sky130_ef_sc_hd__decap_12
XFILLER_60_141 VGND VPWR VPWR VGND sky130_ef_sc_hd__decap_12
XFILLER_33_322 VGND VGND VPWR VPWR sky130_fd_sc_hd__decap_4
X_0924_ u_jt49.periodC\[11\] _0534_ _0566_ _0567_ VGND VGND VPWR VPWR _0568_ sky130_fd_sc_hd__a211o_1
X_0855_ _0505_ _0020_ VGND VGND VPWR VPWR _0507_ sky130_fd_sc_hd__nand2b_1
X_0786_ u_jt49.eg_period\[6\] VGND VGND VPWR VPWR _0440_ sky130_fd_sc_hd__inv_2
Xhold29 _0003_ VGND VGND VPWR VPWR net126 sky130_fd_sc_hd__dlygate4sd3_1
X_1338_ net42 u_jt49.u_chA.count\[4\] _0368_ VGND VGND VPWR VPWR _0370_ sky130_fd_sc_hd__and3_1
Xhold18 u_jt49.eg_restart VGND VGND VPWR VPWR net115 sky130_fd_sc_hd__dlygate4sd3_1
X_1407_ net200 net62 _0400_ VGND VGND VPWR VPWR _0142_ sky130_fd_sc_hd__mux2_1
X_1269_ net39 u_jt49.u_chB.count\[3\] _0305_ _0314_ VGND VGND VPWR VPWR _0090_ sky130_fd_sc_hd__a22o_1
XFILLER_10_64 VGND VPWR VPWR VGND sky130_ef_sc_hd__decap_12
XFILLER_42_152 VGND VGND VPWR VPWR sky130_fd_sc_hd__decap_8
XFILLER_35_83 VGND VPWR VPWR VGND sky130_ef_sc_hd__decap_12
X_1054_ u_jt49.u_chC.count\[7\] u_jt49.u_chC.count\[6\] _0662_ VGND VGND VPWR VPWR
+ _0668_ sky130_fd_sc_hd__and3_1
X_1123_ _0438_ u_jt49.u_envdiv.count\[4\] u_jt49.u_envdiv.count\[3\] _0435_ VGND VGND
+ VPWR VPWR _0723_ sky130_fd_sc_hd__o22a_1
XFILLER_21_303 VGND VGND VPWR VPWR sky130_fd_sc_hd__decap_6
X_0907_ u_jt49.periodB\[9\] _0515_ _0527_ u_jt49.periodB\[1\] VGND VGND VPWR VPWR
+ _0553_ sky130_fd_sc_hd__a22o_1
XFILLER_21_369 VGND VGND VPWR VPWR sky130_fd_sc_hd__decap_8
X_0838_ u_jt49.periodA\[2\] VGND VGND VPWR VPWR _0492_ sky130_fd_sc_hd__inv_2
XFILLER_56_288 VGND VGND VPWR VPWR sky130_fd_sc_hd__decap_8
X_1810_ clknet_leaf_23_clk _0253_ VGND VGND VPWR VPWR u_jt49.logB\[3\] sky130_fd_sc_hd__dfxtp_1
XFILLER_15_196 VGND VGND VPWR VPWR sky130_fd_sc_hd__decap_6
X_1741_ clknet_leaf_26_clk _0184_ net84 VGND VGND VPWR VPWR u_jt49.regarray\[6\]\[3\]
+ sky130_fd_sc_hd__dfrtp_1
X_1672_ clknet_leaf_23_clk net126 VGND VGND VPWR VPWR u_jt49.u_env.cen sky130_fd_sc_hd__dfxtp_1
XFILLER_7_373 VGND VGND VPWR VPWR sky130_fd_sc_hd__decap_6
X_1106_ u_jt49.eg_period\[13\] _0459_ _0460_ u_jt49.eg_period\[12\] VGND VGND VPWR
+ VPWR _0706_ sky130_fd_sc_hd__o22a_1
XFILLER_38_211 VGND VGND VPWR VPWR sky130_fd_sc_hd__decap_3
X_1037_ u_jt49.u_chC.count\[1\] u_jt49.u_chC.count\[0\] net43 u_jt49.u_chC.count\[2\]
+ VGND VGND VPWR VPWR _0656_ sky130_fd_sc_hd__a31o_1
XFILLER_44_247 VGND VGND VPWR VPWR sky130_fd_sc_hd__decap_4
XPHY_EDGE_ROW_11_Right_11 VGND VGND VPWR VPWR sky130_fd_sc_hd__decap_3
XFILLER_16_85 VGND VGND VPWR VPWR sky130_fd_sc_hd__decap_8
XFILLER_32_95 VGND VPWR VPWR VGND sky130_ef_sc_hd__decap_12
XFILLER_4_365 VGND VPWR VPWR VGND sky130_ef_sc_hd__decap_12
XFILLER_4_332 VGND VPWR VPWR VGND sky130_ef_sc_hd__decap_12
XPHY_EDGE_ROW_20_Right_20 VGND VGND VPWR VPWR sky130_fd_sc_hd__decap_3
XFILLER_57_81 VGND VPWR VPWR VGND sky130_ef_sc_hd__decap_12
Xhold115 u_jt49.regarray\[10\]\[2\] VGND VGND VPWR VPWR net212 sky130_fd_sc_hd__dlygate4sd3_1
X_1724_ clknet_leaf_27_clk _0167_ net73 VGND VGND VPWR VPWR u_jt49.regarray\[8\]\[2\]
+ sky130_fd_sc_hd__dfrtp_1
Xhold104 u_jt49.eg_step VGND VGND VPWR VPWR net201 sky130_fd_sc_hd__dlygate4sd3_1
X_1586_ clknet_leaf_13_clk _0033_ net95 VGND VGND VPWR VPWR u_jt49.u_chC.count\[9\]
+ sky130_fd_sc_hd__dfrtp_1
X_1655_ clknet_leaf_29_clk _0100_ net67 VGND VGND VPWR VPWR u_jt49.u_chA.count\[0\]
+ sky130_fd_sc_hd__dfstp_1
XFILLER_53_39 VGND VPWR VPWR VGND sky130_ef_sc_hd__decap_12
XFILLER_49_317 VGND VPWR VPWR VGND sky130_ef_sc_hd__decap_12
XFILLER_17_203 VGND VGND VPWR VPWR sky130_fd_sc_hd__decap_6
XFILLER_27_62 VGND VPWR VPWR VGND sky130_ef_sc_hd__decap_12
X_1440_ net139 net49 _0403_ VGND VGND VPWR VPWR _0172_ sky130_fd_sc_hd__mux2_1
X_1371_ net188 net20 VGND VGND VPWR VPWR _0113_ sky130_fd_sc_hd__xor2_1
X_1638_ clknet_leaf_27_clk _0085_ net73 VGND VGND VPWR VPWR u_jt49.u_ng.noise_en sky130_fd_sc_hd__dfrtp_1
X_1707_ clknet_leaf_25_clk _0150_ net83 VGND VGND VPWR VPWR u_jt49.regarray\[9\]\[1\]
+ sky130_fd_sc_hd__dfrtp_1
XFILLER_46_309 VGND VGND VPWR VPWR sky130_fd_sc_hd__decap_4
X_1569_ clknet_leaf_27_clk _0016_ net73 VGND VGND VPWR VPWR u_jt49.u_ng.u_div.count\[4\]
+ sky130_fd_sc_hd__dfrtp_1
XFILLER_14_206 VGND VPWR VPWR VGND sky130_ef_sc_hd__decap_12
Xfanout76 net81 VGND VGND VPWR VPWR net76 sky130_fd_sc_hd__clkbuf_4
Xfanout54 din_latch\[5\] VGND VGND VPWR VPWR net54 sky130_fd_sc_hd__buf_2
Xfanout32 _0651_ VGND VGND VPWR VPWR net32 sky130_fd_sc_hd__clkbuf_2
Xfanout43 net44 VGND VGND VPWR VPWR net43 sky130_fd_sc_hd__buf_2
Xfanout87 net88 VGND VGND VPWR VPWR net87 sky130_fd_sc_hd__buf_2
Xfanout65 _0501_ VGND VGND VPWR VPWR net65 sky130_fd_sc_hd__buf_2
XFILLER_13_86 VGND VGND VPWR VPWR sky130_fd_sc_hd__decap_4
XFILLER_38_50 VGND VGND VPWR VPWR sky130_fd_sc_hd__decap_6
XFILLER_37_309 VGND VGND VPWR VPWR sky130_fd_sc_hd__decap_8
XFILLER_60_345 VGND VPWR VPWR VGND sky130_ef_sc_hd__decap_12
XFILLER_60_301 VGND VGND VPWR VPWR sky130_fd_sc_hd__decap_6
X_0940_ u_jt49.periodA\[4\] _0518_ _0544_ _0582_ u_jt49.read_mask\[4\] VGND VGND VPWR
+ VPWR _0583_ sky130_fd_sc_hd__o2111a_1
Xclkload24 clknet_leaf_13_clk VGND VGND VPWR VPWR clkload24/Y sky130_fd_sc_hd__inv_6
Xclkload13 clknet_leaf_9_clk VGND VGND VPWR VPWR clkload13/Y sky130_fd_sc_hd__clkinv_4
XPHY_EDGE_ROW_41_Left_105 VGND VGND VPWR VPWR sky130_fd_sc_hd__decap_3
X_0871_ _0514_ _0516_ VGND VGND VPWR VPWR _0518_ sky130_fd_sc_hd__or2_2
X_1285_ net43 _0322_ u_jt49.u_chB.count\[8\] VGND VGND VPWR VPWR _0326_ sky130_fd_sc_hd__a21o_1
XPHY_EDGE_ROW_50_Left_114 VGND VGND VPWR VPWR sky130_fd_sc_hd__decap_3
XFILLER_48_3 VGND VGND VPWR VPWR sky130_fd_sc_hd__decap_6
XFILLER_28_309 VGND VGND VPWR VPWR sky130_fd_sc_hd__decap_3
X_1423_ net37 _0547_ VGND VGND VPWR VPWR _0402_ sky130_fd_sc_hd__nand2_4
X_1354_ _0381_ VGND VGND VPWR VPWR _0382_ sky130_fd_sc_hd__inv_2
XFILLER_50_29 VGND VPWR VPWR VGND sky130_ef_sc_hd__decap_12
Xclkload7 clknet_leaf_2_clk VGND VGND VPWR VPWR clkload7/Y sky130_fd_sc_hd__inv_8
XFILLER_59_38 VGND VPWR VPWR VGND sky130_ef_sc_hd__decap_12
XFILLER_24_74 VGND VGND VPWR VPWR sky130_fd_sc_hd__decap_6
XFILLER_6_246 VGND VGND VPWR VPWR sky130_fd_sc_hd__decap_6
XFILLER_1_45 VGND VGND VPWR VPWR sky130_fd_sc_hd__decap_8
X_1070_ u_jt49.eg_period\[1\] u_jt49.eg_period\[0\] u_jt49.eg_period\[3\] u_jt49.eg_period\[2\]
+ VGND VGND VPWR VPWR _0678_ sky130_fd_sc_hd__or4_1
XFILLER_60_197 VGND VPWR VPWR VGND sky130_ef_sc_hd__decap_12
XFILLER_60_153 VGND VPWR VPWR VGND sky130_ef_sc_hd__decap_12
X_0854_ net78 _0506_ VGND VGND VPWR VPWR _0020_ sky130_fd_sc_hd__and2_1
X_0923_ u_jt49.periodB\[11\] _0515_ _0526_ u_jt49.regarray\[10\]\[3\] _0517_ VGND
+ VGND VPWR VPWR _0567_ sky130_fd_sc_hd__a221o_1
XPHY_EDGE_ROW_49_Right_49 VGND VGND VPWR VPWR sky130_fd_sc_hd__decap_3
X_0785_ u_jt49.eg_period\[7\] VGND VGND VPWR VPWR _0439_ sky130_fd_sc_hd__inv_2
XPHY_EDGE_ROW_58_Right_58 VGND VGND VPWR VPWR sky130_fd_sc_hd__decap_3
X_1268_ u_jt49.u_chB.count\[3\] _0311_ _0313_ VGND VGND VPWR VPWR _0314_ sky130_fd_sc_hd__o21ba_1
XFILLER_28_117 VGND VPWR VPWR VGND sky130_ef_sc_hd__decap_12
X_1337_ net38 u_jt49.u_chA.count\[3\] _0360_ _0369_ VGND VGND VPWR VPWR _0103_ sky130_fd_sc_hd__a22o_1
Xhold19 _0036_ VGND VGND VPWR VPWR net116 sky130_fd_sc_hd__dlygate4sd3_1
X_1406_ net207 net64 _0400_ VGND VGND VPWR VPWR _0141_ sky130_fd_sc_hd__mux2_1
X_1199_ u_jt49.u_ng.last_en u_jt49.u_ng.noise_en net42 VGND VGND VPWR VPWR _0777_
+ sky130_fd_sc_hd__and3b_1
XFILLER_10_76 VGND VGND VPWR VPWR sky130_fd_sc_hd__decap_8
XFILLER_42_197 VGND VGND VPWR VPWR sky130_fd_sc_hd__decap_8
XFILLER_35_95 VGND VGND VPWR VPWR sky130_fd_sc_hd__decap_4
X_1122_ _0719_ _0720_ _0721_ VGND VGND VPWR VPWR _0722_ sky130_fd_sc_hd__a21o_1
X_1053_ _0448_ _0665_ VGND VGND VPWR VPWR _0667_ sky130_fd_sc_hd__nand2_1
X_0837_ u_jt49.periodA\[3\] VGND VGND VPWR VPWR _0491_ sky130_fd_sc_hd__inv_2
X_0906_ u_jt49.regarray\[6\]\[1\] _0521_ _0533_ u_jt49.regarray\[8\]\[1\] _0517_ VGND
+ VGND VPWR VPWR _0552_ sky130_fd_sc_hd__a221o_1
XFILLER_56_256 VGND VGND VPWR VPWR sky130_fd_sc_hd__decap_4
XFILLER_56_212 VGND VGND VPWR VPWR sky130_fd_sc_hd__decap_4
XFILLER_21_31 VGND VPWR VPWR VGND sky130_ef_sc_hd__decap_12
XFILLER_46_72 VGND VPWR VPWR VGND sky130_ef_sc_hd__decap_12
X_1671_ clknet_leaf_24_clk _0002_ VGND VGND VPWR VPWR u_jt49.u_chA.cen sky130_fd_sc_hd__dfxtp_1
X_1740_ clknet_leaf_25_clk _0183_ net84 VGND VGND VPWR VPWR u_jt49.regarray\[6\]\[2\]
+ sky130_fd_sc_hd__dfrtp_1
X_1105_ u_jt49.eg_period\[15\] _0457_ VGND VGND VPWR VPWR _0705_ sky130_fd_sc_hd__and2_1
XFILLER_61_281 VGND VPWR VPWR VGND sky130_ef_sc_hd__decap_12
X_1036_ _0654_ VGND VGND VPWR VPWR _0655_ sky130_fd_sc_hd__inv_2
XFILLER_21_189 VGND VPWR VPWR VGND sky130_ef_sc_hd__decap_12
XFILLER_29_234 VGND VGND VPWR VPWR sky130_fd_sc_hd__decap_8
XFILLER_4_377 VGND VGND VPWR VPWR sky130_fd_sc_hd__decap_3
XFILLER_4_344 VGND VPWR VPWR VGND sky130_ef_sc_hd__decap_12
XFILLER_57_93 VGND VPWR VPWR VGND sky130_ef_sc_hd__decap_12
X_1654_ clknet_leaf_3_clk _0099_ net77 VGND VGND VPWR VPWR u_jt49.bitB sky130_fd_sc_hd__dfrtp_1
X_1723_ clknet_leaf_26_clk _0166_ net71 VGND VGND VPWR VPWR u_jt49.regarray\[8\]\[1\]
+ sky130_fd_sc_hd__dfrtp_1
Xhold105 u_jt49.regarray\[6\]\[0\] VGND VGND VPWR VPWR net202 sky130_fd_sc_hd__dlygate4sd3_1
Xhold116 u_jt49.regarray\[10\]\[3\] VGND VGND VPWR VPWR net213 sky130_fd_sc_hd__dlygate4sd3_1
X_1585_ clknet_leaf_13_clk _0032_ net95 VGND VGND VPWR VPWR u_jt49.u_chC.count\[8\]
+ sky130_fd_sc_hd__dfrtp_1
X_1019_ _0637_ _0638_ _0639_ VGND VGND VPWR VPWR _0640_ sky130_fd_sc_hd__a21o_1
XFILLER_57_362 VGND VGND VPWR VPWR sky130_fd_sc_hd__decap_6
XFILLER_49_329 VGND VGND VPWR VPWR sky130_fd_sc_hd__decap_6
XFILLER_27_52 VGND VGND VPWR VPWR sky130_fd_sc_hd__decap_4
XFILLER_27_96 VGND VGND VPWR VPWR sky130_fd_sc_hd__decap_4
XFILLER_25_281 VGND VGND VPWR VPWR sky130_fd_sc_hd__decap_8
X_1370_ _0393_ net206 _0362_ VGND VGND VPWR VPWR _0112_ sky130_fd_sc_hd__mux2_1
XFILLER_63_365 VGND VPWR VPWR VGND sky130_ef_sc_hd__decap_12
XFILLER_63_343 VGND VPWR VPWR VGND sky130_ef_sc_hd__decap_12
XFILLER_63_321 VGND VPWR VPWR VGND sky130_ef_sc_hd__decap_12
X_1637_ clknet_leaf_0_clk _0084_ VGND VGND VPWR VPWR u_jt49.noise sky130_fd_sc_hd__dfxtp_1
X_1706_ clknet_leaf_25_clk _0149_ net85 VGND VGND VPWR VPWR u_jt49.regarray\[9\]\[0\]
+ sky130_fd_sc_hd__dfrtp_1
XFILLER_54_321 VGND VPWR VPWR VGND sky130_ef_sc_hd__decap_12
XFILLER_48_18 VGND VGND VPWR VPWR sky130_fd_sc_hd__decap_8
X_1499_ u_jt49.periodB\[1\] net61 _0411_ VGND VGND VPWR VPWR _0223_ sky130_fd_sc_hd__mux2_1
X_1568_ clknet_leaf_27_clk _0015_ net73 VGND VGND VPWR VPWR u_jt49.u_ng.u_div.count\[3\]
+ sky130_fd_sc_hd__dfrtp_1
XFILLER_54_376 VGND VGND VPWR VPWR sky130_fd_sc_hd__decap_4
XFILLER_54_365 VGND VGND VPWR VPWR sky130_fd_sc_hd__decap_3
Xfanout55 net56 VGND VGND VPWR VPWR net55 sky130_fd_sc_hd__buf_2
Xfanout44 u_jt49.u_chA.cen VGND VGND VPWR VPWR net44 sky130_fd_sc_hd__buf_2
XFILLER_14_218 VGND VGND VPWR VPWR sky130_fd_sc_hd__decap_4
Xfanout77 net80 VGND VGND VPWR VPWR net77 sky130_fd_sc_hd__clkbuf_4
Xfanout88 net97 VGND VGND VPWR VPWR net88 sky130_fd_sc_hd__buf_2
Xfanout66 _0501_ VGND VGND VPWR VPWR net66 sky130_fd_sc_hd__clkbuf_2
XFILLER_22_262 VGND VGND VPWR VPWR sky130_fd_sc_hd__decap_4
XFILLER_1_177 VGND VGND VPWR VPWR sky130_fd_sc_hd__decap_6
XFILLER_60_357 VGND VGND VPWR VPWR sky130_fd_sc_hd__decap_6
X_0870_ _0514_ _0516_ VGND VGND VPWR VPWR _0517_ sky130_fd_sc_hd__nor2_4
Xclkload25 clknet_leaf_14_clk VGND VGND VPWR VPWR clkload25/Y sky130_fd_sc_hd__clkinv_2
X_1422_ net147 net49 _0401_ VGND VGND VPWR VPWR _0156_ sky130_fd_sc_hd__mux2_1
Xclkload14 clknet_leaf_18_clk VGND VGND VPWR VPWR clkload14/X sky130_fd_sc_hd__clkbuf_4
X_1284_ _0305_ _0323_ _0324_ net211 net39 VGND VGND VPWR VPWR _0094_ sky130_fd_sc_hd__a32o_1
X_1353_ net42 u_jt49.u_chA.count\[8\] _0377_ VGND VGND VPWR VPWR _0381_ sky130_fd_sc_hd__and3_1
XFILLER_51_302 VGND VPWR VPWR VGND sky130_ef_sc_hd__decap_12
XFILLER_36_365 VGND VPWR VPWR VGND sky130_ef_sc_hd__decap_12
Xclkload8 clknet_leaf_3_clk VGND VGND VPWR VPWR clkload8/Y sky130_fd_sc_hd__clkinv_2
X_0999_ u_jt49.u_ng.u_div.count\[3\] _0623_ VGND VGND VPWR VPWR _0625_ sky130_fd_sc_hd__nand2_1
XFILLER_40_41 VGND VGND VPWR VPWR sky130_fd_sc_hd__decap_4
XFILLER_60_165 VGND VPWR VPWR VGND sky130_ef_sc_hd__decap_12
XFILLER_60_121 VGND VPWR VPWR VGND sky130_ef_sc_hd__decap_12
XFILLER_1_57 VGND VGND VPWR VPWR sky130_fd_sc_hd__decap_8
XFILLER_18_365 VGND VPWR VPWR VGND sky130_ef_sc_hd__decap_12
XPHY_EDGE_ROW_23_Left_87 VGND VGND VPWR VPWR sky130_fd_sc_hd__decap_3
XFILLER_60_3 VGND VGND VPWR VPWR sky130_fd_sc_hd__decap_8
X_0853_ net24 net45 _0504_ VGND VGND VPWR VPWR _0506_ sky130_fd_sc_hd__mux2_1
X_0922_ u_jt49.regarray\[6\]\[3\] _0521_ _0524_ u_jt49.regarray\[9\]\[3\] VGND VGND
+ VPWR VPWR _0566_ sky130_fd_sc_hd__a22o_1
X_1405_ net36 _0526_ VGND VGND VPWR VPWR _0400_ sky130_fd_sc_hd__and2_2
X_0784_ u_jt49.eg_period\[4\] VGND VGND VPWR VPWR _0438_ sky130_fd_sc_hd__inv_2
X_1198_ _0457_ _0776_ net31 VGND VGND VPWR VPWR _0066_ sky130_fd_sc_hd__a21boi_1
X_1267_ u_jt49.u_chB.count\[3\] u_jt49.u_chB.count\[2\] u_jt49.u_chB.count\[1\] u_jt49.u_chB.count\[0\]
+ VGND VGND VPWR VPWR _0313_ sky130_fd_sc_hd__and4_1
XFILLER_28_129 VGND VGND VPWR VPWR sky130_fd_sc_hd__decap_8
Xinput1 IOA_in[0] VGND VGND VPWR VPWR net1 sky130_fd_sc_hd__buf_1
X_1336_ u_jt49.u_chA.count\[3\] _0366_ _0368_ VGND VGND VPWR VPWR _0369_ sky130_fd_sc_hd__o21ba_1
XFILLER_51_132 VGND VGND VPWR VPWR sky130_fd_sc_hd__decap_8
XFILLER_35_30 VGND VGND VPWR VPWR sky130_fd_sc_hd__decap_4
XFILLER_15_346 VGND VPWR VPWR VGND sky130_ef_sc_hd__decap_12
XFILLER_30_338 VGND VGND VPWR VPWR sky130_fd_sc_hd__decap_4
X_1052_ net32 _0665_ _0666_ VGND VGND VPWR VPWR _0030_ sky130_fd_sc_hd__and3_1
X_1121_ _0435_ u_jt49.u_envdiv.count\[3\] u_jt49.u_envdiv.count\[2\] _0436_ VGND VGND
+ VPWR VPWR _0721_ sky130_fd_sc_hd__a22o_1
X_0905_ u_jt49.periodC\[1\] _0535_ _0548_ _0550_ VGND VGND VPWR VPWR _0551_ sky130_fd_sc_hd__a211o_1
X_0836_ u_jt49.periodA\[4\] VGND VGND VPWR VPWR _0490_ sky130_fd_sc_hd__inv_2
XFILLER_56_29 VGND VPWR VPWR VGND sky130_ef_sc_hd__decap_12
XFILLER_0_209 VGND VPWR VPWR VGND sky130_ef_sc_hd__decap_12
X_1319_ u_jt49.u_chA.count\[6\] _0488_ _0347_ _0354_ _0346_ VGND VGND VPWR VPWR _0355_
+ sky130_fd_sc_hd__a221o_1
XFILLER_24_121 VGND VGND VPWR VPWR sky130_fd_sc_hd__decap_3
XFILLER_8_309 VGND VPWR VPWR VGND sky130_ef_sc_hd__decap_12
XFILLER_12_316 VGND VPWR VPWR VGND sky130_ef_sc_hd__decap_12
XFILLER_12_305 VGND VGND VPWR VPWR sky130_fd_sc_hd__decap_3
XFILLER_21_43 VGND VGND VPWR VPWR sky130_fd_sc_hd__decap_8
X_1670_ clknet_leaf_23_clk _0115_ net85 VGND VGND VPWR VPWR u_jt49.u_cen.cencnt\[2\]
+ sky130_fd_sc_hd__dfrtp_1
X_1035_ u_jt49.u_chC.count\[2\] u_jt49.u_chC.count\[1\] u_jt49.u_chC.count\[0\] net44
+ VGND VGND VPWR VPWR _0654_ sky130_fd_sc_hd__and4_1
X_1104_ _0703_ VGND VGND VPWR VPWR _0704_ sky130_fd_sc_hd__inv_2
XFILLER_61_293 VGND VPWR VPWR VGND sky130_ef_sc_hd__decap_12
XFILLER_21_157 VGND VGND VPWR VPWR sky130_fd_sc_hd__decap_4
XPHY_EDGE_ROW_26_Left_90 VGND VGND VPWR VPWR sky130_fd_sc_hd__decap_3
X_0819_ u_jt49.u_chB.count\[9\] VGND VGND VPWR VPWR _0473_ sky130_fd_sc_hd__inv_2
X_1799_ clknet_leaf_28_clk _0242_ VGND VGND VPWR VPWR u_jt49.logA\[4\] sky130_fd_sc_hd__dfxtp_1
XPHY_EDGE_ROW_10_Left_74 VGND VGND VPWR VPWR sky130_fd_sc_hd__decap_3
XFILLER_29_268 VGND VGND VPWR VPWR sky130_fd_sc_hd__decap_3
XFILLER_16_43 VGND VGND VPWR VPWR sky130_fd_sc_hd__decap_3
XFILLER_4_356 VGND VGND VPWR VPWR sky130_fd_sc_hd__decap_8
XFILLER_43_271 VGND VGND VPWR VPWR sky130_fd_sc_hd__decap_8
X_1584_ clknet_leaf_13_clk _0031_ net92 VGND VGND VPWR VPWR u_jt49.u_chC.count\[7\]
+ sky130_fd_sc_hd__dfrtp_1
X_1653_ clknet_leaf_7_clk _0098_ net78 VGND VGND VPWR VPWR u_jt49.u_chB.count\[11\]
+ sky130_fd_sc_hd__dfrtp_1
Xhold117 u_jt49.u_cen.cencnt\[2\] VGND VGND VPWR VPWR net214 sky130_fd_sc_hd__dlygate4sd3_1
Xhold106 u_jt49.envelope\[2\] VGND VGND VPWR VPWR net203 sky130_fd_sc_hd__dlygate4sd3_1
XPHY_EDGE_ROW_9_Right_9 VGND VGND VPWR VPWR sky130_fd_sc_hd__decap_3
X_1722_ clknet_leaf_26_clk _0165_ net71 VGND VGND VPWR VPWR u_jt49.regarray\[8\]\[0\]
+ sky130_fd_sc_hd__dfrtp_1
X_1018_ u_jt49.u_chC.count\[3\] _0452_ u_jt49.u_chC.count\[2\] _0453_ VGND VGND VPWR
+ VPWR _0639_ sky130_fd_sc_hd__a22o_1
XFILLER_1_337 VGND VGND VPWR VPWR sky130_fd_sc_hd__decap_6
XFILLER_32_219 VGND VGND VPWR VPWR sky130_fd_sc_hd__decap_3
XFILLER_63_355 VGND VGND VPWR VPWR sky130_fd_sc_hd__decap_8
XFILLER_63_333 VGND VGND VPWR VPWR sky130_fd_sc_hd__decap_3
X_1705_ clknet_leaf_10_clk _0148_ net77 VGND VGND VPWR VPWR u_jt49.regarray\[10\]\[7\]
+ sky130_fd_sc_hd__dfrtp_1
X_1567_ clknet_leaf_27_clk _0014_ net73 VGND VGND VPWR VPWR u_jt49.u_ng.u_div.count\[2\]
+ sky130_fd_sc_hd__dfrtp_1
X_1636_ clknet_leaf_0_clk _0083_ net68 VGND VGND VPWR VPWR u_jt49.u_ng.poly17\[16\]
+ sky130_fd_sc_hd__dfrtp_1
XFILLER_54_333 VGND VGND VPWR VPWR sky130_fd_sc_hd__decap_6
XFILLER_39_363 VGND VPWR VPWR VGND sky130_ef_sc_hd__decap_12
X_1498_ u_jt49.periodB\[0\] net63 _0411_ VGND VGND VPWR VPWR _0222_ sky130_fd_sc_hd__mux2_1
Xfanout56 din_latch\[4\] VGND VGND VPWR VPWR net56 sky130_fd_sc_hd__clkbuf_4
Xfanout45 addr\[3\] VGND VGND VPWR VPWR net45 sky130_fd_sc_hd__clkbuf_4
Xfanout78 net80 VGND VGND VPWR VPWR net78 sky130_fd_sc_hd__buf_2
Xfanout89 net96 VGND VGND VPWR VPWR net89 sky130_fd_sc_hd__clkbuf_4
Xfanout67 net70 VGND VGND VPWR VPWR net67 sky130_fd_sc_hd__clkbuf_4
Xfanout34 _0777_ VGND VGND VPWR VPWR net34 sky130_fd_sc_hd__clkbuf_4
XFILLER_49_116 VGND VGND VPWR VPWR sky130_fd_sc_hd__decap_4
XFILLER_45_377 VGND VGND VPWR VPWR sky130_fd_sc_hd__decap_3
Xclkload26 clknet_leaf_15_clk VGND VGND VPWR VPWR clkload26/Y sky130_fd_sc_hd__inv_6
Xclkload15 clknet_leaf_19_clk VGND VGND VPWR VPWR clkload15/Y sky130_fd_sc_hd__clkinv_4
X_1421_ net131 net51 _0401_ VGND VGND VPWR VPWR _0155_ sky130_fd_sc_hd__mux2_1
X_1283_ u_jt49.u_chB.count\[7\] u_jt49.u_chB.count\[6\] _0318_ VGND VGND VPWR VPWR
+ _0325_ sky130_fd_sc_hd__and3_1
XFILLER_48_193 VGND VGND VPWR VPWR sky130_fd_sc_hd__decap_3
X_1352_ net42 _0377_ u_jt49.u_chA.count\[8\] VGND VGND VPWR VPWR _0380_ sky130_fd_sc_hd__a21o_1
XFILLER_63_141 VGND VPWR VPWR VGND sky130_ef_sc_hd__decap_12
XFILLER_51_314 VGND VPWR VPWR VGND sky130_ef_sc_hd__decap_12
XFILLER_36_377 VGND VGND VPWR VPWR sky130_fd_sc_hd__decap_3
Xclkload9 clknet_leaf_4_clk VGND VGND VPWR VPWR clkload9/Y sky130_fd_sc_hd__clkinv_2
X_0998_ _0623_ _0624_ VGND VGND VPWR VPWR _0014_ sky130_fd_sc_hd__nor2_1
X_1619_ clknet_leaf_14_clk _0066_ net95 VGND VGND VPWR VPWR u_jt49.u_envdiv.count\[15\]
+ sky130_fd_sc_hd__dfrtp_1
XFILLER_54_185 VGND VGND VPWR VPWR sky130_fd_sc_hd__decap_8
XFILLER_60_177 VGND VPWR VPWR VGND sky130_ef_sc_hd__decap_12
XFILLER_60_133 VGND VGND VPWR VPWR sky130_fd_sc_hd__decap_6
XFILLER_45_196 VGND VGND VPWR VPWR sky130_fd_sc_hd__decap_4
XFILLER_45_141 VGND VPWR VPWR VGND sky130_ef_sc_hd__decap_12
X_0921_ net11 _0546_ _0547_ net3 _0565_ VGND VGND VPWR VPWR _0263_ sky130_fd_sc_hd__a221o_1
XFILLER_18_377 VGND VGND VPWR VPWR sky130_fd_sc_hd__decap_3
X_0852_ net23 addr\[2\] _0504_ VGND VGND VPWR VPWR _0505_ sky130_fd_sc_hd__mux2_1
XFILLER_53_3 VGND VPWR VPWR VGND sky130_ef_sc_hd__decap_12
X_0783_ u_jt49.eg_period\[5\] VGND VGND VPWR VPWR _0437_ sky130_fd_sc_hd__inv_2
X_1404_ net50 u_jt49.eg_period\[7\] _0399_ VGND VGND VPWR VPWR _0140_ sky130_fd_sc_hd__mux2_1
XFILLER_5_281 VGND VPWR VPWR VGND sky130_ef_sc_hd__decap_12
X_1335_ u_jt49.u_chA.count\[3\] u_jt49.u_chA.count\[2\] u_jt49.u_chA.count\[1\] u_jt49.u_chA.count\[0\]
+ VGND VGND VPWR VPWR _0368_ sky130_fd_sc_hd__and4_1
X_1197_ net31 _0775_ _0776_ VGND VGND VPWR VPWR _0065_ sky130_fd_sc_hd__and3_1
X_1266_ _0311_ _0312_ VGND VGND VPWR VPWR _0089_ sky130_fd_sc_hd__nor2_1
XFILLER_36_141 VGND VGND VPWR VPWR sky130_fd_sc_hd__decap_4
Xinput2 IOA_in[1] VGND VGND VPWR VPWR net2 sky130_fd_sc_hd__buf_1
XFILLER_24_325 VGND VPWR VPWR VGND sky130_ef_sc_hd__decap_12
XFILLER_61_19 VGND VPWR VPWR VGND sky130_ef_sc_hd__decap_12
XFILLER_51_188 VGND VGND VPWR VPWR sky130_fd_sc_hd__decap_3
XFILLER_3_207 VGND VGND VPWR VPWR sky130_fd_sc_hd__decap_8
XFILLER_19_98 VGND VGND VPWR VPWR sky130_fd_sc_hd__decap_8
XFILLER_15_358 VGND VPWR VPWR VGND sky130_ef_sc_hd__decap_12
XFILLER_51_30 VGND VPWR VPWR VGND sky130_ef_sc_hd__decap_12
X_1051_ u_jt49.u_chC.count\[6\] _0662_ VGND VGND VPWR VPWR _0666_ sky130_fd_sc_hd__or2_1
XPHY_EDGE_ROW_38_Left_102 VGND VGND VPWR VPWR sky130_fd_sc_hd__decap_3
X_1120_ _0436_ u_jt49.u_envdiv.count\[2\] u_jt49.u_envdiv.count\[1\] _0433_ VGND VGND
+ VPWR VPWR _0720_ sky130_fd_sc_hd__o22a_1
X_0904_ u_jt49.regarray\[9\]\[1\] _0524_ _0529_ u_jt49.regarray\[13\]\[1\] _0549_
+ VGND VGND VPWR VPWR _0550_ sky130_fd_sc_hd__a221o_1
XPHY_EDGE_ROW_47_Left_111 VGND VGND VPWR VPWR sky130_fd_sc_hd__decap_3
X_0835_ u_jt49.periodA\[5\] VGND VGND VPWR VPWR _0489_ sky130_fd_sc_hd__inv_2
X_1318_ _0349_ _0353_ _0348_ VGND VGND VPWR VPWR _0354_ sky130_fd_sc_hd__a21o_1
XPHY_EDGE_ROW_56_Left_120 VGND VGND VPWR VPWR sky130_fd_sc_hd__decap_3
X_1249_ _0289_ _0290_ _0296_ _0297_ VGND VGND VPWR VPWR _0298_ sky130_fd_sc_hd__a211o_1
XFILLER_12_328 VGND VPWR VPWR VGND sky130_ef_sc_hd__decap_12
XFILLER_47_225 VGND VGND VPWR VPWR sky130_fd_sc_hd__decap_4
XFILLER_47_203 VGND VGND VPWR VPWR sky130_fd_sc_hd__decap_3
XFILLER_46_96 VGND VGND VPWR VPWR sky130_fd_sc_hd__decap_3
XFILLER_7_57 VGND VPWR VPWR VGND sky130_ef_sc_hd__decap_12
XFILLER_7_310 VGND VPWR VPWR VGND sky130_ef_sc_hd__decap_12
XFILLER_11_361 VGND VPWR VPWR VGND sky130_ef_sc_hd__decap_12
XFILLER_61_261 VGND VPWR VPWR VGND sky130_ef_sc_hd__decap_12
X_1034_ net32 _0652_ _0653_ VGND VGND VPWR VPWR _0025_ sky130_fd_sc_hd__and3_1
X_1103_ u_jt49.eg_period\[14\] _0458_ _0459_ u_jt49.eg_period\[13\] VGND VGND VPWR
+ VPWR _0703_ sky130_fd_sc_hd__a22oi_2
X_0818_ u_jt49.periodB\[10\] VGND VGND VPWR VPWR _0472_ sky130_fd_sc_hd__inv_2
X_1798_ clknet_leaf_28_clk _0241_ VGND VGND VPWR VPWR u_jt49.logA\[3\] sky130_fd_sc_hd__dfxtp_1
XFILLER_29_203 VGND VGND VPWR VPWR sky130_fd_sc_hd__decap_4
XFILLER_20_191 VGND VGND VPWR VPWR sky130_fd_sc_hd__decap_4
XFILLER_57_51 VGND VGND VPWR VPWR sky130_fd_sc_hd__decap_4
X_1721_ clknet_leaf_14_clk _0164_ net96 VGND VGND VPWR VPWR IOA_out[7] sky130_fd_sc_hd__dfrtp_4
X_1583_ clknet_leaf_12_clk _0030_ net91 VGND VGND VPWR VPWR u_jt49.u_chC.count\[6\]
+ sky130_fd_sc_hd__dfrtp_1
X_1652_ clknet_leaf_7_clk _0097_ net78 VGND VGND VPWR VPWR u_jt49.u_chB.count\[10\]
+ sky130_fd_sc_hd__dfrtp_1
Xhold118 _0611_ VGND VGND VPWR VPWR net215 sky130_fd_sc_hd__dlygate4sd3_1
Xhold107 u_jt49.regarray\[8\]\[2\] VGND VGND VPWR VPWR net204 sky130_fd_sc_hd__dlygate4sd3_1
XFILLER_58_309 VGND VGND VPWR VPWR sky130_fd_sc_hd__decap_8
X_1017_ u_jt49.u_chC.count\[2\] _0453_ u_jt49.u_chC.count\[1\] _0454_ VGND VGND VPWR
+ VPWR _0638_ sky130_fd_sc_hd__o22a_1
XFILLER_57_331 VGND VGND VPWR VPWR sky130_fd_sc_hd__decap_4
XFILLER_43_42 VGND VGND VPWR VPWR sky130_fd_sc_hd__decap_8
XFILLER_40_253 VGND VGND VPWR VPWR sky130_fd_sc_hd__decap_6
XFILLER_4_121 VGND VGND VPWR VPWR sky130_fd_sc_hd__decap_4
XFILLER_16_272 VGND VGND VPWR VPWR sky130_fd_sc_hd__decap_8
X_1704_ clknet_leaf_10_clk _0147_ net89 VGND VGND VPWR VPWR u_jt49.regarray\[10\]\[6\]
+ sky130_fd_sc_hd__dfrtp_1
X_1497_ net36 _0527_ VGND VGND VPWR VPWR _0411_ sky130_fd_sc_hd__and2_2
X_1566_ clknet_leaf_24_clk _0013_ net85 VGND VGND VPWR VPWR u_jt49.u_ng.u_div.count\[1\]
+ sky130_fd_sc_hd__dfrtp_1
X_1635_ clknet_leaf_31_clk _0082_ net68 VGND VGND VPWR VPWR u_jt49.u_ng.poly17\[15\]
+ sky130_fd_sc_hd__dfrtp_1
XFILLER_54_356 VGND VGND VPWR VPWR sky130_fd_sc_hd__decap_8
XFILLER_39_375 VGND VGND VPWR VPWR sky130_fd_sc_hd__decap_4
Xfanout79 net80 VGND VGND VPWR VPWR net79 sky130_fd_sc_hd__clkbuf_2
Xfanout57 din_latch\[3\] VGND VGND VPWR VPWR net57 sky130_fd_sc_hd__clkbuf_4
Xfanout46 addr\[2\] VGND VGND VPWR VPWR net46 sky130_fd_sc_hd__clkbuf_4
XFILLER_22_275 VGND VGND VPWR VPWR sky130_fd_sc_hd__decap_8
Xfanout35 _0777_ VGND VGND VPWR VPWR net35 sky130_fd_sc_hd__buf_2
Xfanout68 net69 VGND VGND VPWR VPWR net68 sky130_fd_sc_hd__clkbuf_4
XFILLER_54_85 VGND VPWR VPWR VGND sky130_ef_sc_hd__decap_12
XFILLER_54_41 VGND VPWR VPWR VGND sky130_ef_sc_hd__decap_12
Xclkload27 clknet_leaf_16_clk VGND VGND VPWR VPWR clkload27/Y sky130_fd_sc_hd__bufinv_16
Xclkload16 clknet_leaf_20_clk VGND VGND VPWR VPWR clkload16/Y sky130_fd_sc_hd__inv_4
X_1420_ net128 net54 _0401_ VGND VGND VPWR VPWR _0154_ sky130_fd_sc_hd__mux2_1
X_1351_ _0360_ _0378_ _0379_ net175 net38 VGND VGND VPWR VPWR _0107_ sky130_fd_sc_hd__a32o_1
X_1282_ _0475_ _0320_ VGND VGND VPWR VPWR _0324_ sky130_fd_sc_hd__nand2_1
XFILLER_63_197 VGND VPWR VPWR VGND sky130_ef_sc_hd__decap_12
XFILLER_51_326 VGND VGND VPWR VPWR sky130_fd_sc_hd__decap_8
XFILLER_51_337 VGND VPWR VPWR VGND sky130_ef_sc_hd__decap_12
X_1618_ clknet_leaf_14_clk _0065_ net96 VGND VGND VPWR VPWR u_jt49.u_envdiv.count\[14\]
+ sky130_fd_sc_hd__dfrtp_1
XFILLER_8_290 VGND VGND VPWR VPWR sky130_fd_sc_hd__decap_4
X_0997_ net205 _0620_ _0619_ VGND VGND VPWR VPWR _0624_ sky130_fd_sc_hd__o21ai_1
X_1549_ net66 net106 _0427_ _0428_ VGND VGND VPWR VPWR _0256_ sky130_fd_sc_hd__a22o_1
XFILLER_54_197 VGND VGND VPWR VPWR sky130_fd_sc_hd__decap_6
XFILLER_45_153 VGND VGND VPWR VPWR sky130_fd_sc_hd__decap_4
XFILLER_60_189 VGND VGND VPWR VPWR sky130_fd_sc_hd__decap_6
X_0920_ u_jt49.periodA\[2\] _0518_ _0544_ _0564_ VGND VGND VPWR VPWR _0565_ sky130_fd_sc_hd__o211a_1
X_0851_ net18 _0502_ _0503_ VGND VGND VPWR VPWR _0504_ sky130_fd_sc_hd__o21ai_4
X_0782_ u_jt49.eg_period\[2\] VGND VGND VPWR VPWR _0436_ sky130_fd_sc_hd__inv_2
XFILLER_46_3 VGND VPWR VPWR VGND sky130_ef_sc_hd__decap_12
X_1265_ u_jt49.u_chB.count\[2\] _0308_ _0307_ VGND VGND VPWR VPWR _0312_ sky130_fd_sc_hd__o21ai_1
X_1403_ net51 u_jt49.eg_period\[6\] _0399_ VGND VGND VPWR VPWR _0139_ sky130_fd_sc_hd__mux2_1
XFILLER_5_293 VGND VPWR VPWR VGND sky130_ef_sc_hd__decap_12
X_1334_ _0366_ _0367_ VGND VGND VPWR VPWR _0102_ sky130_fd_sc_hd__nor2_1
XPHY_EDGE_ROW_18_Right_18 VGND VGND VPWR VPWR sky130_fd_sc_hd__decap_3
X_1196_ _0458_ _0459_ _0771_ VGND VGND VPWR VPWR _0776_ sky130_fd_sc_hd__or3b_1
XPHY_EDGE_ROW_27_Right_27 VGND VGND VPWR VPWR sky130_fd_sc_hd__decap_3
Xinput3 IOA_in[2] VGND VGND VPWR VPWR net3 sky130_fd_sc_hd__buf_1
XFILLER_24_337 VGND VGND VPWR VPWR sky130_fd_sc_hd__decap_6
XFILLER_59_201 VGND VGND VPWR VPWR sky130_fd_sc_hd__decap_3
XPHY_EDGE_ROW_36_Right_36 VGND VGND VPWR VPWR sky130_fd_sc_hd__decap_3
XPHY_EDGE_ROW_45_Right_45 VGND VGND VPWR VPWR sky130_fd_sc_hd__decap_3
XFILLER_30_318 VGND VPWR VPWR VGND sky130_ef_sc_hd__decap_12
XFILLER_23_370 VGND VGND VPWR VPWR sky130_fd_sc_hd__decap_6
XPHY_EDGE_ROW_54_Right_54 VGND VGND VPWR VPWR sky130_fd_sc_hd__decap_3
XFILLER_51_42 VGND VPWR VPWR VGND sky130_ef_sc_hd__decap_12
XPHY_EDGE_ROW_63_Right_63 VGND VGND VPWR VPWR sky130_fd_sc_hd__decap_3
X_1050_ u_jt49.u_chC.count\[6\] _0662_ VGND VGND VPWR VPWR _0665_ sky130_fd_sc_hd__nand2_1
XFILLER_33_134 VGND VGND VPWR VPWR sky130_fd_sc_hd__decap_3
XFILLER_18_197 VGND VGND VPWR VPWR sky130_fd_sc_hd__decap_3
X_0834_ u_jt49.periodA\[6\] VGND VGND VPWR VPWR _0488_ sky130_fd_sc_hd__inv_2
X_0903_ u_jt49.regarray\[10\]\[1\] _0526_ _0530_ u_jt49.eg_period\[1\] VGND VGND VPWR
+ VPWR _0549_ sky130_fd_sc_hd__a22o_1
X_1248_ _0476_ u_jt49.periodB\[6\] _0282_ _0291_ _0292_ VGND VGND VPWR VPWR _0297_
+ sky130_fd_sc_hd__a2111o_1
X_1317_ _0350_ _0351_ _0352_ VGND VGND VPWR VPWR _0353_ sky130_fd_sc_hd__a21o_1
X_1179_ _0763_ VGND VGND VPWR VPWR _0764_ sky130_fd_sc_hd__inv_2
XFILLER_62_85 VGND VPWR VPWR VGND sky130_ef_sc_hd__decap_12
XFILLER_62_41 VGND VPWR VPWR VGND sky130_ef_sc_hd__decap_12
XFILLER_30_159 VGND VGND VPWR VPWR sky130_fd_sc_hd__decap_4
XFILLER_7_322 VGND VPWR VPWR VGND sky130_ef_sc_hd__decap_12
XFILLER_11_373 VGND VGND VPWR VPWR sky130_fd_sc_hd__decap_4
XFILLER_7_69 VGND VPWR VPWR VGND sky130_ef_sc_hd__decap_12
X_1102_ u_jt49.eg_period\[15\] _0457_ _0458_ u_jt49.eg_period\[14\] VGND VGND VPWR
+ VPWR _0702_ sky130_fd_sc_hd__o22a_1
XFILLER_61_273 VGND VGND VPWR VPWR sky130_fd_sc_hd__decap_6
X_1033_ u_jt49.u_chC.count\[1\] u_jt49.u_chC.count\[0\] net44 VGND VGND VPWR VPWR
+ _0653_ sky130_fd_sc_hd__nand3_1
XFILLER_21_104 VGND VGND VPWR VPWR sky130_fd_sc_hd__decap_8
X_0817_ u_jt49.periodB\[11\] VGND VGND VPWR VPWR _0471_ sky130_fd_sc_hd__inv_2
X_1797_ clknet_leaf_28_clk _0240_ VGND VGND VPWR VPWR u_jt49.logA\[2\] sky130_fd_sc_hd__dfxtp_1
XFILLER_16_23 VGND VGND VPWR VPWR sky130_fd_sc_hd__decap_4
XPHY_EDGE_ROW_0_Right_0 VGND VGND VPWR VPWR sky130_fd_sc_hd__decap_3
XFILLER_32_66 VGND VPWR VPWR VGND sky130_ef_sc_hd__decap_12
X_1651_ clknet_leaf_7_clk _0096_ net81 VGND VGND VPWR VPWR u_jt49.u_chB.count\[9\]
+ sky130_fd_sc_hd__dfrtp_1
X_1720_ clknet_leaf_15_clk _0163_ net94 VGND VGND VPWR VPWR IOA_out[6] sky130_fd_sc_hd__dfrtp_4
XFILLER_7_174 VGND VPWR VPWR VGND sky130_ef_sc_hd__decap_12
Xhold108 u_jt49.u_ng.u_div.count\[2\] VGND VGND VPWR VPWR net205 sky130_fd_sc_hd__dlygate4sd3_1
XFILLER_11_181 VGND VGND VPWR VPWR sky130_fd_sc_hd__decap_6
X_1582_ clknet_leaf_12_clk _0029_ net91 VGND VGND VPWR VPWR u_jt49.u_chC.count\[5\]
+ sky130_fd_sc_hd__dfrtp_1
XFILLER_19_281 VGND VGND VPWR VPWR sky130_fd_sc_hd__decap_4
X_1016_ u_jt49.u_chC.count\[1\] _0454_ _0455_ u_jt49.u_chC.count\[0\] VGND VGND VPWR
+ VPWR _0637_ sky130_fd_sc_hd__a211o_1
XFILLER_34_273 VGND VPWR VPWR VGND sky130_ef_sc_hd__decap_12
XFILLER_17_218 VGND VGND VPWR VPWR sky130_fd_sc_hd__decap_6
Xclkbuf_leaf_20_clk clknet_2_2__leaf_clk VGND VGND VPWR VPWR clknet_leaf_20_clk sky130_fd_sc_hd__clkbuf_8
XFILLER_4_133 VGND VGND VPWR VPWR sky130_fd_sc_hd__decap_6
XFILLER_48_365 VGND VPWR VPWR VGND sky130_ef_sc_hd__decap_12
XFILLER_48_321 VGND VPWR VPWR VGND sky130_ef_sc_hd__decap_12
XFILLER_0_361 VGND VGND VPWR VPWR sky130_fd_sc_hd__decap_3
Xclkbuf_leaf_11_clk clknet_2_3__leaf_clk VGND VGND VPWR VPWR clknet_leaf_11_clk sky130_fd_sc_hd__clkbuf_8
X_1703_ clknet_leaf_10_clk _0146_ net89 VGND VGND VPWR VPWR u_jt49.regarray\[10\]\[5\]
+ sky130_fd_sc_hd__dfrtp_1
X_1634_ clknet_leaf_31_clk _0081_ net68 VGND VGND VPWR VPWR u_jt49.u_ng.poly17\[14\]
+ sky130_fd_sc_hd__dfrtp_1
XFILLER_39_321 VGND VGND VPWR VPWR sky130_fd_sc_hd__decap_6
X_1496_ net113 net65 _0410_ VGND VGND VPWR VPWR _0221_ sky130_fd_sc_hd__a21o_1
X_1565_ clknet_leaf_24_clk _0012_ net85 VGND VGND VPWR VPWR u_jt49.u_ng.u_div.count\[0\]
+ sky130_fd_sc_hd__dfstp_1
Xfanout47 addr\[1\] VGND VGND VPWR VPWR net47 sky130_fd_sc_hd__buf_2
Xfanout58 din_latch\[3\] VGND VGND VPWR VPWR net58 sky130_fd_sc_hd__buf_2
Xfanout36 net37 VGND VGND VPWR VPWR net36 sky130_fd_sc_hd__clkbuf_4
Xfanout69 net70 VGND VGND VPWR VPWR net69 sky130_fd_sc_hd__clkbuf_4
XFILLER_1_136 VGND VPWR VPWR VGND sky130_ef_sc_hd__decap_12
XFILLER_8_6 VGND VPWR VPWR VGND sky130_ef_sc_hd__decap_12
XFILLER_54_97 VGND VGND VPWR VPWR sky130_fd_sc_hd__decap_6
XFILLER_54_53 VGND VPWR VPWR VGND sky130_ef_sc_hd__decap_12
XFILLER_9_225 VGND VGND VPWR VPWR sky130_fd_sc_hd__decap_8
XFILLER_13_265 VGND VPWR VPWR VGND sky130_ef_sc_hd__decap_12
Xclkload17 clknet_leaf_21_clk VGND VGND VPWR VPWR clkload17/Y sky130_fd_sc_hd__inv_6
X_1281_ _0322_ VGND VGND VPWR VPWR _0323_ sky130_fd_sc_hd__inv_2
X_1350_ _0487_ _0375_ VGND VGND VPWR VPWR _0379_ sky130_fd_sc_hd__nand2_1
XFILLER_63_121 VGND VPWR VPWR VGND sky130_ef_sc_hd__decap_12
Xclkbuf_leaf_0_clk clknet_2_0__leaf_clk VGND VGND VPWR VPWR clknet_leaf_0_clk sky130_fd_sc_hd__clkbuf_8
XFILLER_51_349 VGND VGND VPWR VPWR sky130_fd_sc_hd__decap_8
X_0996_ _0467_ _0621_ VGND VGND VPWR VPWR _0623_ sky130_fd_sc_hd__nor2_1
X_1617_ clknet_leaf_15_clk _0064_ net93 VGND VGND VPWR VPWR u_jt49.u_envdiv.count\[13\]
+ sky130_fd_sc_hd__dfrtp_1
X_1479_ net61 IOB_out[1] _0408_ VGND VGND VPWR VPWR _0206_ sky130_fd_sc_hd__mux2_1
X_1548_ u_jt49.regarray\[10\]\[0\] u_jt49.envelope\[1\] u_jt49.regarray\[10\]\[4\]
+ VGND VGND VPWR VPWR _0428_ sky130_fd_sc_hd__mux2_1
XFILLER_6_3 VGND VPWR VPWR VGND sky130_ef_sc_hd__decap_12
XFILLER_33_305 VGND VGND VPWR VPWR sky130_fd_sc_hd__decap_6
X_0850_ net17 net19 net18 VGND VGND VPWR VPWR _0503_ sky130_fd_sc_hd__a21bo_1
X_1402_ net54 u_jt49.eg_period\[5\] _0399_ VGND VGND VPWR VPWR _0138_ sky130_fd_sc_hd__mux2_1
X_0781_ u_jt49.eg_period\[3\] VGND VGND VPWR VPWR _0435_ sky130_fd_sc_hd__inv_2
X_1264_ _0480_ _0309_ VGND VGND VPWR VPWR _0311_ sky130_fd_sc_hd__nor2_1
XFILLER_39_3 VGND VGND VPWR VPWR sky130_fd_sc_hd__decap_4
X_1333_ u_jt49.u_chA.count\[2\] _0363_ _0362_ VGND VGND VPWR VPWR _0367_ sky130_fd_sc_hd__o21ai_1
Xinput4 IOA_in[3] VGND VGND VPWR VPWR net4 sky130_fd_sc_hd__buf_1
X_1195_ u_jt49.u_envdiv.count\[13\] u_jt49.u_envdiv.count\[12\] _0768_ u_jt49.u_envdiv.count\[14\]
+ VGND VGND VPWR VPWR _0775_ sky130_fd_sc_hd__a31o_1
Xclkbuf_2_1__f_clk clknet_0_clk VGND VGND VPWR VPWR clknet_2_1__leaf_clk sky130_fd_sc_hd__clkbuf_16
XFILLER_36_165 VGND VGND VPWR VPWR sky130_fd_sc_hd__decap_3
XFILLER_32_360 VGND VGND VPWR VPWR sky130_fd_sc_hd__decap_4
X_0979_ net57 net24 _0612_ VGND VGND VPWR VPWR _0007_ sky130_fd_sc_hd__mux2_1
XFILLER_59_246 VGND VPWR VPWR VGND sky130_ef_sc_hd__decap_12
XFILLER_50_190 VGND VGND VPWR VPWR sky130_fd_sc_hd__decap_6
XFILLER_33_102 VGND VGND VPWR VPWR sky130_fd_sc_hd__decap_8
X_0902_ u_jt49.regarray\[7\]\[1\] _0532_ _0534_ u_jt49.periodC\[9\] VGND VGND VPWR
+ VPWR _0548_ sky130_fd_sc_hd__a22o_1
X_0833_ u_jt49.u_chA.count\[7\] VGND VGND VPWR VPWR _0487_ sky130_fd_sc_hd__inv_2
X_1247_ _0478_ u_jt49.periodB\[4\] _0284_ _0293_ _0294_ VGND VGND VPWR VPWR _0296_
+ sky130_fd_sc_hd__o2111ai_1
X_1178_ u_jt49.u_envdiv.count\[9\] _0760_ VGND VGND VPWR VPWR _0763_ sky130_fd_sc_hd__and2_1
X_1316_ u_jt49.u_chA.count\[3\] _0491_ u_jt49.u_chA.count\[2\] _0492_ VGND VGND VPWR
+ VPWR _0352_ sky130_fd_sc_hd__a22o_1
XFILLER_21_68 VGND VGND VPWR VPWR sky130_fd_sc_hd__decap_6
XFILLER_46_54 VGND VPWR VPWR VGND sky130_ef_sc_hd__decap_12
Xmax_cap33 _0699_ VGND VGND VPWR VPWR net33 sky130_fd_sc_hd__clkbuf_1
XFILLER_62_97 VGND VPWR VPWR VGND sky130_ef_sc_hd__decap_12
XFILLER_62_53 VGND VPWR VPWR VGND sky130_ef_sc_hd__decap_12
XFILLER_7_15 VGND VPWR VPWR VGND sky130_ef_sc_hd__decap_12
X_1032_ u_jt49.u_chC.count\[0\] net44 u_jt49.u_chC.count\[1\] VGND VGND VPWR VPWR
+ _0652_ sky130_fd_sc_hd__a21o_1
X_1101_ _0688_ _0694_ _0701_ VGND VGND VPWR VPWR _0044_ sky130_fd_sc_hd__o21ai_1
XFILLER_23_6 VGND VGND VPWR VPWR sky130_fd_sc_hd__decap_8
XFILLER_21_138 VGND VGND VPWR VPWR sky130_fd_sc_hd__decap_3
X_0816_ u_jt49.u_chB.count\[11\] VGND VGND VPWR VPWR _0470_ sky130_fd_sc_hd__inv_2
X_1796_ clknet_leaf_28_clk _0239_ VGND VGND VPWR VPWR u_jt49.logA\[1\] sky130_fd_sc_hd__dfxtp_1
XFILLER_52_241 VGND VGND VPWR VPWR sky130_fd_sc_hd__decap_8
XFILLER_52_296 VGND VPWR VPWR VGND sky130_ef_sc_hd__decap_12
XFILLER_32_78 VGND VGND VPWR VPWR sky130_fd_sc_hd__decap_6
XFILLER_8_109 VGND VPWR VPWR VGND sky130_ef_sc_hd__decap_12
XFILLER_16_79 VGND VGND VPWR VPWR sky130_fd_sc_hd__decap_4
X_1581_ clknet_leaf_12_clk _0028_ net91 VGND VGND VPWR VPWR u_jt49.u_chC.count\[4\]
+ sky130_fd_sc_hd__dfrtp_1
X_1650_ clknet_leaf_7_clk _0095_ net76 VGND VGND VPWR VPWR u_jt49.u_chB.count\[8\]
+ sky130_fd_sc_hd__dfrtp_1
XFILLER_11_160 VGND VGND VPWR VPWR sky130_fd_sc_hd__decap_8
Xhold109 u_jt49.bitA VGND VGND VPWR VPWR net206 sky130_fd_sc_hd__dlygate4sd3_1
X_1015_ u_jt49.u_chC.count\[5\] _0450_ u_jt49.u_chC.count\[4\] _0451_ VGND VGND VPWR
+ VPWR _0636_ sky130_fd_sc_hd__a22o_1
XPHY_EDGE_ROW_14_Left_78 VGND VGND VPWR VPWR sky130_fd_sc_hd__decap_3
X_1779_ clknet_leaf_4_clk _0222_ net74 VGND VGND VPWR VPWR u_jt49.periodB\[0\] sky130_fd_sc_hd__dfrtp_1
XFILLER_57_311 VGND VGND VPWR VPWR sky130_fd_sc_hd__decap_4
XFILLER_43_99 VGND VPWR VPWR VGND sky130_ef_sc_hd__decap_12
XFILLER_48_377 VGND VGND VPWR VPWR sky130_fd_sc_hd__decap_3
XFILLER_48_333 VGND VPWR VPWR VGND sky130_ef_sc_hd__decap_12
X_1564_ clknet_leaf_14_clk _0011_ VGND VGND VPWR VPWR din_latch\[7\] sky130_fd_sc_hd__dfxtp_1
X_1633_ clknet_leaf_31_clk _0080_ net67 VGND VGND VPWR VPWR u_jt49.u_ng.poly17\[13\]
+ sky130_fd_sc_hd__dfrtp_1
X_1702_ clknet_leaf_18_clk _0145_ net97 VGND VGND VPWR VPWR u_jt49.regarray\[10\]\[4\]
+ sky130_fd_sc_hd__dfrtp_4
X_1495_ u_jt49.bitA u_jt49.regarray\[7\]\[0\] u_jt49.regarray\[7\]\[3\] u_jt49.noise
+ net20 VGND VGND VPWR VPWR _0410_ sky130_fd_sc_hd__o221a_1
Xfanout37 u_jt49.write VGND VGND VPWR VPWR net37 sky130_fd_sc_hd__buf_4
Xfanout48 addr\[0\] VGND VGND VPWR VPWR net48 sky130_fd_sc_hd__buf_2
Xfanout59 din_latch\[2\] VGND VGND VPWR VPWR net59 sky130_fd_sc_hd__clkbuf_4
XFILLER_38_66 VGND VPWR VPWR VGND sky130_ef_sc_hd__decap_12
XFILLER_54_65 VGND VPWR VPWR VGND sky130_ef_sc_hd__decap_12
XFILLER_9_204 VGND VPWR VPWR VGND sky130_ef_sc_hd__decap_12
XFILLER_13_277 VGND VGND VPWR VPWR sky130_fd_sc_hd__decap_3
Xclkload18 clknet_leaf_22_clk VGND VGND VPWR VPWR clkload18/Y sky130_fd_sc_hd__inv_4
X_1280_ u_jt49.u_chB.count\[7\] u_jt49.u_chB.count\[6\] _0318_ VGND VGND VPWR VPWR
+ _0322_ sky130_fd_sc_hd__and3_1
XFILLER_48_141 VGND VPWR VPWR VGND sky130_ef_sc_hd__decap_12
XFILLER_0_181 VGND VGND VPWR VPWR sky130_fd_sc_hd__decap_8
XFILLER_63_133 VGND VGND VPWR VPWR sky130_fd_sc_hd__decap_6
X_0995_ _0619_ _0621_ _0622_ VGND VGND VPWR VPWR _0013_ sky130_fd_sc_hd__and3_1
X_1616_ clknet_leaf_15_clk _0063_ net93 VGND VGND VPWR VPWR u_jt49.u_envdiv.count\[12\]
+ sky130_fd_sc_hd__dfrtp_1
X_1547_ u_jt49.Cmix net20 VGND VGND VPWR VPWR _0427_ sky130_fd_sc_hd__and2_1
XFILLER_5_81 VGND VPWR VPWR VGND sky130_ef_sc_hd__decap_12
XFILLER_39_163 VGND VGND VPWR VPWR sky130_fd_sc_hd__decap_4
X_1478_ net63 IOB_out[0] _0408_ VGND VGND VPWR VPWR _0205_ sky130_fd_sc_hd__mux2_1
XFILLER_27_347 VGND VGND VPWR VPWR sky130_fd_sc_hd__decap_8
XFILLER_27_303 VGND VGND VPWR VPWR sky130_fd_sc_hd__decap_3
XPHY_EDGE_ROW_17_Left_81 VGND VGND VPWR VPWR sky130_fd_sc_hd__decap_3
XFILLER_49_65 VGND VGND VPWR VPWR sky130_fd_sc_hd__decap_4
X_0780_ u_jt49.eg_period\[0\] VGND VGND VPWR VPWR _0434_ sky130_fd_sc_hd__inv_2
X_1401_ net55 u_jt49.eg_period\[4\] _0399_ VGND VGND VPWR VPWR _0137_ sky130_fd_sc_hd__mux2_1
XFILLER_5_251 VGND VGND VPWR VPWR sky130_fd_sc_hd__decap_3
X_1194_ _0459_ _0772_ _0774_ VGND VGND VPWR VPWR _0064_ sky130_fd_sc_hd__o21a_1
X_1263_ _0307_ _0309_ _0310_ VGND VGND VPWR VPWR _0088_ sky130_fd_sc_hd__and3_1
X_1332_ u_jt49.u_chA.count\[2\] _0363_ VGND VGND VPWR VPWR _0366_ sky130_fd_sc_hd__and2_1
Xinput5 IOA_in[4] VGND VGND VPWR VPWR net5 sky130_fd_sc_hd__buf_1
XFILLER_36_188 VGND VGND VPWR VPWR sky130_fd_sc_hd__decap_8
X_0978_ net59 net23 _0612_ VGND VGND VPWR VPWR _0006_ sky130_fd_sc_hd__mux2_1
XFILLER_10_15 VGND VPWR VPWR VGND sky130_ef_sc_hd__decap_12
XFILLER_59_258 VGND VPWR VPWR VGND sky130_ef_sc_hd__decap_12
XFILLER_59_225 VGND VGND VPWR VPWR sky130_fd_sc_hd__decap_4
XFILLER_19_57 VGND VPWR VPWR VGND sky130_ef_sc_hd__decap_12
XFILLER_42_169 VGND VGND VPWR VPWR sky130_fd_sc_hd__decap_4
XPHY_EDGE_ROW_2_Left_66 VGND VGND VPWR VPWR sky130_fd_sc_hd__decap_3
XFILLER_2_276 VGND VPWR VPWR VGND sky130_ef_sc_hd__decap_12
X_0901_ net9 _0546_ _0547_ net1 _0545_ VGND VGND VPWR VPWR _0261_ sky130_fd_sc_hd__a221o_1
X_0832_ u_jt49.periodA\[8\] VGND VGND VPWR VPWR _0486_ sky130_fd_sc_hd__inv_2
XFILLER_51_3 VGND VGND VPWR VPWR sky130_fd_sc_hd__decap_6
X_1315_ u_jt49.u_chA.count\[2\] _0492_ u_jt49.u_chA.count\[1\] _0493_ VGND VGND VPWR
+ VPWR _0351_ sky130_fd_sc_hd__o22a_1
X_1246_ _0283_ _0285_ _0293_ _0294_ VGND VGND VPWR VPWR _0295_ sky130_fd_sc_hd__o211a_1
X_1177_ net30 _0761_ _0762_ VGND VGND VPWR VPWR _0059_ sky130_fd_sc_hd__and3_1
XFILLER_12_309 VGND VGND VPWR VPWR sky130_fd_sc_hd__decap_4
XFILLER_62_209 VGND VPWR VPWR VGND sky130_ef_sc_hd__decap_12
XFILLER_55_261 VGND VGND VPWR VPWR sky130_fd_sc_hd__decap_8
XFILLER_46_88 VGND VGND VPWR VPWR sky130_fd_sc_hd__decap_8
XFILLER_15_125 VGND VGND VPWR VPWR sky130_fd_sc_hd__decap_4
XFILLER_15_169 VGND VPWR VPWR VGND sky130_ef_sc_hd__decap_12
XFILLER_62_65 VGND VPWR VPWR VGND sky130_ef_sc_hd__decap_12
XFILLER_7_27 VGND VPWR VPWR VGND sky130_ef_sc_hd__decap_12
X_1031_ net43 _0649_ VGND VGND VPWR VPWR _0651_ sky130_fd_sc_hd__nand2_1
X_1100_ _0685_ _0686_ net193 VGND VGND VPWR VPWR _0701_ sky130_fd_sc_hd__o21ai_1
X_1795_ clknet_leaf_1_clk _0238_ net71 VGND VGND VPWR VPWR u_jt49.regarray\[1\]\[7\]
+ sky130_fd_sc_hd__dfrtp_1
X_0815_ u_jt49.u_ng.u_div.count\[0\] VGND VGND VPWR VPWR _0469_ sky130_fd_sc_hd__inv_2
XFILLER_52_231 VGND VGND VPWR VPWR sky130_fd_sc_hd__decap_6
X_1229_ u_jt49.periodC\[11\] u_jt49.periodC\[10\] u_jt49.periodC\[9\] u_jt49.periodC\[8\]
+ VGND VGND VPWR VPWR _0279_ sky130_fd_sc_hd__or4_1
XFILLER_20_172 VGND VGND VPWR VPWR sky130_fd_sc_hd__decap_3
XFILLER_28_261 VGND VPWR VPWR VGND sky130_ef_sc_hd__decap_12
X_1580_ clknet_leaf_12_clk _0027_ net91 VGND VGND VPWR VPWR u_jt49.u_chC.count\[3\]
+ sky130_fd_sc_hd__dfrtp_1
XFILLER_7_165 VGND VGND VPWR VPWR sky130_fd_sc_hd__decap_3
XFILLER_11_172 VGND VGND VPWR VPWR sky130_fd_sc_hd__decap_6
X_1014_ _0446_ u_jt49.periodC\[9\] _0447_ u_jt49.periodC\[8\] VGND VGND VPWR VPWR
+ _0635_ sky130_fd_sc_hd__o22a_1
X_1778_ clknet_leaf_28_clk _0221_ VGND VGND VPWR VPWR u_jt49.Amix sky130_fd_sc_hd__dfxtp_1
XPHY_EDGE_ROW_31_Left_95 VGND VGND VPWR VPWR sky130_fd_sc_hd__decap_3
XFILLER_4_168 VGND VGND VPWR VPWR sky130_fd_sc_hd__decap_3
XFILLER_63_337 VGND VGND VPWR VPWR sky130_fd_sc_hd__decap_3
XFILLER_48_345 VGND VPWR VPWR VGND sky130_ef_sc_hd__decap_12
XFILLER_16_253 VGND VGND VPWR VPWR sky130_fd_sc_hd__decap_6
X_1701_ clknet_leaf_26_clk _0144_ net84 VGND VGND VPWR VPWR u_jt49.regarray\[10\]\[3\]
+ sky130_fd_sc_hd__dfrtp_1
X_1563_ clknet_leaf_14_clk _0010_ VGND VGND VPWR VPWR din_latch\[6\] sky130_fd_sc_hd__dfxtp_1
X_1494_ net138 net49 _0409_ VGND VGND VPWR VPWR _0220_ sky130_fd_sc_hd__mux2_1
X_1632_ clknet_leaf_30_clk _0079_ net67 VGND VGND VPWR VPWR u_jt49.u_ng.poly17\[12\]
+ sky130_fd_sc_hd__dfrtp_1
XFILLER_58_109 VGND VPWR VPWR VGND sky130_ef_sc_hd__decap_12
Xfanout38 _0456_ VGND VGND VPWR VPWR net38 sky130_fd_sc_hd__clkbuf_4
Xfanout49 din_latch\[7\] VGND VGND VPWR VPWR net49 sky130_fd_sc_hd__clkbuf_4
XFILLER_45_348 VGND VPWR VPWR VGND sky130_ef_sc_hd__decap_12
XFILLER_45_304 VGND VPWR VPWR VGND sky130_ef_sc_hd__decap_12
XFILLER_38_78 VGND VGND VPWR VPWR sky130_fd_sc_hd__decap_6
XFILLER_54_77 VGND VGND VPWR VPWR sky130_fd_sc_hd__decap_6
XFILLER_9_216 VGND VGND VPWR VPWR sky130_fd_sc_hd__decap_8
Xclkload19 clknet_leaf_24_clk VGND VGND VPWR VPWR clkload19/Y sky130_fd_sc_hd__inv_6
XFILLER_48_153 VGND VPWR VPWR VGND sky130_ef_sc_hd__decap_12
XFILLER_63_189 VGND VGND VPWR VPWR sky130_fd_sc_hd__decap_3
XFILLER_48_197 VGND VPWR VPWR VGND sky130_ef_sc_hd__decap_12
X_0994_ net42 u_jt49.u_ng.u_div.count\[0\] u_jt49.u_ng.u_div.count\[1\] VGND VGND
+ VPWR VPWR _0622_ sky130_fd_sc_hd__a21o_1
X_1615_ clknet_leaf_16_clk _0062_ net93 VGND VGND VPWR VPWR u_jt49.u_envdiv.count\[11\]
+ sky130_fd_sc_hd__dfrtp_1
X_1477_ net36 _0546_ VGND VGND VPWR VPWR _0408_ sky130_fd_sc_hd__nand2_4
XFILLER_5_93 VGND VPWR VPWR VGND sky130_ef_sc_hd__decap_12
X_1546_ net153 _0397_ net37 net115 VGND VGND VPWR VPWR _0255_ sky130_fd_sc_hd__a2bb2o_1
XFILLER_39_142 VGND VGND VPWR VPWR sky130_fd_sc_hd__decap_3
XFILLER_10_226 VGND VGND VPWR VPWR sky130_fd_sc_hd__decap_3
XFILLER_1_18 VGND VGND VPWR VPWR sky130_fd_sc_hd__decap_4
XFILLER_33_329 VGND VGND VPWR VPWR sky130_fd_sc_hd__decap_4
X_1400_ net58 u_jt49.eg_period\[3\] _0399_ VGND VGND VPWR VPWR _0136_ sky130_fd_sc_hd__mux2_1
X_1331_ _0362_ _0364_ _0365_ VGND VGND VPWR VPWR _0101_ sky130_fd_sc_hd__and3_1
X_1193_ net41 _0731_ _0771_ u_jt49.u_envdiv.count\[13\] VGND VGND VPWR VPWR _0774_
+ sky130_fd_sc_hd__o2bb2a_1
X_1262_ net43 u_jt49.u_chB.count\[0\] u_jt49.u_chB.count\[1\] VGND VGND VPWR VPWR
+ _0310_ sky130_fd_sc_hd__a21o_1
Xinput6 IOA_in[5] VGND VGND VPWR VPWR net6 sky130_fd_sc_hd__buf_1
XFILLER_51_159 VGND VGND VPWR VPWR sky130_fd_sc_hd__decap_6
X_0977_ net61 net22 _0612_ VGND VGND VPWR VPWR _0005_ sky130_fd_sc_hd__mux2_1
X_1529_ u_jt49.periodA\[1\] net61 _0420_ VGND VGND VPWR VPWR _0244_ sky130_fd_sc_hd__mux2_1
XFILLER_19_69 VGND VPWR VPWR VGND sky130_ef_sc_hd__decap_12
XFILLER_35_57 VGND VGND VPWR VPWR sky130_fd_sc_hd__decap_4
XPHY_EDGE_ROW_14_Right_14 VGND VGND VPWR VPWR sky130_fd_sc_hd__decap_3
XFILLER_2_288 VGND VPWR VPWR VGND sky130_ef_sc_hd__decap_12
XPHY_EDGE_ROW_23_Right_23 VGND VGND VPWR VPWR sky130_fd_sc_hd__decap_3
XFILLER_18_167 VGND VGND VPWR VPWR sky130_fd_sc_hd__decap_4
XFILLER_33_159 VGND VGND VPWR VPWR sky130_fd_sc_hd__decap_4
XPHY_EDGE_ROW_32_Right_32 VGND VGND VPWR VPWR sky130_fd_sc_hd__decap_3
X_0900_ net48 _0544_ VGND VGND VPWR VPWR _0547_ sky130_fd_sc_hd__nor2_4
X_0831_ u_jt49.periodA\[9\] VGND VGND VPWR VPWR _0485_ sky130_fd_sc_hd__inv_2
XPHY_EDGE_ROW_41_Right_41 VGND VGND VPWR VPWR sky130_fd_sc_hd__decap_3
X_1314_ u_jt49.u_chA.count\[1\] _0493_ u_jt49.u_chA.count\[0\] _0494_ VGND VGND VPWR
+ VPWR _0350_ sky130_fd_sc_hd__a211o_1
XPHY_EDGE_ROW_50_Right_50 VGND VGND VPWR VPWR sky130_fd_sc_hd__decap_3
X_1245_ u_jt49.periodB\[6\] u_jt49.u_chB.count\[6\] VGND VGND VPWR VPWR _0294_ sky130_fd_sc_hd__nand2b_1
X_1176_ _0464_ _0759_ VGND VGND VPWR VPWR _0762_ sky130_fd_sc_hd__nand2_1
XFILLER_32_170 VGND VGND VPWR VPWR sky130_fd_sc_hd__decap_4
XFILLER_20_365 VGND VPWR VPWR VGND sky130_ef_sc_hd__decap_12
XFILLER_62_77 VGND VGND VPWR VPWR sky130_fd_sc_hd__decap_6
XFILLER_7_39 VGND VPWR VPWR VGND sky130_ef_sc_hd__decap_12
X_1030_ net44 _0650_ u_jt49.u_chC.count\[0\] VGND VGND VPWR VPWR _0024_ sky130_fd_sc_hd__mux2_1
XFILLER_46_284 VGND VGND VPWR VPWR sky130_fd_sc_hd__decap_3
Xinput20 clk_en VGND VGND VPWR VPWR net20 sky130_fd_sc_hd__clkbuf_4
X_0814_ u_jt49.u_ng.u_div.count\[1\] VGND VGND VPWR VPWR _0468_ sky130_fd_sc_hd__inv_2
X_1794_ clknet_leaf_3_clk _0237_ net77 VGND VGND VPWR VPWR u_jt49.regarray\[1\]\[6\]
+ sky130_fd_sc_hd__dfrtp_1
X_1228_ u_jt49.periodC\[7\] u_jt49.periodC\[6\] u_jt49.periodC\[5\] u_jt49.periodC\[4\]
+ VGND VGND VPWR VPWR _0278_ sky130_fd_sc_hd__or4_1
X_1159_ u_jt49.u_envdiv.count\[4\] u_jt49.u_envdiv.count\[3\] _0745_ VGND VGND VPWR
+ VPWR _0749_ sky130_fd_sc_hd__and3_1
XFILLER_28_273 VGND VPWR VPWR VGND sky130_ef_sc_hd__decap_12
XFILLER_28_240 VGND VPWR VPWR VGND sky130_ef_sc_hd__decap_12
Xclkbuf_leaf_23_clk clknet_2_2__leaf_clk VGND VGND VPWR VPWR clknet_leaf_23_clk sky130_fd_sc_hd__clkbuf_8
XPHY_EDGE_ROW_44_Left_108 VGND VGND VPWR VPWR sky130_fd_sc_hd__decap_3
XFILLER_3_361 VGND VPWR VPWR VGND sky130_ef_sc_hd__decap_12
XPHY_EDGE_ROW_53_Left_117 VGND VGND VPWR VPWR sky130_fd_sc_hd__decap_3
X_1013_ _0445_ u_jt49.periodC\[10\] _0446_ u_jt49.periodC\[9\] VGND VGND VPWR VPWR
+ _0634_ sky130_fd_sc_hd__a22o_1
XPHY_EDGE_ROW_62_Left_126 VGND VGND VPWR VPWR sky130_fd_sc_hd__decap_3
Xclkbuf_leaf_14_clk clknet_2_3__leaf_clk VGND VGND VPWR VPWR clknet_leaf_14_clk sky130_fd_sc_hd__clkbuf_8
X_1777_ clknet_leaf_8_clk _0220_ net79 VGND VGND VPWR VPWR u_jt49.regarray\[3\]\[7\]
+ sky130_fd_sc_hd__dfrtp_1
XPHY_EDGE_ROW_4_Right_4 VGND VGND VPWR VPWR sky130_fd_sc_hd__decap_3
XFILLER_25_276 VGND VGND VPWR VPWR sky130_fd_sc_hd__decap_4
XFILLER_4_18 VGND VGND VPWR VPWR sky130_fd_sc_hd__decap_3
XFILLER_48_357 VGND VGND VPWR VPWR sky130_fd_sc_hd__decap_6
XFILLER_48_302 VGND VGND VPWR VPWR sky130_fd_sc_hd__decap_6
XFILLER_17_80 VGND VGND VPWR VPWR sky130_fd_sc_hd__decap_8
X_1700_ clknet_leaf_18_clk _0143_ net85 VGND VGND VPWR VPWR u_jt49.regarray\[10\]\[2\]
+ sky130_fd_sc_hd__dfrtp_1
X_1631_ clknet_leaf_31_clk net143 net67 VGND VGND VPWR VPWR u_jt49.u_ng.poly17\[11\]
+ sky130_fd_sc_hd__dfrtp_1
X_1562_ clknet_leaf_14_clk _0009_ VGND VGND VPWR VPWR din_latch\[5\] sky130_fd_sc_hd__dfxtp_1
X_1493_ net150 net52 _0409_ VGND VGND VPWR VPWR _0219_ sky130_fd_sc_hd__mux2_1
Xclkbuf_leaf_3_clk clknet_2_1__leaf_clk VGND VGND VPWR VPWR clknet_leaf_3_clk sky130_fd_sc_hd__clkbuf_8
Xfanout39 _0456_ VGND VGND VPWR VPWR net39 sky130_fd_sc_hd__dlymetal6s2s_1
X_1829_ clknet_leaf_29_clk _0264_ net67 VGND VGND VPWR VPWR dout[3] sky130_fd_sc_hd__dfrtp_4
XFILLER_13_49 VGND VGND VPWR VPWR sky130_fd_sc_hd__decap_6
XFILLER_63_113 VGND VGND VPWR VPWR sky130_fd_sc_hd__decap_4
XFILLER_48_165 VGND VGND VPWR VPWR sky130_fd_sc_hd__decap_8
X_0993_ _0620_ VGND VGND VPWR VPWR _0621_ sky130_fd_sc_hd__inv_2
X_1614_ clknet_leaf_16_clk _0061_ net93 VGND VGND VPWR VPWR u_jt49.u_envdiv.count\[10\]
+ sky130_fd_sc_hd__dfrtp_1
X_1476_ u_jt49.periodC\[7\] net50 _0407_ VGND VGND VPWR VPWR _0204_ sky130_fd_sc_hd__mux2_1
X_1545_ net66 net107 _0423_ _0426_ VGND VGND VPWR VPWR _0254_ sky130_fd_sc_hd__a22o_1
XFILLER_10_238 VGND VPWR VPWR VGND sky130_ef_sc_hd__decap_12
XFILLER_45_113 VGND VGND VPWR VPWR sky130_fd_sc_hd__decap_6
XFILLER_45_102 VGND VGND VPWR VPWR sky130_fd_sc_hd__decap_6
X_1261_ _0308_ VGND VGND VPWR VPWR _0309_ sky130_fd_sc_hd__inv_2
X_1330_ net42 u_jt49.u_chA.count\[0\] u_jt49.u_chA.count\[1\] VGND VGND VPWR VPWR
+ _0365_ sky130_fd_sc_hd__a21o_1
X_1192_ net31 _0772_ _0773_ VGND VGND VPWR VPWR _0063_ sky130_fd_sc_hd__and3_1
XFILLER_36_157 VGND VGND VPWR VPWR sky130_fd_sc_hd__decap_8
Xinput7 IOA_in[6] VGND VGND VPWR VPWR net7 sky130_fd_sc_hd__buf_1
X_0976_ net63 net21 _0612_ VGND VGND VPWR VPWR _0004_ sky130_fd_sc_hd__mux2_1
X_1459_ net37 _0534_ VGND VGND VPWR VPWR _0406_ sky130_fd_sc_hd__and2_2
XFILLER_27_113 VGND VGND VPWR VPWR sky130_fd_sc_hd__decap_4
X_1528_ u_jt49.periodA\[0\] net63 _0420_ VGND VGND VPWR VPWR _0243_ sky130_fd_sc_hd__mux2_1
XFILLER_51_57 VGND VPWR VPWR VGND sky130_ef_sc_hd__decap_12
X_0830_ u_jt49.periodA\[10\] VGND VGND VPWR VPWR _0484_ sky130_fd_sc_hd__inv_2
X_1244_ u_jt49.periodB\[7\] u_jt49.u_chB.count\[7\] VGND VGND VPWR VPWR _0293_ sky130_fd_sc_hd__nand2b_1
XFILLER_37_3 VGND VGND VPWR VPWR sky130_fd_sc_hd__decap_8
X_1313_ u_jt49.u_chA.count\[4\] _0490_ u_jt49.u_chA.count\[3\] _0491_ VGND VGND VPWR
+ VPWR _0349_ sky130_fd_sc_hd__o22a_1
X_1175_ _0760_ VGND VGND VPWR VPWR _0761_ sky130_fd_sc_hd__inv_2
X_0959_ _0595_ _0597_ _0599_ VGND VGND VPWR VPWR _0600_ sky130_fd_sc_hd__or3_1
XFILLER_20_300 VGND VGND VPWR VPWR sky130_fd_sc_hd__decap_8
XFILLER_15_149 VGND VPWR VPWR VGND sky130_ef_sc_hd__decap_12
XFILLER_7_337 VGND VPWR VPWR VGND sky130_ef_sc_hd__decap_12
XFILLER_11_93 VGND VPWR VPWR VGND sky130_ef_sc_hd__decap_12
Xinput21 din[0] VGND VGND VPWR VPWR net21 sky130_fd_sc_hd__buf_1
X_1793_ clknet_leaf_3_clk _0236_ net77 VGND VGND VPWR VPWR u_jt49.regarray\[1\]\[5\]
+ sky130_fd_sc_hd__dfrtp_1
Xinput10 IOB_in[1] VGND VGND VPWR VPWR net10 sky130_fd_sc_hd__buf_1
X_0813_ u_jt49.u_ng.u_div.count\[2\] VGND VGND VPWR VPWR _0467_ sky130_fd_sc_hd__inv_2
X_1227_ u_jt49.periodC\[3\] u_jt49.periodC\[2\] u_jt49.periodC\[1\] u_jt49.periodC\[0\]
+ VGND VGND VPWR VPWR _0277_ sky130_fd_sc_hd__or4_1
X_1158_ net30 _0747_ _0748_ VGND VGND VPWR VPWR _0054_ sky130_fd_sc_hd__and3_1
XFILLER_52_277 VGND VGND VPWR VPWR sky130_fd_sc_hd__decap_3
X_1089_ _0685_ _0693_ VGND VGND VPWR VPWR _0694_ sky130_fd_sc_hd__nand2b_1
XFILLER_20_141 VGND VGND VPWR VPWR sky130_fd_sc_hd__decap_8
XFILLER_28_285 VGND VPWR VPWR VGND sky130_ef_sc_hd__decap_12
XFILLER_3_373 VGND VGND VPWR VPWR sky130_fd_sc_hd__decap_6
X_1012_ _0444_ u_jt49.periodC\[11\] VGND VGND VPWR VPWR _0633_ sky130_fd_sc_hd__nand2_1
X_1776_ clknet_leaf_9_clk _0219_ net77 VGND VGND VPWR VPWR u_jt49.regarray\[3\]\[6\]
+ sky130_fd_sc_hd__dfrtp_1
XFILLER_40_269 VGND VPWR VPWR VGND sky130_ef_sc_hd__decap_12
XFILLER_25_299 VGND VGND VPWR VPWR sky130_fd_sc_hd__decap_8
XFILLER_0_321 VGND VPWR VPWR VGND sky130_ef_sc_hd__decap_12
XFILLER_0_365 VGND VPWR VPWR VGND sky130_ef_sc_hd__decap_12
XFILLER_31_225 VGND VGND VPWR VPWR sky130_fd_sc_hd__decap_4
X_1630_ clknet_leaf_31_clk net161 net68 VGND VGND VPWR VPWR u_jt49.u_ng.poly17\[10\]
+ sky130_fd_sc_hd__dfrtp_1
X_1561_ clknet_leaf_14_clk _0008_ VGND VGND VPWR VPWR din_latch\[4\] sky130_fd_sc_hd__dfxtp_1
X_1492_ net140 net53 _0409_ VGND VGND VPWR VPWR _0218_ sky130_fd_sc_hd__mux2_1
X_1759_ clknet_leaf_11_clk _0202_ net91 VGND VGND VPWR VPWR u_jt49.periodC\[5\] sky130_fd_sc_hd__dfrtp_1
X_1828_ clknet_leaf_30_clk _0263_ net67 VGND VGND VPWR VPWR dout[2] sky130_fd_sc_hd__dfrtp_4
XFILLER_60_309 VGND VPWR VPWR VGND sky130_ef_sc_hd__decap_12
XFILLER_13_203 VGND VPWR VPWR VGND sky130_ef_sc_hd__decap_12
XFILLER_13_225 VGND VGND VPWR VPWR sky130_fd_sc_hd__decap_6
XFILLER_48_100 VGND VPWR VPWR VGND sky130_ef_sc_hd__decap_12
XFILLER_63_158 VGND VGND VPWR VPWR sky130_fd_sc_hd__decap_8
XFILLER_63_169 VGND VPWR VPWR VGND sky130_ef_sc_hd__decap_12
XFILLER_63_103 VGND VGND VPWR VPWR sky130_fd_sc_hd__decap_8
X_0992_ net44 u_jt49.u_ng.u_div.count\[1\] u_jt49.u_ng.u_div.count\[0\] VGND VGND
+ VPWR VPWR _0620_ sky130_fd_sc_hd__and3_1
X_1613_ clknet_leaf_16_clk _0060_ net93 VGND VGND VPWR VPWR u_jt49.u_envdiv.count\[9\]
+ sky130_fd_sc_hd__dfrtp_1
XFILLER_5_51 VGND VGND VPWR VPWR sky130_fd_sc_hd__decap_4
X_1544_ u_jt49.regarray\[9\]\[3\] u_jt49.envelope\[4\] u_jt49.regarray\[9\]\[4\] VGND
+ VGND VPWR VPWR _0426_ sky130_fd_sc_hd__mux2_1
X_1475_ u_jt49.periodC\[6\] net51 _0407_ VGND VGND VPWR VPWR _0203_ sky130_fd_sc_hd__mux2_1
XFILLER_50_320 VGND VPWR VPWR VGND sky130_ef_sc_hd__decap_12
XFILLER_35_350 VGND VGND VPWR VPWR sky130_fd_sc_hd__decap_6
XFILLER_18_317 VGND VGND VPWR VPWR sky130_fd_sc_hd__decap_3
XFILLER_26_361 VGND VGND VPWR VPWR sky130_fd_sc_hd__decap_3
XFILLER_30_81 VGND VGND VPWR VPWR sky130_fd_sc_hd__decap_3
X_1191_ u_jt49.u_envdiv.count\[12\] _0768_ VGND VGND VPWR VPWR _0773_ sky130_fd_sc_hd__or2_1
X_1260_ net43 u_jt49.u_chB.count\[1\] u_jt49.u_chB.count\[0\] VGND VGND VPWR VPWR
+ _0308_ sky130_fd_sc_hd__and3_1
Xinput8 IOA_in[7] VGND VGND VPWR VPWR net8 sky130_fd_sc_hd__buf_1
XFILLER_36_136 VGND VGND VPWR VPWR sky130_fd_sc_hd__decap_4
X_0975_ net17 net19 net95 net18 VGND VGND VPWR VPWR _0612_ sky130_fd_sc_hd__and4b_4
XFILLER_10_29 VGND VPWR VPWR VGND sky130_ef_sc_hd__decap_12
X_1527_ net36 _0517_ VGND VGND VPWR VPWR _0420_ sky130_fd_sc_hd__and2_2
X_1389_ u_jt49.eg_period\[9\] net62 _0398_ VGND VGND VPWR VPWR _0126_ sky130_fd_sc_hd__mux2_1
X_1458_ net144 net49 _0405_ VGND VGND VPWR VPWR _0188_ sky130_fd_sc_hd__mux2_1
XFILLER_19_38 VGND VGND VPWR VPWR sky130_fd_sc_hd__decap_4
XFILLER_27_169 VGND VPWR VPWR VGND sky130_ef_sc_hd__decap_12
XFILLER_23_320 VGND VGND VPWR VPWR sky130_fd_sc_hd__decap_8
X_1243_ u_jt49.u_chB.count\[3\] u_jt49.periodB\[3\] VGND VGND VPWR VPWR _0292_ sky130_fd_sc_hd__and2b_1
X_1174_ u_jt49.u_envdiv.count\[8\] u_jt49.u_envdiv.count\[7\] _0755_ VGND VGND VPWR
+ VPWR _0760_ sky130_fd_sc_hd__and3_1
XFILLER_2_85 VGND VPWR VPWR VGND sky130_ef_sc_hd__decap_12
XFILLER_2_63 VGND VPWR VPWR VGND sky130_ef_sc_hd__decap_12
X_1312_ u_jt49.u_chA.count\[5\] _0489_ u_jt49.u_chA.count\[4\] _0490_ VGND VGND VPWR
+ VPWR _0348_ sky130_fd_sc_hd__a22o_1
X_0958_ u_jt49.periodB\[6\] _0527_ _0528_ u_jt49.regarray\[1\]\[6\] _0598_ VGND VGND
+ VPWR VPWR _0599_ sky130_fd_sc_hd__a221o_1
X_0889_ u_jt49.periodA\[8\] _0528_ _0532_ u_jt49.regarray\[7\]\[0\] VGND VGND VPWR
+ VPWR _0536_ sky130_fd_sc_hd__a22o_1
XFILLER_11_312 VGND VPWR VPWR VGND sky130_ef_sc_hd__decap_12
XFILLER_7_349 VGND VPWR VPWR VGND sky130_ef_sc_hd__decap_12
Xinput22 din[1] VGND VGND VPWR VPWR net22 sky130_fd_sc_hd__clkbuf_1
X_1792_ clknet_leaf_9_clk _0235_ net80 VGND VGND VPWR VPWR u_jt49.regarray\[1\]\[4\]
+ sky130_fd_sc_hd__dfrtp_1
Xinput11 IOB_in[2] VGND VGND VPWR VPWR net11 sky130_fd_sc_hd__buf_1
X_0812_ u_jt49.u_ng.u_div.count\[3\] VGND VGND VPWR VPWR _0466_ sky130_fd_sc_hd__inv_2
X_1226_ _0276_ u_jt49.u_ng.noise_en _0619_ VGND VGND VPWR VPWR _0085_ sky130_fd_sc_hd__mux2_1
X_1157_ u_jt49.u_envdiv.count\[3\] _0745_ VGND VGND VPWR VPWR _0748_ sky130_fd_sc_hd__nand2_1
X_1088_ _0685_ _0693_ net151 _0631_ VGND VGND VPWR VPWR _0039_ sky130_fd_sc_hd__a2bb2o_1
XFILLER_20_120 VGND VGND VPWR VPWR sky130_fd_sc_hd__decap_3
XFILLER_57_57 VGND VPWR VPWR VGND sky130_ef_sc_hd__decap_12
XFILLER_28_297 VGND VGND VPWR VPWR sky130_fd_sc_hd__decap_8
XFILLER_7_113 VGND VPWR VPWR VGND sky130_ef_sc_hd__decap_12
XFILLER_22_71 VGND VGND VPWR VPWR sky130_fd_sc_hd__decap_6
X_1011_ _0444_ u_jt49.periodC\[11\] _0445_ u_jt49.periodC\[10\] VGND VGND VPWR VPWR
+ _0632_ sky130_fd_sc_hd__o22ai_1
X_1775_ clknet_leaf_9_clk _0218_ net80 VGND VGND VPWR VPWR u_jt49.regarray\[3\]\[5\]
+ sky130_fd_sc_hd__dfrtp_1
X_1209_ u_jt49.u_ng.poly17\[9\] net171 net34 VGND VGND VPWR VPWR _0076_ sky130_fd_sc_hd__mux2_1
XFILLER_25_234 VGND VGND VPWR VPWR sky130_fd_sc_hd__decap_8
XFILLER_0_333 VGND VGND VPWR VPWR sky130_fd_sc_hd__decap_3
XFILLER_0_377 VGND VGND VPWR VPWR sky130_fd_sc_hd__decap_3
XPHY_EDGE_ROW_9_Left_73 VGND VGND VPWR VPWR sky130_fd_sc_hd__decap_3
X_1560_ clknet_leaf_8_clk _0007_ VGND VGND VPWR VPWR din_latch\[3\] sky130_fd_sc_hd__dfxtp_1
X_1491_ net148 net56 _0409_ VGND VGND VPWR VPWR _0217_ sky130_fd_sc_hd__mux2_1
XFILLER_62_373 VGND VGND VPWR VPWR sky130_fd_sc_hd__decap_3
X_1827_ clknet_leaf_30_clk _0262_ net67 VGND VGND VPWR VPWR dout[1] sky130_fd_sc_hd__dfrtp_4
X_1758_ clknet_leaf_11_clk _0201_ net91 VGND VGND VPWR VPWR u_jt49.periodC\[4\] sky130_fd_sc_hd__dfrtp_1
X_1689_ clknet_leaf_15_clk _0132_ net95 VGND VGND VPWR VPWR u_jt49.eg_period\[15\]
+ sky130_fd_sc_hd__dfrtp_2
XFILLER_38_15 VGND VPWR VPWR VGND sky130_ef_sc_hd__decap_12
XFILLER_13_215 VGND VGND VPWR VPWR sky130_fd_sc_hd__decap_8
XPHY_EDGE_ROW_35_Left_99 VGND VGND VPWR VPWR sky130_fd_sc_hd__decap_3
XFILLER_48_112 VGND VPWR VPWR VGND sky130_ef_sc_hd__decap_12
XFILLER_44_80 VGND VGND VPWR VPWR sky130_fd_sc_hd__decap_4
X_0991_ net44 _0617_ VGND VGND VPWR VPWR _0619_ sky130_fd_sc_hd__nand2_1
X_1474_ u_jt49.periodC\[5\] net54 _0407_ VGND VGND VPWR VPWR _0202_ sky130_fd_sc_hd__mux2_1
X_1612_ clknet_leaf_16_clk _0059_ net93 VGND VGND VPWR VPWR u_jt49.u_envdiv.count\[8\]
+ sky130_fd_sc_hd__dfrtp_1
X_1543_ net66 net104 _0423_ _0425_ VGND VGND VPWR VPWR _0253_ sky130_fd_sc_hd__a22o_1
XFILLER_39_189 VGND VGND VPWR VPWR sky130_fd_sc_hd__decap_4
XFILLER_39_134 VGND VGND VPWR VPWR sky130_fd_sc_hd__decap_8
XPHY_EDGE_ROW_59_Left_123 VGND VGND VPWR VPWR sky130_fd_sc_hd__decap_3
XFILLER_50_365 VGND VPWR VPWR VGND sky130_ef_sc_hd__decap_12
XFILLER_50_332 VGND VPWR VPWR VGND sky130_ef_sc_hd__decap_12
XFILLER_10_218 VGND VGND VPWR VPWR sky130_fd_sc_hd__decap_8
XFILLER_41_321 VGND VGND VPWR VPWR sky130_fd_sc_hd__decap_6
XFILLER_5_277 VGND VGND VPWR VPWR sky130_fd_sc_hd__decap_3
X_1190_ _0771_ VGND VGND VPWR VPWR _0772_ sky130_fd_sc_hd__inv_2
XFILLER_36_115 VGND VGND VPWR VPWR sky130_fd_sc_hd__decap_4
Xinput9 IOB_in[0] VGND VGND VPWR VPWR net9 sky130_fd_sc_hd__buf_1
XFILLER_32_365 VGND VGND VPWR VPWR sky130_fd_sc_hd__decap_4
X_0974_ net215 VGND VGND VPWR VPWR _0002_ sky130_fd_sc_hd__inv_2
XFILLER_59_207 VGND VGND VPWR VPWR sky130_fd_sc_hd__decap_4
X_1457_ net133 net51 _0405_ VGND VGND VPWR VPWR _0187_ sky130_fd_sc_hd__mux2_1
X_1526_ net65 net100 _0416_ _0419_ VGND VGND VPWR VPWR _0242_ sky130_fd_sc_hd__a22o_1
X_1388_ u_jt49.eg_period\[8\] net64 _0398_ VGND VGND VPWR VPWR _0125_ sky130_fd_sc_hd__mux2_1
XFILLER_27_126 VGND VPWR VPWR VGND sky130_ef_sc_hd__decap_12
XFILLER_2_247 VGND VGND VPWR VPWR sky130_fd_sc_hd__decap_4
XFILLER_58_273 VGND VPWR VPWR VGND sky130_ef_sc_hd__decap_12
XFILLER_26_192 VGND VGND VPWR VPWR sky130_fd_sc_hd__decap_4
XFILLER_14_343 VGND VPWR VPWR VGND sky130_ef_sc_hd__decap_12
XFILLER_14_365 VGND VPWR VPWR VGND sky130_ef_sc_hd__decap_12
XFILLER_25_82 VGND VGND VPWR VPWR sky130_fd_sc_hd__decap_4
X_1311_ u_jt49.u_chA.count\[6\] _0488_ u_jt49.u_chA.count\[5\] _0489_ VGND VGND VPWR
+ VPWR _0347_ sky130_fd_sc_hd__o22a_1
XFILLER_49_273 VGND VGND VPWR VPWR sky130_fd_sc_hd__decap_6
X_1242_ u_jt49.u_chB.count\[4\] u_jt49.periodB\[4\] VGND VGND VPWR VPWR _0291_ sky130_fd_sc_hd__and2b_1
X_1173_ net30 _0758_ _0759_ VGND VGND VPWR VPWR _0058_ sky130_fd_sc_hd__and3_1
XFILLER_2_75 VGND VGND VPWR VPWR sky130_fd_sc_hd__decap_8
XFILLER_2_97 VGND VPWR VPWR VGND sky130_ef_sc_hd__decap_12
XPHY_EDGE_ROW_10_Right_10 VGND VGND VPWR VPWR sky130_fd_sc_hd__decap_3
XPHY_EDGE_ROW_22_Left_86 VGND VGND VPWR VPWR sky130_fd_sc_hd__decap_3
XFILLER_20_335 VGND VPWR VPWR VGND sky130_ef_sc_hd__decap_12
X_0957_ u_jt49.regarray\[3\]\[6\] _0515_ _0533_ u_jt49.regarray\[8\]\[6\] VGND VGND
+ VPWR VPWR _0598_ sky130_fd_sc_hd__a22o_1
X_0888_ _0516_ _0520_ VGND VGND VPWR VPWR _0535_ sky130_fd_sc_hd__nor2_4
XFILLER_46_15 VGND VPWR VPWR VGND sky130_ef_sc_hd__decap_12
X_1509_ u_jt49.periodA\[8\] net63 _0413_ VGND VGND VPWR VPWR _0231_ sky130_fd_sc_hd__mux2_1
XFILLER_11_324 VGND VPWR VPWR VGND sky130_ef_sc_hd__decap_12
XFILLER_23_184 VGND VGND VPWR VPWR sky130_fd_sc_hd__decap_3
XFILLER_14_173 VGND VGND VPWR VPWR sky130_fd_sc_hd__decap_3
Xclkbuf_leaf_26_clk clknet_2_0__leaf_clk VGND VGND VPWR VPWR clknet_leaf_26_clk sky130_fd_sc_hd__clkbuf_8
Xinput23 din[2] VGND VGND VPWR VPWR net23 sky130_fd_sc_hd__buf_1
X_1791_ clknet_leaf_1_clk _0234_ net71 VGND VGND VPWR VPWR u_jt49.periodA\[11\] sky130_fd_sc_hd__dfrtp_1
Xinput12 IOB_in[3] VGND VGND VPWR VPWR net12 sky130_fd_sc_hd__buf_1
X_0811_ u_jt49.u_ng.u_div.count\[4\] VGND VGND VPWR VPWR _0465_ sky130_fd_sc_hd__inv_2
XFILLER_42_3 VGND VPWR VPWR VGND sky130_ef_sc_hd__decap_12
XFILLER_52_268 VGND VGND VPWR VPWR sky130_fd_sc_hd__decap_6
Xclkbuf_leaf_17_clk clknet_2_3__leaf_clk VGND VGND VPWR VPWR clknet_leaf_17_clk sky130_fd_sc_hd__clkbuf_8
X_1225_ u_jt49.regarray\[6\]\[1\] _0275_ u_jt49.u_ng.noise_en VGND VGND VPWR VPWR
+ _0276_ sky130_fd_sc_hd__o21ba_1
XFILLER_16_29 VGND VGND VPWR VPWR sky130_fd_sc_hd__decap_3
X_1087_ u_jt49.regarray\[13\]\[3\] _0442_ u_jt49.u_env.gain\[4\] _0686_ u_jt49.u_env.rst_latch
+ VGND VGND VPWR VPWR _0693_ sky130_fd_sc_hd__a2111o_1
X_1156_ u_jt49.u_envdiv.count\[3\] _0745_ VGND VGND VPWR VPWR _0747_ sky130_fd_sc_hd__or2_1
XFILLER_57_69 VGND VPWR VPWR VGND sky130_ef_sc_hd__decap_12
XFILLER_7_125 VGND VPWR VPWR VGND sky130_ef_sc_hd__decap_12
XFILLER_47_91 VGND VGND VPWR VPWR sky130_fd_sc_hd__decap_8
XFILLER_34_246 VGND VGND VPWR VPWR sky130_fd_sc_hd__decap_6
XFILLER_34_235 VGND VGND VPWR VPWR sky130_fd_sc_hd__decap_3
X_1010_ _0432_ net40 _0631_ VGND VGND VPWR VPWR _0023_ sky130_fd_sc_hd__o21ai_1
XFILLER_8_41 VGND VPWR VPWR VGND sky130_ef_sc_hd__decap_12
XFILLER_8_85 VGND VGND VPWR VPWR sky130_fd_sc_hd__decap_3
Xclkbuf_leaf_6_clk clknet_2_1__leaf_clk VGND VGND VPWR VPWR clknet_leaf_6_clk sky130_fd_sc_hd__clkbuf_8
X_1774_ clknet_leaf_9_clk _0217_ net80 VGND VGND VPWR VPWR u_jt49.regarray\[3\]\[4\]
+ sky130_fd_sc_hd__dfrtp_1
X_1208_ net169 u_jt49.u_ng.poly17\[9\] net34 VGND VGND VPWR VPWR _0075_ sky130_fd_sc_hd__mux2_1
XPHY_EDGE_ROW_40_Left_104 VGND VGND VPWR VPWR sky130_fd_sc_hd__decap_3
X_1139_ u_jt49.u_env.gain\[3\] u_jt49.u_env.inv VGND VGND VPWR VPWR _0736_ sky130_fd_sc_hd__xor2_1
X_1490_ u_jt49.periodB\[11\] net57 _0409_ VGND VGND VPWR VPWR _0216_ sky130_fd_sc_hd__mux2_1
XFILLER_3_194 VGND VGND VPWR VPWR sky130_fd_sc_hd__decap_4
Xhold1 u_jt49.logA\[3\] VGND VGND VPWR VPWR net98 sky130_fd_sc_hd__dlygate4sd3_1
XPHY_EDGE_ROW_8_Right_8 VGND VGND VPWR VPWR sky130_fd_sc_hd__decap_3
X_1826_ clknet_leaf_30_clk _0261_ net67 VGND VGND VPWR VPWR dout[0] sky130_fd_sc_hd__dfrtp_4
X_1757_ clknet_leaf_8_clk _0200_ net79 VGND VGND VPWR VPWR u_jt49.periodC\[3\] sky130_fd_sc_hd__dfrtp_1
X_1688_ clknet_leaf_15_clk _0131_ net95 VGND VGND VPWR VPWR u_jt49.eg_period\[14\]
+ sky130_fd_sc_hd__dfrtp_2
XPHY_EDGE_ROW_39_Right_39 VGND VGND VPWR VPWR sky130_fd_sc_hd__decap_3
XFILLER_57_113 VGND VPWR VPWR VGND sky130_ef_sc_hd__decap_12
XFILLER_54_15 VGND VPWR VPWR VGND sky130_ef_sc_hd__decap_12
XPHY_EDGE_ROW_48_Right_48 VGND VGND VPWR VPWR sky130_fd_sc_hd__decap_3
XFILLER_13_249 VGND VGND VPWR VPWR sky130_fd_sc_hd__decap_8
XPHY_EDGE_ROW_57_Right_57 VGND VGND VPWR VPWR sky130_fd_sc_hd__decap_3
XFILLER_48_124 VGND VGND VPWR VPWR sky130_fd_sc_hd__decap_6
XFILLER_0_197 VGND VPWR VPWR VGND sky130_ef_sc_hd__decap_12
XFILLER_29_360 VGND VGND VPWR VPWR sky130_fd_sc_hd__decap_8
XFILLER_44_92 VGND VPWR VPWR VGND sky130_ef_sc_hd__decap_12
X_1611_ clknet_leaf_16_clk _0058_ net93 VGND VGND VPWR VPWR u_jt49.u_envdiv.count\[7\]
+ sky130_fd_sc_hd__dfrtp_1
X_0990_ net44 u_jt49.u_ng.u_div.count\[0\] _0618_ VGND VGND VPWR VPWR _0012_ sky130_fd_sc_hd__o21a_1
XFILLER_12_293 VGND VGND VPWR VPWR sky130_fd_sc_hd__decap_6
X_1473_ u_jt49.periodC\[4\] net55 _0407_ VGND VGND VPWR VPWR _0201_ sky130_fd_sc_hd__mux2_1
X_1542_ u_jt49.regarray\[9\]\[2\] u_jt49.envelope\[3\] u_jt49.regarray\[9\]\[4\] VGND
+ VGND VPWR VPWR _0425_ sky130_fd_sc_hd__mux2_1
XFILLER_39_113 VGND VPWR VPWR VGND sky130_ef_sc_hd__decap_12
XFILLER_50_377 VGND VGND VPWR VPWR sky130_fd_sc_hd__decap_3
XFILLER_50_344 VGND VPWR VPWR VGND sky130_ef_sc_hd__decap_12
X_1809_ clknet_leaf_23_clk _0252_ VGND VGND VPWR VPWR u_jt49.logB\[2\] sky130_fd_sc_hd__dfxtp_1
XFILLER_49_15 VGND VPWR VPWR VGND sky130_ef_sc_hd__decap_12
XFILLER_26_374 VGND VGND VPWR VPWR sky130_fd_sc_hd__decap_6
XFILLER_26_341 VGND VPWR VPWR VGND sky130_ef_sc_hd__decap_12
XFILLER_30_61 VGND VPWR VPWR VGND sky130_ef_sc_hd__decap_12
X_0973_ u_jt49.u_cen.cencnt\[0\] u_jt49.u_cen.cencnt\[1\] net214 net65 VGND VGND VPWR
+ VPWR _0611_ sky130_fd_sc_hd__or4_1
X_1456_ net132 net53 _0405_ VGND VGND VPWR VPWR _0186_ sky130_fd_sc_hd__mux2_1
X_1387_ net37 _0531_ VGND VGND VPWR VPWR _0398_ sky130_fd_sc_hd__and2_2
X_1525_ u_jt49.regarray\[8\]\[3\] u_jt49.envelope\[4\] u_jt49.regarray\[8\]\[4\] VGND
+ VGND VPWR VPWR _0419_ sky130_fd_sc_hd__mux2_1
XFILLER_35_182 VGND VGND VPWR VPWR sky130_fd_sc_hd__decap_4
XFILLER_27_138 VGND VPWR VPWR VGND sky130_ef_sc_hd__decap_12
XFILLER_4_6 VGND VPWR VPWR VGND sky130_ef_sc_hd__decap_12
XFILLER_58_285 VGND VPWR VPWR VGND sky130_ef_sc_hd__decap_12
XFILLER_41_141 VGND VGND VPWR VPWR sky130_fd_sc_hd__decap_4
XFILLER_14_355 VGND VGND VPWR VPWR sky130_fd_sc_hd__decap_8
X_1241_ _0479_ u_jt49.periodB\[3\] _0480_ u_jt49.periodB\[2\] VGND VGND VPWR VPWR
+ _0290_ sky130_fd_sc_hd__o22a_1
X_1310_ _0487_ u_jt49.periodA\[7\] VGND VGND VPWR VPWR _0346_ sky130_fd_sc_hd__nor2_1
X_1172_ u_jt49.u_envdiv.count\[7\] _0755_ VGND VGND VPWR VPWR _0759_ sky130_fd_sc_hd__nand2_1
X_0956_ u_jt49.eg_period\[6\] _0530_ _0535_ u_jt49.periodC\[6\] _0596_ VGND VGND VPWR
+ VPWR _0597_ sky130_fd_sc_hd__a221o_1
XFILLER_20_347 VGND VPWR VPWR VGND sky130_ef_sc_hd__decap_12
X_0887_ _0520_ _0523_ VGND VGND VPWR VPWR _0534_ sky130_fd_sc_hd__nor2_4
X_1439_ net124 net52 _0403_ VGND VGND VPWR VPWR _0171_ sky130_fd_sc_hd__mux2_1
X_1508_ net36 _0528_ VGND VGND VPWR VPWR _0413_ sky130_fd_sc_hd__and2_2
XFILLER_62_15 VGND VPWR VPWR VGND sky130_ef_sc_hd__decap_12
XFILLER_55_277 VGND VGND VPWR VPWR sky130_fd_sc_hd__decap_3
XFILLER_23_130 VGND VGND VPWR VPWR sky130_fd_sc_hd__decap_8
XFILLER_23_152 VGND VGND VPWR VPWR sky130_fd_sc_hd__decap_3
XFILLER_61_225 VGND VPWR VPWR VGND sky130_ef_sc_hd__decap_12
XFILLER_46_244 VGND VGND VPWR VPWR sky130_fd_sc_hd__decap_4
X_0810_ u_jt49.u_envdiv.count\[8\] VGND VGND VPWR VPWR _0464_ sky130_fd_sc_hd__inv_2
XFILLER_14_141 VGND VGND VPWR VPWR sky130_fd_sc_hd__decap_3
Xinput13 IOB_in[4] VGND VGND VPWR VPWR net13 sky130_fd_sc_hd__buf_1
X_1790_ clknet_leaf_1_clk _0233_ net71 VGND VGND VPWR VPWR u_jt49.periodA\[10\] sky130_fd_sc_hd__dfrtp_1
Xinput24 din[3] VGND VGND VPWR VPWR net24 sky130_fd_sc_hd__buf_1
XFILLER_35_3 VGND VGND VPWR VPWR sky130_fd_sc_hd__decap_6
X_1224_ u_jt49.regarray\[6\]\[0\] u_jt49.regarray\[6\]\[3\] u_jt49.regarray\[6\]\[2\]
+ u_jt49.regarray\[6\]\[4\] VGND VGND VPWR VPWR _0275_ sky130_fd_sc_hd__or4_1
X_1086_ u_jt49.eg_step net118 _0692_ VGND VGND VPWR VPWR _0038_ sky130_fd_sc_hd__mux2_1
X_1155_ net30 _0744_ _0746_ VGND VGND VPWR VPWR _0053_ sky130_fd_sc_hd__and3_1
X_0939_ _0578_ _0579_ _0581_ VGND VGND VPWR VPWR _0582_ sky130_fd_sc_hd__or3_1
XFILLER_32_29 VGND VGND VPWR VPWR sky130_fd_sc_hd__decap_4
XFILLER_32_18 VGND VGND VPWR VPWR sky130_fd_sc_hd__decap_8
XFILLER_57_15 VGND VPWR VPWR VGND sky130_ef_sc_hd__decap_12
Xclkbuf_2_2__f_clk clknet_0_clk VGND VGND VPWR VPWR clknet_2_2__leaf_clk sky130_fd_sc_hd__clkbuf_16
XFILLER_3_321 VGND VPWR VPWR VGND sky130_ef_sc_hd__decap_12
XFILLER_19_211 VGND VGND VPWR VPWR sky130_fd_sc_hd__decap_4
XFILLER_63_91 VGND VPWR VPWR VGND sky130_ef_sc_hd__decap_12
X_1773_ clknet_leaf_8_clk _0216_ net78 VGND VGND VPWR VPWR u_jt49.periodB\[11\] sky130_fd_sc_hd__dfrtp_2
XFILLER_8_53 VGND VPWR VPWR VGND sky130_ef_sc_hd__decap_12
XFILLER_8_97 VGND VPWR VPWR VGND sky130_ef_sc_hd__decap_12
X_1207_ net164 u_jt49.u_ng.poly17\[8\] net35 VGND VGND VPWR VPWR _0074_ sky130_fd_sc_hd__mux2_1
X_1069_ u_jt49.eg_period\[5\] u_jt49.eg_period\[4\] u_jt49.eg_period\[7\] u_jt49.eg_period\[6\]
+ VGND VGND VPWR VPWR _0677_ sky130_fd_sc_hd__or4_1
X_1138_ net203 _0735_ net40 VGND VGND VPWR VPWR _0047_ sky130_fd_sc_hd__mux2_1
XFILLER_63_309 VGND VPWR VPWR VGND sky130_ef_sc_hd__decap_12
XFILLER_17_51 VGND VGND VPWR VPWR sky130_fd_sc_hd__decap_4
XFILLER_31_239 VGND VGND VPWR VPWR sky130_fd_sc_hd__decap_4
XFILLER_54_309 VGND VPWR VPWR VGND sky130_ef_sc_hd__decap_12
Xhold2 u_jt49.logA\[2\] VGND VGND VPWR VPWR net99 sky130_fd_sc_hd__dlygate4sd3_1
X_1756_ clknet_leaf_11_clk _0199_ net91 VGND VGND VPWR VPWR u_jt49.periodC\[2\] sky130_fd_sc_hd__dfrtp_1
X_1825_ clknet_leaf_22_clk net107 VGND VGND VPWR VPWR B[3] sky130_fd_sc_hd__dfxtp_2
XFILLER_57_125 VGND VPWR VPWR VGND sky130_ef_sc_hd__decap_12
X_1687_ clknet_leaf_17_clk _0130_ net94 VGND VGND VPWR VPWR u_jt49.eg_period\[13\]
+ sky130_fd_sc_hd__dfrtp_1
XFILLER_57_169 VGND VGND VPWR VPWR sky130_fd_sc_hd__decap_4
X_1610_ clknet_leaf_16_clk _0057_ net87 VGND VGND VPWR VPWR u_jt49.u_envdiv.count\[6\]
+ sky130_fd_sc_hd__dfrtp_1
XFILLER_12_261 VGND VPWR VPWR VGND sky130_ef_sc_hd__decap_12
X_1472_ u_jt49.periodC\[3\] net57 _0407_ VGND VGND VPWR VPWR _0200_ sky130_fd_sc_hd__mux2_1
X_1541_ net66 net102 _0423_ _0424_ VGND VGND VPWR VPWR _0252_ sky130_fd_sc_hd__a22o_1
XFILLER_39_169 VGND VPWR VPWR VGND sky130_ef_sc_hd__decap_12
XFILLER_50_356 VGND VGND VPWR VPWR sky130_fd_sc_hd__decap_8
XFILLER_49_27 VGND VGND VPWR VPWR sky130_fd_sc_hd__decap_6
XFILLER_40_29 VGND VGND VPWR VPWR sky130_fd_sc_hd__decap_8
X_1808_ clknet_leaf_23_clk _0251_ VGND VGND VPWR VPWR u_jt49.logB\[1\] sky130_fd_sc_hd__dfxtp_1
X_1739_ clknet_leaf_26_clk _0182_ net72 VGND VGND VPWR VPWR u_jt49.regarray\[6\]\[1\]
+ sky130_fd_sc_hd__dfrtp_1
XFILLER_60_109 VGND VPWR VPWR VGND sky130_ef_sc_hd__decap_12
XFILLER_38_191 VGND VGND VPWR VPWR sky130_fd_sc_hd__decap_4
XFILLER_26_353 VGND VGND VPWR VPWR sky130_fd_sc_hd__decap_8
XFILLER_14_85 VGND VGND VPWR VPWR sky130_fd_sc_hd__decap_6
XFILLER_30_73 VGND VGND VPWR VPWR sky130_fd_sc_hd__decap_8
XFILLER_55_81 VGND VPWR VPWR VGND sky130_ef_sc_hd__decap_12
X_0972_ u_jt49.u_cen.cencnt\[0\] net125 net65 VGND VGND VPWR VPWR _0003_ sky130_fd_sc_hd__nor3_1
X_1524_ net65 net98 _0416_ _0418_ VGND VGND VPWR VPWR _0241_ sky130_fd_sc_hd__a22o_1
X_1386_ net50 net149 _0397_ VGND VGND VPWR VPWR _0124_ sky130_fd_sc_hd__mux2_1
X_1455_ u_jt49.regarray\[6\]\[4\] net55 _0405_ VGND VGND VPWR VPWR _0185_ sky130_fd_sc_hd__mux2_1
XFILLER_35_194 VGND VGND VPWR VPWR sky130_fd_sc_hd__decap_8
XFILLER_35_18 VGND VPWR VPWR VGND sky130_ef_sc_hd__decap_12
XFILLER_58_297 VGND VGND VPWR VPWR sky130_fd_sc_hd__decap_8
X_1240_ u_jt49.periodB\[0\] _0481_ _0286_ _0287_ _0288_ VGND VGND VPWR VPWR _0289_
+ sky130_fd_sc_hd__a311o_1
X_1171_ u_jt49.u_envdiv.count\[7\] _0755_ VGND VGND VPWR VPWR _0758_ sky130_fd_sc_hd__or2_1
X_0955_ u_jt49.regarray\[9\]\[6\] _0524_ _0534_ u_jt49.regarray\[5\]\[6\] VGND VGND
+ VPWR VPWR _0596_ sky130_fd_sc_hd__a22o_1
X_0886_ _0516_ _0522_ VGND VGND VPWR VPWR _0533_ sky130_fd_sc_hd__nor2_2
XFILLER_20_359 VGND VGND VPWR VPWR sky130_fd_sc_hd__decap_4
X_1507_ net111 net65 _0412_ VGND VGND VPWR VPWR _0230_ sky130_fd_sc_hd__a21o_1
X_1438_ net123 net53 _0403_ VGND VGND VPWR VPWR _0170_ sky130_fd_sc_hd__mux2_1
X_1369_ _0390_ _0391_ _0392_ _0498_ VGND VGND VPWR VPWR _0393_ sky130_fd_sc_hd__o31a_1
XFILLER_11_337 VGND VPWR VPWR VGND sky130_ef_sc_hd__decap_12
XFILLER_23_164 VGND VGND VPWR VPWR sky130_fd_sc_hd__decap_4
XFILLER_61_237 VGND VPWR VPWR VGND sky130_ef_sc_hd__decap_12
XFILLER_36_94 VGND VGND VPWR VPWR sky130_fd_sc_hd__decap_4
Xinput25 din[4] VGND VGND VPWR VPWR net25 sky130_fd_sc_hd__buf_1
Xinput14 IOB_in[5] VGND VGND VPWR VPWR net14 sky130_fd_sc_hd__buf_1
X_1223_ _0499_ u_jt49.noise net38 VGND VGND VPWR VPWR _0084_ sky130_fd_sc_hd__mux2_1
X_1154_ _0745_ VGND VGND VPWR VPWR _0746_ sky130_fd_sc_hd__inv_2
X_1085_ net41 net86 VGND VGND VPWR VPWR _0692_ sky130_fd_sc_hd__nand2_1
X_0938_ u_jt49.regarray\[3\]\[4\] _0515_ _0528_ u_jt49.regarray\[1\]\[4\] _0580_ VGND
+ VGND VPWR VPWR _0581_ sky130_fd_sc_hd__a221o_1
X_0869_ net47 net48 VGND VGND VPWR VPWR _0516_ sky130_fd_sc_hd__or2_2
XFILLER_57_27 VGND VPWR VPWR VGND sky130_ef_sc_hd__decap_12
XFILLER_43_204 VGND VGND VPWR VPWR sky130_fd_sc_hd__decap_4
XFILLER_7_105 VGND VGND VPWR VPWR sky130_fd_sc_hd__decap_6
XFILLER_3_333 VGND VGND VPWR VPWR sky130_fd_sc_hd__decap_3
XFILLER_63_81 VGND VGND VPWR VPWR sky130_fd_sc_hd__decap_3
X_1772_ clknet_leaf_9_clk _0215_ net77 VGND VGND VPWR VPWR u_jt49.periodB\[10\] sky130_fd_sc_hd__dfrtp_1
XFILLER_8_65 VGND VPWR VPWR VGND sky130_ef_sc_hd__decap_12
X_1137_ u_jt49.u_env.gain\[2\] u_jt49.u_env.inv VGND VGND VPWR VPWR _0735_ sky130_fd_sc_hd__xor2_1
X_1206_ net167 net164 net35 VGND VGND VPWR VPWR _0073_ sky130_fd_sc_hd__mux2_1
XFILLER_33_281 VGND VPWR VPWR VGND sky130_ef_sc_hd__decap_12
X_1068_ u_jt49.u_env.rst_latch _0432_ net115 VGND VGND VPWR VPWR _0036_ sky130_fd_sc_hd__a21o_1
XFILLER_16_215 VGND VGND VPWR VPWR sky130_fd_sc_hd__decap_6
XFILLER_62_321 VGND VPWR VPWR VGND sky130_ef_sc_hd__decap_12
Xhold3 u_jt49.logA\[4\] VGND VGND VPWR VPWR net100 sky130_fd_sc_hd__dlygate4sd3_1
XFILLER_62_365 VGND VGND VPWR VPWR sky130_fd_sc_hd__decap_8
X_1755_ clknet_leaf_8_clk _0198_ net79 VGND VGND VPWR VPWR u_jt49.periodC\[1\] sky130_fd_sc_hd__dfrtp_1
X_1686_ clknet_leaf_17_clk _0129_ net94 VGND VGND VPWR VPWR u_jt49.eg_period\[12\]
+ sky130_fd_sc_hd__dfrtp_2
X_1824_ clknet_leaf_23_clk net104 VGND VGND VPWR VPWR B[2] sky130_fd_sc_hd__dfxtp_2
XFILLER_57_137 VGND VPWR VPWR VGND sky130_ef_sc_hd__decap_12
XFILLER_44_365 VGND VGND VPWR VPWR sky130_fd_sc_hd__decap_3
XFILLER_8_244 VGND VGND VPWR VPWR sky130_fd_sc_hd__decap_8
X_1540_ u_jt49.regarray\[9\]\[1\] u_jt49.envelope\[2\] u_jt49.regarray\[9\]\[4\] VGND
+ VGND VPWR VPWR _0424_ sky130_fd_sc_hd__mux2_1
XFILLER_12_273 VGND VPWR VPWR VGND sky130_ef_sc_hd__decap_12
X_1471_ u_jt49.periodC\[2\] net60 _0407_ VGND VGND VPWR VPWR _0199_ sky130_fd_sc_hd__mux2_1
XFILLER_10_3 VGND VPWR VPWR VGND sky130_ef_sc_hd__decap_12
XFILLER_35_332 VGND VGND VPWR VPWR sky130_fd_sc_hd__decap_4
X_1807_ clknet_leaf_0_clk _0250_ net70 VGND VGND VPWR VPWR u_jt49.periodA\[7\] sky130_fd_sc_hd__dfrtp_1
XFILLER_49_39 VGND VGND VPWR VPWR sky130_fd_sc_hd__decap_4
XPHY_EDGE_ROW_37_Left_101 VGND VGND VPWR VPWR sky130_fd_sc_hd__decap_3
X_1669_ clknet_leaf_24_clk _0114_ net85 VGND VGND VPWR VPWR u_jt49.u_cen.cencnt\[1\]
+ sky130_fd_sc_hd__dfrtp_1
X_1738_ clknet_leaf_26_clk _0181_ net72 VGND VGND VPWR VPWR u_jt49.regarray\[6\]\[0\]
+ sky130_fd_sc_hd__dfrtp_1
XFILLER_45_129 VGND VPWR VPWR VGND sky130_ef_sc_hd__decap_12
XPHY_EDGE_ROW_46_Left_110 VGND VGND VPWR VPWR sky130_fd_sc_hd__decap_3
XFILLER_41_302 VGND VGND VPWR VPWR sky130_fd_sc_hd__decap_6
XFILLER_30_85 VGND VGND VPWR VPWR sky130_fd_sc_hd__decap_6
XFILLER_55_93 VGND VPWR VPWR VGND sky130_ef_sc_hd__decap_12
XFILLER_17_343 VGND VPWR VPWR VGND sky130_ef_sc_hd__decap_12
X_0971_ net16 _0546_ _0547_ net8 _0610_ VGND VGND VPWR VPWR _0268_ sky130_fd_sc_hd__a221o_1
XFILLER_58_3 VGND VGND VPWR VPWR sky130_fd_sc_hd__decap_6
XFILLER_4_280 VGND VGND VPWR VPWR sky130_fd_sc_hd__decap_4
X_1523_ u_jt49.regarray\[8\]\[2\] u_jt49.envelope\[3\] u_jt49.regarray\[8\]\[4\] VGND
+ VGND VPWR VPWR _0418_ sky130_fd_sc_hd__mux2_1
X_1454_ u_jt49.regarray\[6\]\[3\] net57 _0405_ VGND VGND VPWR VPWR _0184_ sky130_fd_sc_hd__mux2_1
X_1385_ net51 net154 _0397_ VGND VGND VPWR VPWR _0123_ sky130_fd_sc_hd__mux2_1
XFILLER_51_18 VGND VPWR VPWR VGND sky130_ef_sc_hd__decap_12
XFILLER_2_217 VGND VGND VPWR VPWR sky130_fd_sc_hd__decap_6
XFILLER_41_165 VGND VGND VPWR VPWR sky130_fd_sc_hd__decap_3
XFILLER_25_41 VGND VGND VPWR VPWR sky130_fd_sc_hd__decap_4
X_1170_ net30 _0756_ _0757_ VGND VGND VPWR VPWR _0057_ sky130_fd_sc_hd__and3_1
Xclkbuf_leaf_29_clk clknet_2_0__leaf_clk VGND VGND VPWR VPWR clknet_leaf_29_clk sky130_fd_sc_hd__clkbuf_8
X_0885_ net45 net46 net47 addr\[0\] VGND VGND VPWR VPWR _0532_ sky130_fd_sc_hd__and4b_4
X_0954_ u_jt49.regarray\[13\]\[6\] _0529_ _0593_ _0594_ VGND VGND VPWR VPWR _0595_
+ sky130_fd_sc_hd__a211o_1
XFILLER_9_361 VGND VPWR VPWR VGND sky130_ef_sc_hd__decap_12
X_1506_ u_jt49.bitB u_jt49.regarray\[7\]\[1\] u_jt49.regarray\[7\]\[4\] u_jt49.noise
+ net20 VGND VGND VPWR VPWR _0412_ sky130_fd_sc_hd__o221a_1
X_1437_ u_jt49.regarray\[8\]\[4\] net56 _0403_ VGND VGND VPWR VPWR _0169_ sky130_fd_sc_hd__mux2_1
XFILLER_46_29 VGND VGND VPWR VPWR sky130_fd_sc_hd__decap_8
X_1299_ u_jt49.periodB\[3\] u_jt49.periodB\[2\] u_jt49.periodB\[1\] u_jt49.periodB\[0\]
+ VGND VGND VPWR VPWR _0336_ sky130_fd_sc_hd__or4_1
X_1368_ u_jt49.periodA\[11\] u_jt49.periodA\[10\] u_jt49.periodA\[9\] u_jt49.periodA\[8\]
+ VGND VGND VPWR VPWR _0392_ sky130_fd_sc_hd__or4_1
XFILLER_11_349 VGND VPWR VPWR VGND sky130_ef_sc_hd__decap_12
XFILLER_11_65 VGND VGND VPWR VPWR sky130_fd_sc_hd__decap_8
XFILLER_61_249 VGND VPWR VPWR VGND sky130_ef_sc_hd__decap_12
XFILLER_61_205 VGND VPWR VPWR VGND sky130_ef_sc_hd__decap_12
XFILLER_14_132 VGND VGND VPWR VPWR sky130_fd_sc_hd__decap_8
Xinput26 din[5] VGND VGND VPWR VPWR net26 sky130_fd_sc_hd__clkbuf_1
Xinput15 IOB_in[6] VGND VGND VPWR VPWR net15 sky130_fd_sc_hd__buf_1
XFILLER_37_257 VGND VGND VPWR VPWR sky130_fd_sc_hd__decap_6
X_1084_ _0691_ u_jt49.u_env.inv _0690_ VGND VGND VPWR VPWR _0037_ sky130_fd_sc_hd__mux2_1
X_1222_ net177 _0274_ net34 VGND VGND VPWR VPWR _0083_ sky130_fd_sc_hd__mux2_1
X_1153_ net41 u_jt49.u_envdiv.count\[2\] u_jt49.u_envdiv.count\[1\] u_jt49.u_envdiv.count\[0\]
+ VGND VGND VPWR VPWR _0745_ sky130_fd_sc_hd__and4_1
XFILLER_52_249 VGND VGND VPWR VPWR sky130_fd_sc_hd__decap_3
X_0799_ u_jt49.periodC\[2\] VGND VGND VPWR VPWR _0453_ sky130_fd_sc_hd__inv_2
X_0868_ addr\[3\] net46 net47 net48 VGND VGND VPWR VPWR _0515_ sky130_fd_sc_hd__and4bb_2
Xclkbuf_leaf_9_clk clknet_2_1__leaf_clk VGND VGND VPWR VPWR clknet_leaf_9_clk sky130_fd_sc_hd__clkbuf_8
X_0937_ u_jt49.eg_period\[12\] _0531_ _0533_ u_jt49.regarray\[8\]\[4\] VGND VGND VPWR
+ VPWR _0580_ sky130_fd_sc_hd__a22o_1
XFILLER_57_39 VGND VPWR VPWR VGND sky130_ef_sc_hd__decap_12
XFILLER_34_205 VGND VGND VPWR VPWR sky130_fd_sc_hd__decap_4
X_1771_ clknet_leaf_9_clk _0214_ net78 VGND VGND VPWR VPWR u_jt49.periodB\[9\] sky130_fd_sc_hd__dfrtp_1
XFILLER_8_77 VGND VGND VPWR VPWR sky130_fd_sc_hd__decap_6
X_1067_ _0444_ _0675_ _0651_ VGND VGND VPWR VPWR _0035_ sky130_fd_sc_hd__a21boi_1
X_1136_ net192 _0734_ net40 VGND VGND VPWR VPWR _0046_ sky130_fd_sc_hd__mux2_1
X_1205_ u_jt49.u_ng.poly17\[5\] net167 net35 VGND VGND VPWR VPWR _0072_ sky130_fd_sc_hd__mux2_1
XFILLER_33_293 VGND VPWR VPWR VGND sky130_ef_sc_hd__decap_12
XFILLER_4_109 VGND VPWR VPWR VGND sky130_ef_sc_hd__decap_12
XFILLER_0_337 VGND VPWR VPWR VGND sky130_ef_sc_hd__decap_12
XFILLER_31_219 VGND VGND VPWR VPWR sky130_fd_sc_hd__decap_4
Xhold4 u_jt49.logB\[1\] VGND VGND VPWR VPWR net101 sky130_fd_sc_hd__dlygate4sd3_1
XFILLER_62_333 VGND VPWR VPWR VGND sky130_ef_sc_hd__decap_12
X_1823_ clknet_leaf_23_clk net102 VGND VGND VPWR VPWR B[1] sky130_fd_sc_hd__dfxtp_2
X_1754_ clknet_leaf_8_clk _0197_ net79 VGND VGND VPWR VPWR u_jt49.periodC\[0\] sky130_fd_sc_hd__dfrtp_1
X_1685_ clknet_leaf_17_clk _0128_ net94 VGND VGND VPWR VPWR u_jt49.eg_period\[11\]
+ sky130_fd_sc_hd__dfrtp_2
XPHY_EDGE_ROW_29_Left_93 VGND VGND VPWR VPWR sky130_fd_sc_hd__decap_3
XFILLER_57_149 VGND VGND VPWR VPWR sky130_fd_sc_hd__decap_3
XFILLER_57_105 VGND VGND VPWR VPWR sky130_fd_sc_hd__decap_6
XPHY_EDGE_ROW_13_Left_77 VGND VGND VPWR VPWR sky130_fd_sc_hd__decap_3
XFILLER_54_29 VGND VPWR VPWR VGND sky130_ef_sc_hd__decap_12
XFILLER_53_366 VGND VPWR VPWR VGND sky130_ef_sc_hd__decap_12
X_1119_ _0433_ u_jt49.u_envdiv.count\[1\] u_jt49.u_envdiv.count\[0\] _0434_ VGND VGND
+ VPWR VPWR _0719_ sky130_fd_sc_hd__a211o_1
XPHY_EDGE_ROW_17_Right_17 VGND VGND VPWR VPWR sky130_fd_sc_hd__decap_3
XPHY_EDGE_ROW_26_Right_26 VGND VGND VPWR VPWR sky130_fd_sc_hd__decap_3
XFILLER_28_85 VGND VPWR VPWR VGND sky130_ef_sc_hd__decap_12
XFILLER_44_377 VGND VGND VPWR VPWR sky130_fd_sc_hd__decap_3
XPHY_EDGE_ROW_35_Right_35 VGND VGND VPWR VPWR sky130_fd_sc_hd__decap_3
X_1470_ u_jt49.periodC\[1\] net61 _0407_ VGND VGND VPWR VPWR _0198_ sky130_fd_sc_hd__mux2_1
XFILLER_8_278 VGND VPWR VPWR VGND sky130_ef_sc_hd__decap_12
XPHY_EDGE_ROW_44_Right_44 VGND VGND VPWR VPWR sky130_fd_sc_hd__decap_3
XFILLER_62_141 VGND VPWR VPWR VGND sky130_ef_sc_hd__decap_12
XFILLER_54_119 VGND VGND VPWR VPWR sky130_fd_sc_hd__decap_4
XPHY_EDGE_ROW_53_Right_53 VGND VGND VPWR VPWR sky130_fd_sc_hd__decap_3
XFILLER_35_300 VGND VPWR VPWR VGND sky130_ef_sc_hd__decap_12
X_1806_ clknet_leaf_3_clk _0249_ net81 VGND VGND VPWR VPWR u_jt49.periodA\[6\] sky130_fd_sc_hd__dfrtp_1
XPHY_EDGE_ROW_62_Right_62 VGND VGND VPWR VPWR sky130_fd_sc_hd__decap_3
X_1737_ clknet_leaf_8_clk _0180_ net79 VGND VGND VPWR VPWR IOB_oe sky130_fd_sc_hd__dfrtp_4
X_1668_ clknet_leaf_28_clk _0113_ net73 VGND VGND VPWR VPWR u_jt49.u_cen.cencnt\[0\]
+ sky130_fd_sc_hd__dfrtp_1
X_1599_ clknet_leaf_22_clk _0046_ VGND VGND VPWR VPWR u_jt49.envelope\[1\] sky130_fd_sc_hd__dfxtp_1
XFILLER_14_54 VGND VGND VPWR VPWR sky130_fd_sc_hd__decap_3
XFILLER_39_62 VGND VGND VPWR VPWR sky130_fd_sc_hd__decap_4
XFILLER_55_50 VGND VGND VPWR VPWR sky130_fd_sc_hd__decap_6
XFILLER_32_314 VGND VPWR VPWR VGND sky130_ef_sc_hd__decap_12
XFILLER_17_355 VGND VPWR VPWR VGND sky130_ef_sc_hd__decap_12
X_0970_ u_jt49.periodA\[7\] _0518_ _0544_ _0609_ u_jt49.read_mask\[5\] VGND VGND VPWR
+ VPWR _0610_ sky130_fd_sc_hd__o2111a_1
X_1522_ net65 net99 _0416_ _0417_ VGND VGND VPWR VPWR _0240_ sky130_fd_sc_hd__a22o_1
X_1453_ u_jt49.regarray\[6\]\[2\] net60 _0405_ VGND VGND VPWR VPWR _0183_ sky130_fd_sc_hd__mux2_1
X_1384_ net53 net146 _0397_ VGND VGND VPWR VPWR _0122_ sky130_fd_sc_hd__mux2_1
XFILLER_35_163 VGND VGND VPWR VPWR sky130_fd_sc_hd__decap_4
XFILLER_26_141 VGND VGND VPWR VPWR sky130_fd_sc_hd__decap_4
XPHY_EDGE_ROW_16_Left_80 VGND VGND VPWR VPWR sky130_fd_sc_hd__decap_3
XFILLER_32_188 VGND VGND VPWR VPWR sky130_fd_sc_hd__decap_8
XFILLER_20_317 VGND VPWR VPWR VGND sky130_ef_sc_hd__decap_12
X_0884_ net47 net48 net45 net46 VGND VGND VPWR VPWR _0531_ sky130_fd_sc_hd__and4bb_4
X_0953_ u_jt49.regarray\[6\]\[6\] _0521_ _0531_ u_jt49.eg_period\[14\] _0517_ VGND
+ VGND VPWR VPWR _0594_ sky130_fd_sc_hd__a221o_1
XFILLER_9_373 VGND VGND VPWR VPWR sky130_fd_sc_hd__decap_6
X_1505_ u_jt49.periodB\[7\] net49 _0411_ VGND VGND VPWR VPWR _0229_ sky130_fd_sc_hd__mux2_1
X_1436_ net190 net57 _0403_ VGND VGND VPWR VPWR _0168_ sky130_fd_sc_hd__mux2_1
X_1367_ u_jt49.periodA\[7\] u_jt49.periodA\[6\] u_jt49.periodA\[5\] u_jt49.periodA\[4\]
+ VGND VGND VPWR VPWR _0391_ sky130_fd_sc_hd__or4_1
XFILLER_55_225 VGND VPWR VPWR VGND sky130_ef_sc_hd__decap_12
X_1298_ _0307_ _0334_ _0335_ VGND VGND VPWR VPWR _0098_ sky130_fd_sc_hd__and3_1
XFILLER_62_29 VGND VPWR VPWR VGND sky130_ef_sc_hd__decap_12
XFILLER_23_144 VGND VGND VPWR VPWR sky130_fd_sc_hd__decap_8
XFILLER_61_217 VGND VGND VPWR VPWR sky130_fd_sc_hd__decap_6
XFILLER_36_41 VGND VGND VPWR VPWR sky130_fd_sc_hd__decap_4
XPHY_EDGE_ROW_1_Left_65 VGND VGND VPWR VPWR sky130_fd_sc_hd__decap_3
XFILLER_14_111 VGND VPWR VPWR VGND sky130_ef_sc_hd__decap_12
Xinput27 din[6] VGND VGND VPWR VPWR net27 sky130_fd_sc_hd__clkbuf_1
XFILLER_6_321 VGND VPWR VPWR VGND sky130_ef_sc_hd__decap_12
XFILLER_6_365 VGND VPWR VPWR VGND sky130_ef_sc_hd__decap_12
Xinput16 IOB_in[7] VGND VGND VPWR VPWR net16 sky130_fd_sc_hd__buf_1
X_1221_ u_jt49.u_ng.poly17\[0\] u_jt49.u_ng.poly17\[3\] _0273_ VGND VGND VPWR VPWR
+ _0274_ sky130_fd_sc_hd__a21oi_1
XFILLER_37_225 VGND VGND VPWR VPWR sky130_fd_sc_hd__decap_4
X_1083_ _0495_ u_jt49.regarray\[13\]\[2\] u_jt49.u_env.rst_latch VGND VGND VPWR VPWR
+ _0691_ sky130_fd_sc_hd__mux2_1
X_1152_ u_jt49.u_envdiv.count\[2\] _0741_ VGND VGND VPWR VPWR _0744_ sky130_fd_sc_hd__or2_1
X_0936_ u_jt49.regarray\[10\]\[4\] _0526_ _0527_ u_jt49.periodB\[4\] _0517_ VGND VGND
+ VPWR VPWR _0579_ sky130_fd_sc_hd__a221o_1
X_0798_ u_jt49.periodC\[3\] VGND VGND VPWR VPWR _0452_ sky130_fd_sc_hd__inv_2
X_0867_ net45 net46 VGND VGND VPWR VPWR _0514_ sky130_fd_sc_hd__or2_2
X_1419_ u_jt49.regarray\[9\]\[4\] net55 _0401_ VGND VGND VPWR VPWR _0153_ sky130_fd_sc_hd__mux2_1
XFILLER_51_272 VGND VGND VPWR VPWR sky130_fd_sc_hd__decap_8
XFILLER_22_98 VGND VPWR VPWR VGND sky130_ef_sc_hd__decap_12
XFILLER_59_361 VGND VPWR VPWR VGND sky130_ef_sc_hd__decap_12
XFILLER_19_225 VGND VGND VPWR VPWR sky130_fd_sc_hd__decap_4
X_1770_ clknet_leaf_9_clk _0213_ net77 VGND VGND VPWR VPWR u_jt49.periodB\[8\] sky130_fd_sc_hd__dfrtp_1
XFILLER_42_294 VGND VGND VPWR VPWR sky130_fd_sc_hd__decap_3
X_1204_ net157 u_jt49.u_ng.poly17\[5\] net34 VGND VGND VPWR VPWR _0071_ sky130_fd_sc_hd__mux2_1
X_1066_ _0651_ _0675_ _0676_ VGND VGND VPWR VPWR _0034_ sky130_fd_sc_hd__and3_1
XFILLER_40_209 VGND VGND VPWR VPWR sky130_fd_sc_hd__decap_4
X_1135_ u_jt49.u_env.gain\[1\] u_jt49.u_env.inv VGND VGND VPWR VPWR _0734_ sky130_fd_sc_hd__xor2_1
XFILLER_25_217 VGND VGND VPWR VPWR sky130_fd_sc_hd__decap_6
X_0919_ _0559_ _0561_ _0563_ VGND VGND VPWR VPWR _0564_ sky130_fd_sc_hd__or3_1
XFILLER_0_305 VGND VGND VPWR VPWR sky130_fd_sc_hd__decap_3
XFILLER_0_349 VGND VPWR VPWR VGND sky130_ef_sc_hd__decap_12
XFILLER_56_331 VGND VGND VPWR VPWR sky130_fd_sc_hd__decap_3
XFILLER_48_309 VGND VPWR VPWR VGND sky130_ef_sc_hd__decap_12
XFILLER_39_309 VGND VPWR VPWR VGND sky130_ef_sc_hd__decap_12
Xhold5 u_jt49.logB\[2\] VGND VGND VPWR VPWR net102 sky130_fd_sc_hd__dlygate4sd3_1
XFILLER_62_345 VGND VPWR VPWR VGND sky130_ef_sc_hd__decap_12
XFILLER_62_301 VGND VGND VPWR VPWR sky130_fd_sc_hd__decap_6
XFILLER_22_209 VGND VGND VPWR VPWR sky130_fd_sc_hd__decap_6
X_1753_ clknet_leaf_10_clk _0196_ net90 VGND VGND VPWR VPWR u_jt49.regarray\[5\]\[7\]
+ sky130_fd_sc_hd__dfrtp_1
XFILLER_30_253 VGND VGND VPWR VPWR sky130_fd_sc_hd__decap_4
X_1822_ clknet_leaf_23_clk net101 VGND VGND VPWR VPWR B[0] sky130_fd_sc_hd__dfxtp_2
X_1684_ clknet_leaf_17_clk _0127_ net94 VGND VGND VPWR VPWR u_jt49.eg_period\[10\]
+ sky130_fd_sc_hd__dfrtp_1
X_1049_ net32 _0663_ _0664_ VGND VGND VPWR VPWR _0029_ sky130_fd_sc_hd__and3_1
X_1118_ _0717_ VGND VGND VPWR VPWR _0718_ sky130_fd_sc_hd__inv_2
XFILLER_29_320 VGND VPWR VPWR VGND sky130_ef_sc_hd__decap_12
XFILLER_0_113 VGND VPWR VPWR VGND sky130_ef_sc_hd__decap_12
XFILLER_44_356 VGND VGND VPWR VPWR sky130_fd_sc_hd__decap_8
XFILLER_28_97 VGND VPWR VPWR VGND sky130_ef_sc_hd__decap_12
XPHY_EDGE_ROW_30_Left_94 VGND VGND VPWR VPWR sky130_fd_sc_hd__decap_3
XFILLER_8_213 VGND VGND VPWR VPWR sky130_fd_sc_hd__decap_3
XFILLER_5_57 VGND VPWR VPWR VGND sky130_ef_sc_hd__decap_12
XFILLER_39_106 VGND VGND VPWR VPWR sky130_fd_sc_hd__decap_6
XFILLER_35_323 VGND VGND VPWR VPWR sky130_fd_sc_hd__decap_6
XFILLER_35_312 VGND VGND VPWR VPWR sky130_fd_sc_hd__decap_6
XFILLER_62_197 VGND VPWR VPWR VGND sky130_ef_sc_hd__decap_12
XFILLER_62_153 VGND VPWR VPWR VGND sky130_ef_sc_hd__decap_12
XFILLER_47_183 VGND VPWR VPWR VGND sky130_ef_sc_hd__decap_12
X_1736_ clknet_leaf_11_clk _0179_ net91 VGND VGND VPWR VPWR IOA_oe sky130_fd_sc_hd__dfrtp_4
X_1805_ clknet_leaf_1_clk _0248_ net69 VGND VGND VPWR VPWR u_jt49.periodA\[5\] sky130_fd_sc_hd__dfrtp_1
X_1667_ clknet_leaf_1_clk _0112_ net71 VGND VGND VPWR VPWR u_jt49.bitA sky130_fd_sc_hd__dfrtp_1
X_1598_ clknet_leaf_20_clk _0045_ net86 VGND VGND VPWR VPWR u_jt49.eg_step sky130_fd_sc_hd__dfrtp_1
XFILLER_53_153 VGND VPWR VPWR VGND sky130_ef_sc_hd__decap_12
XFILLER_41_337 VGND VPWR VPWR VGND sky130_ef_sc_hd__decap_12
XFILLER_14_99 VGND VPWR VPWR VGND sky130_ef_sc_hd__decap_12
XFILLER_44_197 VGND VGND VPWR VPWR sky130_fd_sc_hd__decap_4
XFILLER_32_304 VGND VGND VPWR VPWR sky130_fd_sc_hd__decap_4
XFILLER_17_367 VGND VGND VPWR VPWR sky130_fd_sc_hd__decap_8
X_1383_ net55 net155 _0397_ VGND VGND VPWR VPWR _0121_ sky130_fd_sc_hd__mux2_1
XFILLER_4_293 VGND VGND VPWR VPWR sky130_fd_sc_hd__decap_8
X_1521_ u_jt49.regarray\[8\]\[1\] u_jt49.envelope\[2\] u_jt49.regarray\[8\]\[4\] VGND
+ VGND VPWR VPWR _0417_ sky130_fd_sc_hd__mux2_1
X_1452_ u_jt49.regarray\[6\]\[1\] net61 _0405_ VGND VGND VPWR VPWR _0182_ sky130_fd_sc_hd__mux2_1
X_1719_ clknet_leaf_15_clk _0162_ net94 VGND VGND VPWR VPWR IOA_out[5] sky130_fd_sc_hd__dfrtp_4
XFILLER_26_197 VGND VGND VPWR VPWR sky130_fd_sc_hd__decap_8
XFILLER_25_65 VGND VPWR VPWR VGND sky130_ef_sc_hd__decap_12
XFILLER_41_189 VGND VGND VPWR VPWR sky130_fd_sc_hd__decap_3
X_0952_ u_jt49.regarray\[10\]\[6\] _0526_ _0532_ IOA_oe VGND VGND VPWR VPWR _0593_
+ sky130_fd_sc_hd__a22o_1
XFILLER_63_3 VGND VGND VPWR VPWR sky130_fd_sc_hd__decap_4
X_1504_ u_jt49.periodB\[6\] net52 _0411_ VGND VGND VPWR VPWR _0228_ sky130_fd_sc_hd__mux2_1
X_0883_ net46 net47 net48 net45 VGND VGND VPWR VPWR _0530_ sky130_fd_sc_hd__and4b_4
X_1435_ net204 net59 _0403_ VGND VGND VPWR VPWR _0167_ sky130_fd_sc_hd__mux2_1
X_1366_ u_jt49.periodA\[3\] u_jt49.periodA\[2\] u_jt49.periodA\[1\] u_jt49.periodA\[0\]
+ VGND VGND VPWR VPWR _0390_ sky130_fd_sc_hd__or4_1
XFILLER_63_281 VGND VPWR VPWR VGND sky130_ef_sc_hd__decap_12
XFILLER_55_237 VGND VPWR VPWR VGND sky130_ef_sc_hd__decap_12
X_1297_ u_jt49.u_chB.count\[11\] _0332_ VGND VGND VPWR VPWR _0335_ sky130_fd_sc_hd__nand2_1
XFILLER_23_101 VGND VGND VPWR VPWR sky130_fd_sc_hd__decap_8
XFILLER_52_41 VGND VPWR VPWR VGND sky130_ef_sc_hd__decap_12
Xinput28 din[7] VGND VGND VPWR VPWR net28 sky130_fd_sc_hd__clkbuf_1
Xinput17 bc1 VGND VGND VPWR VPWR net17 sky130_fd_sc_hd__buf_1
XFILLER_6_333 VGND VPWR VPWR VGND sky130_ef_sc_hd__decap_12
XFILLER_6_377 VGND VGND VPWR VPWR sky130_fd_sc_hd__decap_3
X_1151_ net30 _0742_ _0743_ VGND VGND VPWR VPWR _0052_ sky130_fd_sc_hd__and3_1
X_1220_ _0270_ _0271_ _0272_ _0500_ _0499_ VGND VGND VPWR VPWR _0273_ sky130_fd_sc_hd__o311a_1
X_1082_ _0685_ _0688_ _0689_ VGND VGND VPWR VPWR _0690_ sky130_fd_sc_hd__or3_1
X_0866_ _0507_ _0510_ _0512_ _0513_ VGND VGND VPWR VPWR _0001_ sky130_fd_sc_hd__o22a_1
X_0935_ u_jt49.periodC\[4\] _0535_ _0575_ _0577_ VGND VGND VPWR VPWR _0578_ sky130_fd_sc_hd__a211o_1
XFILLER_20_137 VGND VGND VPWR VPWR sky130_fd_sc_hd__decap_3
X_0797_ u_jt49.periodC\[4\] VGND VGND VPWR VPWR _0451_ sky130_fd_sc_hd__inv_2
X_1418_ net184 net58 _0401_ VGND VGND VPWR VPWR _0152_ sky130_fd_sc_hd__mux2_1
X_1349_ _0377_ VGND VGND VPWR VPWR _0378_ sky130_fd_sc_hd__inv_2
XFILLER_59_373 VGND VGND VPWR VPWR sky130_fd_sc_hd__decap_4
XFILLER_34_218 VGND VGND VPWR VPWR sky130_fd_sc_hd__decap_4
XFILLER_6_141 VGND VGND VPWR VPWR sky130_fd_sc_hd__decap_3
X_1203_ u_jt49.u_ng.poly17\[3\] net157 net35 VGND VGND VPWR VPWR _0070_ sky130_fd_sc_hd__mux2_1
X_1134_ _0733_ net201 net30 VGND VGND VPWR VPWR _0045_ sky130_fd_sc_hd__mux2_1
X_1065_ _0445_ _0674_ VGND VGND VPWR VPWR _0676_ sky130_fd_sc_hd__nand2_1
X_0849_ net17 net19 VGND VGND VPWR VPWR _0502_ sky130_fd_sc_hd__xor2_2
X_0918_ u_jt49.periodA\[10\] _0528_ _0533_ u_jt49.regarray\[8\]\[2\] _0562_ VGND VGND
+ VPWR VPWR _0563_ sky130_fd_sc_hd__a221o_1
XFILLER_3_133 VGND VGND VPWR VPWR sky130_fd_sc_hd__decap_8
XFILLER_59_181 VGND VPWR VPWR VGND sky130_ef_sc_hd__decap_12
Xhold6 u_jt49.logA\[1\] VGND VGND VPWR VPWR net103 sky130_fd_sc_hd__dlygate4sd3_1
XFILLER_62_357 VGND VGND VPWR VPWR sky130_fd_sc_hd__decap_6
X_1752_ clknet_leaf_10_clk _0195_ net90 VGND VGND VPWR VPWR u_jt49.regarray\[5\]\[6\]
+ sky130_fd_sc_hd__dfrtp_1
Xclkbuf_leaf_10_clk clknet_2_3__leaf_clk VGND VGND VPWR VPWR clknet_leaf_10_clk sky130_fd_sc_hd__clkbuf_8
X_1683_ clknet_leaf_17_clk _0126_ net94 VGND VGND VPWR VPWR u_jt49.eg_period\[9\]
+ sky130_fd_sc_hd__dfrtp_2
X_1821_ clknet_leaf_24_clk net100 VGND VGND VPWR VPWR A[3] sky130_fd_sc_hd__dfxtp_2
XFILLER_38_365 VGND VGND VPWR VPWR sky130_fd_sc_hd__decap_4
X_1117_ _0712_ _0713_ _0715_ _0711_ _0710_ VGND VGND VPWR VPWR _0717_ sky130_fd_sc_hd__o32a_1
X_1048_ u_jt49.u_chC.count\[5\] _0659_ VGND VGND VPWR VPWR _0664_ sky130_fd_sc_hd__or2_1
XPHY_EDGE_ROW_3_Right_3 VGND VGND VPWR VPWR sky130_fd_sc_hd__decap_3
XFILLER_21_210 VGND VPWR VPWR VGND sky130_ef_sc_hd__decap_12
XFILLER_29_332 VGND VGND VPWR VPWR sky130_fd_sc_hd__decap_4
XFILLER_28_65 VGND VGND VPWR VPWR sky130_fd_sc_hd__decap_8
XFILLER_28_43 VGND VGND VPWR VPWR sky130_fd_sc_hd__decap_6
XFILLER_0_125 VGND VPWR VPWR VGND sky130_ef_sc_hd__decap_12
XFILLER_0_169 VGND VPWR VPWR VGND sky130_ef_sc_hd__decap_12
XFILLER_0_158 VGND VGND VPWR VPWR sky130_fd_sc_hd__decap_8
XFILLER_60_85 VGND VPWR VPWR VGND sky130_ef_sc_hd__decap_12
XFILLER_60_41 VGND VPWR VPWR VGND sky130_ef_sc_hd__decap_12
XFILLER_5_69 VGND VPWR VPWR VGND sky130_ef_sc_hd__decap_12
XFILLER_62_121 VGND VPWR VPWR VGND sky130_ef_sc_hd__decap_12
XFILLER_47_195 VGND VGND VPWR VPWR sky130_fd_sc_hd__decap_8
XFILLER_62_165 VGND VPWR VPWR VGND sky130_ef_sc_hd__decap_12
X_1735_ clknet_leaf_10_clk _0178_ net89 VGND VGND VPWR VPWR u_jt49.regarray\[7\]\[5\]
+ sky130_fd_sc_hd__dfrtp_1
X_1804_ clknet_leaf_2_clk _0247_ net77 VGND VGND VPWR VPWR u_jt49.periodA\[4\] sky130_fd_sc_hd__dfrtp_1
X_1666_ clknet_leaf_0_clk _0111_ net69 VGND VGND VPWR VPWR u_jt49.u_chA.count\[11\]
+ sky130_fd_sc_hd__dfrtp_1
X_1597_ clknet_leaf_21_clk _0044_ net88 VGND VGND VPWR VPWR u_jt49.u_env.gain\[4\]
+ sky130_fd_sc_hd__dfstp_1
XFILLER_53_165 VGND VGND VPWR VPWR sky130_fd_sc_hd__decap_3
XFILLER_41_349 VGND VGND VPWR VPWR sky130_fd_sc_hd__decap_8
XFILLER_44_110 VGND VPWR VPWR VGND sky130_ef_sc_hd__decap_12
XFILLER_39_53 VGND VGND VPWR VPWR sky130_fd_sc_hd__decap_3
XFILLER_29_173 VGND VGND VPWR VPWR sky130_fd_sc_hd__decap_3
XFILLER_44_176 VGND VGND VPWR VPWR sky130_fd_sc_hd__decap_4
X_1520_ _0414_ _0415_ _0416_ net103 net65 VGND VGND VPWR VPWR _0239_ sky130_fd_sc_hd__a32o_1
X_1382_ net58 u_jt49.regarray\[13\]\[3\] _0397_ VGND VGND VPWR VPWR _0120_ sky130_fd_sc_hd__mux2_1
X_1451_ net202 net63 _0405_ VGND VGND VPWR VPWR _0181_ sky130_fd_sc_hd__mux2_1
XFILLER_35_121 VGND VGND VPWR VPWR sky130_fd_sc_hd__decap_3
X_1649_ clknet_leaf_7_clk _0094_ net76 VGND VGND VPWR VPWR u_jt49.u_chB.count\[7\]
+ sky130_fd_sc_hd__dfrtp_1
X_1718_ clknet_leaf_16_clk _0161_ net93 VGND VGND VPWR VPWR IOA_out[4] sky130_fd_sc_hd__dfrtp_4
XFILLER_2_37 VGND VGND VPWR VPWR sky130_fd_sc_hd__decap_3
X_0882_ net47 net48 net45 net46 VGND VGND VPWR VPWR _0529_ sky130_fd_sc_hd__and4b_4
X_0951_ net14 _0546_ _0547_ net6 _0592_ VGND VGND VPWR VPWR _0266_ sky130_fd_sc_hd__a221o_1
X_1503_ u_jt49.periodB\[5\] net53 _0411_ VGND VGND VPWR VPWR _0227_ sky130_fd_sc_hd__mux2_1
XFILLER_55_249 VGND VPWR VPWR VGND sky130_ef_sc_hd__decap_12
X_1296_ u_jt49.u_chB.count\[11\] _0332_ VGND VGND VPWR VPWR _0334_ sky130_fd_sc_hd__or2_1
X_1365_ _0362_ _0388_ _0389_ VGND VGND VPWR VPWR _0111_ sky130_fd_sc_hd__and3_1
X_1434_ net198 net61 _0403_ VGND VGND VPWR VPWR _0166_ sky130_fd_sc_hd__mux2_1
XFILLER_63_293 VGND VGND VPWR VPWR sky130_fd_sc_hd__decap_8
XFILLER_48_290 VGND VPWR VPWR VGND sky130_ef_sc_hd__decap_12
XFILLER_23_113 VGND VGND VPWR VPWR sky130_fd_sc_hd__decap_4
XFILLER_54_260 VGND VGND VPWR VPWR sky130_fd_sc_hd__decap_8
Xinput18 bc2 VGND VGND VPWR VPWR net18 sky130_fd_sc_hd__clkbuf_2
XFILLER_52_53 VGND VGND VPWR VPWR sky130_fd_sc_hd__decap_8
XFILLER_10_330 VGND VPWR VPWR VGND sky130_ef_sc_hd__decap_12
Xinput29 rst_n VGND VGND VPWR VPWR net29 sky130_fd_sc_hd__clkbuf_1
XFILLER_6_345 VGND VPWR VPWR VGND sky130_ef_sc_hd__decap_12
X_1150_ net41 u_jt49.u_envdiv.count\[0\] u_jt49.u_envdiv.count\[1\] VGND VGND VPWR
+ VPWR _0743_ sky130_fd_sc_hd__a21o_1
X_1081_ u_jt49.u_env.rst_latch _0687_ VGND VGND VPWR VPWR _0689_ sky130_fd_sc_hd__nor2_1
X_0865_ _0509_ _0510_ _0511_ VGND VGND VPWR VPWR _0513_ sky130_fd_sc_hd__o21a_1
X_0934_ u_jt49.regarray\[6\]\[4\] _0521_ _0524_ u_jt49.regarray\[9\]\[4\] _0576_ VGND
+ VGND VPWR VPWR _0577_ sky130_fd_sc_hd__a221o_1
XFILLER_20_149 VGND VGND VPWR VPWR sky130_fd_sc_hd__decap_3
X_0796_ u_jt49.periodC\[5\] VGND VGND VPWR VPWR _0450_ sky130_fd_sc_hd__inv_2
X_1417_ net194 net60 _0401_ VGND VGND VPWR VPWR _0151_ sky130_fd_sc_hd__mux2_1
X_1279_ _0307_ _0320_ _0321_ VGND VGND VPWR VPWR _0093_ sky130_fd_sc_hd__and3_1
XFILLER_36_260 VGND VGND VPWR VPWR sky130_fd_sc_hd__decap_8
X_1348_ u_jt49.u_chA.count\[7\] u_jt49.u_chA.count\[6\] _0373_ VGND VGND VPWR VPWR
+ _0377_ sky130_fd_sc_hd__and3_1
XFILLER_11_105 VGND VGND VPWR VPWR sky130_fd_sc_hd__decap_4
XFILLER_3_337 VGND VPWR VPWR VGND sky130_ef_sc_hd__decap_12
XFILLER_63_41 VGND VPWR VPWR VGND sky130_ef_sc_hd__decap_12
XFILLER_6_120 VGND VPWR VPWR VGND sky130_ef_sc_hd__decap_12
X_1064_ _0445_ _0674_ VGND VGND VPWR VPWR _0675_ sky130_fd_sc_hd__or2_1
X_1202_ net176 u_jt49.u_ng.poly17\[3\] net35 VGND VGND VPWR VPWR _0069_ sky130_fd_sc_hd__mux2_1
X_1133_ u_jt49.eg_step _0682_ VGND VGND VPWR VPWR _0733_ sky130_fd_sc_hd__nor2_1
XFILLER_19_3 VGND VGND VPWR VPWR sky130_fd_sc_hd__decap_6
XFILLER_18_282 VGND VGND VPWR VPWR sky130_fd_sc_hd__decap_4
X_0848_ u_jt49.wr_n cs_n VGND VGND VPWR VPWR u_jt49.write sky130_fd_sc_hd__nor2_1
X_0917_ u_jt49.periodB\[10\] _0515_ _0527_ u_jt49.periodB\[2\] VGND VGND VPWR VPWR
+ _0562_ sky130_fd_sc_hd__a22o_1
X_0779_ u_jt49.eg_period\[1\] VGND VGND VPWR VPWR _0433_ sky130_fd_sc_hd__inv_2
XFILLER_59_193 VGND VGND VPWR VPWR sky130_fd_sc_hd__decap_8
XFILLER_58_85 VGND VPWR VPWR VGND sky130_ef_sc_hd__decap_12
XFILLER_58_41 VGND VPWR VPWR VGND sky130_ef_sc_hd__decap_12
Xhold7 u_jt49.logB\[3\] VGND VGND VPWR VPWR net104 sky130_fd_sc_hd__dlygate4sd3_1
X_1820_ clknet_leaf_28_clk net98 VGND VGND VPWR VPWR A[2] sky130_fd_sc_hd__dfxtp_2
X_1751_ clknet_leaf_17_clk _0194_ net90 VGND VGND VPWR VPWR u_jt49.regarray\[5\]\[5\]
+ sky130_fd_sc_hd__dfrtp_1
X_1682_ clknet_leaf_17_clk _0125_ net90 VGND VGND VPWR VPWR u_jt49.eg_period\[8\]
+ sky130_fd_sc_hd__dfrtp_1
X_1047_ _0662_ VGND VGND VPWR VPWR _0663_ sky130_fd_sc_hd__inv_2
XFILLER_53_303 VGND VPWR VPWR VGND sky130_ef_sc_hd__decap_12
X_1116_ _0713_ _0715_ VGND VGND VPWR VPWR _0716_ sky130_fd_sc_hd__nor2_1
XFILLER_0_81 VGND VGND VPWR VPWR sky130_fd_sc_hd__decap_3
XFILLER_0_137 VGND VGND VPWR VPWR sky130_fd_sc_hd__decap_3
XFILLER_12_200 VGND VGND VPWR VPWR sky130_fd_sc_hd__decap_3
XFILLER_60_97 VGND VPWR VPWR VGND sky130_ef_sc_hd__decap_12
XFILLER_60_53 VGND VPWR VPWR VGND sky130_ef_sc_hd__decap_12
XFILLER_5_15 VGND VPWR VPWR VGND sky130_ef_sc_hd__decap_12
XFILLER_62_133 VGND VGND VPWR VPWR sky130_fd_sc_hd__decap_6
XPHY_EDGE_ROW_13_Right_13 VGND VGND VPWR VPWR sky130_fd_sc_hd__decap_3
XFILLER_62_177 VGND VPWR VPWR VGND sky130_ef_sc_hd__decap_12
X_1803_ clknet_leaf_1_clk _0246_ net71 VGND VGND VPWR VPWR u_jt49.periodA\[3\] sky130_fd_sc_hd__dfrtp_1
XPHY_EDGE_ROW_22_Right_22 VGND VGND VPWR VPWR sky130_fd_sc_hd__decap_3
X_1734_ clknet_leaf_18_clk _0177_ net84 VGND VGND VPWR VPWR u_jt49.regarray\[7\]\[4\]
+ sky130_fd_sc_hd__dfrtp_1
X_1596_ clknet_leaf_22_clk _0043_ net85 VGND VGND VPWR VPWR u_jt49.u_env.gain\[3\]
+ sky130_fd_sc_hd__dfstp_1
X_1665_ clknet_leaf_0_clk _0110_ net69 VGND VGND VPWR VPWR u_jt49.u_chA.count\[10\]
+ sky130_fd_sc_hd__dfrtp_1
XPHY_EDGE_ROW_31_Right_31 VGND VGND VPWR VPWR sky130_fd_sc_hd__decap_3
XPHY_EDGE_ROW_40_Right_40 VGND VGND VPWR VPWR sky130_fd_sc_hd__decap_3
XFILLER_14_79 VGND VGND VPWR VPWR sky130_fd_sc_hd__decap_4
XFILLER_39_76 VGND VPWR VPWR VGND sky130_ef_sc_hd__decap_12
X_1450_ net36 _0521_ VGND VGND VPWR VPWR _0405_ sky130_fd_sc_hd__and2_2
X_1381_ net59 net208 _0397_ VGND VGND VPWR VPWR _0119_ sky130_fd_sc_hd__mux2_1
X_1579_ clknet_leaf_12_clk _0026_ net91 VGND VGND VPWR VPWR u_jt49.u_chC.count\[2\]
+ sky130_fd_sc_hd__dfrtp_1
X_1648_ clknet_leaf_5_clk _0093_ net76 VGND VGND VPWR VPWR u_jt49.u_chB.count\[6\]
+ sky130_fd_sc_hd__dfrtp_1
X_1717_ clknet_leaf_16_clk _0160_ net93 VGND VGND VPWR VPWR IOA_out[3] sky130_fd_sc_hd__dfrtp_4
XFILLER_49_236 VGND VGND VPWR VPWR sky130_fd_sc_hd__decap_3
XFILLER_1_276 VGND VGND VPWR VPWR sky130_fd_sc_hd__decap_4
X_0881_ _0514_ _0523_ VGND VGND VPWR VPWR _0528_ sky130_fd_sc_hd__nor2_2
X_0950_ u_jt49.periodA\[5\] _0518_ _0544_ _0591_ u_jt49.read_mask\[5\] VGND VGND VPWR
+ VPWR _0592_ sky130_fd_sc_hd__o2111a_1
XFILLER_49_3 VGND VPWR VPWR VGND sky130_ef_sc_hd__decap_12
X_1502_ u_jt49.periodB\[4\] net56 _0411_ VGND VGND VPWR VPWR _0226_ sky130_fd_sc_hd__mux2_1
X_1433_ net117 net63 _0403_ VGND VGND VPWR VPWR _0165_ sky130_fd_sc_hd__mux2_1
XFILLER_55_206 VGND VPWR VPWR VGND sky130_ef_sc_hd__decap_12
X_1295_ _0307_ _0331_ _0333_ VGND VGND VPWR VPWR _0097_ sky130_fd_sc_hd__and3_1
X_1364_ u_jt49.u_chA.count\[11\] _0386_ VGND VGND VPWR VPWR _0389_ sky130_fd_sc_hd__nand2_1
XPHY_EDGE_ROW_43_Left_107 VGND VGND VPWR VPWR sky130_fd_sc_hd__decap_3
XPHY_EDGE_ROW_52_Left_116 VGND VGND VPWR VPWR sky130_fd_sc_hd__decap_3
XPHY_EDGE_ROW_61_Left_125 VGND VGND VPWR VPWR sky130_fd_sc_hd__decap_3
XFILLER_46_217 VGND VGND VPWR VPWR sky130_fd_sc_hd__decap_4
XFILLER_36_66 VGND VGND VPWR VPWR sky130_fd_sc_hd__decap_3
Xinput19 bdir VGND VGND VPWR VPWR net19 sky130_fd_sc_hd__buf_1
XFILLER_10_342 VGND VPWR VPWR VGND sky130_ef_sc_hd__decap_12
XFILLER_6_357 VGND VGND VPWR VPWR sky130_fd_sc_hd__decap_6
X_1080_ u_jt49.u_env.gain\[4\] _0686_ u_jt49.u_env.rst_latch VGND VGND VPWR VPWR _0688_
+ sky130_fd_sc_hd__o21ba_1
XFILLER_60_253 VGND VPWR VPWR VGND sky130_ef_sc_hd__decap_12
X_0864_ net78 _0506_ _0508_ VGND VGND VPWR VPWR _0512_ sky130_fd_sc_hd__and3_1
X_0795_ u_jt49.periodC\[6\] VGND VGND VPWR VPWR _0449_ sky130_fd_sc_hd__inv_2
X_0933_ u_jt49.regarray\[13\]\[4\] _0529_ _0532_ u_jt49.regarray\[7\]\[4\] VGND VGND
+ VPWR VPWR _0576_ sky130_fd_sc_hd__a22o_1
XFILLER_3_81 VGND VPWR VPWR VGND sky130_ef_sc_hd__decap_12
X_1347_ _0362_ _0375_ _0376_ VGND VGND VPWR VPWR _0106_ sky130_fd_sc_hd__and3_1
X_1416_ net195 net62 _0401_ VGND VGND VPWR VPWR _0150_ sky130_fd_sc_hd__mux2_1
X_1278_ u_jt49.u_chB.count\[5\] _0315_ u_jt49.u_chB.count\[6\] VGND VGND VPWR VPWR
+ _0321_ sky130_fd_sc_hd__a21o_1
XFILLER_36_294 VGND VPWR VPWR VGND sky130_ef_sc_hd__decap_12
XPHY_EDGE_ROW_5_Left_69 VGND VGND VPWR VPWR sky130_fd_sc_hd__decap_3
XFILLER_3_349 VGND VPWR VPWR VGND sky130_ef_sc_hd__decap_12
XFILLER_63_53 VGND VGND VPWR VPWR sky130_fd_sc_hd__decap_3
XFILLER_6_176 VGND VGND VPWR VPWR sky130_fd_sc_hd__decap_8
XFILLER_6_132 VGND VGND VPWR VPWR sky130_fd_sc_hd__decap_8
X_1201_ net162 u_jt49.u_ng.poly17\[2\] net35 VGND VGND VPWR VPWR _0068_ sky130_fd_sc_hd__mux2_1
X_1063_ net32 _0673_ _0674_ VGND VGND VPWR VPWR _0033_ sky130_fd_sc_hd__and3_1
X_1132_ net41 _0731_ VGND VGND VPWR VPWR _0732_ sky130_fd_sc_hd__nand2_1
X_0916_ u_jt49.regarray\[9\]\[2\] _0524_ _0529_ u_jt49.regarray\[13\]\[2\] _0560_
+ VGND VGND VPWR VPWR _0561_ sky130_fd_sc_hd__a221o_1
X_0847_ net20 VGND VGND VPWR VPWR _0501_ sky130_fd_sc_hd__inv_2
X_0778_ net191 VGND VGND VPWR VPWR _0432_ sky130_fd_sc_hd__inv_2
XFILLER_17_57 VGND VGND VPWR VPWR sky130_fd_sc_hd__decap_6
XFILLER_24_253 VGND VGND VPWR VPWR sky130_fd_sc_hd__decap_8
XFILLER_58_53 VGND VPWR VPWR VGND sky130_ef_sc_hd__decap_12
XFILLER_3_113 VGND VPWR VPWR VGND sky130_ef_sc_hd__decap_12
XFILLER_59_161 VGND VGND VPWR VPWR sky130_fd_sc_hd__decap_6
XFILLER_58_97 VGND VPWR VPWR VGND sky130_ef_sc_hd__decap_12
Xhold8 u_jt49.logC\[2\] VGND VGND VPWR VPWR net105 sky130_fd_sc_hd__dlygate4sd3_1
X_1750_ clknet_leaf_17_clk _0193_ net90 VGND VGND VPWR VPWR u_jt49.regarray\[5\]\[4\]
+ sky130_fd_sc_hd__dfrtp_1
X_1681_ clknet_leaf_18_clk _0124_ net83 VGND VGND VPWR VPWR u_jt49.regarray\[13\]\[7\]
+ sky130_fd_sc_hd__dfrtp_1
XFILLER_31_3 VGND VPWR VPWR VGND sky130_ef_sc_hd__decap_12
X_1046_ u_jt49.u_chC.count\[5\] _0659_ VGND VGND VPWR VPWR _0662_ sky130_fd_sc_hd__and2_1
XFILLER_53_315 VGND VPWR VPWR VGND sky130_ef_sc_hd__decap_12
X_1115_ _0711_ _0714_ _0710_ VGND VGND VPWR VPWR _0715_ sky130_fd_sc_hd__or3b_1
XFILLER_21_234 VGND VGND VPWR VPWR sky130_fd_sc_hd__decap_8
XFILLER_44_304 VGND VGND VPWR VPWR sky130_fd_sc_hd__decap_4
XFILLER_44_44 VGND VGND VPWR VPWR sky130_fd_sc_hd__decap_8
XFILLER_44_33 VGND VGND VPWR VPWR sky130_fd_sc_hd__decap_3
XFILLER_60_65 VGND VPWR VPWR VGND sky130_ef_sc_hd__decap_12
XFILLER_5_27 VGND VPWR VPWR VGND sky130_ef_sc_hd__decap_12
XFILLER_47_120 VGND VGND VPWR VPWR sky130_fd_sc_hd__decap_4
XPHY_EDGE_ROW_8_Left_72 VGND VGND VPWR VPWR sky130_fd_sc_hd__decap_3
XFILLER_62_189 VGND VGND VPWR VPWR sky130_fd_sc_hd__decap_6
Xclkbuf_2_3__f_clk clknet_0_clk VGND VGND VPWR VPWR clknet_2_3__leaf_clk sky130_fd_sc_hd__clkbuf_16
XFILLER_35_337 VGND VGND VPWR VPWR sky130_fd_sc_hd__decap_3
X_1733_ clknet_leaf_26_clk _0176_ net72 VGND VGND VPWR VPWR u_jt49.regarray\[7\]\[3\]
+ sky130_fd_sc_hd__dfrtp_1
X_1802_ clknet_leaf_1_clk _0245_ net71 VGND VGND VPWR VPWR u_jt49.periodA\[2\] sky130_fd_sc_hd__dfrtp_1
X_1595_ clknet_leaf_21_clk _0042_ net88 VGND VGND VPWR VPWR u_jt49.u_env.gain\[2\]
+ sky130_fd_sc_hd__dfstp_1
X_1664_ clknet_leaf_0_clk _0109_ net68 VGND VGND VPWR VPWR u_jt49.u_chA.count\[9\]
+ sky130_fd_sc_hd__dfrtp_1
XFILLER_38_197 VGND VGND VPWR VPWR sky130_fd_sc_hd__decap_4
X_1029_ net38 _0649_ VGND VGND VPWR VPWR _0650_ sky130_fd_sc_hd__or2_1
XFILLER_39_88 VGND VPWR VPWR VGND sky130_ef_sc_hd__decap_12
XPHY_EDGE_ROW_34_Left_98 VGND VGND VPWR VPWR sky130_fd_sc_hd__decap_3
XFILLER_40_351 VGND VPWR VPWR VGND sky130_ef_sc_hd__decap_12
X_1380_ net62 net187 _0397_ VGND VGND VPWR VPWR _0118_ sky130_fd_sc_hd__mux2_1
XFILLER_50_126 VGND VPWR VPWR VGND sky130_ef_sc_hd__decap_12
X_1716_ clknet_leaf_16_clk _0159_ net93 VGND VGND VPWR VPWR IOA_out[2] sky130_fd_sc_hd__dfrtp_4
X_1578_ clknet_leaf_8_clk _0025_ net79 VGND VGND VPWR VPWR u_jt49.u_chC.count\[1\]
+ sky130_fd_sc_hd__dfrtp_1
X_1647_ clknet_leaf_5_clk _0092_ net76 VGND VGND VPWR VPWR u_jt49.u_chB.count\[5\]
+ sky130_fd_sc_hd__dfrtp_2
XFILLER_41_45 VGND VGND VPWR VPWR sky130_fd_sc_hd__decap_4
XFILLER_9_3 VGND VPWR VPWR VGND sky130_ef_sc_hd__decap_12
XFILLER_49_259 VGND VGND VPWR VPWR sky130_fd_sc_hd__decap_8
XFILLER_13_340 VGND VPWR VPWR VGND sky130_ef_sc_hd__decap_12
XFILLER_17_145 VGND VGND VPWR VPWR sky130_fd_sc_hd__decap_3
X_0880_ _0514_ _0519_ VGND VGND VPWR VPWR _0527_ sky130_fd_sc_hd__nor2_2
X_1501_ u_jt49.periodB\[3\] net57 _0411_ VGND VGND VPWR VPWR _0225_ sky130_fd_sc_hd__mux2_1
X_1432_ net36 _0533_ VGND VGND VPWR VPWR _0403_ sky130_fd_sc_hd__and2_2
X_1363_ u_jt49.u_chA.count\[11\] _0386_ VGND VGND VPWR VPWR _0388_ sky130_fd_sc_hd__or2_1
XFILLER_55_218 VGND VGND VPWR VPWR sky130_fd_sc_hd__decap_3
X_1294_ _0332_ VGND VGND VPWR VPWR _0333_ sky130_fd_sc_hd__inv_2
XFILLER_11_26 VGND VGND VPWR VPWR sky130_fd_sc_hd__decap_8
XFILLER_54_284 VGND VPWR VPWR VGND sky130_ef_sc_hd__decap_12
XFILLER_39_281 VGND VGND VPWR VPWR sky130_fd_sc_hd__decap_8
XFILLER_10_365 VGND VPWR VPWR VGND sky130_ef_sc_hd__decap_12
XFILLER_10_354 VGND VGND VPWR VPWR sky130_fd_sc_hd__decap_8
XFILLER_60_265 VGND VPWR VPWR VGND sky130_ef_sc_hd__decap_12
XFILLER_60_221 VGND VPWR VPWR VGND sky130_ef_sc_hd__decap_12
X_0932_ u_jt49.eg_period\[4\] _0530_ _0534_ u_jt49.regarray\[5\]\[4\] VGND VGND VPWR
+ VPWR _0575_ sky130_fd_sc_hd__a22o_1
XFILLER_20_129 VGND VGND VPWR VPWR sky130_fd_sc_hd__decap_8
XFILLER_61_3 VGND VPWR VPWR VGND sky130_ef_sc_hd__decap_12
X_0794_ u_jt49.u_chC.count\[7\] VGND VGND VPWR VPWR _0448_ sky130_fd_sc_hd__inv_2
X_0863_ _0511_ _0507_ VGND VGND VPWR VPWR _0000_ sky130_fd_sc_hd__nand2b_1
XPHY_EDGE_ROW_21_Left_85 VGND VGND VPWR VPWR sky130_fd_sc_hd__decap_3
XFILLER_3_93 VGND VPWR VPWR VGND sky130_ef_sc_hd__decap_12
X_1346_ u_jt49.u_chA.count\[5\] _0370_ u_jt49.u_chA.count\[6\] VGND VGND VPWR VPWR
+ _0376_ sky130_fd_sc_hd__a21o_1
X_1415_ net114 net64 _0401_ VGND VGND VPWR VPWR _0149_ sky130_fd_sc_hd__mux2_1
X_1277_ _0476_ _0477_ _0316_ VGND VGND VPWR VPWR _0320_ sky130_fd_sc_hd__or3_1
Xclkbuf_leaf_31_clk clknet_2_0__leaf_clk VGND VGND VPWR VPWR clknet_leaf_31_clk sky130_fd_sc_hd__clkbuf_8
XFILLER_47_66 VGND VGND VPWR VPWR sky130_fd_sc_hd__decap_4
XFILLER_63_10 VGND VPWR VPWR VGND sky130_ef_sc_hd__decap_12
Xclkbuf_leaf_22_clk clknet_2_2__leaf_clk VGND VGND VPWR VPWR clknet_leaf_22_clk sky130_fd_sc_hd__clkbuf_8
X_1200_ net174 net162 net35 VGND VGND VPWR VPWR _0067_ sky130_fd_sc_hd__mux2_1
X_1062_ u_jt49.u_chC.count\[9\] _0671_ VGND VGND VPWR VPWR _0674_ sky130_fd_sc_hd__nand2_1
X_1131_ _0705_ _0707_ _0709_ _0730_ VGND VGND VPWR VPWR _0731_ sky130_fd_sc_hd__a2bb2o_1
XFILLER_33_254 VGND VGND VPWR VPWR sky130_fd_sc_hd__decap_8
Xclkbuf_leaf_13_clk clknet_2_3__leaf_clk VGND VGND VPWR VPWR clknet_leaf_13_clk sky130_fd_sc_hd__clkbuf_8
X_0915_ u_jt49.regarray\[6\]\[2\] _0521_ _0530_ u_jt49.eg_period\[2\] VGND VGND VPWR
+ VPWR _0560_ sky130_fd_sc_hd__a22o_1
XFILLER_0_309 VGND VPWR VPWR VGND sky130_ef_sc_hd__decap_12
X_0846_ u_jt49.u_ng.poly17\[3\] VGND VGND VPWR VPWR _0500_ sky130_fd_sc_hd__inv_2
X_1329_ _0363_ VGND VGND VPWR VPWR _0364_ sky130_fd_sc_hd__inv_2
XFILLER_33_57 VGND VGND VPWR VPWR sky130_fd_sc_hd__decap_4
XFILLER_58_65 VGND VPWR VPWR VGND sky130_ef_sc_hd__decap_12
Xhold9 u_jt49.logC\[1\] VGND VGND VPWR VPWR net106 sky130_fd_sc_hd__dlygate4sd3_1
X_1680_ clknet_leaf_18_clk _0123_ net89 VGND VGND VPWR VPWR u_jt49.regarray\[13\]\[6\]
+ sky130_fd_sc_hd__dfrtp_1
X_1114_ u_jt49.eg_period\[10\] _0462_ VGND VGND VPWR VPWR _0714_ sky130_fd_sc_hd__and2_1
Xclkbuf_leaf_2_clk clknet_2_1__leaf_clk VGND VGND VPWR VPWR clknet_leaf_2_clk sky130_fd_sc_hd__clkbuf_8
X_1045_ net32 _0660_ _0661_ VGND VGND VPWR VPWR _0028_ sky130_fd_sc_hd__and3_1
XFILLER_53_327 VGND VGND VPWR VPWR sky130_fd_sc_hd__decap_8
X_0829_ u_jt49.u_chA.count\[10\] VGND VGND VPWR VPWR _0483_ sky130_fd_sc_hd__inv_2
XFILLER_56_121 VGND VPWR VPWR VGND sky130_ef_sc_hd__decap_12
XFILLER_52_360 VGND VGND VPWR VPWR sky130_fd_sc_hd__decap_4
XFILLER_12_224 VGND VGND VPWR VPWR sky130_fd_sc_hd__decap_6
XFILLER_12_246 VGND VGND VPWR VPWR sky130_fd_sc_hd__decap_6
XFILLER_60_77 VGND VGND VPWR VPWR sky130_fd_sc_hd__decap_6
XFILLER_5_39 VGND VPWR VPWR VGND sky130_ef_sc_hd__decap_12
X_1732_ clknet_leaf_10_clk _0175_ net89 VGND VGND VPWR VPWR u_jt49.regarray\[7\]\[2\]
+ sky130_fd_sc_hd__dfrtp_1
X_1801_ clknet_leaf_27_clk _0244_ net71 VGND VGND VPWR VPWR u_jt49.periodA\[1\] sky130_fd_sc_hd__dfrtp_1
X_1663_ clknet_leaf_31_clk _0108_ net69 VGND VGND VPWR VPWR u_jt49.u_chA.count\[8\]
+ sky130_fd_sc_hd__dfrtp_1
X_1594_ clknet_leaf_22_clk _0041_ net88 VGND VGND VPWR VPWR u_jt49.u_env.gain\[1\]
+ sky130_fd_sc_hd__dfstp_1
XPHY_EDGE_ROW_7_Right_7 VGND VGND VPWR VPWR sky130_fd_sc_hd__decap_3
X_1028_ _0647_ _0648_ _0632_ _0633_ VGND VGND VPWR VPWR _0649_ sky130_fd_sc_hd__a2bb2o_1
XFILLER_30_25 VGND VGND VPWR VPWR sky130_fd_sc_hd__decap_3
XFILLER_4_253 VGND VGND VPWR VPWR sky130_fd_sc_hd__decap_3
XFILLER_20_91 VGND VGND VPWR VPWR sky130_fd_sc_hd__decap_8
X_1646_ clknet_leaf_5_clk _0091_ net76 VGND VGND VPWR VPWR u_jt49.u_chB.count\[4\]
+ sky130_fd_sc_hd__dfrtp_1
X_1715_ clknet_leaf_20_clk _0158_ net87 VGND VGND VPWR VPWR IOA_out[1] sky130_fd_sc_hd__dfrtp_4
X_1577_ clknet_leaf_11_clk _0024_ net78 VGND VGND VPWR VPWR u_jt49.u_chC.count\[0\]
+ sky130_fd_sc_hd__dfstp_1
XFILLER_41_57 VGND VPWR VPWR VGND sky130_ef_sc_hd__decap_12
XFILLER_1_201 VGND VGND VPWR VPWR sky130_fd_sc_hd__decap_6
XFILLER_2_29 VGND VGND VPWR VPWR sky130_fd_sc_hd__decap_8
XFILLER_17_102 VGND VGND VPWR VPWR sky130_fd_sc_hd__decap_8
XFILLER_13_352 VGND VPWR VPWR VGND sky130_ef_sc_hd__decap_12
XFILLER_15_91 VGND VPWR VPWR VGND sky130_ef_sc_hd__decap_12
X_1500_ u_jt49.periodB\[2\] net59 _0411_ VGND VGND VPWR VPWR _0224_ sky130_fd_sc_hd__mux2_1
X_1293_ u_jt49.u_chB.count\[10\] u_jt49.u_chB.count\[9\] _0327_ VGND VGND VPWR VPWR
+ _0332_ sky130_fd_sc_hd__and3_1
X_1431_ net50 IOA_out[7] _0402_ VGND VGND VPWR VPWR _0164_ sky130_fd_sc_hd__mux2_1
X_1362_ _0362_ _0385_ _0387_ VGND VGND VPWR VPWR _0110_ sky130_fd_sc_hd__and3_1
XFILLER_23_138 VGND VGND VPWR VPWR sky130_fd_sc_hd__decap_3
X_1629_ clknet_leaf_31_clk net172 net68 VGND VGND VPWR VPWR u_jt49.u_ng.poly17\[9\]
+ sky130_fd_sc_hd__dfrtp_1
XFILLER_54_296 VGND VPWR VPWR VGND sky130_ef_sc_hd__decap_12
XFILLER_10_377 VGND VGND VPWR VPWR sky130_fd_sc_hd__decap_3
XFILLER_22_193 VGND VGND VPWR VPWR sky130_fd_sc_hd__decap_3
XFILLER_37_219 VGND VGND VPWR VPWR sky130_fd_sc_hd__decap_4
XFILLER_60_277 VGND VPWR VPWR VGND sky130_ef_sc_hd__decap_12
XFILLER_60_233 VGND VPWR VPWR VGND sky130_ef_sc_hd__decap_12
X_0862_ _0509_ _0017_ VGND VGND VPWR VPWR _0511_ sky130_fd_sc_hd__nand2_1
X_0931_ net12 _0546_ _0547_ net4 _0574_ VGND VGND VPWR VPWR _0264_ sky130_fd_sc_hd__a221o_1
X_0793_ u_jt49.u_chC.count\[8\] VGND VGND VPWR VPWR _0447_ sky130_fd_sc_hd__inv_2
XFILLER_54_3 VGND VPWR VPWR VGND sky130_ef_sc_hd__decap_12
X_1276_ net39 u_jt49.u_chB.count\[5\] _0305_ _0319_ VGND VGND VPWR VPWR _0092_ sky130_fd_sc_hd__a22o_1
X_1345_ u_jt49.u_chA.count\[6\] u_jt49.u_chA.count\[5\] _0370_ VGND VGND VPWR VPWR
+ _0375_ sky130_fd_sc_hd__nand3_1
X_1414_ net36 _0524_ VGND VGND VPWR VPWR _0401_ sky130_fd_sc_hd__and2_2
XFILLER_63_22 VGND VGND VPWR VPWR sky130_fd_sc_hd__decap_6
XFILLER_10_141 VGND VPWR VPWR VGND sky130_ef_sc_hd__decap_12
XFILLER_10_130 VGND VGND VPWR VPWR sky130_fd_sc_hd__decap_8
XFILLER_12_81 VGND VGND VPWR VPWR sky130_fd_sc_hd__decap_3
X_1130_ _0716_ _0728_ _0729_ _0718_ VGND VGND VPWR VPWR _0730_ sky130_fd_sc_hd__a31o_1
X_1061_ u_jt49.u_chC.count\[9\] _0671_ VGND VGND VPWR VPWR _0673_ sky130_fd_sc_hd__or2_1
XFILLER_33_277 VGND VGND VPWR VPWR sky130_fd_sc_hd__decap_3
X_0914_ u_jt49.periodC\[2\] _0535_ _0557_ _0558_ VGND VGND VPWR VPWR _0559_ sky130_fd_sc_hd__a211o_1
X_0845_ u_jt49.u_ng.poly17\[0\] VGND VGND VPWR VPWR _0499_ sky130_fd_sc_hd__inv_2
XFILLER_56_347 VGND VPWR VPWR VGND sky130_ef_sc_hd__decap_12
X_1259_ net39 _0305_ VGND VGND VPWR VPWR _0307_ sky130_fd_sc_hd__or2_2
X_1328_ net42 u_jt49.u_chA.count\[1\] u_jt49.u_chA.count\[0\] VGND VGND VPWR VPWR
+ _0363_ sky130_fd_sc_hd__and3_1
XPHY_EDGE_ROW_49_Left_113 VGND VGND VPWR VPWR sky130_fd_sc_hd__decap_3
XFILLER_58_77 VGND VGND VPWR VPWR sky130_fd_sc_hd__decap_6
XPHY_EDGE_ROW_58_Left_122 VGND VGND VPWR VPWR sky130_fd_sc_hd__decap_3
X_1044_ u_jt49.u_chC.count\[3\] _0654_ u_jt49.u_chC.count\[4\] VGND VGND VPWR VPWR
+ _0661_ sky130_fd_sc_hd__a21o_1
X_1113_ u_jt49.eg_period\[9\] _0463_ VGND VGND VPWR VPWR _0713_ sky130_fd_sc_hd__and2_1
XFILLER_61_361 VGND VPWR VPWR VGND sky130_ef_sc_hd__decap_12
X_0828_ u_jt49.u_chA.count\[11\] VGND VGND VPWR VPWR _0482_ sky130_fd_sc_hd__inv_2
XFILLER_56_166 VGND VPWR VPWR VGND sky130_ef_sc_hd__decap_12
XFILLER_8_229 VGND VGND VPWR VPWR sky130_fd_sc_hd__decap_6
X_1800_ clknet_leaf_26_clk _0243_ net71 VGND VGND VPWR VPWR u_jt49.periodA\[0\] sky130_fd_sc_hd__dfrtp_1
X_1731_ clknet_leaf_18_clk _0174_ net89 VGND VGND VPWR VPWR u_jt49.regarray\[7\]\[1\]
+ sky130_fd_sc_hd__dfrtp_1
X_1662_ clknet_leaf_31_clk _0107_ net69 VGND VGND VPWR VPWR u_jt49.u_chA.count\[7\]
+ sky130_fd_sc_hd__dfrtp_1
X_1593_ clknet_leaf_21_clk _0040_ net88 VGND VGND VPWR VPWR u_jt49.u_env.gain\[0\]
+ sky130_fd_sc_hd__dfstp_1
X_1027_ _0632_ _0634_ _0633_ VGND VGND VPWR VPWR _0648_ sky130_fd_sc_hd__or3b_1
XFILLER_17_328 VGND VGND VPWR VPWR sky130_fd_sc_hd__decap_8
XFILLER_35_169 VGND VGND VPWR VPWR sky130_fd_sc_hd__decap_4
Xhold90 u_jt49.regarray\[13\]\[1\] VGND VGND VPWR VPWR net187 sky130_fd_sc_hd__dlygate4sd3_1
X_1645_ clknet_leaf_5_clk _0090_ net76 VGND VGND VPWR VPWR u_jt49.u_chB.count\[3\]
+ sky130_fd_sc_hd__dfrtp_1
X_1576_ clknet_leaf_21_clk _0023_ net88 VGND VGND VPWR VPWR u_jt49.u_env.rst_clr sky130_fd_sc_hd__dfrtp_1
X_1714_ clknet_leaf_20_clk _0157_ net87 VGND VGND VPWR VPWR IOA_out[0] sky130_fd_sc_hd__dfrtp_4
XFILLER_41_69 VGND VGND VPWR VPWR sky130_fd_sc_hd__decap_8
XFILLER_17_169 VGND VPWR VPWR VGND sky130_ef_sc_hd__decap_12
XFILLER_13_364 VGND VPWR VPWR VGND sky130_ef_sc_hd__decap_12
X_1430_ net51 IOA_out[6] _0402_ VGND VGND VPWR VPWR _0163_ sky130_fd_sc_hd__mux2_1
X_1292_ u_jt49.u_chB.count\[9\] _0327_ u_jt49.u_chB.count\[10\] VGND VGND VPWR VPWR
+ _0331_ sky130_fd_sc_hd__a21o_1
X_1361_ _0386_ VGND VGND VPWR VPWR _0387_ sky130_fd_sc_hd__inv_2
XFILLER_63_253 VGND VPWR VPWR VGND sky130_ef_sc_hd__decap_12
X_1559_ clknet_leaf_8_clk _0006_ VGND VGND VPWR VPWR din_latch\[2\] sky130_fd_sc_hd__dfxtp_1
X_1628_ clknet_leaf_31_clk net170 net68 VGND VGND VPWR VPWR u_jt49.u_ng.poly17\[8\]
+ sky130_fd_sc_hd__dfrtp_1
XFILLER_54_242 VGND VGND VPWR VPWR sky130_fd_sc_hd__decap_4
XFILLER_22_183 VGND VGND VPWR VPWR sky130_fd_sc_hd__decap_3
XFILLER_60_245 VGND VGND VPWR VPWR sky130_fd_sc_hd__decap_6
XFILLER_45_275 VGND VGND VPWR VPWR sky130_fd_sc_hd__decap_4
XFILLER_45_242 VGND VGND VPWR VPWR sky130_fd_sc_hd__decap_3
XFILLER_60_289 VGND VPWR VPWR VGND sky130_ef_sc_hd__decap_12
X_0792_ u_jt49.u_chC.count\[9\] VGND VGND VPWR VPWR _0446_ sky130_fd_sc_hd__inv_2
X_0861_ net78 _0510_ VGND VGND VPWR VPWR _0017_ sky130_fd_sc_hd__and2_1
X_0930_ u_jt49.periodA\[3\] _0518_ _0544_ _0573_ VGND VGND VPWR VPWR _0574_ sky130_fd_sc_hd__o211a_1
X_1413_ net135 net49 _0400_ VGND VGND VPWR VPWR _0148_ sky130_fd_sc_hd__mux2_1
X_1275_ _0477_ _0316_ _0318_ VGND VGND VPWR VPWR _0319_ sky130_fd_sc_hd__a21oi_1
XFILLER_3_51 VGND VGND VPWR VPWR sky130_fd_sc_hd__decap_4
X_1344_ net38 u_jt49.u_chA.count\[5\] _0360_ _0374_ VGND VGND VPWR VPWR _0105_ sky130_fd_sc_hd__a22o_1
XPHY_EDGE_ROW_29_Right_29 VGND VGND VPWR VPWR sky130_fd_sc_hd__decap_3
XPHY_EDGE_ROW_38_Right_38 VGND VGND VPWR VPWR sky130_fd_sc_hd__decap_3
XFILLER_8_18 VGND VGND VPWR VPWR sky130_fd_sc_hd__decap_8
XFILLER_8_29 VGND VPWR VPWR VGND sky130_ef_sc_hd__decap_12
XFILLER_10_153 VGND VGND VPWR VPWR sky130_fd_sc_hd__decap_3
X_1060_ net32 _0670_ _0672_ VGND VGND VPWR VPWR _0032_ sky130_fd_sc_hd__and3_1
XPHY_EDGE_ROW_47_Right_47 VGND VGND VPWR VPWR sky130_fd_sc_hd__decap_3
XPHY_EDGE_ROW_56_Right_56 VGND VGND VPWR VPWR sky130_fd_sc_hd__decap_3
X_0913_ u_jt49.regarray\[10\]\[2\] _0526_ _0531_ u_jt49.eg_period\[10\] _0517_ VGND
+ VGND VPWR VPWR _0558_ sky130_fd_sc_hd__a221o_1
X_0844_ u_jt49.bitA VGND VGND VPWR VPWR _0498_ sky130_fd_sc_hd__inv_2
X_1189_ u_jt49.u_envdiv.count\[12\] _0768_ VGND VGND VPWR VPWR _0771_ sky130_fd_sc_hd__and2_1
X_1258_ net38 _0481_ _0306_ VGND VGND VPWR VPWR _0087_ sky130_fd_sc_hd__a21oi_1
X_1327_ net38 _0360_ VGND VGND VPWR VPWR _0362_ sky130_fd_sc_hd__or2_2
XFILLER_33_26 VGND VGND VPWR VPWR sky130_fd_sc_hd__decap_4
XFILLER_3_105 VGND VGND VPWR VPWR sky130_fd_sc_hd__decap_6
XFILLER_47_337 VGND VPWR VPWR VGND sky130_ef_sc_hd__decap_12
XFILLER_15_245 VGND VGND VPWR VPWR sky130_fd_sc_hd__decap_4
X_1043_ _0659_ VGND VGND VPWR VPWR _0660_ sky130_fd_sc_hd__inv_2
X_1112_ u_jt49.eg_period\[9\] _0463_ _0464_ u_jt49.eg_period\[8\] VGND VGND VPWR VPWR
+ _0712_ sky130_fd_sc_hd__o22a_1
XFILLER_0_41 VGND VPWR VPWR VGND sky130_ef_sc_hd__decap_12
XFILLER_0_85 VGND VPWR VPWR VGND sky130_ef_sc_hd__decap_12
XFILLER_61_373 VGND VGND VPWR VPWR sky130_fd_sc_hd__decap_6
X_0827_ net196 VGND VGND VPWR VPWR _0481_ sky130_fd_sc_hd__inv_2
XFILLER_29_348 VGND VPWR VPWR VGND sky130_ef_sc_hd__decap_12
XFILLER_56_178 VGND VGND VPWR VPWR sky130_fd_sc_hd__decap_6
XFILLER_18_92 VGND VGND VPWR VPWR sky130_fd_sc_hd__decap_6
X_1730_ clknet_leaf_1_clk _0173_ net72 VGND VGND VPWR VPWR u_jt49.regarray\[7\]\[0\]
+ sky130_fd_sc_hd__dfrtp_1
XFILLER_7_252 VGND VGND VPWR VPWR sky130_fd_sc_hd__decap_3
X_1661_ clknet_leaf_31_clk _0106_ net69 VGND VGND VPWR VPWR u_jt49.u_chA.count\[6\]
+ sky130_fd_sc_hd__dfrtp_1
X_1592_ clknet_leaf_21_clk _0039_ net88 VGND VGND VPWR VPWR u_jt49.u_env.stop sky130_fd_sc_hd__dfrtp_1
X_1026_ _0645_ _0646_ _0635_ VGND VGND VPWR VPWR _0647_ sky130_fd_sc_hd__o21a_1
XFILLER_61_181 VGND VPWR VPWR VGND sky130_ef_sc_hd__decap_12
XFILLER_30_49 VGND VPWR VPWR VGND sky130_ef_sc_hd__decap_12
XFILLER_55_57 VGND VPWR VPWR VGND sky130_ef_sc_hd__decap_12
XFILLER_44_104 VGND VGND VPWR VPWR sky130_fd_sc_hd__decap_3
XFILLER_40_365 VGND VGND VPWR VPWR sky130_fd_sc_hd__decap_4
Xhold91 u_jt49.u_cen.cencnt\[0\] VGND VGND VPWR VPWR net188 sky130_fd_sc_hd__dlygate4sd3_1
Xhold80 u_jt49.u_ng.poly17\[16\] VGND VGND VPWR VPWR net177 sky130_fd_sc_hd__dlygate4sd3_1
XFILLER_43_192 VGND VPWR VPWR VGND sky130_ef_sc_hd__decap_12
X_1713_ clknet_leaf_10_clk _0156_ net89 VGND VGND VPWR VPWR u_jt49.regarray\[9\]\[7\]
+ sky130_fd_sc_hd__dfrtp_1
X_1575_ clknet_leaf_14_clk _0022_ VGND VGND VPWR VPWR cs_n sky130_fd_sc_hd__dfxtp_1
X_1644_ clknet_leaf_4_clk _0089_ net74 VGND VGND VPWR VPWR u_jt49.u_chB.count\[2\]
+ sky130_fd_sc_hd__dfrtp_1
X_1009_ u_jt49.u_env.rst_latch net40 VGND VGND VPWR VPWR _0631_ sky130_fd_sc_hd__nand2_1
XFILLER_22_365 VGND VPWR VPWR VGND sky130_ef_sc_hd__decap_12
XFILLER_25_49 VGND VGND VPWR VPWR sky130_fd_sc_hd__decap_4
XFILLER_41_15 VGND VPWR VPWR VGND sky130_ef_sc_hd__decap_12
XFILLER_32_107 VGND VPWR VPWR VGND sky130_ef_sc_hd__decap_12
XFILLER_40_162 VGND VGND VPWR VPWR sky130_fd_sc_hd__decap_4
XFILLER_13_376 VGND VGND VPWR VPWR sky130_fd_sc_hd__decap_4
X_1360_ net38 _0483_ _0383_ VGND VGND VPWR VPWR _0386_ sky130_fd_sc_hd__nor3_1
XFILLER_63_221 VGND VGND VPWR VPWR sky130_fd_sc_hd__decap_3
X_1291_ _0305_ _0329_ _0330_ net209 net39 VGND VGND VPWR VPWR _0096_ sky130_fd_sc_hd__a32o_1
XFILLER_63_232 VGND VPWR VPWR VGND sky130_ef_sc_hd__decap_12
XFILLER_16_170 VGND VPWR VPWR VGND sky130_ef_sc_hd__decap_12
X_1558_ clknet_leaf_8_clk _0005_ VGND VGND VPWR VPWR din_latch\[1\] sky130_fd_sc_hd__dfxtp_1
X_1489_ u_jt49.periodB\[10\] net59 _0409_ VGND VGND VPWR VPWR _0215_ sky130_fd_sc_hd__mux2_1
X_1627_ clknet_leaf_0_clk net165 net69 VGND VGND VPWR VPWR u_jt49.u_ng.poly17\[7\]
+ sky130_fd_sc_hd__dfrtp_1
XFILLER_7_3 VGND VPWR VPWR VGND sky130_ef_sc_hd__decap_12
XFILLER_45_210 VGND VPWR VPWR VGND sky130_ef_sc_hd__decap_12
Xclkbuf_leaf_25_clk clknet_2_2__leaf_clk VGND VGND VPWR VPWR clknet_leaf_25_clk sky130_fd_sc_hd__clkbuf_8
X_0860_ net21 net48 _0504_ VGND VGND VPWR VPWR _0510_ sky130_fd_sc_hd__mux2_1
X_0791_ u_jt49.u_chC.count\[10\] VGND VGND VPWR VPWR _0445_ sky130_fd_sc_hd__inv_2
XFILLER_42_80 VGND VGND VPWR VPWR sky130_fd_sc_hd__decap_4
XFILLER_9_133 VGND VPWR VPWR VGND sky130_ef_sc_hd__decap_12
X_1412_ net129 net51 _0400_ VGND VGND VPWR VPWR _0147_ sky130_fd_sc_hd__mux2_1
XFILLER_5_361 VGND VPWR VPWR VGND sky130_ef_sc_hd__decap_12
X_1343_ u_jt49.u_chA.count\[5\] _0370_ _0373_ VGND VGND VPWR VPWR _0374_ sky130_fd_sc_hd__o21ba_1
X_1274_ u_jt49.u_chB.count\[5\] u_jt49.u_chB.count\[4\] _0313_ VGND VGND VPWR VPWR
+ _0318_ sky130_fd_sc_hd__and3_1
Xclkbuf_leaf_16_clk clknet_2_3__leaf_clk VGND VGND VPWR VPWR clknet_leaf_16_clk sky130_fd_sc_hd__clkbuf_8
XFILLER_22_17 VGND VGND VPWR VPWR sky130_fd_sc_hd__decap_4
X_0989_ net38 _0469_ _0617_ VGND VGND VPWR VPWR _0618_ sky130_fd_sc_hd__or3_1
XFILLER_63_57 VGND VPWR VPWR VGND sky130_ef_sc_hd__decap_12
XPHY_EDGE_ROW_25_Left_89 VGND VGND VPWR VPWR sky130_fd_sc_hd__decap_3
X_0912_ u_jt49.regarray\[7\]\[2\] _0532_ _0534_ u_jt49.periodC\[10\] VGND VGND VPWR
+ VPWR _0557_ sky130_fd_sc_hd__a22o_1
X_0843_ u_jt49.bitB VGND VGND VPWR VPWR _0497_ sky130_fd_sc_hd__inv_2
Xclkbuf_leaf_5_clk clknet_2_1__leaf_clk VGND VGND VPWR VPWR clknet_leaf_5_clk sky130_fd_sc_hd__clkbuf_8
X_1326_ u_jt49.u_chA.count\[0\] _0361_ net42 VGND VGND VPWR VPWR _0100_ sky130_fd_sc_hd__mux2_1
X_1188_ net31 _0769_ _0770_ VGND VGND VPWR VPWR _0062_ sky130_fd_sc_hd__and3_1
X_1257_ net43 u_jt49.u_chB.count\[0\] _0305_ VGND VGND VPWR VPWR _0306_ sky130_fd_sc_hd__and3_1
XFILLER_47_349 VGND VGND VPWR VPWR sky130_fd_sc_hd__decap_8
XFILLER_47_305 VGND VPWR VPWR VGND sky130_ef_sc_hd__decap_12
X_1042_ u_jt49.u_chC.count\[4\] u_jt49.u_chC.count\[3\] _0654_ VGND VGND VPWR VPWR
+ _0659_ sky130_fd_sc_hd__and3_1
X_1111_ u_jt49.eg_period\[11\] _0461_ VGND VGND VPWR VPWR _0711_ sky130_fd_sc_hd__and2_1
XFILLER_0_53 VGND VGND VPWR VPWR sky130_fd_sc_hd__decap_3
XFILLER_0_97 VGND VPWR VPWR VGND sky130_ef_sc_hd__decap_12
XFILLER_9_51 VGND VGND VPWR VPWR sky130_fd_sc_hd__decap_4
X_0826_ u_jt49.u_chB.count\[2\] VGND VGND VPWR VPWR _0480_ sky130_fd_sc_hd__inv_2
XFILLER_0_109 VGND VGND VPWR VPWR sky130_fd_sc_hd__decap_3
XFILLER_29_305 VGND VGND VPWR VPWR sky130_fd_sc_hd__decap_4
X_1309_ u_jt49.u_chA.count\[9\] _0485_ u_jt49.u_chA.count\[8\] _0486_ VGND VGND VPWR
+ VPWR _0345_ sky130_fd_sc_hd__a22o_1
XFILLER_18_71 VGND VPWR VPWR VGND sky130_ef_sc_hd__decap_12
XFILLER_11_271 VGND VGND VPWR VPWR sky130_fd_sc_hd__decap_8
XFILLER_50_80 VGND VGND VPWR VPWR sky130_fd_sc_hd__decap_4
XFILLER_7_264 VGND VGND VPWR VPWR sky130_fd_sc_hd__decap_6
X_1660_ clknet_leaf_31_clk _0105_ net70 VGND VGND VPWR VPWR u_jt49.u_chA.count\[5\]
+ sky130_fd_sc_hd__dfrtp_2
X_1591_ clknet_leaf_20_clk net119 VGND VGND VPWR VPWR u_jt49.u_env.last_step sky130_fd_sc_hd__dfxtp_1
XFILLER_26_319 VGND VGND VPWR VPWR sky130_fd_sc_hd__decap_8
XFILLER_22_3 VGND VGND VPWR VPWR sky130_fd_sc_hd__decap_6
XFILLER_61_193 VGND VPWR VPWR VGND sky130_ef_sc_hd__decap_12
X_1025_ _0447_ u_jt49.periodC\[8\] _0448_ u_jt49.periodC\[7\] VGND VGND VPWR VPWR
+ _0646_ sky130_fd_sc_hd__a22o_1
XFILLER_34_330 VGND VGND VPWR VPWR sky130_fd_sc_hd__decap_4
XPHY_EDGE_ROW_28_Left_92 VGND VGND VPWR VPWR sky130_fd_sc_hd__decap_3
X_0809_ u_jt49.u_envdiv.count\[9\] VGND VGND VPWR VPWR _0463_ sky130_fd_sc_hd__inv_2
XPHY_EDGE_ROW_12_Left_76 VGND VGND VPWR VPWR sky130_fd_sc_hd__decap_3
X_1789_ clknet_leaf_3_clk _0232_ net75 VGND VGND VPWR VPWR u_jt49.periodA\[9\] sky130_fd_sc_hd__dfrtp_1
XFILLER_55_69 VGND VPWR VPWR VGND sky130_ef_sc_hd__decap_12
XFILLER_29_113 VGND VGND VPWR VPWR sky130_fd_sc_hd__decap_6
XFILLER_17_319 VGND VGND VPWR VPWR sky130_fd_sc_hd__decap_6
Xhold81 u_jt49.u_chC.count\[11\] VGND VGND VPWR VPWR net178 sky130_fd_sc_hd__dlygate4sd3_1
Xhold92 _0395_ VGND VGND VPWR VPWR net189 sky130_fd_sc_hd__dlygate4sd3_1
Xhold70 u_jt49.u_ng.poly17\[6\] VGND VGND VPWR VPWR net167 sky130_fd_sc_hd__dlygate4sd3_1
XFILLER_31_333 VGND VGND VPWR VPWR sky130_fd_sc_hd__decap_3
XFILLER_28_190 VGND VGND VPWR VPWR sky130_fd_sc_hd__decap_6
XANTENNA_1 net52 VGND VGND VPWR VPWR sky130_fd_sc_hd__diode_2
X_1643_ clknet_leaf_4_clk _0088_ net74 VGND VGND VPWR VPWR u_jt49.u_chB.count\[1\]
+ sky130_fd_sc_hd__dfrtp_1
X_1712_ clknet_leaf_10_clk _0155_ net90 VGND VGND VPWR VPWR u_jt49.regarray\[9\]\[6\]
+ sky130_fd_sc_hd__dfrtp_1
XFILLER_6_41 VGND VPWR VPWR VGND sky130_ef_sc_hd__decap_12
X_1574_ clknet_leaf_14_clk _0021_ VGND VGND VPWR VPWR addr_ok sky130_fd_sc_hd__dfxtp_1
XFILLER_6_96 VGND VPWR VPWR VGND sky130_ef_sc_hd__decap_12
XFILLER_41_108 VGND VGND VPWR VPWR sky130_fd_sc_hd__decap_4
X_1008_ u_jt49.u_env.rst_latch net40 VGND VGND VPWR VPWR _0630_ sky130_fd_sc_hd__and2_1
XFILLER_22_377 VGND VGND VPWR VPWR sky130_fd_sc_hd__decap_3
XFILLER_57_285 VGND VPWR VPWR VGND sky130_ef_sc_hd__decap_12
XFILLER_32_119 VGND VGND VPWR VPWR sky130_fd_sc_hd__decap_4
XFILLER_17_116 VGND VGND VPWR VPWR sky130_fd_sc_hd__decap_4
XFILLER_9_337 VGND VPWR VPWR VGND sky130_ef_sc_hd__decap_12
XFILLER_9_326 VGND VGND VPWR VPWR sky130_fd_sc_hd__decap_8
XFILLER_63_244 VGND VGND VPWR VPWR sky130_fd_sc_hd__decap_8
X_1290_ _0473_ _0474_ _0323_ VGND VGND VPWR VPWR _0330_ sky130_fd_sc_hd__or3_1
XFILLER_0_281 VGND VPWR VPWR VGND sky130_ef_sc_hd__decap_12
XFILLER_63_277 VGND VGND VPWR VPWR sky130_fd_sc_hd__decap_3
XFILLER_31_152 VGND VPWR VPWR VGND sky130_ef_sc_hd__decap_12
XFILLER_16_182 VGND VPWR VPWR VGND sky130_ef_sc_hd__decap_12
X_1626_ clknet_leaf_0_clk _0073_ net69 VGND VGND VPWR VPWR u_jt49.u_ng.poly17\[6\]
+ sky130_fd_sc_hd__dfrtp_1
X_1557_ clknet_leaf_8_clk _0004_ VGND VGND VPWR VPWR din_latch\[0\] sky130_fd_sc_hd__dfxtp_1
X_1488_ u_jt49.periodB\[9\] net61 _0409_ VGND VGND VPWR VPWR _0214_ sky130_fd_sc_hd__mux2_1
XFILLER_22_152 VGND VGND VPWR VPWR sky130_fd_sc_hd__decap_4
X_0790_ net178 VGND VGND VPWR VPWR _0444_ sky130_fd_sc_hd__inv_2
XFILLER_5_373 VGND VGND VPWR VPWR sky130_fd_sc_hd__decap_4
XFILLER_9_145 VGND VGND VPWR VPWR sky130_fd_sc_hd__decap_8
X_1273_ _0307_ _0316_ _0317_ VGND VGND VPWR VPWR _0091_ sky130_fd_sc_hd__and3_1
X_1411_ net130 net54 _0400_ VGND VGND VPWR VPWR _0146_ sky130_fd_sc_hd__mux2_1
X_1342_ u_jt49.u_chA.count\[5\] u_jt49.u_chA.count\[4\] _0368_ VGND VGND VPWR VPWR
+ _0373_ sky130_fd_sc_hd__and3_1
XFILLER_36_244 VGND VGND VPWR VPWR sky130_fd_sc_hd__decap_8
XFILLER_51_247 VGND VPWR VPWR VGND sky130_ef_sc_hd__decap_12
X_0988_ u_jt49.regarray\[6\]\[4\] _0465_ _0616_ VGND VGND VPWR VPWR _0617_ sky130_fd_sc_hd__a21oi_1
XFILLER_22_29 VGND VGND VPWR VPWR sky130_fd_sc_hd__decap_4
X_1609_ clknet_leaf_20_clk _0056_ net87 VGND VGND VPWR VPWR u_jt49.u_envdiv.count\[5\]
+ sky130_fd_sc_hd__dfrtp_1
XFILLER_47_26 VGND VGND VPWR VPWR sky130_fd_sc_hd__decap_4
XFILLER_63_69 VGND VPWR VPWR VGND sky130_ef_sc_hd__decap_12
XFILLER_2_365 VGND VPWR VPWR VGND sky130_ef_sc_hd__decap_12
XPHY_EDGE_ROW_0_Left_64 VGND VGND VPWR VPWR sky130_fd_sc_hd__decap_3
XFILLER_33_225 VGND VGND VPWR VPWR sky130_fd_sc_hd__decap_4
X_0842_ u_jt49.bitC VGND VGND VPWR VPWR _0496_ sky130_fd_sc_hd__inv_2
X_0911_ net10 _0546_ _0547_ net2 _0556_ VGND VGND VPWR VPWR _0262_ sky130_fd_sc_hd__a221o_1
X_1256_ _0301_ _0302_ _0304_ _0303_ VGND VGND VPWR VPWR _0305_ sky130_fd_sc_hd__o31a_2
X_1325_ u_jt49.u_chA.count\[0\] _0360_ VGND VGND VPWR VPWR _0361_ sky130_fd_sc_hd__nand2_1
X_1187_ _0461_ _0766_ VGND VGND VPWR VPWR _0770_ sky130_fd_sc_hd__nand2_1
XFILLER_62_309 VGND VPWR VPWR VGND sky130_ef_sc_hd__decap_12
XFILLER_55_350 VGND VGND VPWR VPWR sky130_fd_sc_hd__decap_8
XFILLER_47_317 VGND VPWR VPWR VGND sky130_ef_sc_hd__decap_12
XPHY_EDGE_ROW_36_Left_100 VGND VGND VPWR VPWR sky130_fd_sc_hd__decap_3
XFILLER_23_94 VGND VGND VPWR VPWR sky130_fd_sc_hd__decap_4
X_1110_ u_jt49.eg_period\[11\] _0461_ _0462_ u_jt49.eg_period\[10\] VGND VGND VPWR
+ VPWR _0710_ sky130_fd_sc_hd__o22a_1
XFILLER_2_184 VGND VGND VPWR VPWR sky130_fd_sc_hd__decap_4
XFILLER_17_6 VGND VGND VPWR VPWR sky130_fd_sc_hd__decap_4
X_1041_ net32 _0657_ _0658_ VGND VGND VPWR VPWR _0027_ sky130_fd_sc_hd__and3_1
X_0825_ u_jt49.u_chB.count\[3\] VGND VGND VPWR VPWR _0479_ sky130_fd_sc_hd__inv_2
X_1239_ u_jt49.u_chB.count\[1\] u_jt49.periodB\[1\] VGND VGND VPWR VPWR _0288_ sky130_fd_sc_hd__and2b_1
X_1308_ _0342_ _0343_ VGND VGND VPWR VPWR _0344_ sky130_fd_sc_hd__nor2_1
XFILLER_52_342 VGND VGND VPWR VPWR sky130_fd_sc_hd__decap_4
X_1590_ clknet_leaf_25_clk _0037_ net85 VGND VGND VPWR VPWR u_jt49.u_env.inv sky130_fd_sc_hd__dfrtp_4
X_1024_ _0642_ _0643_ _0644_ VGND VGND VPWR VPWR _0645_ sky130_fd_sc_hd__a21oi_1
XFILLER_61_161 VGND VGND VPWR VPWR sky130_fd_sc_hd__decap_6
X_0808_ u_jt49.u_envdiv.count\[10\] VGND VGND VPWR VPWR _0462_ sky130_fd_sc_hd__inv_2
X_1788_ clknet_leaf_0_clk _0231_ net69 VGND VGND VPWR VPWR u_jt49.periodA\[8\] sky130_fd_sc_hd__dfrtp_1
XFILLER_55_26 VGND VPWR VPWR VGND sky130_ef_sc_hd__decap_12
XFILLER_52_150 VGND VGND VPWR VPWR sky130_fd_sc_hd__decap_8
XFILLER_25_353 VGND VGND VPWR VPWR sky130_fd_sc_hd__decap_4
XFILLER_52_183 VGND VPWR VPWR VGND sky130_ef_sc_hd__decap_12
XFILLER_40_334 VGND VGND VPWR VPWR sky130_fd_sc_hd__decap_3
XFILLER_4_235 VGND VGND VPWR VPWR sky130_fd_sc_hd__decap_4
Xhold82 u_jt49.regarray\[7\]\[0\] VGND VGND VPWR VPWR net179 sky130_fd_sc_hd__dlygate4sd3_1
Xhold93 u_jt49.regarray\[8\]\[3\] VGND VGND VPWR VPWR net190 sky130_fd_sc_hd__dlygate4sd3_1
Xhold60 u_jt49.u_ng.poly17\[4\] VGND VGND VPWR VPWR net157 sky130_fd_sc_hd__dlygate4sd3_1
Xhold71 _0072_ VGND VGND VPWR VPWR net168 sky130_fd_sc_hd__dlygate4sd3_1
XFILLER_31_345 VGND VPWR VPWR VGND sky130_ef_sc_hd__decap_12
XANTENNA_2 net54 VGND VGND VPWR VPWR sky130_fd_sc_hd__diode_2
X_1711_ clknet_leaf_10_clk _0154_ net89 VGND VGND VPWR VPWR u_jt49.regarray\[9\]\[5\]
+ sky130_fd_sc_hd__dfrtp_1
X_1642_ clknet_leaf_4_clk _0087_ net74 VGND VGND VPWR VPWR u_jt49.u_chB.count\[0\]
+ sky130_fd_sc_hd__dfstp_1
XFILLER_6_53 VGND VPWR VPWR VGND sky130_ef_sc_hd__decap_12
X_1573_ clknet_leaf_8_clk _0020_ VGND VGND VPWR VPWR addr\[3\] sky130_fd_sc_hd__dfxtp_1
X_1007_ net110 net95 net18 _0502_ VGND VGND VPWR VPWR _0022_ sky130_fd_sc_hd__nand4_1
XFILLER_22_312 VGND VGND VPWR VPWR sky130_fd_sc_hd__decap_3
XFILLER_57_297 VGND VGND VPWR VPWR sky130_fd_sc_hd__decap_8
XFILLER_25_194 VGND VGND VPWR VPWR sky130_fd_sc_hd__decap_3
XFILLER_40_197 VGND VGND VPWR VPWR sky130_fd_sc_hd__decap_3
XFILLER_9_349 VGND VPWR VPWR VGND sky130_ef_sc_hd__decap_12
XFILLER_48_253 VGND VGND VPWR VPWR sky130_fd_sc_hd__decap_8
XFILLER_0_293 VGND VPWR VPWR VGND sky130_ef_sc_hd__decap_12
XFILLER_23_109 VGND VGND VPWR VPWR sky130_fd_sc_hd__decap_3
XFILLER_31_164 VGND VGND VPWR VPWR sky130_fd_sc_hd__decap_4
X_1556_ net110 _0612_ VGND VGND VPWR VPWR _0260_ sky130_fd_sc_hd__nand2_1
X_1625_ clknet_leaf_0_clk net168 net68 VGND VGND VPWR VPWR u_jt49.u_ng.poly17\[5\]
+ sky130_fd_sc_hd__dfrtp_1
X_1487_ u_jt49.periodB\[8\] net63 _0409_ VGND VGND VPWR VPWR _0213_ sky130_fd_sc_hd__mux2_1
XFILLER_22_197 VGND VPWR VPWR VGND sky130_ef_sc_hd__decap_12
XFILLER_22_175 VGND VGND VPWR VPWR sky130_fd_sc_hd__decap_8
XFILLER_45_234 VGND VGND VPWR VPWR sky130_fd_sc_hd__decap_8
XFILLER_26_94 VGND VGND VPWR VPWR sky130_fd_sc_hd__decap_4
XFILLER_9_102 VGND VGND VPWR VPWR sky130_fd_sc_hd__decap_8
XFILLER_13_120 VGND VPWR VPWR VGND sky130_ef_sc_hd__decap_12
X_1410_ u_jt49.regarray\[10\]\[4\] net55 _0400_ VGND VGND VPWR VPWR _0145_ sky130_fd_sc_hd__mux2_1
X_1272_ net43 _0313_ u_jt49.u_chB.count\[4\] VGND VGND VPWR VPWR _0317_ sky130_fd_sc_hd__a21o_1
X_1341_ _0362_ _0371_ _0372_ VGND VGND VPWR VPWR _0104_ sky130_fd_sc_hd__and3_1
XFILLER_51_259 VGND VGND VPWR VPWR sky130_fd_sc_hd__decap_8
X_0987_ u_jt49.regarray\[6\]\[4\] _0465_ _0466_ u_jt49.regarray\[6\]\[3\] _0615_ VGND
+ VGND VPWR VPWR _0616_ sky130_fd_sc_hd__o221a_1
XFILLER_59_337 VGND VPWR VPWR VGND sky130_ef_sc_hd__decap_12
X_1608_ clknet_leaf_19_clk _0055_ net87 VGND VGND VPWR VPWR u_jt49.u_envdiv.count\[4\]
+ sky130_fd_sc_hd__dfrtp_1
X_1539_ _0421_ _0422_ _0423_ net101 net65 VGND VGND VPWR VPWR _0251_ sky130_fd_sc_hd__a32o_1
XFILLER_27_201 VGND VGND VPWR VPWR sky130_fd_sc_hd__decap_4
XFILLER_2_300 VGND VGND VPWR VPWR sky130_fd_sc_hd__decap_8
XFILLER_12_85 VGND VPWR VPWR VGND sky130_ef_sc_hd__decap_12
XFILLER_2_344 VGND VPWR VPWR VGND sky130_ef_sc_hd__decap_12
XFILLER_33_237 VGND VGND VPWR VPWR sky130_fd_sc_hd__decap_8
XFILLER_33_204 VGND VPWR VPWR VGND sky130_ef_sc_hd__decap_12
XPHY_EDGE_ROW_16_Right_16 VGND VGND VPWR VPWR sky130_fd_sc_hd__decap_3
XFILLER_18_289 VGND VGND VPWR VPWR sky130_fd_sc_hd__decap_8
X_0841_ u_jt49.u_env.inv VGND VGND VPWR VPWR _0495_ sky130_fd_sc_hd__inv_2
X_0910_ u_jt49.periodA\[1\] _0518_ _0551_ _0555_ _0544_ VGND VGND VPWR VPWR _0556_
+ sky130_fd_sc_hd__o221a_1
XPHY_EDGE_ROW_25_Right_25 VGND VGND VPWR VPWR sky130_fd_sc_hd__decap_3
XFILLER_45_3 VGND VGND VPWR VPWR sky130_fd_sc_hd__decap_4
X_1255_ _0470_ u_jt49.periodB\[11\] _0473_ u_jt49.periodB\[9\] _0281_ VGND VGND VPWR
+ VPWR _0304_ sky130_fd_sc_hd__a221o_1
X_1186_ _0768_ VGND VGND VPWR VPWR _0769_ sky130_fd_sc_hd__inv_2
XPHY_EDGE_ROW_34_Right_34 VGND VGND VPWR VPWR sky130_fd_sc_hd__decap_3
X_1324_ _0355_ _0359_ _0357_ _0340_ VGND VGND VPWR VPWR _0360_ sky130_fd_sc_hd__o2bb2a_2
XPHY_EDGE_ROW_43_Right_43 VGND VGND VPWR VPWR sky130_fd_sc_hd__decap_3
XPHY_EDGE_ROW_52_Right_52 VGND VGND VPWR VPWR sky130_fd_sc_hd__decap_3
XFILLER_47_329 VGND VGND VPWR VPWR sky130_fd_sc_hd__decap_6
XPHY_EDGE_ROW_61_Right_61 VGND VGND VPWR VPWR sky130_fd_sc_hd__decap_3
XFILLER_2_141 VGND VGND VPWR VPWR sky130_fd_sc_hd__decap_6
X_1040_ u_jt49.u_chC.count\[3\] _0654_ VGND VGND VPWR VPWR _0658_ sky130_fd_sc_hd__or2_1
XFILLER_14_270 VGND VGND VPWR VPWR sky130_fd_sc_hd__decap_8
X_0824_ u_jt49.u_chB.count\[4\] VGND VGND VPWR VPWR _0478_ sky130_fd_sc_hd__inv_2
XFILLER_52_321 VGND VPWR VPWR VGND sky130_ef_sc_hd__decap_12
X_1238_ u_jt49.u_chB.count\[2\] u_jt49.periodB\[2\] VGND VGND VPWR VPWR _0287_ sky130_fd_sc_hd__and2b_1
X_1169_ u_jt49.u_envdiv.count\[6\] _0752_ VGND VGND VPWR VPWR _0757_ sky130_fd_sc_hd__or2_1
X_1307_ u_jt49.u_chA.count\[9\] _0485_ VGND VGND VPWR VPWR _0343_ sky130_fd_sc_hd__nor2_1
XFILLER_7_244 VGND VGND VPWR VPWR sky130_fd_sc_hd__decap_8
X_1023_ _0448_ u_jt49.periodC\[7\] u_jt49.u_chC.count\[6\] _0449_ VGND VGND VPWR VPWR
+ _0644_ sky130_fd_sc_hd__a2bb2o_1
XFILLER_38_137 VGND VGND VPWR VPWR sky130_fd_sc_hd__decap_3
XFILLER_34_376 VGND VGND VPWR VPWR sky130_fd_sc_hd__decap_4
XPHY_EDGE_ROW_55_Left_119 VGND VGND VPWR VPWR sky130_fd_sc_hd__decap_3
X_0807_ u_jt49.u_envdiv.count\[11\] VGND VGND VPWR VPWR _0461_ sky130_fd_sc_hd__inv_2
X_1787_ clknet_leaf_24_clk _0230_ VGND VGND VPWR VPWR u_jt49.Bmix sky130_fd_sc_hd__dfxtp_1
XPHY_EDGE_ROW_2_Right_2 VGND VGND VPWR VPWR sky130_fd_sc_hd__decap_3
XFILLER_55_38 VGND VPWR VPWR VGND sky130_ef_sc_hd__decap_12
XFILLER_44_129 VGND VGND VPWR VPWR sky130_fd_sc_hd__decap_4
XFILLER_40_302 VGND VGND VPWR VPWR sky130_fd_sc_hd__decap_6
Xhold83 u_jt49.u_envdiv.count\[15\] VGND VGND VPWR VPWR net180 sky130_fd_sc_hd__dlygate4sd3_1
Xhold50 u_jt49.regarray\[9\]\[7\] VGND VGND VPWR VPWR net147 sky130_fd_sc_hd__dlygate4sd3_1
XFILLER_29_83 VGND VGND VPWR VPWR sky130_fd_sc_hd__decap_4
Xhold61 _0071_ VGND VGND VPWR VPWR net158 sky130_fd_sc_hd__dlygate4sd3_1
Xhold94 u_jt49.u_env.rst_clr VGND VGND VPWR VPWR net191 sky130_fd_sc_hd__dlygate4sd3_1
Xhold72 u_jt49.u_ng.poly17\[8\] VGND VGND VPWR VPWR net169 sky130_fd_sc_hd__dlygate4sd3_1
XFILLER_16_365 VGND VPWR VPWR VGND sky130_ef_sc_hd__decap_12
XFILLER_61_81 VGND VPWR VPWR VGND sky130_ef_sc_hd__decap_12
X_1572_ clknet_leaf_8_clk _0019_ VGND VGND VPWR VPWR addr\[2\] sky130_fd_sc_hd__dfxtp_1
X_1641_ clknet_leaf_11_clk _0086_ net91 VGND VGND VPWR VPWR u_jt49.bitC sky130_fd_sc_hd__dfrtp_1
XANTENNA_3 net60 VGND VGND VPWR VPWR sky130_fd_sc_hd__diode_2
XFILLER_6_65 VGND VPWR VPWR VGND sky130_ef_sc_hd__decap_12
X_1710_ clknet_leaf_18_clk _0153_ net84 VGND VGND VPWR VPWR u_jt49.regarray\[9\]\[4\]
+ sky130_fd_sc_hd__dfrtp_4
X_1006_ net110 _0504_ _0629_ VGND VGND VPWR VPWR _0021_ sky130_fd_sc_hd__a21o_1
XFILLER_57_276 VGND VGND VPWR VPWR sky130_fd_sc_hd__decap_4
XFILLER_40_176 VGND VGND VPWR VPWR sky130_fd_sc_hd__decap_4
XFILLER_15_63 VGND VGND VPWR VPWR sky130_fd_sc_hd__decap_4
XFILLER_48_232 VGND VGND VPWR VPWR sky130_fd_sc_hd__decap_3
Xclkbuf_leaf_28_clk clknet_2_0__leaf_clk VGND VGND VPWR VPWR clknet_leaf_28_clk sky130_fd_sc_hd__clkbuf_8
X_1624_ clknet_leaf_0_clk net158 net68 VGND VGND VPWR VPWR u_jt49.u_ng.poly17\[4\]
+ sky130_fd_sc_hd__dfrtp_1
X_1555_ net66 net109 _0427_ _0431_ VGND VGND VPWR VPWR _0259_ sky130_fd_sc_hd__a22o_1
X_1486_ net36 _0515_ VGND VGND VPWR VPWR _0409_ sky130_fd_sc_hd__and2_2
XFILLER_36_29 VGND VPWR VPWR VGND sky130_ef_sc_hd__decap_12
Xclkbuf_leaf_19_clk clknet_2_2__leaf_clk VGND VGND VPWR VPWR clknet_leaf_19_clk sky130_fd_sc_hd__clkbuf_8
XFILLER_22_110 VGND VGND VPWR VPWR sky130_fd_sc_hd__decap_6
XFILLER_6_309 VGND VPWR VPWR VGND sky130_ef_sc_hd__decap_12
XFILLER_9_169 VGND VGND VPWR VPWR sky130_fd_sc_hd__decap_3
XFILLER_13_132 VGND VPWR VPWR VGND sky130_ef_sc_hd__decap_12
X_1340_ net42 _0368_ u_jt49.u_chA.count\[4\] VGND VGND VPWR VPWR _0372_ sky130_fd_sc_hd__a21o_1
X_1271_ _0315_ VGND VGND VPWR VPWR _0316_ sky130_fd_sc_hd__inv_2
Xclkbuf_leaf_8_clk clknet_2_1__leaf_clk VGND VGND VPWR VPWR clknet_leaf_8_clk sky130_fd_sc_hd__clkbuf_8
X_0986_ u_jt49.regarray\[6\]\[3\] _0466_ _0467_ u_jt49.regarray\[6\]\[2\] _0614_ VGND
+ VGND VPWR VPWR _0615_ sky130_fd_sc_hd__a221o_1
XFILLER_59_349 VGND VPWR VPWR VGND sky130_ef_sc_hd__decap_12
XFILLER_59_305 VGND VPWR VPWR VGND sky130_ef_sc_hd__decap_12
X_1469_ u_jt49.periodC\[0\] net63 _0407_ VGND VGND VPWR VPWR _0197_ sky130_fd_sc_hd__mux2_1
X_1538_ u_jt49.Bmix net20 VGND VGND VPWR VPWR _0423_ sky130_fd_sc_hd__and2_1
X_1607_ clknet_leaf_20_clk _0054_ net87 VGND VGND VPWR VPWR u_jt49.u_envdiv.count\[3\]
+ sky130_fd_sc_hd__dfrtp_2
XFILLER_42_216 VGND VGND VPWR VPWR sky130_fd_sc_hd__decap_6
XFILLER_42_205 VGND VGND VPWR VPWR sky130_fd_sc_hd__decap_3
XFILLER_5_3 VGND VPWR VPWR VGND sky130_ef_sc_hd__decap_12
XFILLER_2_356 VGND VGND VPWR VPWR sky130_fd_sc_hd__decap_8
XFILLER_33_216 VGND VGND VPWR VPWR sky130_fd_sc_hd__decap_8
X_0840_ u_jt49.periodA\[0\] VGND VGND VPWR VPWR _0494_ sky130_fd_sc_hd__inv_2
XFILLER_38_3 VGND VPWR VPWR VGND sky130_ef_sc_hd__decap_12
X_1323_ _0340_ _0342_ _0358_ VGND VGND VPWR VPWR _0359_ sky130_fd_sc_hd__nor3_1
X_1254_ u_jt49.u_chB.count\[11\] _0471_ _0281_ VGND VGND VPWR VPWR _0303_ sky130_fd_sc_hd__o21ai_1
X_1185_ u_jt49.u_envdiv.count\[11\] u_jt49.u_envdiv.count\[10\] _0763_ VGND VGND VPWR
+ VPWR _0768_ sky130_fd_sc_hd__and3_1
X_0969_ _0604_ _0605_ _0608_ VGND VGND VPWR VPWR _0609_ sky130_fd_sc_hd__or3_1
XFILLER_59_113 VGND VPWR VPWR VGND sky130_ef_sc_hd__decap_12
XFILLER_23_63 VGND VPWR VPWR VGND sky130_ef_sc_hd__decap_12
XFILLER_48_71 VGND VGND VPWR VPWR sky130_fd_sc_hd__decap_4
X_0823_ u_jt49.u_chB.count\[5\] VGND VGND VPWR VPWR _0477_ sky130_fd_sc_hd__inv_2
X_1306_ u_jt49.u_chA.count\[10\] _0484_ VGND VGND VPWR VPWR _0342_ sky130_fd_sc_hd__nor2_1
XFILLER_52_333 VGND VGND VPWR VPWR sky130_fd_sc_hd__decap_4
X_1237_ u_jt49.periodB\[1\] u_jt49.u_chB.count\[1\] VGND VGND VPWR VPWR _0286_ sky130_fd_sc_hd__nand2b_1
X_1168_ _0755_ VGND VGND VPWR VPWR _0756_ sky130_fd_sc_hd__inv_2
X_1099_ _0443_ net33 _0700_ VGND VGND VPWR VPWR _0043_ sky130_fd_sc_hd__a21o_1
XFILLER_28_374 VGND VGND VPWR VPWR sky130_fd_sc_hd__decap_6
XFILLER_18_52 VGND VGND VPWR VPWR sky130_fd_sc_hd__decap_4
XFILLER_34_62 VGND VGND VPWR VPWR sky130_fd_sc_hd__decap_3
XFILLER_59_81 VGND VPWR VPWR VGND sky130_ef_sc_hd__decap_12
XFILLER_38_105 VGND VPWR VPWR VGND sky130_ef_sc_hd__decap_12
X_1022_ u_jt49.u_chC.count\[6\] _0449_ u_jt49.u_chC.count\[5\] _0450_ VGND VGND VPWR
+ VPWR _0643_ sky130_fd_sc_hd__o22a_1
X_0806_ u_jt49.u_envdiv.count\[12\] VGND VGND VPWR VPWR _0460_ sky130_fd_sc_hd__inv_2
X_1786_ clknet_leaf_3_clk _0229_ net75 VGND VGND VPWR VPWR u_jt49.periodB\[7\] sky130_fd_sc_hd__dfrtp_1
Xhold40 u_jt49.regarray\[5\]\[4\] VGND VGND VPWR VPWR net137 sky130_fd_sc_hd__dlygate4sd3_1
Xhold51 u_jt49.regarray\[3\]\[4\] VGND VGND VPWR VPWR net148 sky130_fd_sc_hd__dlygate4sd3_1
XFILLER_35_108 VGND VGND VPWR VPWR sky130_fd_sc_hd__decap_4
Xhold95 u_jt49.envelope\[1\] VGND VGND VPWR VPWR net192 sky130_fd_sc_hd__dlygate4sd3_1
Xhold62 u_jt49.u_ng.poly17\[13\] VGND VGND VPWR VPWR net159 sky130_fd_sc_hd__dlygate4sd3_1
Xhold84 u_jt49.envelope\[4\] VGND VGND VPWR VPWR net181 sky130_fd_sc_hd__dlygate4sd3_1
Xhold73 _0075_ VGND VGND VPWR VPWR net170 sky130_fd_sc_hd__dlygate4sd3_1
XFILLER_61_93 VGND VPWR VPWR VGND sky130_ef_sc_hd__decap_12
XFILLER_31_325 VGND VGND VPWR VPWR sky130_fd_sc_hd__decap_8
XFILLER_16_377 VGND VGND VPWR VPWR sky130_fd_sc_hd__decap_3
X_1571_ clknet_leaf_7_clk _0018_ VGND VGND VPWR VPWR addr\[1\] sky130_fd_sc_hd__dfxtp_1
X_1640_ clknet_leaf_7_clk _0001_ VGND VGND VPWR VPWR u_jt49.read_mask\[5\] sky130_fd_sc_hd__dfxtp_1
X_1005_ _0504_ _0628_ net95 VGND VGND VPWR VPWR _0629_ sky130_fd_sc_hd__o21ai_1
X_1838_ clknet_leaf_14_clk _0260_ VGND VGND VPWR VPWR u_jt49.wr_n sky130_fd_sc_hd__dfxtp_1
X_1769_ clknet_leaf_6_clk _0212_ net76 VGND VGND VPWR VPWR IOB_out[7] sky130_fd_sc_hd__dfrtp_4
XFILLER_40_188 VGND VGND VPWR VPWR sky130_fd_sc_hd__decap_8
XFILLER_48_266 VGND VPWR VPWR VGND sky130_ef_sc_hd__decap_12
XFILLER_48_244 VGND VGND VPWR VPWR sky130_fd_sc_hd__decap_8
XFILLER_63_269 VGND VGND VPWR VPWR sky130_fd_sc_hd__decap_8
XFILLER_63_225 VGND VGND VPWR VPWR sky130_fd_sc_hd__decap_4
XFILLER_31_122 VGND VGND VPWR VPWR sky130_fd_sc_hd__decap_4
X_1485_ net49 IOB_out[7] _0408_ VGND VGND VPWR VPWR _0212_ sky130_fd_sc_hd__mux2_1
X_1623_ clknet_leaf_4_clk _0070_ net74 VGND VGND VPWR VPWR u_jt49.u_ng.poly17\[3\]
+ sky130_fd_sc_hd__dfrtp_1
X_1554_ u_jt49.regarray\[10\]\[3\] u_jt49.envelope\[4\] u_jt49.regarray\[10\]\[4\]
+ VGND VGND VPWR VPWR _0431_ sky130_fd_sc_hd__mux2_1
C0 net24 _0504_ 2.44048f
C1 VPWR net50 4.83393f
C2 clk VPWR 5.59548f
C3 VPWR net64 5.50964f
C4 VPWR u_jt49.envelope\[1\] 2.65762f
C5 _0524_ VPWR 2.96975f
C6 clknet_leaf_27_clk VPWR 2.37455f
C7 _0529_ VPWR 5.29669f
C8 VPWR _0305_ 4.89595f
C9 net61 net44 2.05472f
C10 net32 VPWR 4.79192f
C11 net48 VPWR 2.11288f
C12 net57 VPWR 7.41465f
C13 IOB_oe addr\[0\] 2.27191f
C14 u_jt49.periodB\[3\] VPWR 3.85955f
C15 _0651_ _0649_ 2.72316f
C16 u_jt49.periodC\[8\] VPWR 2.1101f
C17 net44 VPWR 3.562f
C18 u_jt49.eg_period\[15\] VPWR 6.89221f
C19 _0534_ VPWR 4.21698f
C20 _0526_ VPWR 4.77573f
C21 VPWR u_jt49.eg_period\[8\] 2.92197f
C22 _0545_ VPWR 2.61274f
C23 u_jt49.envelope\[4\] VPWR 2.81762f
C24 _0420_ VPWR 3.28122f
C25 net97 _0559_ 2.6935f
C26 u_jt49.regarray\[10\]\[4\] VPWR 3.06387f
C27 net59 net64 4.20524f
C28 _0407_ VPWR 3.23527f
C29 _0777_ VPWR 2.07981f
C30 _0262_ VPWR 6.51467f
C31 _0532_ VPWR 2.50847f
C32 VPWR net51 5.28137f
C33 VPWR _0528_ 4.76974f
C34 _0404_ net36 2.01935f
C35 din_latch\[7\] VPWR 4.61475f
C36 _0406_ VPWR 2.45514f
C37 VPWR _0360_ 2.99114f
C38 VPWR _0556_ 3.02227f
C39 net5 VPWR 7.75646f
C40 u_jt49.eg_period\[9\] VPWR 2.32589f
C41 _0531_ VPWR 2.25228f
C42 u_jt49.periodC\[11\] VPWR 2.09157f
C43 _0600_ VPWR 5.20307f
C44 clknet_leaf_25_clk VPWR 2.26639f
C45 _0542_ VPWR 2.44559f
C46 net1 VPWR 14.63605f
C47 clknet_leaf_14_clk VPWR 3.15906f
C48 clknet_leaf_9_clk VPWR 2.33373f
C49 VPWR net62 7.17124f
C50 clknet_leaf_19_clk VPWR 2.58952f
C51 VPWR net88 2.769f
C52 u_jt49.regarray\[10\]\[0\] VPWR 2.17777f
C53 _0402_ VPWR 2.30799f
C54 VPWR net38 6.76886f
C55 net67 VPWR 5.94992f
C56 net84 VPWR 2.86925f
C57 net73 VPWR 4.0507f
C58 u_jt49.eg_period\[13\] VPWR 2.16596f
C59 VPWR clknet_leaf_23_clk 2.33534f
C60 VPWR net2 9.55112f
C61 VPWR u_jt49.regarray\[6\]\[1\] 2.07639f
C62 u_jt49.periodC\[1\] VPWR 2.79419f
C63 net37 VPWR 9.28051f
C64 _0547_ VPWR 7.7688f
C65 net53 VPWR 6.15645f
C66 net61 VPWR 8.13468f
C67 net52 net53 3.55575f
C68 VPWR clknet_leaf_7_clk 3.87276f
C69 VPWR net20 16.78932f
C70 VPWR clknet_2_3__leaf_clk 9.40335f
C71 clknet_2_2__leaf_clk u_jt49.eg_period\[2\] 2.28143f
C72 VPWR _0403_ 3.49125f
C73 VPWR net15 4.45224f
C74 clknet_leaf_18_clk VPWR 3.32522f
C75 net96 VPWR 6.34632f
C76 u_jt49.eg_period\[3\] VPWR 2.83949f
C77 _0612_ VPWR 6.75594f
C78 u_jt49.eg_period\[12\] VPWR 2.94048f
C79 VPWR u_jt49.eg_period\[14\] 2.97718f
C80 _0517_ VPWR 4.24476f
C81 net75 VPWR 4.18632f
C82 net52 VPWR 10.38374f
C83 net8 VPWR 6.52755f
C84 u_jt49.regarray\[9\]\[4\] VPWR 2.21897f
C85 net13 VPWR 5.37392f
C86 VPWR u_jt49.envelope\[3\] 3.68941f
C87 _0307_ VPWR 4.43625f
C88 din_latch\[3\] VPWR 2.7018f
C89 _0408_ net56 2.14113f
C90 clknet_leaf_31_clk VPWR 3.47509f
C91 VPWR clknet_leaf_1_clk 3.16702f
C92 VPWR clknet_leaf_8_clk 2.93197f
C93 _0535_ VPWR 2.29463f
C94 net58 net62 2.34638f
C95 u_jt49.periodB\[8\] VPWR 4.49684f
C96 net49 VPWR 7.45717f
C97 net80 VPWR 5.8718f
C98 u_jt49.periodB\[3\] _0599_ 2.40079f
C99 VPWR u_jt49.periodB\[7\] 3.98355f
C100 IOB_oe VPWR 4.50414f
C101 _0264_ VPWR 2.71541f
C102 clknet_0_clk VPWR 4.36418f
C103 VPWR clknet_leaf_11_clk 2.15041f
C104 _0263_ _0261_ 2.68043f
C105 net68 VPWR 2.14303f
C106 u_jt49.noise VPWR 5.38912f
C107 net41 VPWR 3.07967f
C108 net57 _0521_ 2.9972f
C109 net21 VPWR 3.32512f
C110 VPWR clknet_leaf_4_clk 3.8754f
C111 clknet_leaf_29_clk VPWR 4.01152f
C112 _0400_ VPWR 6.11842f
C113 net28 VPWR 3.11734f
C114 u_jt49.periodC\[3\] net60 2.123f
C115 clknet_leaf_28_clk VPWR 3.10615f
C116 VPWR net4 2.26246f
C117 net60 net20 3.4226f
C118 VPWR clknet_leaf_10_clk 2.49923f
C119 VPWR net30 2.22594f
C120 VPWR net55 4.57859f
C121 VPWR net59 8.04586f
C122 din_latch\[0\] VPWR 4.41839f
C123 net85 _0412_ 3.53444f
C124 VPWR net60 9.63064f
C125 _0396_ VPWR 2.47864f
C126 net7 VPWR 11.81467f
C127 _0263_ VPWR 2.31653f
C128 VPWR _0578_ 2.77309f
C129 VPWR net95 2.24371f
C130 net23 VPWR 2.90349f
C131 VPWR net58 7.83375f
C132 u_jt49.envelope\[1\] u_jt49.envelope\[2\] 2.07684f
C133 _0589_ VPWR 3.85067f
C134 _0544_ VPWR 2.64436f
C135 u_jt49.periodC\[9\] VPWR 3.14378f
C136 VPWR u_jt49.read_mask\[5\] 2.22035f
C137 clknet_0_clk net59 2.19254f
C138 _0523_ VPWR 2.04848f
C139 VPWR u_jt49.regarray\[6\]\[2\] 2.02237f
C140 u_jt49.periodC\[1\] net36 2.06248f
C141 VPWR _0397_ 3.91531f
C142 net97 VPWR 8.65643f
C143 net59 net77 2.294f
C144 u_jt49.u_chA.count\[8\] VPWR 2.08114f
C145 VPWR clknet_leaf_3_clk 2.63757f
C146 VPWR net91 2.67112f
C147 clknet_leaf_26_clk VPWR 2.57524f
C148 _0504_ VPWR 9.45335f
C149 VPWR net42 5.50777f
C150 _0362_ VPWR 6.65865f
C151 _0564_ VPWR 3.26618f
C152 _0413_ VPWR 4.15281f
C153 net70 VPWR 5.24472f
C154 VPWR net36 5.30596f
C155 net63 VPWR 7.94521f
C156 VPWR net12 2.50246f
C157 net92 VPWR 2.3871f
C158 VPWR net47 2.01743f
C159 VPWR net6 2.3848f
C160 VPWR u_jt49.periodB\[2\] 3.08035f
C161 u_jt49.periodA\[4\] VPWR 3.63905f
C162 VPWR clknet_2_0__leaf_clk 6.45715f
C163 VPWR net40 4.6512f
C164 u_jt49.periodA\[8\] VPWR 3.34309f
C165 u_jt49.periodB\[11\] VPWR 3.94537f
C166 u_jt49.eg_period\[11\] u_jt49.eg_period\[9\] 5.09738f
C167 VPWR _0527_ 3.04709f
C168 VPWR net69 4.8417f
C169 din_latch\[7\] IOA_oe 2.37823f
C170 clknet_leaf_22_clk VPWR 2.32122f
C171 VPWR u_jt49.u_env.rst_latch 3.96326f
C172 VPWR _0521_ 2.86332f
C173 _0530_ VPWR 4.48265f
C174 VPWR net39 3.25399f
C175 net82 VPWR 6.59468f
C176 u_jt49.u_ng.noise_en VPWR 4.13181f
C177 _0268_ VPWR 2.02196f
C178 net52 net82 3.98142f
C179 VPWR net78 2.57836f
C180 clknet_leaf_0_clk VPWR 3.82026f
C181 clknet_leaf_17_clk VPWR 2.90557f
C182 _0408_ VPWR 8.18368f
C183 _0307_ net39 2.17864f
C184 VPWR u_jt49.periodC\[6\] 2.11922f
C185 VPWR u_jt49.regarray\[13\]\[3\] 3.76778f
C186 VPWR net81 5.38718f
C187 _0515_ VPWR 4.87119f
C188 VPWR u_jt49.eg_period\[2\] 2.84831f
C189 VPWR _0562_ 3.51361f
C190 net40 net4 2.06245f
C191 VPWR _0401_ 2.34635f
C192 net85 VPWR 2.78208f
C193 u_jt49.periodC\[11\] _0651_ 2.38487f
C194 _0411_ VPWR 3.41777f
C195 net34 VPWR 3.22757f
C196 din_latch\[1\] VPWR 2.20397f
C197 VPWR net79 2.24538f
C198 net49 net81 3.15305f
C199 VPWR net14 3.37161f
C200 net86 net88 2.61787f
C201 IOB_oe addr\[3\] 2.08166f
C202 _0327_ VPWR 2.27476f
C203 u_jt49.eg_period\[11\] VPWR 2.90627f
C204 clknet_2_2__leaf_clk VPWR 4.691f
C205 net76 VPWR 2.46242f
C206 _0404_ VPWR 5.23551f
C207 net11 VPWR 2.05131f
C208 _0682_ VPWR 2.74135f
C209 u_jt49.periodA\[5\] VPWR 2.59111f
C210 VPWR IOA_oe 4.75019f
C211 net54 VPWR 5.69404f
C212 u_jt49.periodB\[0\] VPWR 3.44824f
C213 _0456_ VPWR 3.68443f
C214 net3 VPWR 13.39989f
C215 VPWR u_jt49.periodB\[4\] 7.86283f
C216 net25 VPWR 4.86758f
C217 VPWR u_jt49.periodA\[9\] 2.49166f
C218 VPWR net56 11.72668f
C219 VPWR clknet_2_1__leaf_clk 6.70105f
C220 net52 clknet_2_1__leaf_clk 2.96049f
C221 net10 clknet_2_0__leaf_clk 2.61563f
C222 _0565_ _0546_ 2.42356f
C223 VPWR clknet_leaf_20_clk 2.29146f
C224 VPWR _0405_ 3.39379f
C225 u_jt49.regarray\[10\]\[3\] VGND 2.95897f
C226 net74 VGND 4.59707f
C227 clknet_leaf_4_clk VGND 5.38712f
C228 u_jt49.periodA\[0\] VGND 2.60691f
C229 net20 VGND 12.35316f
C230 u_jt49.regarray\[6\]\[3\] VGND 2.84399f
C231 net109 VGND 3.52623f
C232 _0427_ VGND 2.12922f
C233 clknet_2_0__leaf_clk VGND 13.16176f
C234 _0551_ VGND 3.83678f
C235 net65 VGND 3.8354f
C236 net2 VGND 2.12577f
C237 _0556_ VGND 2.3093f
C238 clknet_leaf_20_clk VGND 4.41914f
C239 _0305_ VGND 2.06944f
C240 net43 VGND 9.73898f
C241 net31 VGND 2.26589f
C242 u_jt49.u_chA.count\[0\] VGND 2.23759f
C243 net42 VGND 5.91215f
C244 u_jt49.periodC\[10\] VGND 5.08365f
C245 clknet_2_3__leaf_clk VGND 8.30063f
C246 _0409_ VGND 2.68516f
C247 clknet_leaf_10_clk VGND 3.75077f
C248 u_jt49.eg_period\[10\] VGND 5.91105f
C249 u_jt49.u_chA.count\[5\] VGND 2.25682f
C250 net38 VGND 14.7985f
C251 u_jt49.u_chC.count\[9\] VGND 2.01162f
C252 net69 VGND 3.02945f
C253 net89 VGND 4.40062f
C254 u_jt49.periodC\[2\] VGND 2.52744f
C255 net12 VGND 3.04311f
C256 net4 VGND 11.31727f
C257 u_jt49.periodB\[2\] VGND 3.82206f
C258 u_jt49.u_chC.count\[0\] VGND 2.66798f
C259 net88 VGND 4.9651f
C260 clknet_2_1__leaf_clk VGND 10.50812f
C261 u_jt49.u_ng.poly17\[3\] VGND 2.16285f
C262 net64 VGND 9.68559f
C263 _0401_ VGND 3.39519f
C264 _0533_ VGND 5.16812f
C265 clknet_leaf_21_clk VGND 2.42991f
C266 clknet_leaf_1_clk VGND 2.79713f
C267 net90 VGND 2.33431f
C268 net62 VGND 4.69115f
C269 _0397_ VGND 3.7703f
C270 _0521_ VGND 6.24304f
C271 net36 VGND 5.71613f
C272 u_jt49.eg_period\[8\] VGND 2.11257f
C273 net60 VGND 7.94568f
C274 u_jt49.periodB\[5\] VGND 4.60754f
C275 net14 VGND 3.21849f
C276 net6 VGND 11.13968f
C277 u_jt49.u_chB.count\[7\] VGND 2.10092f
C278 clknet_leaf_7_clk VGND 3.70802f
C279 _0405_ VGND 3.594f
C280 net77 VGND 4.26148f
C281 clknet_leaf_24_clk VGND 2.73245f
C282 _0528_ VGND 2.21331f
C283 net30 VGND 4.70521f
C284 net58 VGND 8.15222f
C285 u_jt49.periodC\[4\] VGND 2.17362f
C286 net59 VGND 15.32363f
C287 _0403_ VGND 4.22373f
C288 IOA_oe VGND 4.55931f
C289 u_jt49.envelope\[2\] VGND 4.78664f
C290 _0559_ VGND 4.46239f
C291 u_jt49.u_env.gain\[1\] VGND 2.34836f
C292 u_jt49.u_env.inv VGND 2.11084f
C293 _0527_ VGND 3.74118f
C294 net16 VGND 6.22974f
C295 _0609_ VGND 2.86074f
C296 u_jt49.envelope\[1\] VGND 2.16976f
C297 net79 VGND 2.24441f
C298 net81 VGND 5.66509f
C299 clknet_leaf_3_clk VGND 3.75514f
C300 net40 VGND 4.11733f
C301 net78 VGND 4.09759f
C302 _0745_ VGND 2.22316f
C303 net15 VGND 3.56375f
C304 net56 VGND 11.6291f
C305 u_jt49.bitB VGND 2.95783f
C306 net51 VGND 9.44895f
C307 u_jt49.envelope\[3\] VGND 3.49356f
C308 u_jt49.regarray\[8\]\[2\] VGND 2.82214f
C309 net72 VGND 3.95718f
C310 u_jt49.regarray\[9\]\[1\] VGND 2.10508f
C311 net47 VGND 3.20794f
C312 net86 VGND 5.12772f
C313 net55 VGND 11.70237f
C314 net50 VGND 6.5344f
C315 clknet_leaf_23_clk VGND 5.11079f
C316 clknet_leaf_16_clk VGND 3.30664f
C317 net91 VGND 4.36665f
C318 clknet_leaf_11_clk VGND 4.41872f
C319 net35 VGND 2.53197f
C320 clknet_leaf_8_clk VGND 4.36143f
C321 u_jt49.regarray\[6\]\[4\] VGND 3.37292f
C322 _0398_ VGND 2.72764f
C323 net93 VGND 5.63785f
C324 net95 VGND 7.1171f
C325 _0261_ VGND 5.4325f
C326 u_jt49.regarray\[6\]\[1\] VGND 2.04779f
C327 net9 VGND 7.30382f
C328 VPWR VGND 2.73552p
C329 net67 VGND 6.90948f
C330 clknet_leaf_30_clk VGND 3.02717f
C331 _0444_ VGND 2.61156f
C332 net11 VGND 8.86886f
C333 net80 VGND 5.52275f
C334 clknet_leaf_9_clk VGND 4.01197f
C335 _0532_ VGND 8.43021f
C336 u_jt49.periodB\[6\] VGND 4.89862f
C337 _0517_ VGND 5.08807f
C338 net8 VGND 3.36224f
C339 u_jt49.u_ng.u_div.count\[0\] VGND 2.28793f
C340 net44 VGND 4.25189f
C341 net68 VGND 4.70002f
C342 net10 VGND 5.6515f
C343 u_jt49.periodA\[10\] VGND 2.12614f
C344 net63 VGND 13.49121f
C345 net21 VGND 2.58438f
C346 net7 VGND 2.40614f
C347 net107 VGND 2.05912f
C348 net66 VGND 5.1423f
C349 dout[3] VGND 2.05812f
C350 net48 VGND 4.60429f
C351 net61 VGND 11.52037f
C352 u_jt49.periodA\[1\] VGND 2.43524f
C353 _0420_ VGND 3.18909f
C354 _0771_ VGND 2.28843f
C355 _0362_ VGND 4.8337f
C356 net37 VGND 6.15001f
C357 din_latch\[7\] VGND 4.52967f
C358 u_jt49.periodA\[8\] VGND 3.2965f
C359 _0546_ VGND 3.5237f
C360 _0547_ VGND 7.27922f
C361 net23 VGND 2.22241f
C362 _0612_ VGND 10.17248f
C363 _0307_ VGND 6.07254f
C364 u_jt49.eg_period\[4\] VGND 3.1687f
C365 IOB_out[0] VGND 2.15523f
C366 _0408_ VGND 5.26037f
C367 u_jt49.write VGND 2.02707f
C368 u_jt49.noise VGND 5.23267f
C369 net97 VGND 12.43793f
C370 u_jt49.periodC\[9\] VGND 5.45548f
C371 net54 VGND 13.81837f
C372 net18 VGND 2.58257f
C373 u_jt49.regarray\[10\]\[4\] VGND 5.37872f
C374 IOB_out[1] VGND 2.67993f
C375 clknet_leaf_15_clk VGND 5.49586f
C376 din_latch\[3\] VGND 3.04484f
C377 u_jt49.periodA\[6\] VGND 3.0231f
C378 _0544_ VGND 2.96706f
C379 _0518_ VGND 2.14514f
C380 u_jt49.periodA\[5\] VGND 2.61382f
C381 _0529_ VGND 2.98235f
C382 _0504_ VGND 4.88471f
C383 net3 VGND 4.11392f
C384 clknet_leaf_14_clk VGND 5.33509f
C385 net96 VGND 7.10388f
C386 u_jt49.periodB\[0\] VGND 3.76436f
C387 _0411_ VGND 4.39932f
C388 clknet_leaf_0_clk VGND 3.6979f
C389 u_jt49.u_chC.count\[3\] VGND 2.86813f
C390 net85 VGND 7.82209f
C391 u_jt49.periodC\[1\] VGND 2.28744f
C392 u_jt49.u_envdiv.count\[3\] VGND 2.5888f
C393 net71 VGND 3.73538f
C394 clknet_leaf_26_clk VGND 4.32196f
C395 _0400_ VGND 3.67709f
C396 _0515_ VGND 2.60744f
C397 u_jt49.periodB\[11\] VGND 3.43127f
C398 u_jt49.eg_period\[3\] VGND 2.89151f
C399 _0582_ VGND 3.69706f
C400 net83 VGND 5.10741f
C401 net84 VGND 4.03188f
C402 u_jt49.periodB\[9\] VGND 3.46305f
C403 u_jt49.periodC\[11\] VGND 2.80648f
C404 _0534_ VGND 4.32794f
C405 _0402_ VGND 4.32488f
C406 net5 VGND 2.16245f
C407 din_latch\[5\] VGND 2.71759f
C408 clknet_leaf_27_clk VGND 3.8134f
C409 u_jt49.eg_period\[9\] VGND 3.23087f
C410 u_jt49.eg_period\[0\] VGND 8.31557f
C411 _0535_ VGND 4.12694f
C412 u_jt49.eg_period\[12\] VGND 4.52501f
C413 _0520_ VGND 2.44065f
C414 _0413_ VGND 3.72545f
C415 _0530_ VGND 3.91562f
C416 clknet_0_clk VGND 5.29419f
C417 clknet_leaf_19_clk VGND 3.25224f
C418 net82 VGND 6.71724f
C419 net41 VGND 6.91703f
C420 din_latch\[1\] VGND 4.46379f
C421 u_jt49.periodC\[8\] VGND 2.64312f
C422 clk VGND 6.23813f
C423 net70 VGND 5.62866f
C424 _0265_ VGND 3.16888f
C425 clknet_leaf_29_clk VGND 3.725f
C426 net34 VGND 4.29986f
C427 clknet_2_2__leaf_clk VGND 5.65434f
C428 _0266_ VGND 4.70453f
C429 u_jt49.eg_period\[11\] VGND 3.02833f
C430 u_jt49.u_ng.noise_en VGND 3.01116f
C431 u_jt49.u_chA.count\[10\] VGND 2.16578f
C432 u_jt49.periodC\[5\] VGND 2.14531f
C433 u_jt49.u_envdiv.count\[4\] VGND 2.39798f
C434 _0404_ VGND 6.56465f
C435 u_jt49.periodC\[7\] VGND 3.92255f
C436 net57 VGND 15.22262f
C437 net73 VGND 4.10606f
C438 _0267_ VGND 2.3109f
C439 _0682_ VGND 3.31365f
C440 u_jt49.periodB\[1\] VGND 2.46994f
C441 net32 VGND 5.21207f
C442 _0396_ VGND 2.40741f
C443 _0531_ VGND 6.57946f
C444 u_jt49.eg_period\[15\] VGND 2.34535f
C445 u_jt49.periodC\[0\] VGND 2.07134f
C446 IOB_out[2] VGND 2.30151f
C447 _0268_ VGND 2.11185f
C448 _0685_ VGND 2.23684f
C449 clknet_leaf_5_clk VGND 3.20022f
C450 _0524_ VGND 5.14137f
C451 _0526_ VGND 3.24912f
C452 u_jt49.eg_period\[7\] VGND 2.18194f
C453 net53 VGND 13.87334f
C454 _0406_ VGND 2.55957f
C455 clknet_leaf_25_clk VGND 3.81729f
C456 net26 VGND 2.73291f
C457 clknet_leaf_17_clk VGND 4.82192f
C458 clknet_leaf_13_clk VGND 2.92782f
C459 net94 VGND 4.51231f
C460 _0619_ VGND 3.05699f
C461 _0731_ VGND 2.21788f
C462 u_jt49.periodB\[3\] VGND 3.12661f
C463 u_jt49.regarray\[8\]\[4\] VGND 3.412f
C464 clknet_leaf_31_clk VGND 6.88116f
C465 net52 VGND 12.82051f
C466 clknet_leaf_28_clk VGND 4.3322f
C467 net76 VGND 8.74648f
C468 net105 VGND 2.29285f
C469 clknet_leaf_22_clk VGND 5.18526f
C470 net75 VGND 4.40778f
C471 IOB_oe VGND 5.76988f
C472 net45 VGND 3.5578f
C473 net46 VGND 3.81222f
C474 u_jt49.periodA\[7\] VGND 4.86238f
C475 net49 VGND 10.88514f
C476 clknet_leaf_6_clk VGND 2.85582f
C477 u_jt49.u_chB.count\[5\] VGND 2.17643f
C478 _0399_ VGND 3.39004f
C479 u_jt49.regarray\[9\]\[0\] VGND 2.86078f
C480 clknet_leaf_18_clk VGND 4.97114f
C481 u_jt49.regarray\[9\]\[7\] VGND 2.55356f
C482 u_jt49.regarray\[9\]\[4\] VGND 3.02629f
C483 _0407_ VGND 2.60713f
C484 net87 VGND 4.45599f
.ends
