* NGSPICE file created from digital_core.ext - technology: sky130A

.subckt sky130_fd_sc_hd__decap_4 VGND VNB VPB VPWR
X0 VPWR VGND VPWR VPB sky130_fd_pr__pfet_01v8_hvt ad=0.2262 pd=2.26 as=0.4524 ps=4.52 w=0.87 l=1.05
X1 VGND VPWR VGND VNB sky130_fd_pr__nfet_01v8 ad=0.143 pd=1.62 as=0.286 ps=3.24 w=0.55 l=1.05
.ends

.subckt sky130_ef_sc_hd__decap_12 VGND VPWR VPB VNB
X0 VPWR VGND VPWR VPB sky130_fd_pr__pfet_01v8_hvt ad=0.2262 pd=2.26 as=0.4524 ps=4.52 w=0.87 l=4.73
X1 VGND VPWR VGND VNB sky130_fd_pr__nfet_01v8 ad=0.143 pd=1.62 as=0.286 ps=3.24 w=0.55 l=4.73
.ends

.subckt sky130_fd_sc_hd__decap_8 VGND VNB VPB VPWR
X0 VPWR VGND VPWR VPB sky130_fd_pr__pfet_01v8_hvt ad=0.2262 pd=2.26 as=0.4524 ps=4.52 w=0.87 l=2.89
X1 VGND VPWR VGND VNB sky130_fd_pr__nfet_01v8 ad=0.143 pd=1.62 as=0.286 ps=3.24 w=0.55 l=2.89
.ends

.subckt sky130_fd_sc_hd__decap_3 VGND VNB VPB VPWR
X0 VPWR VGND VPWR VPB sky130_fd_pr__pfet_01v8_hvt ad=0.2262 pd=2.26 as=0.4524 ps=4.52 w=0.87 l=0.59
X1 VGND VPWR VGND VNB sky130_fd_pr__nfet_01v8 ad=0.143 pd=1.62 as=0.286 ps=3.24 w=0.55 l=0.59
.ends

.subckt sky130_fd_sc_hd__or3b_1 A B C_N VGND VNB VPB VPWR X
X0 a_109_93# C_N VGND VNB sky130_fd_pr__nfet_01v8 ad=0.1092 pd=1.36 as=0.1092 ps=1.36 w=0.42 l=0.15
X1 a_215_53# B VGND VNB sky130_fd_pr__nfet_01v8 ad=0.0567 pd=0.69 as=0.0567 ps=0.69 w=0.42 l=0.15
X2 VGND a_109_93# a_215_53# VNB sky130_fd_pr__nfet_01v8 ad=0.0567 pd=0.69 as=0.1092 ps=1.36 w=0.42 l=0.15
X3 VGND A a_215_53# VNB sky130_fd_pr__nfet_01v8 ad=0.10025 pd=0.985 as=0.0567 ps=0.69 w=0.42 l=0.15
X4 VPWR A a_369_297# VPB sky130_fd_pr__pfet_01v8_hvt ad=0.14825 pd=1.34 as=0.06825 ps=0.745 w=0.42 l=0.15
X5 a_369_297# B a_297_297# VPB sky130_fd_pr__pfet_01v8_hvt ad=0.06825 pd=0.745 as=0.0441 ps=0.63 w=0.42 l=0.15
X6 X a_215_53# VPWR VPB sky130_fd_pr__pfet_01v8_hvt ad=0.275 pd=2.55 as=0.14825 ps=1.34 w=1 l=0.15
X7 a_297_297# a_109_93# a_215_53# VPB sky130_fd_pr__pfet_01v8_hvt ad=0.0441 pd=0.63 as=0.1092 ps=1.36 w=0.42 l=0.15
X8 a_109_93# C_N VPWR VPB sky130_fd_pr__pfet_01v8_hvt ad=0.1092 pd=1.36 as=0.1092 ps=1.36 w=0.42 l=0.15
X9 X a_215_53# VGND VNB sky130_fd_pr__nfet_01v8 ad=0.17875 pd=1.85 as=0.10025 ps=0.985 w=0.65 l=0.15
.ends

.subckt sky130_fd_sc_hd__mux2_1 A0 A1 S VGND VNB VPB VPWR X
X0 VPWR a_505_21# a_535_374# VPB sky130_fd_pr__pfet_01v8_hvt ad=0.0693 pd=0.75 as=0.0441 ps=0.63 w=0.42 l=0.15
X1 a_505_21# S VPWR VPB sky130_fd_pr__pfet_01v8_hvt ad=0.1176 pd=1.4 as=0.0693 ps=0.75 w=0.42 l=0.15
X2 a_218_374# S VPWR VPB sky130_fd_pr__pfet_01v8_hvt ad=0.07665 pd=0.785 as=0.15835 ps=1.395 w=0.42 l=0.15
X3 VGND a_505_21# a_439_47# VNB sky130_fd_pr__nfet_01v8 ad=0.1449 pd=1.11 as=0.0693 ps=0.75 w=0.42 l=0.15
X4 a_76_199# A0 a_218_374# VPB sky130_fd_pr__pfet_01v8_hvt ad=0.1932 pd=1.34 as=0.07665 ps=0.785 w=0.42 l=0.15
X5 a_505_21# S VGND VNB sky130_fd_pr__nfet_01v8 ad=0.1092 pd=1.36 as=0.1449 ps=1.11 w=0.42 l=0.15
X6 a_439_47# A0 a_76_199# VNB sky130_fd_pr__nfet_01v8 ad=0.0693 pd=0.75 as=0.09975 ps=0.895 w=0.42 l=0.15
X7 a_535_374# A1 a_76_199# VPB sky130_fd_pr__pfet_01v8_hvt ad=0.0441 pd=0.63 as=0.1932 ps=1.34 w=0.42 l=0.15
X8 a_76_199# A1 a_218_47# VNB sky130_fd_pr__nfet_01v8 ad=0.09975 pd=0.895 as=0.0693 ps=0.75 w=0.42 l=0.15
X9 a_218_47# S VGND VNB sky130_fd_pr__nfet_01v8 ad=0.0693 pd=0.75 as=0.11285 ps=1.045 w=0.42 l=0.15
X10 VPWR a_76_199# X VPB sky130_fd_pr__pfet_01v8_hvt ad=0.15835 pd=1.395 as=0.26 ps=2.52 w=1 l=0.15
X11 VGND a_76_199# X VNB sky130_fd_pr__nfet_01v8 ad=0.11285 pd=1.045 as=0.169 ps=1.82 w=0.65 l=0.15
.ends

.subckt sky130_fd_sc_hd__dfrtp_1 CLK D RESET_B VGND VNB VPB VPWR Q
X0 a_805_47# a_761_289# a_639_47# VNB sky130_fd_pr__nfet_01v8 ad=0.0441 pd=0.63 as=0.1401 ps=1.1 w=0.42 l=0.15
X1 a_1217_47# a_27_47# a_1108_47# VNB sky130_fd_pr__special_nfet_01v8 ad=0.0669 pd=0.75 as=0.0711 ps=0.755 w=0.36 l=0.15
X2 a_1283_21# a_1108_47# a_1462_47# VNB sky130_fd_pr__nfet_01v8 ad=0.1092 pd=1.36 as=0.06405 ps=0.725 w=0.42 l=0.15
X3 a_651_413# a_27_47# a_543_47# VPB sky130_fd_pr__pfet_01v8_hvt ad=0.1155 pd=0.97 as=0.07245 ps=0.765 w=0.42 l=0.15
X4 a_1108_47# a_193_47# a_761_289# VNB sky130_fd_pr__special_nfet_01v8 ad=0.0711 pd=0.755 as=0.0999 ps=0.985 w=0.36 l=0.15
X5 VGND RESET_B a_805_47# VNB sky130_fd_pr__nfet_01v8 ad=0.1346 pd=1.15 as=0.0441 ps=0.63 w=0.42 l=0.15
X6 Q a_1283_21# VPWR VPB sky130_fd_pr__pfet_01v8_hvt ad=0.26 pd=2.52 as=0.3012 ps=2.66 w=1 l=0.15
X7 VPWR CLK a_27_47# VPB sky130_fd_pr__pfet_01v8_hvt ad=0.0864 pd=0.91 as=0.1664 ps=1.8 w=0.64 l=0.15
X8 a_448_47# D VPWR VPB sky130_fd_pr__pfet_01v8_hvt ad=0.0651 pd=0.73 as=0.1092 ps=1.36 w=0.42 l=0.15
X9 a_761_289# a_543_47# VGND VNB sky130_fd_pr__nfet_01v8 ad=0.0999 pd=0.985 as=0.1346 ps=1.15 w=0.64 l=0.15
X10 a_193_47# a_27_47# VGND VNB sky130_fd_pr__nfet_01v8 ad=0.1092 pd=1.36 as=0.0567 ps=0.69 w=0.42 l=0.15
X11 a_1108_47# a_27_47# a_761_289# VPB sky130_fd_pr__pfet_01v8_hvt ad=0.0588 pd=0.7 as=0.12915 ps=1.185 w=0.42 l=0.15
X12 a_1462_47# RESET_B VGND VNB sky130_fd_pr__nfet_01v8 ad=0.06405 pd=0.725 as=0.12495 ps=1.015 w=0.42 l=0.15
X13 a_543_47# a_27_47# a_448_47# VNB sky130_fd_pr__special_nfet_01v8 ad=0.0594 pd=0.69 as=0.066 ps=0.745 w=0.36 l=0.15
X14 a_543_47# a_193_47# a_448_47# VPB sky130_fd_pr__pfet_01v8_hvt ad=0.07245 pd=0.765 as=0.0651 ps=0.73 w=0.42 l=0.15
X15 a_448_47# D VGND VNB sky130_fd_pr__nfet_01v8 ad=0.066 pd=0.745 as=0.2205 ps=1.89 w=0.42 l=0.15
X16 VPWR a_1283_21# a_1270_413# VPB sky130_fd_pr__pfet_01v8_hvt ad=0.0819 pd=0.81 as=0.0567 ps=0.69 w=0.42 l=0.15
X17 VPWR a_1108_47# a_1283_21# VPB sky130_fd_pr__pfet_01v8_hvt ad=0.1134 pd=1.38 as=0.0567 ps=0.69 w=0.42 l=0.15
X18 a_1270_413# a_193_47# a_1108_47# VPB sky130_fd_pr__pfet_01v8_hvt ad=0.0567 pd=0.69 as=0.0588 ps=0.7 w=0.42 l=0.15
X19 a_193_47# a_27_47# VPWR VPB sky130_fd_pr__pfet_01v8_hvt ad=0.1664 pd=1.8 as=0.0864 ps=0.91 w=0.64 l=0.15
X20 a_1283_21# RESET_B VPWR VPB sky130_fd_pr__pfet_01v8_hvt ad=0.0567 pd=0.69 as=0.0819 ps=0.81 w=0.42 l=0.15
X21 VPWR a_761_289# a_651_413# VPB sky130_fd_pr__pfet_01v8_hvt ad=0.07035 pd=0.755 as=0.1155 ps=0.97 w=0.42 l=0.15
X22 Q a_1283_21# VGND VNB sky130_fd_pr__nfet_01v8 ad=0.169 pd=1.82 as=0.2087 ps=2.02 w=0.65 l=0.15
X23 a_639_47# a_193_47# a_543_47# VNB sky130_fd_pr__special_nfet_01v8 ad=0.1401 pd=1.1 as=0.0594 ps=0.69 w=0.36 l=0.15
X24 VGND a_1283_21# a_1217_47# VNB sky130_fd_pr__nfet_01v8 ad=0.12495 pd=1.015 as=0.0669 ps=0.75 w=0.42 l=0.15
X25 a_651_413# RESET_B VPWR VPB sky130_fd_pr__pfet_01v8_hvt ad=0.1092 pd=1.36 as=0.07035 ps=0.755 w=0.42 l=0.15
X26 VGND CLK a_27_47# VNB sky130_fd_pr__nfet_01v8 ad=0.0567 pd=0.69 as=0.1092 ps=1.36 w=0.42 l=0.15
X27 a_761_289# a_543_47# VPWR VPB sky130_fd_pr__pfet_01v8_hvt ad=0.12915 pd=1.185 as=0.2184 ps=2.2 w=0.84 l=0.15
.ends

.subckt sky130_fd_sc_hd__buf_2 A VGND VNB VPB VPWR X
X0 VPWR a_27_47# X VPB sky130_fd_pr__pfet_01v8_hvt ad=0.265 pd=2.53 as=0.135 ps=1.27 w=1 l=0.15
X1 X a_27_47# VPWR VPB sky130_fd_pr__pfet_01v8_hvt ad=0.135 pd=1.27 as=0.149 ps=1.325 w=1 l=0.15
X2 VPWR A a_27_47# VPB sky130_fd_pr__pfet_01v8_hvt ad=0.149 pd=1.325 as=0.1664 ps=1.8 w=0.64 l=0.15
X3 X a_27_47# VGND VNB sky130_fd_pr__nfet_01v8 ad=0.08775 pd=0.92 as=0.097 ps=0.975 w=0.65 l=0.15
X4 VGND a_27_47# X VNB sky130_fd_pr__nfet_01v8 ad=0.17225 pd=1.83 as=0.08775 ps=0.92 w=0.65 l=0.15
X5 VGND A a_27_47# VNB sky130_fd_pr__nfet_01v8 ad=0.097 pd=0.975 as=0.1092 ps=1.36 w=0.42 l=0.15
.ends

.subckt sky130_fd_sc_hd__nand2_1 A B VGND VNB VPB VPWR Y
X0 VPWR A Y VPB sky130_fd_pr__pfet_01v8_hvt ad=0.26 pd=2.52 as=0.135 ps=1.27 w=1 l=0.15
X1 Y A a_113_47# VNB sky130_fd_pr__nfet_01v8 ad=0.169 pd=1.82 as=0.08775 ps=0.92 w=0.65 l=0.15
X2 a_113_47# B VGND VNB sky130_fd_pr__nfet_01v8 ad=0.08775 pd=0.92 as=0.169 ps=1.82 w=0.65 l=0.15
X3 Y B VPWR VPB sky130_fd_pr__pfet_01v8_hvt ad=0.135 pd=1.27 as=0.26 ps=2.52 w=1 l=0.15
.ends

.subckt sky130_fd_sc_hd__a2bb2o_1 A1_N A2_N B1 B2 VGND VNB VPB VPWR X
X0 a_226_47# A2_N a_226_297# VPB sky130_fd_pr__pfet_01v8_hvt ad=0.1113 pd=1.37 as=0.0441 ps=0.63 w=0.42 l=0.15
X1 a_489_413# B1 VPWR VPB sky130_fd_pr__pfet_01v8_hvt ad=0.1092 pd=1.36 as=0.0567 ps=0.69 w=0.42 l=0.15
X2 a_226_297# A1_N VPWR VPB sky130_fd_pr__pfet_01v8_hvt ad=0.0441 pd=0.63 as=0.16675 ps=1.435 w=0.42 l=0.15
X3 VPWR B2 a_489_413# VPB sky130_fd_pr__pfet_01v8_hvt ad=0.0567 pd=0.69 as=0.0567 ps=0.69 w=0.42 l=0.15
X4 a_489_413# a_226_47# a_76_199# VPB sky130_fd_pr__pfet_01v8_hvt ad=0.0567 pd=0.69 as=0.1092 ps=1.36 w=0.42 l=0.15
X5 a_76_199# a_226_47# VGND VNB sky130_fd_pr__nfet_01v8 ad=0.0567 pd=0.69 as=0.1386 ps=1.08 w=0.42 l=0.15
X6 VGND B1 a_556_47# VNB sky130_fd_pr__nfet_01v8 ad=0.1092 pd=1.36 as=0.0567 ps=0.69 w=0.42 l=0.15
X7 a_556_47# B2 a_76_199# VNB sky130_fd_pr__nfet_01v8 ad=0.0567 pd=0.69 as=0.0567 ps=0.69 w=0.42 l=0.15
X8 VGND A2_N a_226_47# VNB sky130_fd_pr__nfet_01v8 ad=0.1386 pd=1.08 as=0.0567 ps=0.69 w=0.42 l=0.15
X9 a_226_47# A1_N VGND VNB sky130_fd_pr__nfet_01v8 ad=0.0567 pd=0.69 as=0.1201 ps=1.085 w=0.42 l=0.15
X10 VPWR a_76_199# X VPB sky130_fd_pr__pfet_01v8_hvt ad=0.16675 pd=1.435 as=0.26 ps=2.52 w=1 l=0.15
X11 VGND a_76_199# X VNB sky130_fd_pr__nfet_01v8 ad=0.1201 pd=1.085 as=0.169 ps=1.82 w=0.65 l=0.15
.ends

.subckt sky130_fd_sc_hd__and2b_1 A_N B VGND VNB VPB VPWR X
X0 VPWR B a_207_413# VPB sky130_fd_pr__pfet_01v8_hvt ad=0.2279 pd=1.74 as=0.0609 ps=0.71 w=0.42 l=0.15
X1 X a_207_413# VPWR VPB sky130_fd_pr__pfet_01v8_hvt ad=0.26 pd=2.52 as=0.2279 ps=1.74 w=1 l=0.15
X2 a_297_47# a_27_413# a_207_413# VNB sky130_fd_pr__nfet_01v8 ad=0.0504 pd=0.66 as=0.1092 ps=1.36 w=0.42 l=0.15
X3 X a_207_413# VGND VNB sky130_fd_pr__nfet_01v8 ad=0.169 pd=1.82 as=0.1013 ps=0.99 w=0.65 l=0.15
X4 a_207_413# a_27_413# VPWR VPB sky130_fd_pr__pfet_01v8_hvt ad=0.0609 pd=0.71 as=0.0714 ps=0.76 w=0.42 l=0.15
X5 VPWR A_N a_27_413# VPB sky130_fd_pr__pfet_01v8_hvt ad=0.0714 pd=0.76 as=0.1092 ps=1.36 w=0.42 l=0.15
X6 VGND B a_297_47# VNB sky130_fd_pr__nfet_01v8 ad=0.1013 pd=0.99 as=0.0504 ps=0.66 w=0.42 l=0.15
X7 a_27_413# A_N VGND VNB sky130_fd_pr__nfet_01v8 ad=0.1092 pd=1.36 as=0.1092 ps=1.36 w=0.42 l=0.15
.ends

.subckt sky130_fd_sc_hd__inv_2 A VGND VNB VPB VPWR Y
X0 Y A VPWR VPB sky130_fd_pr__pfet_01v8_hvt ad=0.135 pd=1.27 as=0.26 ps=2.52 w=1 l=0.15
X1 VGND A Y VNB sky130_fd_pr__nfet_01v8 ad=0.169 pd=1.82 as=0.08775 ps=0.92 w=0.65 l=0.15
X2 Y A VGND VNB sky130_fd_pr__nfet_01v8 ad=0.08775 pd=0.92 as=0.169 ps=1.82 w=0.65 l=0.15
X3 VPWR A Y VPB sky130_fd_pr__pfet_01v8_hvt ad=0.26 pd=2.52 as=0.135 ps=1.27 w=1 l=0.15
.ends

.subckt sky130_fd_sc_hd__a221o_1 A1 A2 B1 B2 C1 VGND VNB VPB VPWR X
X0 a_465_47# A1 a_27_47# VNB sky130_fd_pr__nfet_01v8 ad=0.10725 pd=0.98 as=0.169 ps=1.82 w=0.65 l=0.15
X1 X a_27_47# VPWR VPB sky130_fd_pr__pfet_01v8_hvt ad=0.26 pd=2.52 as=0.1575 ps=1.315 w=1 l=0.15
X2 a_109_297# B1 a_193_297# VPB sky130_fd_pr__pfet_01v8_hvt ad=0.26 pd=2.52 as=0.135 ps=1.27 w=1 l=0.15
X3 a_193_297# B2 a_109_297# VPB sky130_fd_pr__pfet_01v8_hvt ad=0.135 pd=1.27 as=0.135 ps=1.27 w=1 l=0.15
X4 X a_27_47# VGND VNB sky130_fd_pr__nfet_01v8 ad=0.169 pd=1.82 as=0.10238 ps=0.965 w=0.65 l=0.15
X5 a_205_47# B2 VGND VNB sky130_fd_pr__nfet_01v8 ad=0.06825 pd=0.86 as=0.10725 ps=0.98 w=0.65 l=0.15
X6 VPWR A2 a_193_297# VPB sky130_fd_pr__pfet_01v8_hvt ad=0.1575 pd=1.315 as=0.165 ps=1.33 w=1 l=0.15
X7 a_193_297# A1 VPWR VPB sky130_fd_pr__pfet_01v8_hvt ad=0.165 pd=1.33 as=0.26 ps=2.52 w=1 l=0.15
X8 a_27_47# B1 a_205_47# VNB sky130_fd_pr__nfet_01v8 ad=0.169 pd=1.82 as=0.06825 ps=0.86 w=0.65 l=0.15
X9 a_109_297# C1 a_27_47# VPB sky130_fd_pr__pfet_01v8_hvt ad=0.135 pd=1.27 as=0.26 ps=2.52 w=1 l=0.15
X10 VGND C1 a_27_47# VNB sky130_fd_pr__nfet_01v8 ad=0.10725 pd=0.98 as=0.169 ps=1.82 w=0.65 l=0.15
X11 VGND A2 a_465_47# VNB sky130_fd_pr__nfet_01v8 ad=0.10238 pd=0.965 as=0.10725 ps=0.98 w=0.65 l=0.15
.ends

.subckt sky130_fd_sc_hd__nand3_4 A B C VGND VNB VPB VPWR Y
X0 a_27_47# B a_445_47# VNB sky130_fd_pr__nfet_01v8 ad=0.08775 pd=0.92 as=0.08775 ps=0.92 w=0.65 l=0.15
X1 a_27_47# B a_445_47# VNB sky130_fd_pr__nfet_01v8 ad=0.169 pd=1.82 as=0.08775 ps=0.92 w=0.65 l=0.15
X2 Y B VPWR VPB sky130_fd_pr__pfet_01v8_hvt ad=0.135 pd=1.27 as=0.135 ps=1.27 w=1 l=0.15
X3 VPWR C Y VPB sky130_fd_pr__pfet_01v8_hvt ad=0.135 pd=1.27 as=0.135 ps=1.27 w=1 l=0.15
X4 Y A a_445_47# VNB sky130_fd_pr__nfet_01v8 ad=0.08775 pd=0.92 as=0.08775 ps=0.92 w=0.65 l=0.15
X5 Y C VPWR VPB sky130_fd_pr__pfet_01v8_hvt ad=0.135 pd=1.27 as=0.135 ps=1.27 w=1 l=0.15
X6 Y A a_445_47# VNB sky130_fd_pr__nfet_01v8 ad=0.08775 pd=0.92 as=0.169 ps=1.82 w=0.65 l=0.15
X7 VPWR C Y VPB sky130_fd_pr__pfet_01v8_hvt ad=0.135 pd=1.27 as=0.135 ps=1.27 w=1 l=0.15
X8 a_27_47# C VGND VNB sky130_fd_pr__nfet_01v8 ad=0.08775 pd=0.92 as=0.08775 ps=0.92 w=0.65 l=0.15
X9 a_27_47# C VGND VNB sky130_fd_pr__nfet_01v8 ad=0.08775 pd=0.92 as=0.08775 ps=0.92 w=0.65 l=0.15
X10 a_445_47# A Y VNB sky130_fd_pr__nfet_01v8 ad=0.1755 pd=1.84 as=0.08775 ps=0.92 w=0.65 l=0.15
X11 VPWR B Y VPB sky130_fd_pr__pfet_01v8_hvt ad=0.26 pd=2.52 as=0.135 ps=1.27 w=1 l=0.15
X12 a_445_47# A Y VNB sky130_fd_pr__nfet_01v8 ad=0.08775 pd=0.92 as=0.08775 ps=0.92 w=0.65 l=0.15
X13 VGND C a_27_47# VNB sky130_fd_pr__nfet_01v8 ad=0.08775 pd=0.92 as=0.08775 ps=0.92 w=0.65 l=0.15
X14 a_445_47# B a_27_47# VNB sky130_fd_pr__nfet_01v8 ad=0.08775 pd=0.92 as=0.08775 ps=0.92 w=0.65 l=0.15
X15 Y B VPWR VPB sky130_fd_pr__pfet_01v8_hvt ad=0.135 pd=1.27 as=0.135 ps=1.27 w=1 l=0.15
X16 VPWR A Y VPB sky130_fd_pr__pfet_01v8_hvt ad=0.27 pd=2.54 as=0.135 ps=1.27 w=1 l=0.15
X17 a_445_47# B a_27_47# VNB sky130_fd_pr__nfet_01v8 ad=0.08775 pd=0.92 as=0.08775 ps=0.92 w=0.65 l=0.15
X18 VPWR B Y VPB sky130_fd_pr__pfet_01v8_hvt ad=0.135 pd=1.27 as=0.135 ps=1.27 w=1 l=0.15
X19 Y A VPWR VPB sky130_fd_pr__pfet_01v8_hvt ad=0.135 pd=1.27 as=0.135 ps=1.27 w=1 l=0.15
X20 VPWR A Y VPB sky130_fd_pr__pfet_01v8_hvt ad=0.135 pd=1.27 as=0.135 ps=1.27 w=1 l=0.15
X21 Y C VPWR VPB sky130_fd_pr__pfet_01v8_hvt ad=0.135 pd=1.27 as=0.26 ps=2.52 w=1 l=0.15
X22 Y A VPWR VPB sky130_fd_pr__pfet_01v8_hvt ad=0.135 pd=1.27 as=0.26 ps=2.52 w=1 l=0.15
X23 VGND C a_27_47# VNB sky130_fd_pr__nfet_01v8 ad=0.08775 pd=0.92 as=0.169 ps=1.82 w=0.65 l=0.15
.ends

.subckt sky130_fd_sc_hd__dfxtp_2 CLK D VGND VNB VPB VPWR Q
X0 Q a_1059_315# VGND VNB sky130_fd_pr__nfet_01v8 ad=0.08775 pd=0.92 as=0.08775 ps=0.92 w=0.65 l=0.15
X1 VPWR a_1059_315# Q VPB sky130_fd_pr__pfet_01v8_hvt ad=0.26 pd=2.52 as=0.135 ps=1.27 w=1 l=0.15
X2 a_891_413# a_193_47# a_634_159# VNB sky130_fd_pr__special_nfet_01v8 ad=0.0684 pd=0.74 as=0.0989 ps=0.995 w=0.36 l=0.15
X3 a_561_413# a_27_47# a_466_413# VPB sky130_fd_pr__pfet_01v8_hvt ad=0.07665 pd=0.785 as=0.06825 ps=0.745 w=0.42 l=0.15
X4 VPWR CLK a_27_47# VPB sky130_fd_pr__pfet_01v8_hvt ad=0.0864 pd=0.91 as=0.1664 ps=1.8 w=0.64 l=0.15
X5 Q a_1059_315# VPWR VPB sky130_fd_pr__pfet_01v8_hvt ad=0.135 pd=1.27 as=0.135 ps=1.27 w=1 l=0.15
X6 a_381_47# D VPWR VPB sky130_fd_pr__pfet_01v8_hvt ad=0.05775 pd=0.695 as=0.1092 ps=1.36 w=0.42 l=0.15
X7 VGND a_634_159# a_592_47# VNB sky130_fd_pr__nfet_01v8 ad=0.12095 pd=1.085 as=0.0696 ps=0.765 w=0.42 l=0.15
X8 VGND a_1059_315# Q VNB sky130_fd_pr__nfet_01v8 ad=0.169 pd=1.82 as=0.08775 ps=0.92 w=0.65 l=0.15
X9 VPWR a_891_413# a_1059_315# VPB sky130_fd_pr__pfet_01v8_hvt ad=0.135 pd=1.27 as=0.27 ps=2.54 w=1 l=0.15
X10 a_466_413# a_193_47# a_381_47# VPB sky130_fd_pr__pfet_01v8_hvt ad=0.06825 pd=0.745 as=0.05775 ps=0.695 w=0.42 l=0.15
X11 VPWR a_634_159# a_561_413# VPB sky130_fd_pr__pfet_01v8_hvt ad=0.17887 pd=1.26 as=0.07665 ps=0.785 w=0.42 l=0.15
X12 a_634_159# a_466_413# VGND VNB sky130_fd_pr__nfet_01v8 ad=0.0989 pd=0.995 as=0.12095 ps=1.085 w=0.64 l=0.15
X13 a_634_159# a_466_413# VPWR VPB sky130_fd_pr__pfet_01v8_hvt ad=0.1095 pd=1.075 as=0.17887 ps=1.26 w=0.75 l=0.15
X14 a_975_413# a_193_47# a_891_413# VPB sky130_fd_pr__pfet_01v8_hvt ad=0.0882 pd=0.84 as=0.0567 ps=0.69 w=0.42 l=0.15
X15 VGND a_1059_315# a_1017_47# VNB sky130_fd_pr__nfet_01v8 ad=0.1092 pd=1.36 as=0.066 ps=0.745 w=0.42 l=0.15
X16 a_193_47# a_27_47# VGND VNB sky130_fd_pr__nfet_01v8 ad=0.1092 pd=1.36 as=0.0567 ps=0.69 w=0.42 l=0.15
X17 a_891_413# a_27_47# a_634_159# VPB sky130_fd_pr__pfet_01v8_hvt ad=0.0567 pd=0.69 as=0.1095 ps=1.075 w=0.42 l=0.15
X18 a_592_47# a_193_47# a_466_413# VNB sky130_fd_pr__special_nfet_01v8 ad=0.0696 pd=0.765 as=0.0621 ps=0.705 w=0.36 l=0.15
X19 VPWR a_1059_315# a_975_413# VPB sky130_fd_pr__pfet_01v8_hvt ad=0.1113 pd=1.37 as=0.0882 ps=0.84 w=0.42 l=0.15
X20 a_1017_47# a_27_47# a_891_413# VNB sky130_fd_pr__special_nfet_01v8 ad=0.066 pd=0.745 as=0.0684 ps=0.74 w=0.36 l=0.15
X21 a_193_47# a_27_47# VPWR VPB sky130_fd_pr__pfet_01v8_hvt ad=0.1664 pd=1.8 as=0.0864 ps=0.91 w=0.64 l=0.15
X22 a_466_413# a_27_47# a_381_47# VNB sky130_fd_pr__special_nfet_01v8 ad=0.0621 pd=0.705 as=0.0813 ps=0.83 w=0.36 l=0.15
X23 VGND a_891_413# a_1059_315# VNB sky130_fd_pr__nfet_01v8 ad=0.08775 pd=0.92 as=0.169 ps=1.82 w=0.65 l=0.15
X24 a_381_47# D VGND VNB sky130_fd_pr__nfet_01v8 ad=0.0813 pd=0.83 as=0.1092 ps=1.36 w=0.42 l=0.15
X25 VGND CLK a_27_47# VNB sky130_fd_pr__nfet_01v8 ad=0.0567 pd=0.69 as=0.1092 ps=1.36 w=0.42 l=0.15
.ends

.subckt sky130_fd_sc_hd__a22o_1 A1 A2 B1 B2 VGND VNB VPB VPWR X
X0 VPWR A2 a_109_297# VPB sky130_fd_pr__pfet_01v8_hvt ad=0.155 pd=1.31 as=0.16 ps=1.32 w=1 l=0.15
X1 a_27_297# B1 a_109_47# VNB sky130_fd_pr__nfet_01v8 ad=0.169 pd=1.82 as=0.07475 ps=0.88 w=0.65 l=0.15
X2 VGND A2 a_373_47# VNB sky130_fd_pr__nfet_01v8 ad=0.10075 pd=0.96 as=0.11375 ps=1 w=0.65 l=0.15
X3 X a_27_297# VPWR VPB sky130_fd_pr__pfet_01v8_hvt ad=0.26 pd=2.52 as=0.155 ps=1.31 w=1 l=0.15
X4 a_27_297# B1 a_109_297# VPB sky130_fd_pr__pfet_01v8_hvt ad=0.25285 pd=2.52 as=0.135 ps=1.27 w=1 l=0.15
X5 a_109_297# A1 VPWR VPB sky130_fd_pr__pfet_01v8_hvt ad=0.16 pd=1.32 as=0.2529 ps=2.52 w=1 l=0.15
X6 a_373_47# A1 a_27_297# VNB sky130_fd_pr__nfet_01v8 ad=0.11375 pd=1 as=0.169 ps=1.82 w=0.65 l=0.15
X7 X a_27_297# VGND VNB sky130_fd_pr__nfet_01v8 ad=0.169 pd=1.82 as=0.10075 ps=0.96 w=0.65 l=0.15
X8 a_109_297# B2 a_27_297# VPB sky130_fd_pr__pfet_01v8_hvt ad=0.135 pd=1.27 as=0.26 ps=2.52 w=1 l=0.15
X9 a_109_47# B2 VGND VNB sky130_fd_pr__nfet_01v8 ad=0.07475 pd=0.88 as=0.169 ps=1.82 w=0.65 l=0.15
.ends

.subckt sky130_fd_sc_hd__a21boi_1 A1 A2 B1_N VGND VNB VPB VPWR Y
X0 a_300_297# a_27_413# Y VPB sky130_fd_pr__pfet_01v8_hvt ad=0.14 pd=1.28 as=0.265 ps=2.53 w=1 l=0.15
X1 VGND A2 a_384_47# VNB sky130_fd_pr__nfet_01v8 ad=0.17225 pd=1.83 as=0.091 ps=0.93 w=0.65 l=0.15
X2 VPWR B1_N a_27_413# VPB sky130_fd_pr__pfet_01v8_hvt ad=0.1113 pd=1.37 as=0.1113 ps=1.37 w=0.42 l=0.15
X3 Y a_27_413# VGND VNB sky130_fd_pr__nfet_01v8 ad=0.143 pd=1.09 as=0.10187 ps=0.99 w=0.65 l=0.15
X4 VPWR A1 a_300_297# VPB sky130_fd_pr__pfet_01v8_hvt ad=0.14 pd=1.28 as=0.14 ps=1.28 w=1 l=0.15
X5 a_384_47# A1 Y VNB sky130_fd_pr__nfet_01v8 ad=0.091 pd=0.93 as=0.143 ps=1.09 w=0.65 l=0.15
X6 VGND B1_N a_27_413# VNB sky130_fd_pr__nfet_01v8 ad=0.10187 pd=0.99 as=0.1113 ps=1.37 w=0.42 l=0.15
X7 a_300_297# A2 VPWR VPB sky130_fd_pr__pfet_01v8_hvt ad=0.265 pd=2.53 as=0.14 ps=1.28 w=1 l=0.15
.ends

.subckt sky130_fd_sc_hd__dlygate4sd3_1 A VGND VNB VPB VPWR X
X0 VPWR A a_49_47# VPB sky130_fd_pr__pfet_01v8_hvt ad=0.0567 pd=0.69 as=0.1092 ps=1.36 w=0.42 l=0.15
X1 VGND a_285_47# a_391_47# VNB sky130_fd_pr__nfet_01v8 ad=0.097 pd=0.975 as=0.1092 ps=1.36 w=0.42 l=0.5
X2 X a_391_47# VPWR VPB sky130_fd_pr__pfet_01v8_hvt ad=0.26 pd=2.52 as=0.14075 ps=1.325 w=1 l=0.15
X3 VGND A a_49_47# VNB sky130_fd_pr__nfet_01v8 ad=0.0567 pd=0.69 as=0.1092 ps=1.36 w=0.42 l=0.15
X4 VPWR a_285_47# a_391_47# VPB sky130_fd_pr__pfet_01v8_hvt ad=0.14075 pd=1.325 as=0.1092 ps=1.36 w=0.42 l=0.5
X5 a_285_47# a_49_47# VGND VNB sky130_fd_pr__nfet_01v8 ad=0.1092 pd=1.36 as=0.0567 ps=0.69 w=0.42 l=0.5
X6 a_285_47# a_49_47# VPWR VPB sky130_fd_pr__pfet_01v8_hvt ad=0.1092 pd=1.36 as=0.0567 ps=0.69 w=0.42 l=0.5
X7 X a_391_47# VGND VNB sky130_fd_pr__nfet_01v8 ad=0.169 pd=1.82 as=0.097 ps=0.975 w=0.65 l=0.15
.ends

.subckt sky130_fd_sc_hd__or2_1 A B VGND VNB VPB VPWR X
X0 VGND A a_68_297# VNB sky130_fd_pr__nfet_01v8 ad=0.10025 pd=0.985 as=0.0567 ps=0.69 w=0.42 l=0.15
X1 a_68_297# B VGND VNB sky130_fd_pr__nfet_01v8 ad=0.0567 pd=0.69 as=0.1092 ps=1.36 w=0.42 l=0.15
X2 X a_68_297# VGND VNB sky130_fd_pr__nfet_01v8 ad=0.169 pd=1.82 as=0.10025 ps=0.985 w=0.65 l=0.15
X3 VPWR A a_150_297# VPB sky130_fd_pr__pfet_01v8_hvt ad=0.14575 pd=1.335 as=0.0441 ps=0.63 w=0.42 l=0.15
X4 X a_68_297# VPWR VPB sky130_fd_pr__pfet_01v8_hvt ad=0.34 pd=2.68 as=0.14575 ps=1.335 w=1 l=0.15
X5 a_150_297# B a_68_297# VPB sky130_fd_pr__pfet_01v8_hvt ad=0.0441 pd=0.63 as=0.1092 ps=1.36 w=0.42 l=0.15
.ends

.subckt sky130_fd_sc_hd__dfrtp_4 CLK D RESET_B VGND VNB VPB VPWR Q
X0 a_805_47# a_761_289# a_639_47# VNB sky130_fd_pr__nfet_01v8 ad=0.0441 pd=0.63 as=0.1401 ps=1.1 w=0.42 l=0.15
X1 a_1217_47# a_27_47# a_1108_47# VNB sky130_fd_pr__special_nfet_01v8 ad=0.0669 pd=0.75 as=0.0711 ps=0.755 w=0.36 l=0.15
X2 a_1283_21# a_1108_47# a_1462_47# VNB sky130_fd_pr__nfet_01v8 ad=0.1092 pd=1.36 as=0.06405 ps=0.725 w=0.42 l=0.15
X3 a_651_413# a_27_47# a_543_47# VPB sky130_fd_pr__pfet_01v8_hvt ad=0.1155 pd=0.97 as=0.07245 ps=0.765 w=0.42 l=0.15
X4 a_1108_47# a_193_47# a_761_289# VNB sky130_fd_pr__special_nfet_01v8 ad=0.0711 pd=0.755 as=0.0999 ps=0.985 w=0.36 l=0.15
X5 VGND RESET_B a_805_47# VNB sky130_fd_pr__nfet_01v8 ad=0.1346 pd=1.15 as=0.0441 ps=0.63 w=0.42 l=0.15
X6 VPWR a_1283_21# Q VPB sky130_fd_pr__pfet_01v8_hvt ad=0.305 pd=2.61 as=0.135 ps=1.27 w=1 l=0.15
X7 VPWR CLK a_27_47# VPB sky130_fd_pr__pfet_01v8_hvt ad=0.0864 pd=0.91 as=0.1664 ps=1.8 w=0.64 l=0.15
X8 a_448_47# D VPWR VPB sky130_fd_pr__pfet_01v8_hvt ad=0.0651 pd=0.73 as=0.1092 ps=1.36 w=0.42 l=0.15
X9 Q a_1283_21# VPWR VPB sky130_fd_pr__pfet_01v8_hvt ad=0.135 pd=1.27 as=0.135 ps=1.27 w=1 l=0.15
X10 VPWR a_1283_21# Q VPB sky130_fd_pr__pfet_01v8_hvt ad=0.135 pd=1.27 as=0.135 ps=1.27 w=1 l=0.15
X11 a_761_289# a_543_47# VGND VNB sky130_fd_pr__nfet_01v8 ad=0.0999 pd=0.985 as=0.1346 ps=1.15 w=0.64 l=0.15
X12 Q a_1283_21# VGND VNB sky130_fd_pr__nfet_01v8 ad=0.08775 pd=0.92 as=0.169 ps=1.82 w=0.65 l=0.15
X13 a_193_47# a_27_47# VGND VNB sky130_fd_pr__nfet_01v8 ad=0.1092 pd=1.36 as=0.0567 ps=0.69 w=0.42 l=0.15
X14 a_1108_47# a_27_47# a_761_289# VPB sky130_fd_pr__pfet_01v8_hvt ad=0.0588 pd=0.7 as=0.12915 ps=1.185 w=0.42 l=0.15
X15 a_1462_47# RESET_B VGND VNB sky130_fd_pr__nfet_01v8 ad=0.06405 pd=0.725 as=0.12495 ps=1.015 w=0.42 l=0.15
X16 a_543_47# a_27_47# a_448_47# VNB sky130_fd_pr__special_nfet_01v8 ad=0.0594 pd=0.69 as=0.066 ps=0.745 w=0.36 l=0.15
X17 a_543_47# a_193_47# a_448_47# VPB sky130_fd_pr__pfet_01v8_hvt ad=0.07245 pd=0.765 as=0.0651 ps=0.73 w=0.42 l=0.15
X18 a_448_47# D VGND VNB sky130_fd_pr__nfet_01v8 ad=0.066 pd=0.745 as=0.2205 ps=1.89 w=0.42 l=0.15
X19 VPWR a_1283_21# a_1270_413# VPB sky130_fd_pr__pfet_01v8_hvt ad=0.0819 pd=0.81 as=0.0567 ps=0.69 w=0.42 l=0.15
X20 VPWR a_1108_47# a_1283_21# VPB sky130_fd_pr__pfet_01v8_hvt ad=0.1134 pd=1.38 as=0.0567 ps=0.69 w=0.42 l=0.15
X21 Q a_1283_21# VPWR VPB sky130_fd_pr__pfet_01v8_hvt ad=0.135 pd=1.27 as=0.26 ps=2.52 w=1 l=0.15
X22 a_1270_413# a_193_47# a_1108_47# VPB sky130_fd_pr__pfet_01v8_hvt ad=0.0567 pd=0.69 as=0.0588 ps=0.7 w=0.42 l=0.15
X23 a_193_47# a_27_47# VPWR VPB sky130_fd_pr__pfet_01v8_hvt ad=0.1664 pd=1.8 as=0.0864 ps=0.91 w=0.64 l=0.15
X24 a_1283_21# RESET_B VPWR VPB sky130_fd_pr__pfet_01v8_hvt ad=0.0567 pd=0.69 as=0.0819 ps=0.81 w=0.42 l=0.15
X25 VGND a_1283_21# Q VNB sky130_fd_pr__nfet_01v8 ad=0.08775 pd=0.92 as=0.08775 ps=0.92 w=0.65 l=0.15
X26 VGND a_1283_21# Q VNB sky130_fd_pr__nfet_01v8 ad=0.182 pd=1.86 as=0.08775 ps=0.92 w=0.65 l=0.15
X27 VPWR a_761_289# a_651_413# VPB sky130_fd_pr__pfet_01v8_hvt ad=0.07035 pd=0.755 as=0.1155 ps=0.97 w=0.42 l=0.15
X28 a_639_47# a_193_47# a_543_47# VNB sky130_fd_pr__special_nfet_01v8 ad=0.1401 pd=1.1 as=0.0594 ps=0.69 w=0.36 l=0.15
X29 VGND a_1283_21# a_1217_47# VNB sky130_fd_pr__nfet_01v8 ad=0.12495 pd=1.015 as=0.0669 ps=0.75 w=0.42 l=0.15
X30 a_651_413# RESET_B VPWR VPB sky130_fd_pr__pfet_01v8_hvt ad=0.1092 pd=1.36 as=0.07035 ps=0.755 w=0.42 l=0.15
X31 VGND CLK a_27_47# VNB sky130_fd_pr__nfet_01v8 ad=0.0567 pd=0.69 as=0.1092 ps=1.36 w=0.42 l=0.15
X32 a_761_289# a_543_47# VPWR VPB sky130_fd_pr__pfet_01v8_hvt ad=0.12915 pd=1.185 as=0.2184 ps=2.2 w=0.84 l=0.15
X33 Q a_1283_21# VGND VNB sky130_fd_pr__nfet_01v8 ad=0.08775 pd=0.92 as=0.08775 ps=0.92 w=0.65 l=0.15
C0 VPB VNB 2.1109f
.ends

.subckt sky130_fd_sc_hd__decap_6 VGND VNB VPB VPWR
X0 VPWR VGND VPWR VPB sky130_fd_pr__pfet_01v8_hvt ad=0.2262 pd=2.26 as=0.4524 ps=4.52 w=0.87 l=1.97
X1 VGND VPWR VGND VNB sky130_fd_pr__nfet_01v8 ad=0.143 pd=1.62 as=0.286 ps=3.24 w=0.55 l=1.97
.ends

.subckt sky130_fd_sc_hd__dfxtp_1 CLK D VGND VNB VPB VPWR Q
X0 Q a_1059_315# VGND VNB sky130_fd_pr__nfet_01v8 ad=0.169 pd=1.82 as=0.08775 ps=0.92 w=0.65 l=0.15
X1 a_891_413# a_193_47# a_634_159# VNB sky130_fd_pr__special_nfet_01v8 ad=0.0684 pd=0.74 as=0.0989 ps=0.995 w=0.36 l=0.15
X2 a_561_413# a_27_47# a_466_413# VPB sky130_fd_pr__pfet_01v8_hvt ad=0.07665 pd=0.785 as=0.06825 ps=0.745 w=0.42 l=0.15
X3 VPWR CLK a_27_47# VPB sky130_fd_pr__pfet_01v8_hvt ad=0.0864 pd=0.91 as=0.1664 ps=1.8 w=0.64 l=0.15
X4 Q a_1059_315# VPWR VPB sky130_fd_pr__pfet_01v8_hvt ad=0.26 pd=2.52 as=0.135 ps=1.27 w=1 l=0.15
X5 a_381_47# D VPWR VPB sky130_fd_pr__pfet_01v8_hvt ad=0.05775 pd=0.695 as=0.1092 ps=1.36 w=0.42 l=0.15
X6 VGND a_634_159# a_592_47# VNB sky130_fd_pr__nfet_01v8 ad=0.12095 pd=1.085 as=0.0696 ps=0.765 w=0.42 l=0.15
X7 VPWR a_891_413# a_1059_315# VPB sky130_fd_pr__pfet_01v8_hvt ad=0.135 pd=1.27 as=0.27 ps=2.54 w=1 l=0.15
X8 a_466_413# a_193_47# a_381_47# VPB sky130_fd_pr__pfet_01v8_hvt ad=0.06825 pd=0.745 as=0.05775 ps=0.695 w=0.42 l=0.15
X9 VPWR a_634_159# a_561_413# VPB sky130_fd_pr__pfet_01v8_hvt ad=0.17887 pd=1.26 as=0.07665 ps=0.785 w=0.42 l=0.15
X10 a_634_159# a_466_413# VGND VNB sky130_fd_pr__nfet_01v8 ad=0.0989 pd=0.995 as=0.12095 ps=1.085 w=0.64 l=0.15
X11 a_634_159# a_466_413# VPWR VPB sky130_fd_pr__pfet_01v8_hvt ad=0.1095 pd=1.075 as=0.17887 ps=1.26 w=0.75 l=0.15
X12 a_975_413# a_193_47# a_891_413# VPB sky130_fd_pr__pfet_01v8_hvt ad=0.0882 pd=0.84 as=0.0567 ps=0.69 w=0.42 l=0.15
X13 VGND a_1059_315# a_1017_47# VNB sky130_fd_pr__nfet_01v8 ad=0.1092 pd=1.36 as=0.066 ps=0.745 w=0.42 l=0.15
X14 a_193_47# a_27_47# VGND VNB sky130_fd_pr__nfet_01v8 ad=0.1092 pd=1.36 as=0.0567 ps=0.69 w=0.42 l=0.15
X15 a_891_413# a_27_47# a_634_159# VPB sky130_fd_pr__pfet_01v8_hvt ad=0.0567 pd=0.69 as=0.1095 ps=1.075 w=0.42 l=0.15
X16 a_592_47# a_193_47# a_466_413# VNB sky130_fd_pr__special_nfet_01v8 ad=0.0696 pd=0.765 as=0.0621 ps=0.705 w=0.36 l=0.15
X17 VPWR a_1059_315# a_975_413# VPB sky130_fd_pr__pfet_01v8_hvt ad=0.1113 pd=1.37 as=0.0882 ps=0.84 w=0.42 l=0.15
X18 a_1017_47# a_27_47# a_891_413# VNB sky130_fd_pr__special_nfet_01v8 ad=0.066 pd=0.745 as=0.0684 ps=0.74 w=0.36 l=0.15
X19 a_193_47# a_27_47# VPWR VPB sky130_fd_pr__pfet_01v8_hvt ad=0.1664 pd=1.8 as=0.0864 ps=0.91 w=0.64 l=0.15
X20 a_466_413# a_27_47# a_381_47# VNB sky130_fd_pr__special_nfet_01v8 ad=0.0621 pd=0.705 as=0.0813 ps=0.83 w=0.36 l=0.15
X21 VGND a_891_413# a_1059_315# VNB sky130_fd_pr__nfet_01v8 ad=0.08775 pd=0.92 as=0.169 ps=1.82 w=0.65 l=0.15
X22 a_381_47# D VGND VNB sky130_fd_pr__nfet_01v8 ad=0.0813 pd=0.83 as=0.1092 ps=1.36 w=0.42 l=0.15
X23 VGND CLK a_27_47# VNB sky130_fd_pr__nfet_01v8 ad=0.0567 pd=0.69 as=0.1092 ps=1.36 w=0.42 l=0.15
.ends

.subckt sky130_fd_sc_hd__clkbuf_4 A VGND VNB VPB VPWR X
X0 VPWR A a_27_47# VPB sky130_fd_pr__pfet_01v8_hvt ad=0.165 pd=1.33 as=0.265 ps=2.53 w=1 l=0.15
X1 VGND a_27_47# X VNB sky130_fd_pr__nfet_01v8 ad=0.1218 pd=1.42 as=0.0588 ps=0.7 w=0.42 l=0.15
X2 VGND a_27_47# X VNB sky130_fd_pr__nfet_01v8 ad=0.0588 pd=0.7 as=0.0588 ps=0.7 w=0.42 l=0.15
X3 X a_27_47# VPWR VPB sky130_fd_pr__pfet_01v8_hvt ad=0.14 pd=1.28 as=0.14 ps=1.28 w=1 l=0.15
X4 X a_27_47# VGND VNB sky130_fd_pr__nfet_01v8 ad=0.0588 pd=0.7 as=0.0588 ps=0.7 w=0.42 l=0.15
X5 VGND A a_27_47# VNB sky130_fd_pr__nfet_01v8 ad=0.07035 pd=0.755 as=0.1113 ps=1.37 w=0.42 l=0.15
X6 VPWR a_27_47# X VPB sky130_fd_pr__pfet_01v8_hvt ad=0.3 pd=2.6 as=0.14 ps=1.28 w=1 l=0.15
X7 X a_27_47# VGND VNB sky130_fd_pr__nfet_01v8 ad=0.0588 pd=0.7 as=0.07035 ps=0.755 w=0.42 l=0.15
X8 X a_27_47# VPWR VPB sky130_fd_pr__pfet_01v8_hvt ad=0.14 pd=1.28 as=0.165 ps=1.33 w=1 l=0.15
X9 VPWR a_27_47# X VPB sky130_fd_pr__pfet_01v8_hvt ad=0.14 pd=1.28 as=0.14 ps=1.28 w=1 l=0.15
.ends

.subckt sky130_fd_sc_hd__nor2_1 A B VGND VNB VPB VPWR Y
X0 VPWR A a_109_297# VPB sky130_fd_pr__pfet_01v8_hvt ad=0.26 pd=2.52 as=0.105 ps=1.21 w=1 l=0.15
X1 VGND A Y VNB sky130_fd_pr__nfet_01v8 ad=0.169 pd=1.82 as=0.08775 ps=0.92 w=0.65 l=0.15
X2 a_109_297# B Y VPB sky130_fd_pr__pfet_01v8_hvt ad=0.105 pd=1.21 as=0.26 ps=2.52 w=1 l=0.15
X3 Y B VGND VNB sky130_fd_pr__nfet_01v8 ad=0.08775 pd=0.92 as=0.169 ps=1.82 w=0.65 l=0.15
.ends

.subckt sky130_fd_sc_hd__nand2_4 A B VGND VNB VPB VPWR Y
X0 a_27_47# A Y VNB sky130_fd_pr__nfet_01v8 ad=0.08775 pd=0.92 as=0.08775 ps=0.92 w=0.65 l=0.15
X1 a_27_47# A Y VNB sky130_fd_pr__nfet_01v8 ad=0.169 pd=1.82 as=0.08775 ps=0.92 w=0.65 l=0.15
X2 Y A VPWR VPB sky130_fd_pr__pfet_01v8_hvt ad=0.135 pd=1.27 as=0.135 ps=1.27 w=1 l=0.15
X3 VPWR B Y VPB sky130_fd_pr__pfet_01v8_hvt ad=0.135 pd=1.27 as=0.135 ps=1.27 w=1 l=0.15
X4 Y B VPWR VPB sky130_fd_pr__pfet_01v8_hvt ad=0.135 pd=1.27 as=0.135 ps=1.27 w=1 l=0.15
X5 VPWR B Y VPB sky130_fd_pr__pfet_01v8_hvt ad=0.135 pd=1.27 as=0.135 ps=1.27 w=1 l=0.15
X6 a_27_47# B VGND VNB sky130_fd_pr__nfet_01v8 ad=0.08775 pd=0.92 as=0.08775 ps=0.92 w=0.65 l=0.15
X7 a_27_47# B VGND VNB sky130_fd_pr__nfet_01v8 ad=0.08775 pd=0.92 as=0.08775 ps=0.92 w=0.65 l=0.15
X8 VPWR A Y VPB sky130_fd_pr__pfet_01v8_hvt ad=0.26 pd=2.52 as=0.135 ps=1.27 w=1 l=0.15
X9 VGND B a_27_47# VNB sky130_fd_pr__nfet_01v8 ad=0.08775 pd=0.92 as=0.08775 ps=0.92 w=0.65 l=0.15
X10 Y A a_27_47# VNB sky130_fd_pr__nfet_01v8 ad=0.08775 pd=0.92 as=0.08775 ps=0.92 w=0.65 l=0.15
X11 Y A VPWR VPB sky130_fd_pr__pfet_01v8_hvt ad=0.135 pd=1.27 as=0.135 ps=1.27 w=1 l=0.15
X12 Y A a_27_47# VNB sky130_fd_pr__nfet_01v8 ad=0.08775 pd=0.92 as=0.08775 ps=0.92 w=0.65 l=0.15
X13 VPWR A Y VPB sky130_fd_pr__pfet_01v8_hvt ad=0.135 pd=1.27 as=0.135 ps=1.27 w=1 l=0.15
X14 Y B VPWR VPB sky130_fd_pr__pfet_01v8_hvt ad=0.135 pd=1.27 as=0.26 ps=2.52 w=1 l=0.15
X15 VGND B a_27_47# VNB sky130_fd_pr__nfet_01v8 ad=0.08775 pd=0.92 as=0.169 ps=1.82 w=0.65 l=0.15
.ends

.subckt sky130_fd_sc_hd__or3_1 A B C VGND VNB VPB VPWR X
X0 X a_29_53# VPWR VPB sky130_fd_pr__pfet_01v8_hvt ad=0.28 pd=2.56 as=0.14825 ps=1.34 w=1 l=0.15
X1 a_111_297# C a_29_53# VPB sky130_fd_pr__pfet_01v8_hvt ad=0.0441 pd=0.63 as=0.1092 ps=1.36 w=0.42 l=0.15
X2 X a_29_53# VGND VNB sky130_fd_pr__nfet_01v8 ad=0.182 pd=1.86 as=0.10187 ps=0.99 w=0.65 l=0.15
X3 a_183_297# B a_111_297# VPB sky130_fd_pr__pfet_01v8_hvt ad=0.0693 pd=0.75 as=0.0441 ps=0.63 w=0.42 l=0.15
X4 VPWR A a_183_297# VPB sky130_fd_pr__pfet_01v8_hvt ad=0.14825 pd=1.34 as=0.0693 ps=0.75 w=0.42 l=0.15
X5 a_29_53# B VGND VNB sky130_fd_pr__nfet_01v8 ad=0.0567 pd=0.69 as=0.0567 ps=0.69 w=0.42 l=0.15
X6 VGND C a_29_53# VNB sky130_fd_pr__nfet_01v8 ad=0.0567 pd=0.69 as=0.1092 ps=1.36 w=0.42 l=0.15
X7 VGND A a_29_53# VNB sky130_fd_pr__nfet_01v8 ad=0.10187 pd=0.99 as=0.0567 ps=0.69 w=0.42 l=0.15
.ends

.subckt sky130_fd_sc_hd__and3_1 A B C VGND VNB VPB VPWR X
X0 VPWR A a_27_47# VPB sky130_fd_pr__pfet_01v8_hvt ad=0.0567 pd=0.69 as=0.1092 ps=1.36 w=0.42 l=0.15
X1 VPWR C a_27_47# VPB sky130_fd_pr__pfet_01v8_hvt ad=0.14222 pd=1.335 as=0.06615 ps=0.735 w=0.42 l=0.15
X2 a_181_47# B a_109_47# VNB sky130_fd_pr__nfet_01v8 ad=0.0441 pd=0.63 as=0.0441 ps=0.63 w=0.42 l=0.15
X3 VGND C a_181_47# VNB sky130_fd_pr__nfet_01v8 ad=0.13165 pd=1.14 as=0.0441 ps=0.63 w=0.42 l=0.15
X4 a_27_47# B VPWR VPB sky130_fd_pr__pfet_01v8_hvt ad=0.06615 pd=0.735 as=0.0567 ps=0.69 w=0.42 l=0.15
X5 X a_27_47# VPWR VPB sky130_fd_pr__pfet_01v8_hvt ad=0.26 pd=2.52 as=0.14222 ps=1.335 w=1 l=0.15
X6 X a_27_47# VGND VNB sky130_fd_pr__nfet_01v8 ad=0.169 pd=1.82 as=0.13165 ps=1.14 w=0.65 l=0.15
X7 a_109_47# A a_27_47# VNB sky130_fd_pr__nfet_01v8 ad=0.0441 pd=0.63 as=0.1092 ps=1.36 w=0.42 l=0.15
.ends

.subckt sky130_fd_sc_hd__o211a_1 A1 A2 B1 C1 VGND VNB VPB VPWR X
X0 VGND A1 a_215_47# VNB sky130_fd_pr__nfet_01v8 ad=0.10563 pd=0.975 as=0.169 ps=1.82 w=0.65 l=0.15
X1 a_510_47# B1 a_215_47# VNB sky130_fd_pr__nfet_01v8 ad=0.11375 pd=1 as=0.143 ps=1.09 w=0.65 l=0.15
X2 a_79_21# C1 VPWR VPB sky130_fd_pr__pfet_01v8_hvt ad=0.3 pd=2.6 as=0.175 ps=1.35 w=1 l=0.15
X3 VPWR B1 a_79_21# VPB sky130_fd_pr__pfet_01v8_hvt ad=0.175 pd=1.35 as=0.22 ps=1.44 w=1 l=0.15
X4 a_79_21# A2 a_297_297# VPB sky130_fd_pr__pfet_01v8_hvt ad=0.22 pd=1.44 as=0.1625 ps=1.325 w=1 l=0.15
X5 a_297_297# A1 VPWR VPB sky130_fd_pr__pfet_01v8_hvt ad=0.1625 pd=1.325 as=0.26 ps=2.52 w=1 l=0.15
X6 a_79_21# C1 a_510_47# VNB sky130_fd_pr__nfet_01v8 ad=0.195 pd=1.9 as=0.11375 ps=1 w=0.65 l=0.15
X7 VPWR a_79_21# X VPB sky130_fd_pr__pfet_01v8_hvt ad=0.26 pd=2.52 as=0.26 ps=2.52 w=1 l=0.15
X8 VGND a_79_21# X VNB sky130_fd_pr__nfet_01v8 ad=0.169 pd=1.82 as=0.169 ps=1.82 w=0.65 l=0.15
X9 a_215_47# A2 VGND VNB sky130_fd_pr__nfet_01v8 ad=0.143 pd=1.09 as=0.10563 ps=0.975 w=0.65 l=0.15
.ends

.subckt sky130_fd_sc_hd__or4_1 A B C D VGND VNB VPB VPWR X
X0 a_27_297# B VGND VNB sky130_fd_pr__nfet_01v8 ad=0.0567 pd=0.69 as=0.0567 ps=0.69 w=0.42 l=0.15
X1 a_27_297# D VGND VNB sky130_fd_pr__nfet_01v8 ad=0.0693 pd=0.75 as=0.1092 ps=1.36 w=0.42 l=0.15
X2 a_277_297# B a_205_297# VPB sky130_fd_pr__pfet_01v8_hvt ad=0.0693 pd=0.75 as=0.0441 ps=0.63 w=0.42 l=0.15
X3 VPWR A a_277_297# VPB sky130_fd_pr__pfet_01v8_hvt ad=0.14825 pd=1.34 as=0.0693 ps=0.75 w=0.42 l=0.15
X4 X a_27_297# VGND VNB sky130_fd_pr__nfet_01v8 ad=0.1755 pd=1.84 as=0.10187 ps=0.99 w=0.65 l=0.15
X5 a_205_297# C a_109_297# VPB sky130_fd_pr__pfet_01v8_hvt ad=0.0441 pd=0.63 as=0.0693 ps=0.75 w=0.42 l=0.15
X6 X a_27_297# VPWR VPB sky130_fd_pr__pfet_01v8_hvt ad=0.27 pd=2.54 as=0.14825 ps=1.34 w=1 l=0.15
X7 VGND C a_27_297# VNB sky130_fd_pr__nfet_01v8 ad=0.0567 pd=0.69 as=0.0693 ps=0.75 w=0.42 l=0.15
X8 a_109_297# D a_27_297# VPB sky130_fd_pr__pfet_01v8_hvt ad=0.0693 pd=0.75 as=0.1092 ps=1.36 w=0.42 l=0.15
X9 VGND A a_27_297# VNB sky130_fd_pr__nfet_01v8 ad=0.10187 pd=0.99 as=0.0567 ps=0.69 w=0.42 l=0.15
.ends

.subckt sky130_fd_sc_hd__and4bb_1 A_N B_N C D VGND VNB VPB VPWR X
X0 VPWR D a_343_93# VPB sky130_fd_pr__pfet_01v8_hvt ad=0.172 pd=1.46 as=0.0777 ps=0.79 w=0.42 l=0.15
X1 a_223_47# B_N VGND VNB sky130_fd_pr__nfet_01v8 ad=0.1386 pd=1.5 as=0.0588 ps=0.7 w=0.42 l=0.15
X2 a_515_93# a_223_47# a_429_93# VNB sky130_fd_pr__nfet_01v8 ad=0.0735 pd=0.77 as=0.0588 ps=0.7 w=0.42 l=0.15
X3 a_223_47# B_N VPWR VPB sky130_fd_pr__pfet_01v8_hvt ad=0.1344 pd=1.48 as=0.0588 ps=0.7 w=0.42 l=0.15
X4 VPWR A_N a_27_47# VPB sky130_fd_pr__pfet_01v8_hvt ad=0.0588 pd=0.7 as=0.168 ps=1.64 w=0.42 l=0.15
X5 VGND A_N a_27_47# VNB sky130_fd_pr__nfet_01v8 ad=0.0588 pd=0.7 as=0.168 ps=1.64 w=0.42 l=0.15
X6 X a_343_93# VPWR VPB sky130_fd_pr__pfet_01v8_hvt ad=0.26 pd=2.52 as=0.172 ps=1.46 w=1 l=0.15
X7 a_429_93# a_27_47# a_343_93# VNB sky130_fd_pr__nfet_01v8 ad=0.0588 pd=0.7 as=0.1176 ps=1.4 w=0.42 l=0.15
X8 VGND D a_615_93# VNB sky130_fd_pr__nfet_01v8 ad=0.1265 pd=1.11 as=0.0777 ps=0.79 w=0.42 l=0.15
X9 a_343_93# C VPWR VPB sky130_fd_pr__pfet_01v8_hvt ad=0.0777 pd=0.79 as=0.0735 ps=0.77 w=0.42 l=0.15
X10 a_343_93# a_27_47# VPWR VPB sky130_fd_pr__pfet_01v8_hvt ad=0.0588 pd=0.7 as=0.1218 ps=1.42 w=0.42 l=0.15
X11 a_615_93# C a_515_93# VNB sky130_fd_pr__nfet_01v8 ad=0.0777 pd=0.79 as=0.0735 ps=0.77 w=0.42 l=0.15
X12 X a_343_93# VGND VNB sky130_fd_pr__nfet_01v8 ad=0.1654 pd=1.82 as=0.1265 ps=1.11 w=0.65 l=0.15
X13 VPWR a_223_47# a_343_93# VPB sky130_fd_pr__pfet_01v8_hvt ad=0.0735 pd=0.77 as=0.0588 ps=0.7 w=0.42 l=0.15
.ends

.subckt sky130_fd_sc_hd__a21oi_1 A1 A2 B1 VGND VNB VPB VPWR Y
X0 a_199_47# A1 Y VNB sky130_fd_pr__nfet_01v8 ad=0.09588 pd=0.945 as=0.091 ps=0.93 w=0.65 l=0.15
X1 a_113_297# A2 VPWR VPB sky130_fd_pr__pfet_01v8_hvt ad=0.265 pd=2.53 as=0.1475 ps=1.295 w=1 l=0.15
X2 Y B1 VGND VNB sky130_fd_pr__nfet_01v8 ad=0.091 pd=0.93 as=0.17225 ps=1.83 w=0.65 l=0.15
X3 VPWR A1 a_113_297# VPB sky130_fd_pr__pfet_01v8_hvt ad=0.1475 pd=1.295 as=0.14 ps=1.28 w=1 l=0.15
X4 a_113_297# B1 Y VPB sky130_fd_pr__pfet_01v8_hvt ad=0.14 pd=1.28 as=0.265 ps=2.53 w=1 l=0.15
X5 VGND A2 a_199_47# VNB sky130_fd_pr__nfet_01v8 ad=0.17225 pd=1.83 as=0.09588 ps=0.945 w=0.65 l=0.15
.ends

.subckt sky130_fd_sc_hd__o31a_1 A1 A2 A3 B1 VGND VNB VPB VPWR X
X0 a_103_199# B1 a_253_47# VNB sky130_fd_pr__nfet_01v8 ad=0.2015 pd=1.92 as=0.10725 ps=0.98 w=0.65 l=0.15
X1 VPWR a_103_199# X VPB sky130_fd_pr__pfet_01v8_hvt ad=0.195 pd=1.39 as=0.36 ps=2.72 w=1 l=0.15
X2 a_337_297# A2 a_253_297# VPB sky130_fd_pr__pfet_01v8_hvt ad=0.165 pd=1.33 as=0.135 ps=1.27 w=1 l=0.15
X3 a_103_199# A3 a_337_297# VPB sky130_fd_pr__pfet_01v8_hvt ad=0.2125 pd=1.425 as=0.165 ps=1.33 w=1 l=0.15
X4 a_253_297# A1 VPWR VPB sky130_fd_pr__pfet_01v8_hvt ad=0.135 pd=1.27 as=0.195 ps=1.39 w=1 l=0.15
X5 VPWR B1 a_103_199# VPB sky130_fd_pr__pfet_01v8_hvt ad=0.345 pd=2.69 as=0.2125 ps=1.425 w=1 l=0.15
X6 VGND a_103_199# X VNB sky130_fd_pr__nfet_01v8 ad=0.12675 pd=1.04 as=0.234 ps=2.02 w=0.65 l=0.15
X7 a_253_47# A1 VGND VNB sky130_fd_pr__nfet_01v8 ad=0.08775 pd=0.92 as=0.12675 ps=1.04 w=0.65 l=0.15
X8 a_253_47# A3 VGND VNB sky130_fd_pr__nfet_01v8 ad=0.10725 pd=0.98 as=0.10725 ps=0.98 w=0.65 l=0.15
X9 VGND A2 a_253_47# VNB sky130_fd_pr__nfet_01v8 ad=0.10725 pd=0.98 as=0.08775 ps=0.92 w=0.65 l=0.15
.ends

.subckt sky130_fd_sc_hd__xor2_1 A B VGND VNB VPB VPWR X
X0 X a_35_297# a_285_297# VPB sky130_fd_pr__pfet_01v8_hvt ad=0.3 pd=2.6 as=0.26 ps=2.52 w=1 l=0.15
X1 X B a_285_47# VNB sky130_fd_pr__nfet_01v8 ad=0.25025 pd=1.42 as=0.08775 ps=0.92 w=0.65 l=0.15
X2 a_35_297# B VGND VNB sky130_fd_pr__nfet_01v8 ad=0.08775 pd=0.92 as=0.169 ps=1.82 w=0.65 l=0.15
X3 a_117_297# B a_35_297# VPB sky130_fd_pr__pfet_01v8_hvt ad=0.135 pd=1.27 as=0.26 ps=2.52 w=1 l=0.15
X4 VPWR B a_285_297# VPB sky130_fd_pr__pfet_01v8_hvt ad=0.26 pd=2.52 as=0.135 ps=1.27 w=1 l=0.15
X5 VGND A a_35_297# VNB sky130_fd_pr__nfet_01v8 ad=0.08775 pd=0.92 as=0.08775 ps=0.92 w=0.65 l=0.15
X6 VGND a_35_297# X VNB sky130_fd_pr__nfet_01v8 ad=0.208 pd=1.94 as=0.25025 ps=1.42 w=0.65 l=0.15
X7 a_285_297# A VPWR VPB sky130_fd_pr__pfet_01v8_hvt ad=0.135 pd=1.27 as=0.135 ps=1.27 w=1 l=0.15
X8 VPWR A a_117_297# VPB sky130_fd_pr__pfet_01v8_hvt ad=0.135 pd=1.27 as=0.135 ps=1.27 w=1 l=0.15
X9 a_285_47# A VGND VNB sky130_fd_pr__nfet_01v8 ad=0.08775 pd=0.92 as=0.08775 ps=0.92 w=0.65 l=0.15
.ends

.subckt sky130_fd_sc_hd__o21bai_1 A1 A2 B1_N VGND VNB VPB VPWR Y
X0 a_388_297# A2 Y VPB sky130_fd_pr__pfet_01v8_hvt ad=0.1275 pd=1.255 as=0.1525 ps=1.305 w=1 l=0.15
X1 a_105_352# B1_N VGND VNB sky130_fd_pr__nfet_01v8 ad=0.1092 pd=1.36 as=0.1092 ps=1.36 w=0.42 l=0.15
X2 a_297_47# a_105_352# Y VNB sky130_fd_pr__nfet_01v8 ad=0.10075 pd=0.96 as=0.169 ps=1.82 w=0.65 l=0.15
X3 a_297_47# A1 VGND VNB sky130_fd_pr__nfet_01v8 ad=0.169 pd=1.82 as=0.08775 ps=0.92 w=0.65 l=0.15
X4 VPWR A1 a_388_297# VPB sky130_fd_pr__pfet_01v8_hvt ad=0.28 pd=2.56 as=0.1275 ps=1.255 w=1 l=0.15
X5 VGND A2 a_297_47# VNB sky130_fd_pr__nfet_01v8 ad=0.08775 pd=0.92 as=0.10075 ps=0.96 w=0.65 l=0.15
X6 VPWR B1_N a_105_352# VPB sky130_fd_pr__pfet_01v8_hvt ad=0.17825 pd=1.4 as=0.1092 ps=1.36 w=0.42 l=0.15
X7 Y a_105_352# VPWR VPB sky130_fd_pr__pfet_01v8_hvt ad=0.1525 pd=1.305 as=0.17825 ps=1.4 w=1 l=0.15
.ends

.subckt sky130_fd_sc_hd__a211oi_1 A1 A2 B1 C1 VGND VNB VPB VPWR Y
X0 a_56_297# A1 VPWR VPB sky130_fd_pr__pfet_01v8_hvt ad=0.14 pd=1.28 as=0.14 ps=1.28 w=1 l=0.15
X1 VPWR A2 a_56_297# VPB sky130_fd_pr__pfet_01v8_hvt ad=0.14 pd=1.28 as=0.265 ps=2.53 w=1 l=0.15
X2 Y C1 VGND VNB sky130_fd_pr__nfet_01v8 ad=0.17225 pd=1.83 as=0.10075 ps=0.96 w=0.65 l=0.15
X3 a_139_47# A2 VGND VNB sky130_fd_pr__nfet_01v8 ad=0.091 pd=0.93 as=0.2665 ps=2.12 w=0.65 l=0.15
X4 a_311_297# B1 a_56_297# VPB sky130_fd_pr__pfet_01v8_hvt ad=0.155 pd=1.31 as=0.14 ps=1.28 w=1 l=0.15
X5 Y C1 a_311_297# VPB sky130_fd_pr__pfet_01v8_hvt ad=0.265 pd=2.53 as=0.155 ps=1.31 w=1 l=0.15
X6 VGND B1 Y VNB sky130_fd_pr__nfet_01v8 ad=0.10075 pd=0.96 as=0.091 ps=0.93 w=0.65 l=0.15
X7 Y A1 a_139_47# VNB sky130_fd_pr__nfet_01v8 ad=0.091 pd=0.93 as=0.091 ps=0.93 w=0.65 l=0.15
.ends

.subckt sky130_fd_sc_hd__and2_2 A B VGND VNB VPB VPWR X
X0 X a_61_75# VPWR VPB sky130_fd_pr__pfet_01v8_hvt ad=0.195 pd=1.39 as=0.16655 ps=1.39 w=1 l=0.15
X1 VPWR a_61_75# X VPB sky130_fd_pr__pfet_01v8_hvt ad=0.38 pd=2.76 as=0.195 ps=1.39 w=1 l=0.15
X2 VPWR B a_61_75# VPB sky130_fd_pr__pfet_01v8_hvt ad=0.16655 pd=1.39 as=0.0567 ps=0.69 w=0.42 l=0.15
X3 VGND B a_147_75# VNB sky130_fd_pr__nfet_01v8 ad=0.1118 pd=1.04 as=0.0567 ps=0.69 w=0.42 l=0.15
X4 X a_61_75# VGND VNB sky130_fd_pr__nfet_01v8 ad=0.12675 pd=1.04 as=0.1118 ps=1.04 w=0.65 l=0.15
X5 VGND a_61_75# X VNB sky130_fd_pr__nfet_01v8 ad=0.247 pd=2.06 as=0.12675 ps=1.04 w=0.65 l=0.15
X6 a_61_75# A VPWR VPB sky130_fd_pr__pfet_01v8_hvt ad=0.0567 pd=0.69 as=0.1176 ps=1.4 w=0.42 l=0.15
X7 a_147_75# A a_61_75# VNB sky130_fd_pr__nfet_01v8 ad=0.0567 pd=0.69 as=0.1176 ps=1.4 w=0.42 l=0.15
.ends

.subckt sky130_fd_sc_hd__and4b_4 A_N B C D VGND VNB VPB VPWR X
X0 VPWR a_174_21# X VPB sky130_fd_pr__pfet_01v8_hvt ad=0.3275 pd=1.655 as=0.135 ps=1.27 w=1 l=0.15
X1 X a_174_21# VPWR VPB sky130_fd_pr__pfet_01v8_hvt ad=0.135 pd=1.27 as=0.135 ps=1.27 w=1 l=0.15
X2 a_815_47# B a_701_47# VNB sky130_fd_pr__nfet_01v8 ad=0.143 pd=1.09 as=0.1365 ps=1.07 w=0.65 l=0.15
X3 VPWR a_174_21# X VPB sky130_fd_pr__pfet_01v8_hvt ad=0.135 pd=1.27 as=0.135 ps=1.27 w=1 l=0.15
X4 VPWR C a_174_21# VPB sky130_fd_pr__pfet_01v8_hvt ad=0.21 pd=1.42 as=0.135 ps=1.27 w=1 l=0.15
X5 a_174_21# a_27_47# a_815_47# VNB sky130_fd_pr__nfet_01v8 ad=0.169 pd=1.82 as=0.143 ps=1.09 w=0.65 l=0.15
X6 X a_174_21# VPWR VPB sky130_fd_pr__pfet_01v8_hvt ad=0.135 pd=1.27 as=0.14075 ps=1.325 w=1 l=0.15
X7 VPWR A_N a_27_47# VPB sky130_fd_pr__pfet_01v8_hvt ad=0.14075 pd=1.325 as=0.1092 ps=1.36 w=0.42 l=0.15
X8 a_701_47# C a_617_47# VNB sky130_fd_pr__nfet_01v8 ad=0.1365 pd=1.07 as=0.08775 ps=0.92 w=0.65 l=0.15
X9 a_174_21# D VPWR VPB sky130_fd_pr__pfet_01v8_hvt ad=0.135 pd=1.27 as=0.3275 ps=1.655 w=1 l=0.15
X10 a_174_21# B VPWR VPB sky130_fd_pr__pfet_01v8_hvt ad=0.22 pd=1.44 as=0.21 ps=1.42 w=1 l=0.15
X11 VPWR a_27_47# a_174_21# VPB sky130_fd_pr__pfet_01v8_hvt ad=0.26 pd=2.52 as=0.22 ps=1.44 w=1 l=0.15
X12 X a_174_21# VGND VNB sky130_fd_pr__nfet_01v8 ad=0.08775 pd=0.92 as=0.097 ps=0.975 w=0.65 l=0.15
X13 X a_174_21# VGND VNB sky130_fd_pr__nfet_01v8 ad=0.08775 pd=0.92 as=0.08775 ps=0.92 w=0.65 l=0.15
X14 a_617_47# D VGND VNB sky130_fd_pr__nfet_01v8 ad=0.08775 pd=0.92 as=0.21287 ps=1.305 w=0.65 l=0.15
X15 VGND a_174_21# X VNB sky130_fd_pr__nfet_01v8 ad=0.08775 pd=0.92 as=0.08775 ps=0.92 w=0.65 l=0.15
X16 VGND a_174_21# X VNB sky130_fd_pr__nfet_01v8 ad=0.21287 pd=1.305 as=0.08775 ps=0.92 w=0.65 l=0.15
X17 VGND A_N a_27_47# VNB sky130_fd_pr__nfet_01v8 ad=0.097 pd=0.975 as=0.1092 ps=1.36 w=0.42 l=0.15
.ends

.subckt sky130_fd_sc_hd__a31o_1 A1 A2 A3 B1 VGND VNB VPB VPWR X
X0 VPWR a_80_21# X VPB sky130_fd_pr__pfet_01v8_hvt ad=0.1725 pd=1.345 as=0.265 ps=2.53 w=1 l=0.15
X1 a_209_297# A3 VPWR VPB sky130_fd_pr__pfet_01v8_hvt ad=0.16 pd=1.32 as=0.1725 ps=1.345 w=1 l=0.15
X2 a_303_47# A2 a_209_47# VNB sky130_fd_pr__nfet_01v8 ad=0.10725 pd=0.98 as=0.104 ps=0.97 w=0.65 l=0.15
X3 a_209_47# A3 VGND VNB sky130_fd_pr__nfet_01v8 ad=0.104 pd=0.97 as=0.11213 ps=0.995 w=0.65 l=0.15
X4 VGND a_80_21# X VNB sky130_fd_pr__nfet_01v8 ad=0.11213 pd=0.995 as=0.17225 ps=1.83 w=0.65 l=0.15
X5 VGND B1 a_80_21# VNB sky130_fd_pr__nfet_01v8 ad=0.208 pd=1.94 as=0.10725 ps=0.98 w=0.65 l=0.15
X6 a_80_21# A1 a_303_47# VNB sky130_fd_pr__nfet_01v8 ad=0.10725 pd=0.98 as=0.10725 ps=0.98 w=0.65 l=0.15
X7 VPWR A2 a_209_297# VPB sky130_fd_pr__pfet_01v8_hvt ad=0.165 pd=1.33 as=0.16 ps=1.32 w=1 l=0.15
X8 a_80_21# B1 a_209_297# VPB sky130_fd_pr__pfet_01v8_hvt ad=0.32 pd=2.64 as=0.165 ps=1.33 w=1 l=0.15
X9 a_209_297# A1 VPWR VPB sky130_fd_pr__pfet_01v8_hvt ad=0.165 pd=1.33 as=0.165 ps=1.33 w=1 l=0.15
.ends

.subckt sky130_fd_sc_hd__a21o_1 A1 A2 B1 VGND VNB VPB VPWR X
X0 a_81_21# B1 VGND VNB sky130_fd_pr__nfet_01v8 ad=0.08937 pd=0.925 as=0.25675 ps=1.44 w=0.65 l=0.15
X1 a_299_297# B1 a_81_21# VPB sky130_fd_pr__pfet_01v8_hvt ad=0.1375 pd=1.275 as=0.26 ps=2.52 w=1 l=0.15
X2 VPWR a_81_21# X VPB sky130_fd_pr__pfet_01v8_hvt ad=0.26 pd=2.52 as=0.26 ps=2.52 w=1 l=0.15
X3 VPWR A1 a_299_297# VPB sky130_fd_pr__pfet_01v8_hvt ad=0.14 pd=1.28 as=0.1375 ps=1.275 w=1 l=0.15
X4 VGND a_81_21# X VNB sky130_fd_pr__nfet_01v8 ad=0.25675 pd=1.44 as=0.169 ps=1.82 w=0.65 l=0.15
X5 VGND A2 a_384_47# VNB sky130_fd_pr__nfet_01v8 ad=0.17225 pd=1.83 as=0.091 ps=0.93 w=0.65 l=0.15
X6 a_299_297# A2 VPWR VPB sky130_fd_pr__pfet_01v8_hvt ad=0.265 pd=2.53 as=0.14 ps=1.28 w=1 l=0.15
X7 a_384_47# A1 a_81_21# VNB sky130_fd_pr__nfet_01v8 ad=0.091 pd=0.93 as=0.08937 ps=0.925 w=0.65 l=0.15
.ends

.subckt sky130_fd_sc_hd__clkbuf_8 A VGND VNB VPB VPWR X
X0 VPWR A a_110_47# VPB sky130_fd_pr__pfet_01v8_hvt ad=0.14 pd=1.28 as=0.14 ps=1.28 w=1 l=0.15
X1 VPWR a_110_47# X VPB sky130_fd_pr__pfet_01v8_hvt ad=0.14 pd=1.28 as=0.14 ps=1.28 w=1 l=0.15
X2 X a_110_47# VPWR VPB sky130_fd_pr__pfet_01v8_hvt ad=0.14 pd=1.28 as=0.14 ps=1.28 w=1 l=0.15
X3 a_110_47# A VPWR VPB sky130_fd_pr__pfet_01v8_hvt ad=0.14 pd=1.28 as=0.265 ps=2.53 w=1 l=0.15
X4 X a_110_47# VGND VNB sky130_fd_pr__nfet_01v8 ad=0.0588 pd=0.7 as=0.0588 ps=0.7 w=0.42 l=0.15
X5 X a_110_47# VPWR VPB sky130_fd_pr__pfet_01v8_hvt ad=0.14 pd=1.28 as=0.14 ps=1.28 w=1 l=0.15
X6 VGND a_110_47# X VNB sky130_fd_pr__nfet_01v8 ad=0.0588 pd=0.7 as=0.0588 ps=0.7 w=0.42 l=0.15
X7 VPWR a_110_47# X VPB sky130_fd_pr__pfet_01v8_hvt ad=0.14 pd=1.28 as=0.14 ps=1.28 w=1 l=0.15
X8 VGND A a_110_47# VNB sky130_fd_pr__nfet_01v8 ad=0.0588 pd=0.7 as=0.0588 ps=0.7 w=0.42 l=0.15
X9 VGND a_110_47# X VNB sky130_fd_pr__nfet_01v8 ad=0.1134 pd=1.38 as=0.0588 ps=0.7 w=0.42 l=0.15
X10 a_110_47# A VGND VNB sky130_fd_pr__nfet_01v8 ad=0.0588 pd=0.7 as=0.1113 ps=1.37 w=0.42 l=0.15
X11 VPWR a_110_47# X VPB sky130_fd_pr__pfet_01v8_hvt ad=0.14 pd=1.28 as=0.14 ps=1.28 w=1 l=0.15
X12 X a_110_47# VPWR VPB sky130_fd_pr__pfet_01v8_hvt ad=0.14 pd=1.28 as=0.14 ps=1.28 w=1 l=0.15
X13 VGND a_110_47# X VNB sky130_fd_pr__nfet_01v8 ad=0.0588 pd=0.7 as=0.0588 ps=0.7 w=0.42 l=0.15
X14 VGND a_110_47# X VNB sky130_fd_pr__nfet_01v8 ad=0.0588 pd=0.7 as=0.0588 ps=0.7 w=0.42 l=0.15
X15 X a_110_47# VPWR VPB sky130_fd_pr__pfet_01v8_hvt ad=0.14 pd=1.28 as=0.14 ps=1.28 w=1 l=0.15
X16 X a_110_47# VGND VNB sky130_fd_pr__nfet_01v8 ad=0.0588 pd=0.7 as=0.0588 ps=0.7 w=0.42 l=0.15
X17 VPWR a_110_47# X VPB sky130_fd_pr__pfet_01v8_hvt ad=0.265 pd=2.53 as=0.14 ps=1.28 w=1 l=0.15
X18 X a_110_47# VGND VNB sky130_fd_pr__nfet_01v8 ad=0.0588 pd=0.7 as=0.0588 ps=0.7 w=0.42 l=0.15
X19 X a_110_47# VGND VNB sky130_fd_pr__nfet_01v8 ad=0.0588 pd=0.7 as=0.0588 ps=0.7 w=0.42 l=0.15
.ends

.subckt sky130_fd_sc_hd__and2_1 A B VGND VNB VPB VPWR X
X0 VPWR B a_59_75# VPB sky130_fd_pr__pfet_01v8_hvt ad=0.16655 pd=1.39 as=0.0567 ps=0.69 w=0.42 l=0.15
X1 X a_59_75# VPWR VPB sky130_fd_pr__pfet_01v8_hvt ad=0.475 pd=2.95 as=0.16655 ps=1.39 w=1 l=0.15
X2 VGND B a_145_75# VNB sky130_fd_pr__nfet_01v8 ad=0.1118 pd=1.04 as=0.0567 ps=0.69 w=0.42 l=0.15
X3 a_59_75# A VPWR VPB sky130_fd_pr__pfet_01v8_hvt ad=0.0567 pd=0.69 as=0.1176 ps=1.4 w=0.42 l=0.15
X4 X a_59_75# VGND VNB sky130_fd_pr__nfet_01v8 ad=0.182 pd=1.86 as=0.1118 ps=1.04 w=0.65 l=0.15
X5 a_145_75# A a_59_75# VNB sky130_fd_pr__nfet_01v8 ad=0.0567 pd=0.69 as=0.1176 ps=1.4 w=0.42 l=0.15
.ends

.subckt sky130_fd_sc_hd__clkbuf_2 A VGND VNB VPB VPWR X
X0 VPWR A a_27_47# VPB sky130_fd_pr__pfet_01v8_hvt ad=0.1625 pd=1.325 as=0.265 ps=2.53 w=1 l=0.15
X1 VPWR a_27_47# X VPB sky130_fd_pr__pfet_01v8_hvt ad=0.26 pd=2.52 as=0.135 ps=1.27 w=1 l=0.15
X2 VGND A a_27_47# VNB sky130_fd_pr__nfet_01v8 ad=0.06825 pd=0.745 as=0.1113 ps=1.37 w=0.42 l=0.15
X3 X a_27_47# VPWR VPB sky130_fd_pr__pfet_01v8_hvt ad=0.135 pd=1.27 as=0.1625 ps=1.325 w=1 l=0.15
X4 X a_27_47# VGND VNB sky130_fd_pr__nfet_01v8 ad=0.0567 pd=0.69 as=0.06825 ps=0.745 w=0.42 l=0.15
X5 VGND a_27_47# X VNB sky130_fd_pr__nfet_01v8 ad=0.1092 pd=1.36 as=0.0567 ps=0.69 w=0.42 l=0.15
.ends

.subckt sky130_fd_sc_hd__nor3_1 A B C VGND VNB VPB VPWR Y
X0 VPWR A a_193_297# VPB sky130_fd_pr__pfet_01v8_hvt ad=0.26 pd=2.52 as=0.135 ps=1.27 w=1 l=0.15
X1 a_193_297# B a_109_297# VPB sky130_fd_pr__pfet_01v8_hvt ad=0.135 pd=1.27 as=0.135 ps=1.27 w=1 l=0.15
X2 Y B VGND VNB sky130_fd_pr__nfet_01v8 ad=0.08775 pd=0.92 as=0.08775 ps=0.92 w=0.65 l=0.15
X3 VGND A Y VNB sky130_fd_pr__nfet_01v8 ad=0.169 pd=1.82 as=0.08775 ps=0.92 w=0.65 l=0.15
X4 a_109_297# C Y VPB sky130_fd_pr__pfet_01v8_hvt ad=0.135 pd=1.27 as=0.26 ps=2.52 w=1 l=0.15
X5 VGND C Y VNB sky130_fd_pr__nfet_01v8 ad=0.08775 pd=0.92 as=0.169 ps=1.82 w=0.65 l=0.15
.ends

.subckt sky130_fd_sc_hd__a211o_1 A1 A2 B1 C1 VGND VNB VPB VPWR X
X0 VPWR a_80_21# X VPB sky130_fd_pr__pfet_01v8_hvt ad=0.265 pd=2.53 as=0.265 ps=2.53 w=1 l=0.15
X1 a_80_21# C1 a_472_297# VPB sky130_fd_pr__pfet_01v8_hvt ad=0.265 pd=2.53 as=0.155 ps=1.31 w=1 l=0.15
X2 VPWR A2 a_217_297# VPB sky130_fd_pr__pfet_01v8_hvt ad=0.14 pd=1.28 as=0.265 ps=2.53 w=1 l=0.15
X3 VGND B1 a_80_21# VNB sky130_fd_pr__nfet_01v8 ad=0.10075 pd=0.96 as=0.091 ps=0.93 w=0.65 l=0.15
X4 VGND a_80_21# X VNB sky130_fd_pr__nfet_01v8 ad=0.26 pd=1.45 as=0.17225 ps=1.83 w=0.65 l=0.15
X5 a_300_47# A2 VGND VNB sky130_fd_pr__nfet_01v8 ad=0.091 pd=0.93 as=0.26 ps=1.45 w=0.65 l=0.15
X6 a_217_297# A1 VPWR VPB sky130_fd_pr__pfet_01v8_hvt ad=0.14 pd=1.28 as=0.14 ps=1.28 w=1 l=0.15
X7 a_80_21# A1 a_300_47# VNB sky130_fd_pr__nfet_01v8 ad=0.091 pd=0.93 as=0.091 ps=0.93 w=0.65 l=0.15
X8 a_472_297# B1 a_217_297# VPB sky130_fd_pr__pfet_01v8_hvt ad=0.155 pd=1.31 as=0.14 ps=1.28 w=1 l=0.15
X9 a_80_21# C1 VGND VNB sky130_fd_pr__nfet_01v8 ad=0.17225 pd=1.83 as=0.10075 ps=0.96 w=0.65 l=0.15
.ends

.subckt sky130_fd_sc_hd__or4_4 A B C D VGND VNB VPB VPWR X
X0 VPWR A a_304_297# VPB sky130_fd_pr__pfet_01v8_hvt ad=0.19 pd=1.38 as=0.135 ps=1.27 w=1 l=0.15
X1 a_304_297# B a_220_297# VPB sky130_fd_pr__pfet_01v8_hvt ad=0.135 pd=1.27 as=0.135 ps=1.27 w=1 l=0.15
X2 VGND C a_32_297# VNB sky130_fd_pr__nfet_01v8 ad=0.08775 pd=0.92 as=0.1235 ps=1.03 w=0.65 l=0.15
X3 a_220_297# C a_114_297# VPB sky130_fd_pr__pfet_01v8_hvt ad=0.135 pd=1.27 as=0.19 ps=1.38 w=1 l=0.15
X4 a_32_297# D VGND VNB sky130_fd_pr__nfet_01v8 ad=0.1235 pd=1.03 as=0.169 ps=1.82 w=0.65 l=0.15
X5 a_32_297# B VGND VNB sky130_fd_pr__nfet_01v8 ad=0.08775 pd=0.92 as=0.08775 ps=0.92 w=0.65 l=0.15
X6 VPWR a_32_297# X VPB sky130_fd_pr__pfet_01v8_hvt ad=0.27 pd=2.54 as=0.135 ps=1.27 w=1 l=0.15
X7 X a_32_297# VPWR VPB sky130_fd_pr__pfet_01v8_hvt ad=0.135 pd=1.27 as=0.135 ps=1.27 w=1 l=0.15
X8 VGND A a_32_297# VNB sky130_fd_pr__nfet_01v8 ad=0.1235 pd=1.03 as=0.08775 ps=0.92 w=0.65 l=0.15
X9 VPWR a_32_297# X VPB sky130_fd_pr__pfet_01v8_hvt ad=0.135 pd=1.27 as=0.135 ps=1.27 w=1 l=0.15
X10 X a_32_297# VGND VNB sky130_fd_pr__nfet_01v8 ad=0.08775 pd=0.92 as=0.1235 ps=1.03 w=0.65 l=0.15
X11 X a_32_297# VGND VNB sky130_fd_pr__nfet_01v8 ad=0.08775 pd=0.92 as=0.08775 ps=0.92 w=0.65 l=0.15
X12 X a_32_297# VPWR VPB sky130_fd_pr__pfet_01v8_hvt ad=0.135 pd=1.27 as=0.19 ps=1.38 w=1 l=0.15
X13 a_114_297# D a_32_297# VPB sky130_fd_pr__pfet_01v8_hvt ad=0.19 pd=1.38 as=0.26 ps=2.52 w=1 l=0.15
X14 VGND a_32_297# X VNB sky130_fd_pr__nfet_01v8 ad=0.08775 pd=0.92 as=0.08775 ps=0.92 w=0.65 l=0.15
X15 VGND a_32_297# X VNB sky130_fd_pr__nfet_01v8 ad=0.17875 pd=1.85 as=0.08775 ps=0.92 w=0.65 l=0.15
.ends

.subckt sky130_fd_sc_hd__o221a_1 A1 A2 B1 B2 C1 VGND VNB VPB VPWR X
X0 a_240_47# A2 VGND VNB sky130_fd_pr__nfet_01v8 ad=0.08775 pd=0.92 as=0.169 ps=1.82 w=0.65 l=0.15
X1 X a_51_297# VGND VNB sky130_fd_pr__nfet_01v8 ad=0.182 pd=1.86 as=0.08775 ps=0.92 w=0.65 l=0.15
X2 VGND A1 a_240_47# VNB sky130_fd_pr__nfet_01v8 ad=0.08775 pd=0.92 as=0.08775 ps=0.92 w=0.65 l=0.15
X3 a_51_297# B2 a_245_297# VPB sky130_fd_pr__pfet_01v8_hvt ad=0.4125 pd=1.825 as=0.105 ps=1.21 w=1 l=0.15
X4 a_149_47# C1 a_51_297# VNB sky130_fd_pr__nfet_01v8 ad=0.09912 pd=0.955 as=0.2015 ps=1.92 w=0.65 l=0.15
X5 a_240_47# B1 a_149_47# VNB sky130_fd_pr__nfet_01v8 ad=0.08775 pd=0.92 as=0.09912 ps=0.955 w=0.65 l=0.15
X6 VPWR A1 a_512_297# VPB sky130_fd_pr__pfet_01v8_hvt ad=0.165 pd=1.33 as=0.105 ps=1.21 w=1 l=0.15
X7 X a_51_297# VPWR VPB sky130_fd_pr__pfet_01v8_hvt ad=0.28 pd=2.56 as=0.165 ps=1.33 w=1 l=0.15
X8 a_149_47# B2 a_240_47# VNB sky130_fd_pr__nfet_01v8 ad=0.169 pd=1.82 as=0.08775 ps=0.92 w=0.65 l=0.15
X9 a_245_297# B1 VPWR VPB sky130_fd_pr__pfet_01v8_hvt ad=0.105 pd=1.21 as=0.165 ps=1.33 w=1 l=0.15
X10 VPWR C1 a_51_297# VPB sky130_fd_pr__pfet_01v8_hvt ad=0.165 pd=1.33 as=0.34 ps=2.68 w=1 l=0.15
X11 a_512_297# A2 a_51_297# VPB sky130_fd_pr__pfet_01v8_hvt ad=0.105 pd=1.21 as=0.4125 ps=1.825 w=1 l=0.15
.ends

.subckt sky130_fd_sc_hd__a32o_1 A1 A2 A3 B1 B2 VGND VNB VPB VPWR X
X0 a_93_21# A1 a_346_47# VNB sky130_fd_pr__nfet_01v8 ad=0.143 pd=1.09 as=0.14625 ps=1.1 w=0.65 l=0.15
X1 a_93_21# B1 a_250_297# VPB sky130_fd_pr__pfet_01v8_hvt ad=0.14 pd=1.28 as=0.185 ps=1.37 w=1 l=0.15
X2 a_584_47# B1 a_93_21# VNB sky130_fd_pr__nfet_01v8 ad=0.06825 pd=0.86 as=0.143 ps=1.09 w=0.65 l=0.15
X3 VPWR a_93_21# X VPB sky130_fd_pr__pfet_01v8_hvt ad=0.2425 pd=1.485 as=0.33 ps=2.66 w=1 l=0.15
X4 VGND B2 a_584_47# VNB sky130_fd_pr__nfet_01v8 ad=0.17225 pd=1.83 as=0.06825 ps=0.86 w=0.65 l=0.15
X5 a_256_47# A3 VGND VNB sky130_fd_pr__nfet_01v8 ad=0.0975 pd=0.95 as=0.16737 ps=1.165 w=0.65 l=0.15
X6 a_250_297# B2 a_93_21# VPB sky130_fd_pr__pfet_01v8_hvt ad=0.265 pd=2.53 as=0.14 ps=1.28 w=1 l=0.15
X7 VGND a_93_21# X VNB sky130_fd_pr__nfet_01v8 ad=0.16737 pd=1.165 as=0.2145 ps=1.96 w=0.65 l=0.15
X8 a_250_297# A3 VPWR VPB sky130_fd_pr__pfet_01v8_hvt ad=0.165 pd=1.33 as=0.2425 ps=1.485 w=1 l=0.15
X9 VPWR A2 a_250_297# VPB sky130_fd_pr__pfet_01v8_hvt ad=0.225 pd=1.45 as=0.165 ps=1.33 w=1 l=0.15
X10 a_250_297# A1 VPWR VPB sky130_fd_pr__pfet_01v8_hvt ad=0.185 pd=1.37 as=0.225 ps=1.45 w=1 l=0.15
X11 a_346_47# A2 a_256_47# VNB sky130_fd_pr__nfet_01v8 ad=0.14625 pd=1.1 as=0.0975 ps=0.95 w=0.65 l=0.15
.ends

.subckt sky130_fd_sc_hd__o2111a_1 A1 A2 B1 C1 D1 VGND VNB VPB VPWR X
X0 a_676_297# A2 a_79_21# VPB sky130_fd_pr__pfet_01v8_hvt ad=0.105 pd=1.21 as=0.2125 ps=1.425 w=1 l=0.15
X1 a_512_47# B1 a_409_47# VNB sky130_fd_pr__nfet_01v8 ad=0.19825 pd=1.26 as=0.11863 ps=1.015 w=0.65 l=0.15
X2 a_306_47# D1 a_79_21# VNB sky130_fd_pr__nfet_01v8 ad=0.11863 pd=1.015 as=0.19825 ps=1.91 w=0.65 l=0.15
X3 VGND A2 a_512_47# VNB sky130_fd_pr__nfet_01v8 ad=0.08775 pd=0.92 as=0.19825 ps=1.26 w=0.65 l=0.15
X4 VPWR C1 a_79_21# VPB sky130_fd_pr__pfet_01v8_hvt ad=0.305 pd=1.61 as=0.2175 ps=1.435 w=1 l=0.15
X5 a_79_21# B1 VPWR VPB sky130_fd_pr__pfet_01v8_hvt ad=0.2125 pd=1.425 as=0.305 ps=1.61 w=1 l=0.15
X6 VPWR A1 a_676_297# VPB sky130_fd_pr__pfet_01v8_hvt ad=0.265 pd=2.53 as=0.105 ps=1.21 w=1 l=0.15
X7 a_512_47# A1 VGND VNB sky130_fd_pr__nfet_01v8 ad=0.17225 pd=1.83 as=0.08775 ps=0.92 w=0.65 l=0.15
X8 a_409_47# C1 a_306_47# VNB sky130_fd_pr__nfet_01v8 ad=0.11863 pd=1.015 as=0.11863 ps=1.015 w=0.65 l=0.15
X9 VPWR a_79_21# X VPB sky130_fd_pr__pfet_01v8_hvt ad=0.3825 pd=1.765 as=0.26 ps=2.52 w=1 l=0.15
X10 a_79_21# D1 VPWR VPB sky130_fd_pr__pfet_01v8_hvt ad=0.2175 pd=1.435 as=0.3825 ps=1.765 w=1 l=0.15
X11 VGND a_79_21# X VNB sky130_fd_pr__nfet_01v8 ad=0.169 pd=1.82 as=0.169 ps=1.82 w=0.65 l=0.15
.ends

.subckt sky130_fd_sc_hd__nor2_2 A B VGND VNB VPB VPWR Y
X0 Y B a_27_297# VPB sky130_fd_pr__pfet_01v8_hvt ad=0.135 pd=1.27 as=0.135 ps=1.27 w=1 l=0.15
X1 Y B VGND VNB sky130_fd_pr__nfet_01v8 ad=0.08775 pd=0.92 as=0.08775 ps=0.92 w=0.65 l=0.15
X2 a_27_297# A VPWR VPB sky130_fd_pr__pfet_01v8_hvt ad=0.135 pd=1.27 as=0.135 ps=1.27 w=1 l=0.15
X3 VGND A Y VNB sky130_fd_pr__nfet_01v8 ad=0.08775 pd=0.92 as=0.08775 ps=0.92 w=0.65 l=0.15
X4 Y A VGND VNB sky130_fd_pr__nfet_01v8 ad=0.08775 pd=0.92 as=0.182 ps=1.86 w=0.65 l=0.15
X5 VGND B Y VNB sky130_fd_pr__nfet_01v8 ad=0.169 pd=1.82 as=0.08775 ps=0.92 w=0.65 l=0.15
X6 VPWR A a_27_297# VPB sky130_fd_pr__pfet_01v8_hvt ad=0.135 pd=1.27 as=0.28 ps=2.56 w=1 l=0.15
X7 a_27_297# B Y VPB sky130_fd_pr__pfet_01v8_hvt ad=0.26 pd=2.52 as=0.135 ps=1.27 w=1 l=0.15
.ends

.subckt sky130_fd_sc_hd__inv_6 A VGND VNB VPB VPWR Y
X0 VPWR A Y VPB sky130_fd_pr__pfet_01v8_hvt ad=0.27 pd=2.54 as=0.135 ps=1.27 w=1 l=0.15
X1 Y A VPWR VPB sky130_fd_pr__pfet_01v8_hvt ad=0.135 pd=1.27 as=0.135 ps=1.27 w=1 l=0.15
X2 Y A VGND VNB sky130_fd_pr__nfet_01v8 ad=0.08775 pd=0.92 as=0.08775 ps=0.92 w=0.65 l=0.15
X3 VPWR A Y VPB sky130_fd_pr__pfet_01v8_hvt ad=0.135 pd=1.27 as=0.135 ps=1.27 w=1 l=0.15
X4 Y A VPWR VPB sky130_fd_pr__pfet_01v8_hvt ad=0.135 pd=1.27 as=0.135 ps=1.27 w=1 l=0.15
X5 VPWR A Y VPB sky130_fd_pr__pfet_01v8_hvt ad=0.135 pd=1.27 as=0.135 ps=1.27 w=1 l=0.15
X6 Y A VGND VNB sky130_fd_pr__nfet_01v8 ad=0.08775 pd=0.92 as=0.247 ps=2.06 w=0.65 l=0.15
X7 Y A VGND VNB sky130_fd_pr__nfet_01v8 ad=0.08775 pd=0.92 as=0.08775 ps=0.92 w=0.65 l=0.15
X8 Y A VPWR VPB sky130_fd_pr__pfet_01v8_hvt ad=0.135 pd=1.27 as=0.43 ps=2.86 w=1 l=0.15
X9 VGND A Y VNB sky130_fd_pr__nfet_01v8 ad=0.08775 pd=0.92 as=0.08775 ps=0.92 w=0.65 l=0.15
X10 VGND A Y VNB sky130_fd_pr__nfet_01v8 ad=0.08775 pd=0.92 as=0.08775 ps=0.92 w=0.65 l=0.15
X11 VGND A Y VNB sky130_fd_pr__nfet_01v8 ad=0.1755 pd=1.84 as=0.08775 ps=0.92 w=0.65 l=0.15
.ends

.subckt sky130_fd_sc_hd__dfrtp_2 CLK D RESET_B VGND VNB VPB VPWR Q
X0 a_805_47# a_761_289# a_639_47# VNB sky130_fd_pr__nfet_01v8 ad=0.0441 pd=0.63 as=0.1401 ps=1.1 w=0.42 l=0.15
X1 a_1217_47# a_27_47# a_1108_47# VNB sky130_fd_pr__special_nfet_01v8 ad=0.0669 pd=0.75 as=0.0711 ps=0.755 w=0.36 l=0.15
X2 VGND a_1283_21# Q VNB sky130_fd_pr__nfet_01v8 ad=0.169 pd=1.82 as=0.08775 ps=0.92 w=0.65 l=0.15
X3 a_1283_21# a_1108_47# a_1462_47# VNB sky130_fd_pr__nfet_01v8 ad=0.1092 pd=1.36 as=0.06405 ps=0.725 w=0.42 l=0.15
X4 a_651_413# a_27_47# a_543_47# VPB sky130_fd_pr__pfet_01v8_hvt ad=0.1155 pd=0.97 as=0.07245 ps=0.765 w=0.42 l=0.15
X5 VPWR a_1283_21# Q VPB sky130_fd_pr__pfet_01v8_hvt ad=0.26 pd=2.52 as=0.135 ps=1.27 w=1 l=0.15
X6 a_1108_47# a_193_47# a_761_289# VNB sky130_fd_pr__special_nfet_01v8 ad=0.0711 pd=0.755 as=0.0999 ps=0.985 w=0.36 l=0.15
X7 VGND RESET_B a_805_47# VNB sky130_fd_pr__nfet_01v8 ad=0.1346 pd=1.15 as=0.0441 ps=0.63 w=0.42 l=0.15
X8 Q a_1283_21# VPWR VPB sky130_fd_pr__pfet_01v8_hvt ad=0.135 pd=1.27 as=0.3012 ps=2.66 w=1 l=0.15
X9 VPWR CLK a_27_47# VPB sky130_fd_pr__pfet_01v8_hvt ad=0.0864 pd=0.91 as=0.1664 ps=1.8 w=0.64 l=0.15
X10 a_448_47# D VPWR VPB sky130_fd_pr__pfet_01v8_hvt ad=0.0651 pd=0.73 as=0.1092 ps=1.36 w=0.42 l=0.15
X11 a_761_289# a_543_47# VGND VNB sky130_fd_pr__nfet_01v8 ad=0.0999 pd=0.985 as=0.1346 ps=1.15 w=0.64 l=0.15
X12 a_193_47# a_27_47# VGND VNB sky130_fd_pr__nfet_01v8 ad=0.1092 pd=1.36 as=0.0567 ps=0.69 w=0.42 l=0.15
X13 a_1108_47# a_27_47# a_761_289# VPB sky130_fd_pr__pfet_01v8_hvt ad=0.0588 pd=0.7 as=0.12915 ps=1.185 w=0.42 l=0.15
X14 a_1462_47# RESET_B VGND VNB sky130_fd_pr__nfet_01v8 ad=0.06405 pd=0.725 as=0.12495 ps=1.015 w=0.42 l=0.15
X15 a_543_47# a_27_47# a_448_47# VNB sky130_fd_pr__special_nfet_01v8 ad=0.0594 pd=0.69 as=0.066 ps=0.745 w=0.36 l=0.15
X16 a_543_47# a_193_47# a_448_47# VPB sky130_fd_pr__pfet_01v8_hvt ad=0.07245 pd=0.765 as=0.0651 ps=0.73 w=0.42 l=0.15
X17 a_448_47# D VGND VNB sky130_fd_pr__nfet_01v8 ad=0.066 pd=0.745 as=0.2205 ps=1.89 w=0.42 l=0.15
X18 VPWR a_1283_21# a_1270_413# VPB sky130_fd_pr__pfet_01v8_hvt ad=0.0819 pd=0.81 as=0.0567 ps=0.69 w=0.42 l=0.15
X19 VPWR a_1108_47# a_1283_21# VPB sky130_fd_pr__pfet_01v8_hvt ad=0.1134 pd=1.38 as=0.0567 ps=0.69 w=0.42 l=0.15
X20 a_1270_413# a_193_47# a_1108_47# VPB sky130_fd_pr__pfet_01v8_hvt ad=0.0567 pd=0.69 as=0.0588 ps=0.7 w=0.42 l=0.15
X21 a_193_47# a_27_47# VPWR VPB sky130_fd_pr__pfet_01v8_hvt ad=0.1664 pd=1.8 as=0.0864 ps=0.91 w=0.64 l=0.15
X22 a_1283_21# RESET_B VPWR VPB sky130_fd_pr__pfet_01v8_hvt ad=0.0567 pd=0.69 as=0.0819 ps=0.81 w=0.42 l=0.15
X23 VPWR a_761_289# a_651_413# VPB sky130_fd_pr__pfet_01v8_hvt ad=0.07035 pd=0.755 as=0.1155 ps=0.97 w=0.42 l=0.15
X24 Q a_1283_21# VGND VNB sky130_fd_pr__nfet_01v8 ad=0.08775 pd=0.92 as=0.2087 ps=2.02 w=0.65 l=0.15
X25 a_639_47# a_193_47# a_543_47# VNB sky130_fd_pr__special_nfet_01v8 ad=0.1401 pd=1.1 as=0.0594 ps=0.69 w=0.36 l=0.15
X26 VGND a_1283_21# a_1217_47# VNB sky130_fd_pr__nfet_01v8 ad=0.12495 pd=1.015 as=0.0669 ps=0.75 w=0.42 l=0.15
X27 a_651_413# RESET_B VPWR VPB sky130_fd_pr__pfet_01v8_hvt ad=0.1092 pd=1.36 as=0.07035 ps=0.755 w=0.42 l=0.15
X28 VGND CLK a_27_47# VNB sky130_fd_pr__nfet_01v8 ad=0.0567 pd=0.69 as=0.1092 ps=1.36 w=0.42 l=0.15
X29 a_761_289# a_543_47# VPWR VPB sky130_fd_pr__pfet_01v8_hvt ad=0.12915 pd=1.185 as=0.2184 ps=2.2 w=0.84 l=0.15
.ends

.subckt sky130_fd_sc_hd__a31o_2 A1 A2 A3 B1 VGND VNB VPB VPWR X
X0 VPWR A2 a_277_297# VPB sky130_fd_pr__pfet_01v8_hvt ad=0.165 pd=1.33 as=0.135 ps=1.27 w=1 l=0.15
X1 a_277_297# A1 VPWR VPB sky130_fd_pr__pfet_01v8_hvt ad=0.165 pd=1.33 as=0.165 ps=1.33 w=1 l=0.15
X2 a_79_21# B1 a_277_297# VPB sky130_fd_pr__pfet_01v8_hvt ad=0.32 pd=2.64 as=0.165 ps=1.33 w=1 l=0.15
X3 a_277_297# A3 VPWR VPB sky130_fd_pr__pfet_01v8_hvt ad=0.135 pd=1.27 as=0.135 ps=1.27 w=1 l=0.15
X4 VPWR a_79_21# X VPB sky130_fd_pr__pfet_01v8_hvt ad=0.135 pd=1.27 as=0.135 ps=1.27 w=1 l=0.15
X5 VGND a_79_21# X VNB sky130_fd_pr__nfet_01v8 ad=0.08775 pd=0.92 as=0.08775 ps=0.92 w=0.65 l=0.15
X6 a_361_47# A2 a_277_47# VNB sky130_fd_pr__nfet_01v8 ad=0.10725 pd=0.98 as=0.08775 ps=0.92 w=0.65 l=0.15
X7 a_277_47# A3 VGND VNB sky130_fd_pr__nfet_01v8 ad=0.08775 pd=0.92 as=0.08775 ps=0.92 w=0.65 l=0.15
X8 VGND B1 a_79_21# VNB sky130_fd_pr__nfet_01v8 ad=0.169 pd=1.82 as=0.12675 ps=1.04 w=0.65 l=0.15
X9 a_79_21# A1 a_361_47# VNB sky130_fd_pr__nfet_01v8 ad=0.12675 pd=1.04 as=0.10725 ps=0.98 w=0.65 l=0.15
X10 X a_79_21# VPWR VPB sky130_fd_pr__pfet_01v8_hvt ad=0.135 pd=1.27 as=0.26 ps=2.52 w=1 l=0.15
X11 X a_79_21# VGND VNB sky130_fd_pr__nfet_01v8 ad=0.08775 pd=0.92 as=0.169 ps=1.82 w=0.65 l=0.15
.ends

.subckt sky130_fd_sc_hd__or2_2 A B VGND VNB VPB VPWR X
X0 a_121_297# B a_39_297# VPB sky130_fd_pr__pfet_01v8_hvt ad=0.0441 pd=0.63 as=0.1092 ps=1.36 w=0.42 l=0.15
X1 X a_39_297# VGND VNB sky130_fd_pr__nfet_01v8 ad=0.08775 pd=0.92 as=0.10675 ps=1.005 w=0.65 l=0.15
X2 VPWR a_39_297# X VPB sky130_fd_pr__pfet_01v8_hvt ad=0.26 pd=2.52 as=0.135 ps=1.27 w=1 l=0.15
X3 X a_39_297# VPWR VPB sky130_fd_pr__pfet_01v8_hvt ad=0.135 pd=1.27 as=0.15575 ps=1.355 w=1 l=0.15
X4 VGND a_39_297# X VNB sky130_fd_pr__nfet_01v8 ad=0.169 pd=1.82 as=0.08775 ps=0.92 w=0.65 l=0.15
X5 VPWR A a_121_297# VPB sky130_fd_pr__pfet_01v8_hvt ad=0.15575 pd=1.355 as=0.0441 ps=0.63 w=0.42 l=0.15
X6 VGND A a_39_297# VNB sky130_fd_pr__nfet_01v8 ad=0.10675 pd=1.005 as=0.0567 ps=0.69 w=0.42 l=0.15
X7 a_39_297# B VGND VNB sky130_fd_pr__nfet_01v8 ad=0.0567 pd=0.69 as=0.1092 ps=1.36 w=0.42 l=0.15
.ends

.subckt sky130_fd_sc_hd__nand3_1 A B C VGND VNB VPB VPWR Y
X0 VPWR B Y VPB sky130_fd_pr__pfet_01v8_hvt ad=0.165 pd=1.33 as=0.135 ps=1.27 w=1 l=0.15
X1 Y A VPWR VPB sky130_fd_pr__pfet_01v8_hvt ad=0.26 pd=2.52 as=0.165 ps=1.33 w=1 l=0.15
X2 a_193_47# B a_109_47# VNB sky130_fd_pr__nfet_01v8 ad=0.10725 pd=0.98 as=0.08775 ps=0.92 w=0.65 l=0.15
X3 Y A a_193_47# VNB sky130_fd_pr__nfet_01v8 ad=0.169 pd=1.82 as=0.10725 ps=0.98 w=0.65 l=0.15
X4 Y C VPWR VPB sky130_fd_pr__pfet_01v8_hvt ad=0.135 pd=1.27 as=0.26 ps=2.52 w=1 l=0.15
X5 a_109_47# C VGND VNB sky130_fd_pr__nfet_01v8 ad=0.08775 pd=0.92 as=0.169 ps=1.82 w=0.65 l=0.15
.ends

.subckt sky130_fd_sc_hd__o21ai_1 A1 A2 B1 VGND VNB VPB VPWR Y
X0 Y A2 a_109_297# VPB sky130_fd_pr__pfet_01v8_hvt ad=0.174 pd=1.39 as=0.105 ps=1.21 w=1 l=0.15
X1 VPWR B1 Y VPB sky130_fd_pr__pfet_01v8_hvt ad=0.182 pd=1.92 as=0.174 ps=1.39 w=0.7 l=0.15
X2 a_27_47# A2 VGND VNB sky130_fd_pr__nfet_01v8 ad=0.08775 pd=0.92 as=0.10725 ps=0.98 w=0.65 l=0.15
X3 Y B1 a_27_47# VNB sky130_fd_pr__nfet_01v8 ad=0.169 pd=1.82 as=0.08775 ps=0.92 w=0.65 l=0.15
X4 a_109_297# A1 VPWR VPB sky130_fd_pr__pfet_01v8_hvt ad=0.105 pd=1.21 as=0.26 ps=2.52 w=1 l=0.15
X5 VGND A1 a_27_47# VNB sky130_fd_pr__nfet_01v8 ad=0.10725 pd=0.98 as=0.169 ps=1.82 w=0.65 l=0.15
.ends

.subckt sky130_fd_sc_hd__buf_4 A VGND VNB VPB VPWR X
X0 VPWR a_27_47# X VPB sky130_fd_pr__pfet_01v8_hvt ad=0.26 pd=2.52 as=0.135 ps=1.27 w=1 l=0.15
X1 X a_27_47# VPWR VPB sky130_fd_pr__pfet_01v8_hvt ad=0.135 pd=1.27 as=0.135 ps=1.27 w=1 l=0.15
X2 VPWR a_27_47# X VPB sky130_fd_pr__pfet_01v8_hvt ad=0.135 pd=1.27 as=0.135 ps=1.27 w=1 l=0.15
X3 X a_27_47# VPWR VPB sky130_fd_pr__pfet_01v8_hvt ad=0.135 pd=1.27 as=0.135 ps=1.27 w=1 l=0.15
X4 X a_27_47# VGND VNB sky130_fd_pr__nfet_01v8 ad=0.08775 pd=0.92 as=0.08775 ps=0.92 w=0.65 l=0.15
X5 X a_27_47# VGND VNB sky130_fd_pr__nfet_01v8 ad=0.08775 pd=0.92 as=0.08775 ps=0.92 w=0.65 l=0.15
X6 VGND a_27_47# X VNB sky130_fd_pr__nfet_01v8 ad=0.08775 pd=0.92 as=0.08775 ps=0.92 w=0.65 l=0.15
X7 VGND a_27_47# X VNB sky130_fd_pr__nfet_01v8 ad=0.169 pd=1.82 as=0.08775 ps=0.92 w=0.65 l=0.15
X8 VPWR A a_27_47# VPB sky130_fd_pr__pfet_01v8_hvt ad=0.135 pd=1.27 as=0.26 ps=2.52 w=1 l=0.15
X9 VGND A a_27_47# VNB sky130_fd_pr__nfet_01v8 ad=0.08775 pd=0.92 as=0.169 ps=1.82 w=0.65 l=0.15
.ends

.subckt sky130_fd_sc_hd__nor4b_2 A B C D_N VGND VNB VPB VPWR Y
X0 VPWR D_N a_694_21# VPB sky130_fd_pr__pfet_01v8_hvt ad=0.1092 pd=1.36 as=0.1092 ps=1.36 w=0.42 l=0.15
X1 a_27_297# B a_277_297# VPB sky130_fd_pr__pfet_01v8_hvt ad=0.26 pd=2.52 as=0.135 ps=1.27 w=1 l=0.15
X2 a_474_297# a_694_21# Y VPB sky130_fd_pr__pfet_01v8_hvt ad=0.26 pd=2.52 as=0.135 ps=1.27 w=1 l=0.15
X3 a_277_297# B a_27_297# VPB sky130_fd_pr__pfet_01v8_hvt ad=0.135 pd=1.27 as=0.135 ps=1.27 w=1 l=0.15
X4 Y a_694_21# a_474_297# VPB sky130_fd_pr__pfet_01v8_hvt ad=0.135 pd=1.27 as=0.135 ps=1.27 w=1 l=0.15
X5 VGND C Y VNB sky130_fd_pr__nfet_01v8 ad=0.08775 pd=0.92 as=0.08775 ps=0.92 w=0.65 l=0.15
X6 VGND D_N a_694_21# VNB sky130_fd_pr__nfet_01v8 ad=0.1092 pd=1.36 as=0.1092 ps=1.36 w=0.42 l=0.15
X7 a_27_297# A VPWR VPB sky130_fd_pr__pfet_01v8_hvt ad=0.135 pd=1.27 as=0.135 ps=1.27 w=1 l=0.15
X8 VGND A Y VNB sky130_fd_pr__nfet_01v8 ad=0.08775 pd=0.92 as=0.08775 ps=0.92 w=0.65 l=0.15
X9 VGND B Y VNB sky130_fd_pr__nfet_01v8 ad=0.169 pd=1.82 as=0.08775 ps=0.92 w=0.65 l=0.15
X10 Y C VGND VNB sky130_fd_pr__nfet_01v8 ad=0.08775 pd=0.92 as=0.169 ps=1.82 w=0.65 l=0.15
X11 a_474_297# C a_277_297# VPB sky130_fd_pr__pfet_01v8_hvt ad=0.135 pd=1.27 as=0.135 ps=1.27 w=1 l=0.15
X12 Y B VGND VNB sky130_fd_pr__nfet_01v8 ad=0.08775 pd=0.92 as=0.08775 ps=0.92 w=0.65 l=0.15
X13 Y a_694_21# VGND VNB sky130_fd_pr__nfet_01v8 ad=0.08775 pd=0.92 as=0.08775 ps=0.92 w=0.65 l=0.15
X14 a_277_297# C a_474_297# VPB sky130_fd_pr__pfet_01v8_hvt ad=0.135 pd=1.27 as=0.26 ps=2.52 w=1 l=0.15
X15 VGND a_694_21# Y VNB sky130_fd_pr__nfet_01v8 ad=0.169 pd=1.82 as=0.08775 ps=0.92 w=0.65 l=0.15
X16 VPWR A a_27_297# VPB sky130_fd_pr__pfet_01v8_hvt ad=0.135 pd=1.27 as=0.26 ps=2.52 w=1 l=0.15
X17 Y A VGND VNB sky130_fd_pr__nfet_01v8 ad=0.08775 pd=0.92 as=0.169 ps=1.82 w=0.65 l=0.15
.ends

.subckt sky130_fd_sc_hd__and4_1 A B C D VGND VNB VPB VPWR X
X0 a_27_47# C VPWR VPB sky130_fd_pr__pfet_01v8_hvt ad=0.0588 pd=0.7 as=0.0777 ps=0.79 w=0.42 l=0.15
X1 a_197_47# B a_109_47# VNB sky130_fd_pr__nfet_01v8 ad=0.0798 pd=0.8 as=0.0609 ps=0.71 w=0.42 l=0.15
X2 X a_27_47# VPWR VPB sky130_fd_pr__pfet_01v8_hvt ad=0.26 pd=2.52 as=0.31245 ps=1.68 w=1 l=0.15
X3 a_303_47# C a_197_47# VNB sky130_fd_pr__nfet_01v8 ad=0.0693 pd=0.75 as=0.0798 ps=0.8 w=0.42 l=0.15
X4 a_27_47# A VPWR VPB sky130_fd_pr__pfet_01v8_hvt ad=0.0735 pd=0.77 as=0.1092 ps=1.36 w=0.42 l=0.15
X5 VPWR D a_27_47# VPB sky130_fd_pr__pfet_01v8_hvt ad=0.31245 pd=1.68 as=0.0588 ps=0.7 w=0.42 l=0.15
X6 VGND D a_303_47# VNB sky130_fd_pr__nfet_01v8 ad=0.19627 pd=1.33 as=0.0693 ps=0.75 w=0.42 l=0.15
X7 VPWR B a_27_47# VPB sky130_fd_pr__pfet_01v8_hvt ad=0.0777 pd=0.79 as=0.0735 ps=0.77 w=0.42 l=0.15
X8 X a_27_47# VGND VNB sky130_fd_pr__nfet_01v8 ad=0.169 pd=1.82 as=0.19627 ps=1.33 w=0.65 l=0.15
X9 a_109_47# A a_27_47# VNB sky130_fd_pr__nfet_01v8 ad=0.0609 pd=0.71 as=0.1092 ps=1.36 w=0.42 l=0.15
.ends

.subckt sky130_fd_sc_hd__o21ai_4 A1 A2 B1 VGND VNB VPB VPWR Y
X0 VPWR B1 Y VPB sky130_fd_pr__pfet_01v8_hvt ad=0.14 pd=1.28 as=0.14 ps=1.28 w=1 l=0.15
X1 a_115_297# A1 VPWR VPB sky130_fd_pr__pfet_01v8_hvt ad=0.14 pd=1.28 as=0.14 ps=1.28 w=1 l=0.15
X2 a_115_297# A2 Y VPB sky130_fd_pr__pfet_01v8_hvt ad=0.14 pd=1.28 as=0.14 ps=1.28 w=1 l=0.15
X3 VPWR A1 a_115_297# VPB sky130_fd_pr__pfet_01v8_hvt ad=0.16 pd=1.32 as=0.14 ps=1.28 w=1 l=0.15
X4 VGND A2 a_32_47# VNB sky130_fd_pr__nfet_01v8 ad=0.104 pd=0.97 as=0.091 ps=0.93 w=0.65 l=0.15
X5 Y B1 a_32_47# VNB sky130_fd_pr__nfet_01v8 ad=0.091 pd=0.93 as=0.091 ps=0.93 w=0.65 l=0.15
X6 VGND A1 a_32_47# VNB sky130_fd_pr__nfet_01v8 ad=0.091 pd=0.93 as=0.17225 ps=1.83 w=0.65 l=0.15
X7 Y B1 VPWR VPB sky130_fd_pr__pfet_01v8_hvt ad=0.14 pd=1.28 as=0.14 ps=1.28 w=1 l=0.15
X8 a_32_47# B1 Y VNB sky130_fd_pr__nfet_01v8 ad=0.18525 pd=1.87 as=0.091 ps=0.93 w=0.65 l=0.15
X9 Y B1 a_32_47# VNB sky130_fd_pr__nfet_01v8 ad=0.091 pd=0.93 as=0.091 ps=0.93 w=0.65 l=0.15
X10 Y A2 a_115_297# VPB sky130_fd_pr__pfet_01v8_hvt ad=0.14 pd=1.28 as=0.14 ps=1.28 w=1 l=0.15
X11 a_32_47# A2 VGND VNB sky130_fd_pr__nfet_01v8 ad=0.091 pd=0.93 as=0.091 ps=0.93 w=0.65 l=0.15
X12 a_32_47# B1 Y VNB sky130_fd_pr__nfet_01v8 ad=0.091 pd=0.93 as=0.091 ps=0.93 w=0.65 l=0.15
X13 a_32_47# A2 VGND VNB sky130_fd_pr__nfet_01v8 ad=0.091 pd=0.93 as=0.091 ps=0.93 w=0.65 l=0.15
X14 a_115_297# A2 Y VPB sky130_fd_pr__pfet_01v8_hvt ad=0.14 pd=1.28 as=0.14 ps=1.28 w=1 l=0.15
X15 a_32_47# A1 VGND VNB sky130_fd_pr__nfet_01v8 ad=0.091 pd=0.93 as=0.104 ps=0.97 w=0.65 l=0.15
X16 VPWR B1 Y VPB sky130_fd_pr__pfet_01v8_hvt ad=0.265 pd=2.53 as=0.14 ps=1.28 w=1 l=0.15
X17 a_32_47# A1 VGND VNB sky130_fd_pr__nfet_01v8 ad=0.091 pd=0.93 as=0.091 ps=0.93 w=0.65 l=0.15
X18 VGND A2 a_32_47# VNB sky130_fd_pr__nfet_01v8 ad=0.091 pd=0.93 as=0.091 ps=0.93 w=0.65 l=0.15
X19 Y B1 VPWR VPB sky130_fd_pr__pfet_01v8_hvt ad=0.14 pd=1.28 as=0.16 ps=1.32 w=1 l=0.15
X20 VPWR A1 a_115_297# VPB sky130_fd_pr__pfet_01v8_hvt ad=0.14 pd=1.28 as=0.14 ps=1.28 w=1 l=0.15
X21 Y A2 a_115_297# VPB sky130_fd_pr__pfet_01v8_hvt ad=0.14 pd=1.28 as=0.14 ps=1.28 w=1 l=0.15
X22 VGND A1 a_32_47# VNB sky130_fd_pr__nfet_01v8 ad=0.091 pd=0.93 as=0.091 ps=0.93 w=0.65 l=0.15
X23 a_115_297# A1 VPWR VPB sky130_fd_pr__pfet_01v8_hvt ad=0.14 pd=1.28 as=0.265 ps=2.53 w=1 l=0.15
.ends

.subckt sky130_fd_sc_hd__clkbuf_16 A VGND VNB VPB VPWR X
X0 VPWR A a_110_47# VPB sky130_fd_pr__pfet_01v8_hvt ad=0.14 pd=1.28 as=0.14 ps=1.28 w=1 l=0.15
X1 VPWR a_110_47# X VPB sky130_fd_pr__pfet_01v8_hvt ad=0.14 pd=1.28 as=0.14 ps=1.28 w=1 l=0.15
X2 X a_110_47# VPWR VPB sky130_fd_pr__pfet_01v8_hvt ad=0.14 pd=1.28 as=0.14 ps=1.28 w=1 l=0.15
X3 X a_110_47# VPWR VPB sky130_fd_pr__pfet_01v8_hvt ad=0.14 pd=1.28 as=0.14 ps=1.28 w=1 l=0.15
X4 VPWR a_110_47# X VPB sky130_fd_pr__pfet_01v8_hvt ad=0.14 pd=1.28 as=0.14 ps=1.28 w=1 l=0.15
X5 VPWR a_110_47# X VPB sky130_fd_pr__pfet_01v8_hvt ad=0.265 pd=2.53 as=0.14 ps=1.28 w=1 l=0.15
X6 a_110_47# A VPWR VPB sky130_fd_pr__pfet_01v8_hvt ad=0.14 pd=1.28 as=0.265 ps=2.53 w=1 l=0.15
X7 a_110_47# A VGND VNB sky130_fd_pr__nfet_01v8 ad=0.0588 pd=0.7 as=0.0588 ps=0.7 w=0.42 l=0.15
X8 VGND a_110_47# X VNB sky130_fd_pr__nfet_01v8 ad=0.0588 pd=0.7 as=0.0588 ps=0.7 w=0.42 l=0.15
X9 X a_110_47# VGND VNB sky130_fd_pr__nfet_01v8 ad=0.0588 pd=0.7 as=0.0588 ps=0.7 w=0.42 l=0.15
X10 VGND a_110_47# X VNB sky130_fd_pr__nfet_01v8 ad=0.0588 pd=0.7 as=0.0588 ps=0.7 w=0.42 l=0.15
X11 a_110_47# A VPWR VPB sky130_fd_pr__pfet_01v8_hvt ad=0.14 pd=1.28 as=0.14 ps=1.28 w=1 l=0.15
X12 VGND A a_110_47# VNB sky130_fd_pr__nfet_01v8 ad=0.0588 pd=0.7 as=0.0588 ps=0.7 w=0.42 l=0.15
X13 VGND a_110_47# X VNB sky130_fd_pr__nfet_01v8 ad=0.05775 pd=0.695 as=0.0588 ps=0.7 w=0.42 l=0.15
X14 VPWR a_110_47# X VPB sky130_fd_pr__pfet_01v8_hvt ad=0.14 pd=1.28 as=0.14 ps=1.28 w=1 l=0.15
X15 X a_110_47# VPWR VPB sky130_fd_pr__pfet_01v8_hvt ad=0.14 pd=1.28 as=0.14 ps=1.28 w=1 l=0.15
X16 VGND A a_110_47# VNB sky130_fd_pr__nfet_01v8 ad=0.0588 pd=0.7 as=0.0588 ps=0.7 w=0.42 l=0.15
X17 VGND a_110_47# X VNB sky130_fd_pr__nfet_01v8 ad=0.1113 pd=1.37 as=0.0588 ps=0.7 w=0.42 l=0.15
X18 VPWR a_110_47# X VPB sky130_fd_pr__pfet_01v8_hvt ad=0.1375 pd=1.275 as=0.14 ps=1.28 w=1 l=0.15
X19 VGND a_110_47# X VNB sky130_fd_pr__nfet_01v8 ad=0.0588 pd=0.7 as=0.0588 ps=0.7 w=0.42 l=0.15
X20 X a_110_47# VPWR VPB sky130_fd_pr__pfet_01v8_hvt ad=0.14 pd=1.28 as=0.1375 ps=1.275 w=1 l=0.15
X21 a_110_47# A VGND VNB sky130_fd_pr__nfet_01v8 ad=0.0588 pd=0.7 as=0.1113 ps=1.37 w=0.42 l=0.15
X22 VPWR A a_110_47# VPB sky130_fd_pr__pfet_01v8_hvt ad=0.14 pd=1.28 as=0.14 ps=1.28 w=1 l=0.15
X23 VPWR a_110_47# X VPB sky130_fd_pr__pfet_01v8_hvt ad=0.14 pd=1.28 as=0.14 ps=1.28 w=1 l=0.15
X24 VPWR a_110_47# X VPB sky130_fd_pr__pfet_01v8_hvt ad=0.14 pd=1.28 as=0.14 ps=1.28 w=1 l=0.15
X25 VGND a_110_47# X VNB sky130_fd_pr__nfet_01v8 ad=0.0588 pd=0.7 as=0.0588 ps=0.7 w=0.42 l=0.15
X26 X a_110_47# VPWR VPB sky130_fd_pr__pfet_01v8_hvt ad=0.14 pd=1.28 as=0.14 ps=1.28 w=1 l=0.15
X27 VGND a_110_47# X VNB sky130_fd_pr__nfet_01v8 ad=0.0588 pd=0.7 as=0.0588 ps=0.7 w=0.42 l=0.15
X28 VGND a_110_47# X VNB sky130_fd_pr__nfet_01v8 ad=0.0588 pd=0.7 as=0.0588 ps=0.7 w=0.42 l=0.15
X29 X a_110_47# VGND VNB sky130_fd_pr__nfet_01v8 ad=0.0588 pd=0.7 as=0.0588 ps=0.7 w=0.42 l=0.15
X30 X a_110_47# VPWR VPB sky130_fd_pr__pfet_01v8_hvt ad=0.14 pd=1.28 as=0.14 ps=1.28 w=1 l=0.15
X31 X a_110_47# VPWR VPB sky130_fd_pr__pfet_01v8_hvt ad=0.14 pd=1.28 as=0.14 ps=1.28 w=1 l=0.15
X32 X a_110_47# VGND VNB sky130_fd_pr__nfet_01v8 ad=0.0588 pd=0.7 as=0.0588 ps=0.7 w=0.42 l=0.15
X33 VPWR a_110_47# X VPB sky130_fd_pr__pfet_01v8_hvt ad=0.14 pd=1.28 as=0.14 ps=1.28 w=1 l=0.15
X34 X a_110_47# VPWR VPB sky130_fd_pr__pfet_01v8_hvt ad=0.14 pd=1.28 as=0.14 ps=1.28 w=1 l=0.15
X35 X a_110_47# VGND VNB sky130_fd_pr__nfet_01v8 ad=0.0588 pd=0.7 as=0.0588 ps=0.7 w=0.42 l=0.15
X36 X a_110_47# VGND VNB sky130_fd_pr__nfet_01v8 ad=0.0588 pd=0.7 as=0.0588 ps=0.7 w=0.42 l=0.15
X37 X a_110_47# VGND VNB sky130_fd_pr__nfet_01v8 ad=0.0588 pd=0.7 as=0.0588 ps=0.7 w=0.42 l=0.15
X38 X a_110_47# VGND VNB sky130_fd_pr__nfet_01v8 ad=0.0588 pd=0.7 as=0.0588 ps=0.7 w=0.42 l=0.15
X39 X a_110_47# VGND VNB sky130_fd_pr__nfet_01v8 ad=0.0588 pd=0.7 as=0.05775 ps=0.695 w=0.42 l=0.15
.ends

.subckt sky130_fd_sc_hd__nor4_1 A B C D VGND VNB VPB VPWR Y
X0 Y B VGND VNB sky130_fd_pr__nfet_01v8 ad=0.08775 pd=0.92 as=0.08937 ps=0.925 w=0.65 l=0.15
X1 a_191_297# C a_109_297# VPB sky130_fd_pr__pfet_01v8_hvt ad=0.19 pd=1.38 as=0.13 ps=1.26 w=1 l=0.15
X2 VPWR A a_297_297# VPB sky130_fd_pr__pfet_01v8_hvt ad=0.26 pd=2.52 as=0.135 ps=1.27 w=1 l=0.15
X3 VGND C Y VNB sky130_fd_pr__nfet_01v8 ad=0.08937 pd=0.925 as=0.11863 ps=1.015 w=0.65 l=0.15
X4 VGND A Y VNB sky130_fd_pr__nfet_01v8 ad=0.169 pd=1.82 as=0.08775 ps=0.92 w=0.65 l=0.15
X5 a_297_297# B a_191_297# VPB sky130_fd_pr__pfet_01v8_hvt ad=0.135 pd=1.27 as=0.19 ps=1.38 w=1 l=0.15
X6 a_109_297# D Y VPB sky130_fd_pr__pfet_01v8_hvt ad=0.13 pd=1.26 as=0.26 ps=2.52 w=1 l=0.15
X7 Y D VGND VNB sky130_fd_pr__nfet_01v8 ad=0.11863 pd=1.015 as=0.169 ps=1.82 w=0.65 l=0.15
.ends

.subckt sky130_fd_sc_hd__clkinv_2 A VGND VNB VPB VPWR Y
X0 Y A VGND VNB sky130_fd_pr__nfet_01v8 ad=0.0588 pd=0.7 as=0.1113 ps=1.37 w=0.42 l=0.15
X1 Y A VPWR VPB sky130_fd_pr__pfet_01v8_hvt ad=0.14 pd=1.28 as=0.14 ps=1.28 w=1 l=0.15
X2 VPWR A Y VPB sky130_fd_pr__pfet_01v8_hvt ad=0.14 pd=1.28 as=0.265 ps=2.53 w=1 l=0.15
X3 VGND A Y VNB sky130_fd_pr__nfet_01v8 ad=0.1092 pd=1.36 as=0.0588 ps=0.7 w=0.42 l=0.15
X4 VPWR A Y VPB sky130_fd_pr__pfet_01v8_hvt ad=0.265 pd=2.53 as=0.14 ps=1.28 w=1 l=0.15
.ends

.subckt sky130_fd_sc_hd__nand2b_1 A_N B VGND VNB VPB VPWR Y
X0 VGND A_N a_27_93# VNB sky130_fd_pr__nfet_01v8 ad=0.10025 pd=0.985 as=0.1092 ps=1.36 w=0.42 l=0.15
X1 Y a_27_93# a_206_47# VNB sky130_fd_pr__nfet_01v8 ad=0.169 pd=1.82 as=0.08775 ps=0.92 w=0.65 l=0.15
X2 a_206_47# B VGND VNB sky130_fd_pr__nfet_01v8 ad=0.08775 pd=0.92 as=0.10025 ps=0.985 w=0.65 l=0.15
X3 VPWR a_27_93# Y VPB sky130_fd_pr__pfet_01v8_hvt ad=0.265 pd=2.53 as=0.135 ps=1.27 w=1 l=0.15
X4 Y B VPWR VPB sky130_fd_pr__pfet_01v8_hvt ad=0.135 pd=1.27 as=0.14575 ps=1.335 w=1 l=0.15
X5 VPWR A_N a_27_93# VPB sky130_fd_pr__pfet_01v8_hvt ad=0.14575 pd=1.335 as=0.1092 ps=1.36 w=0.42 l=0.15
.ends

.subckt sky130_fd_sc_hd__a21bo_1 A1 A2 B1_N VGND VNB VPB VPWR X
X0 a_298_297# a_27_413# a_215_297# VPB sky130_fd_pr__pfet_01v8_hvt ad=0.135 pd=1.27 as=0.265 ps=2.53 w=1 l=0.15
X1 a_215_297# a_27_413# VGND VNB sky130_fd_pr__nfet_01v8 ad=0.08775 pd=0.92 as=0.1359 ps=1.1 w=0.65 l=0.15
X2 a_298_297# A2 VPWR VPB sky130_fd_pr__pfet_01v8_hvt ad=0.265 pd=2.53 as=0.14 ps=1.28 w=1 l=0.15
X3 X a_215_297# VGND VNB sky130_fd_pr__nfet_01v8 ad=0.169 pd=1.82 as=0.25837 ps=1.445 w=0.65 l=0.15
X4 VPWR B1_N a_27_413# VPB sky130_fd_pr__pfet_01v8_hvt ad=0.1092 pd=1.36 as=0.1092 ps=1.36 w=0.42 l=0.15
X5 X a_215_297# VPWR VPB sky130_fd_pr__pfet_01v8_hvt ad=0.26 pd=2.52 as=0.26 ps=2.52 w=1 l=0.15
X6 a_382_47# A1 a_215_297# VNB sky130_fd_pr__nfet_01v8 ad=0.091 pd=0.93 as=0.08775 ps=0.92 w=0.65 l=0.15
X7 VGND B1_N a_27_413# VNB sky130_fd_pr__nfet_01v8 ad=0.1359 pd=1.1 as=0.1113 ps=1.37 w=0.42 l=0.15
X8 VPWR A1 a_298_297# VPB sky130_fd_pr__pfet_01v8_hvt ad=0.14 pd=1.28 as=0.135 ps=1.27 w=1 l=0.15
X9 VGND A2 a_382_47# VNB sky130_fd_pr__nfet_01v8 ad=0.25837 pd=1.445 as=0.091 ps=0.93 w=0.65 l=0.15
.ends

.subckt sky130_fd_sc_hd__nand3b_1 A_N B C VGND VNB VPB VPWR Y
X0 Y a_53_93# VPWR VPB sky130_fd_pr__pfet_01v8_hvt ad=0.28 pd=2.56 as=0.1925 ps=1.385 w=1 l=0.15
X1 a_232_47# C VGND VNB sky130_fd_pr__nfet_01v8 ad=0.08775 pd=0.92 as=0.10025 ps=0.985 w=0.65 l=0.15
X2 VPWR B Y VPB sky130_fd_pr__pfet_01v8_hvt ad=0.1925 pd=1.385 as=0.135 ps=1.27 w=1 l=0.15
X3 VPWR A_N a_53_93# VPB sky130_fd_pr__pfet_01v8_hvt ad=0.14575 pd=1.335 as=0.1092 ps=1.36 w=0.42 l=0.15
X4 VGND A_N a_53_93# VNB sky130_fd_pr__nfet_01v8 ad=0.10025 pd=0.985 as=0.1092 ps=1.36 w=0.42 l=0.15
X5 a_316_47# B a_232_47# VNB sky130_fd_pr__nfet_01v8 ad=0.12513 pd=1.035 as=0.08775 ps=0.92 w=0.65 l=0.15
X6 Y a_53_93# a_316_47# VNB sky130_fd_pr__nfet_01v8 ad=0.182 pd=1.86 as=0.12513 ps=1.035 w=0.65 l=0.15
X7 Y C VPWR VPB sky130_fd_pr__pfet_01v8_hvt ad=0.135 pd=1.27 as=0.14575 ps=1.335 w=1 l=0.15
.ends

.subckt sky130_fd_sc_hd__o21a_1 A1 A2 B1 VGND VNB VPB VPWR X
X0 VPWR A1 a_382_297# VPB sky130_fd_pr__pfet_01v8_hvt ad=0.26 pd=2.52 as=0.1525 ps=1.305 w=1 l=0.15
X1 a_297_47# B1 a_79_21# VNB sky130_fd_pr__nfet_01v8 ad=0.10075 pd=0.96 as=0.169 ps=1.82 w=0.65 l=0.15
X2 a_297_47# A1 VGND VNB sky130_fd_pr__nfet_01v8 ad=0.169 pd=1.82 as=0.08775 ps=0.92 w=0.65 l=0.15
X3 VGND A2 a_297_47# VNB sky130_fd_pr__nfet_01v8 ad=0.08775 pd=0.92 as=0.10075 ps=0.96 w=0.65 l=0.15
X4 VPWR a_79_21# X VPB sky130_fd_pr__pfet_01v8_hvt ad=0.3275 pd=1.655 as=0.28 ps=2.56 w=1 l=0.15
X5 a_79_21# B1 VPWR VPB sky130_fd_pr__pfet_01v8_hvt ad=0.195 pd=1.39 as=0.3275 ps=1.655 w=1 l=0.15
X6 a_382_297# A2 a_79_21# VPB sky130_fd_pr__pfet_01v8_hvt ad=0.1525 pd=1.305 as=0.195 ps=1.39 w=1 l=0.15
X7 VGND a_79_21# X VNB sky130_fd_pr__nfet_01v8 ad=0.169 pd=1.82 as=0.169 ps=1.82 w=0.65 l=0.15
.ends

.subckt sky130_fd_sc_hd__and4bb_4 A_N B_N C D VGND VNB VPB VPWR X
X0 VPWR a_174_21# X VPB sky130_fd_pr__pfet_01v8_hvt ad=0.175 pd=1.35 as=0.135 ps=1.27 w=1 l=0.15
X1 a_174_21# a_832_21# a_766_47# VNB sky130_fd_pr__nfet_01v8 ad=0.169 pd=1.82 as=0.10725 ps=0.98 w=0.65 l=0.15
X2 X a_174_21# VPWR VPB sky130_fd_pr__pfet_01v8_hvt ad=0.135 pd=1.27 as=0.135 ps=1.27 w=1 l=0.15
X3 a_832_21# A_N VGND VNB sky130_fd_pr__nfet_01v8 ad=0.1092 pd=1.36 as=0.1764 ps=1.68 w=0.42 l=0.15
X4 a_766_47# a_27_47# a_652_47# VNB sky130_fd_pr__nfet_01v8 ad=0.10725 pd=0.98 as=0.1365 ps=1.07 w=0.65 l=0.15
X5 VPWR a_174_21# X VPB sky130_fd_pr__pfet_01v8_hvt ad=0.135 pd=1.27 as=0.135 ps=1.27 w=1 l=0.15
X6 X a_174_21# VPWR VPB sky130_fd_pr__pfet_01v8_hvt ad=0.135 pd=1.27 as=0.14075 ps=1.325 w=1 l=0.15
X7 VPWR B_N a_27_47# VPB sky130_fd_pr__pfet_01v8_hvt ad=0.14075 pd=1.325 as=0.1092 ps=1.36 w=0.42 l=0.15
X8 a_652_47# C a_556_47# VNB sky130_fd_pr__nfet_01v8 ad=0.1365 pd=1.07 as=0.10725 ps=0.98 w=0.65 l=0.15
X9 a_832_21# A_N VPWR VPB sky130_fd_pr__pfet_01v8_hvt ad=0.1092 pd=1.36 as=0.31165 ps=2.125 w=0.42 l=0.15
X10 X a_174_21# VGND VNB sky130_fd_pr__nfet_01v8 ad=0.08775 pd=0.92 as=0.097 ps=0.975 w=0.65 l=0.15
X11 X a_174_21# VGND VNB sky130_fd_pr__nfet_01v8 ad=0.08775 pd=0.92 as=0.08775 ps=0.92 w=0.65 l=0.15
X12 a_556_47# D VGND VNB sky130_fd_pr__nfet_01v8 ad=0.10725 pd=0.98 as=0.11375 ps=1 w=0.65 l=0.15
X13 a_174_21# D VPWR VPB sky130_fd_pr__pfet_01v8_hvt ad=0.165 pd=1.33 as=0.175 ps=1.35 w=1 l=0.15
X14 VPWR C a_174_21# VPB sky130_fd_pr__pfet_01v8_hvt ad=0.21 pd=1.42 as=0.165 ps=1.33 w=1 l=0.15
X15 VGND a_174_21# X VNB sky130_fd_pr__nfet_01v8 ad=0.08775 pd=0.92 as=0.08775 ps=0.92 w=0.65 l=0.15
X16 VGND a_174_21# X VNB sky130_fd_pr__nfet_01v8 ad=0.11375 pd=1 as=0.08775 ps=0.92 w=0.65 l=0.15
X17 VPWR a_832_21# a_174_21# VPB sky130_fd_pr__pfet_01v8_hvt ad=0.31165 pd=2.125 as=0.165 ps=1.33 w=1 l=0.15
X18 a_174_21# a_27_47# VPWR VPB sky130_fd_pr__pfet_01v8_hvt ad=0.165 pd=1.33 as=0.21 ps=1.42 w=1 l=0.15
X19 VGND B_N a_27_47# VNB sky130_fd_pr__nfet_01v8 ad=0.097 pd=0.975 as=0.1092 ps=1.36 w=0.42 l=0.15
.ends

.subckt sky130_fd_sc_hd__o22a_1 A1 A2 B1 B2 VGND VNB VPB VPWR X
X0 a_78_199# B1 a_215_47# VNB sky130_fd_pr__nfet_01v8 ad=0.08775 pd=0.92 as=0.169 ps=1.82 w=0.65 l=0.15
X1 VPWR A1 a_493_297# VPB sky130_fd_pr__pfet_01v8_hvt ad=0.26 pd=2.52 as=0.105 ps=1.21 w=1 l=0.15
X2 a_493_297# A2 a_78_199# VPB sky130_fd_pr__pfet_01v8_hvt ad=0.105 pd=1.21 as=0.235 ps=1.47 w=1 l=0.15
X3 VPWR a_78_199# X VPB sky130_fd_pr__pfet_01v8_hvt ad=0.3725 pd=1.745 as=0.28 ps=2.56 w=1 l=0.15
X4 VGND A2 a_215_47# VNB sky130_fd_pr__nfet_01v8 ad=0.08775 pd=0.92 as=0.11375 ps=1 w=0.65 l=0.15
X5 a_78_199# B2 a_292_297# VPB sky130_fd_pr__pfet_01v8_hvt ad=0.235 pd=1.47 as=0.1175 ps=1.235 w=1 l=0.15
X6 a_215_47# A1 VGND VNB sky130_fd_pr__nfet_01v8 ad=0.169 pd=1.82 as=0.08775 ps=0.92 w=0.65 l=0.15
X7 a_215_47# B2 a_78_199# VNB sky130_fd_pr__nfet_01v8 ad=0.11375 pd=1 as=0.08775 ps=0.92 w=0.65 l=0.15
X8 a_292_297# B1 VPWR VPB sky130_fd_pr__pfet_01v8_hvt ad=0.1175 pd=1.235 as=0.3725 ps=1.745 w=1 l=0.15
X9 VGND a_78_199# X VNB sky130_fd_pr__nfet_01v8 ad=0.169 pd=1.82 as=0.169 ps=1.82 w=0.65 l=0.15
.ends

.subckt sky130_fd_sc_hd__clkinvlp_4 A VGND VNB VPB VPWR Y
X0 Y A VPWR VPB sky130_fd_pr__pfet_01v8_hvt ad=0.14 pd=1.28 as=0.265 ps=2.53 w=1 l=0.25
X1 VGND A a_268_47# VNB sky130_fd_pr__nfet_01v8 ad=0.14575 pd=1.63 as=0.05775 ps=0.76 w=0.55 l=0.15
X2 Y A VPWR VPB sky130_fd_pr__pfet_01v8_hvt ad=0.14 pd=1.28 as=0.14 ps=1.28 w=1 l=0.25
X3 Y A a_110_47# VNB sky130_fd_pr__nfet_01v8 ad=0.077 pd=0.83 as=0.05775 ps=0.76 w=0.55 l=0.15
X4 VPWR A Y VPB sky130_fd_pr__pfet_01v8_hvt ad=0.14 pd=1.28 as=0.14 ps=1.28 w=1 l=0.25
X5 a_110_47# A VGND VNB sky130_fd_pr__nfet_01v8 ad=0.05775 pd=0.76 as=0.14575 ps=1.63 w=0.55 l=0.15
X6 a_268_47# A Y VNB sky130_fd_pr__nfet_01v8 ad=0.05775 pd=0.76 as=0.077 ps=0.83 w=0.55 l=0.15
X7 VPWR A Y VPB sky130_fd_pr__pfet_01v8_hvt ad=0.265 pd=2.53 as=0.14 ps=1.28 w=1 l=0.25
.ends

.subckt sky130_fd_sc_hd__xor2_2 A B VGND VNB VPB VPWR X
X0 a_27_297# A VPWR VPB sky130_fd_pr__pfet_01v8_hvt ad=0.135 pd=1.27 as=0.135 ps=1.27 w=1 l=0.15
X1 a_470_47# A VGND VNB sky130_fd_pr__nfet_01v8 ad=0.08775 pd=0.92 as=0.08775 ps=0.92 w=0.65 l=0.15
X2 a_470_297# A VPWR VPB sky130_fd_pr__pfet_01v8_hvt ad=0.135 pd=1.27 as=0.135 ps=1.27 w=1 l=0.15
X3 VPWR A a_470_297# VPB sky130_fd_pr__pfet_01v8_hvt ad=0.135 pd=1.27 as=0.26 ps=2.52 w=1 l=0.15
X4 a_112_47# B VGND VNB sky130_fd_pr__nfet_01v8 ad=0.08775 pd=0.92 as=0.08775 ps=0.92 w=0.65 l=0.15
X5 a_470_47# B X VNB sky130_fd_pr__nfet_01v8 ad=0.169 pd=1.82 as=0.10563 ps=0.975 w=0.65 l=0.15
X6 VGND A a_112_47# VNB sky130_fd_pr__nfet_01v8 ad=0.08775 pd=0.92 as=0.08775 ps=0.92 w=0.65 l=0.15
X7 a_112_47# A VGND VNB sky130_fd_pr__nfet_01v8 ad=0.08775 pd=0.92 as=0.17875 ps=1.85 w=0.65 l=0.15
X8 VGND B a_112_47# VNB sky130_fd_pr__nfet_01v8 ad=0.169 pd=1.82 as=0.08775 ps=0.92 w=0.65 l=0.15
X9 VPWR A a_27_297# VPB sky130_fd_pr__pfet_01v8_hvt ad=0.135 pd=1.27 as=0.275 ps=2.55 w=1 l=0.15
X10 a_470_297# B VPWR VPB sky130_fd_pr__pfet_01v8_hvt ad=0.26 pd=2.52 as=0.1625 ps=1.325 w=1 l=0.15
X11 X a_112_47# VGND VNB sky130_fd_pr__nfet_01v8 ad=0.08775 pd=0.92 as=0.169 ps=1.82 w=0.65 l=0.15
X12 VPWR B a_470_297# VPB sky130_fd_pr__pfet_01v8_hvt ad=0.1625 pd=1.325 as=0.135 ps=1.27 w=1 l=0.15
X13 VGND a_112_47# X VNB sky130_fd_pr__nfet_01v8 ad=0.169 pd=1.82 as=0.08775 ps=0.92 w=0.65 l=0.15
X14 VGND A a_470_47# VNB sky130_fd_pr__nfet_01v8 ad=0.08775 pd=0.92 as=0.169 ps=1.82 w=0.65 l=0.15
X15 a_27_297# B a_112_47# VPB sky130_fd_pr__pfet_01v8_hvt ad=0.26 pd=2.52 as=0.135 ps=1.27 w=1 l=0.15
X16 X a_112_47# a_470_297# VPB sky130_fd_pr__pfet_01v8_hvt ad=0.135 pd=1.27 as=0.26 ps=2.52 w=1 l=0.15
X17 a_470_297# a_112_47# X VPB sky130_fd_pr__pfet_01v8_hvt ad=0.28 pd=2.56 as=0.135 ps=1.27 w=1 l=0.15
X18 X B a_470_47# VNB sky130_fd_pr__nfet_01v8 ad=0.10563 pd=0.975 as=0.08775 ps=0.92 w=0.65 l=0.15
X19 a_112_47# B a_27_297# VPB sky130_fd_pr__pfet_01v8_hvt ad=0.135 pd=1.27 as=0.135 ps=1.27 w=1 l=0.15
.ends

.subckt sky130_fd_sc_hd__a2111o_1 A1 A2 B1 C1 D1 VGND VNB VPB VPWR X
X0 VGND A2 a_660_47# VNB sky130_fd_pr__nfet_01v8 ad=0.1885 pd=1.88 as=0.08287 ps=0.905 w=0.65 l=0.15
X1 VGND C1 a_85_193# VNB sky130_fd_pr__nfet_01v8 ad=0.117 pd=1.01 as=0.10075 ps=0.96 w=0.65 l=0.15
X2 a_414_297# C1 a_334_297# VPB sky130_fd_pr__pfet_01v8_hvt ad=0.18 pd=1.36 as=0.125 ps=1.25 w=1 l=0.15
X3 VGND a_85_193# X VNB sky130_fd_pr__nfet_01v8 ad=0.27463 pd=1.495 as=0.2145 ps=1.96 w=0.65 l=0.15
X4 a_334_297# D1 a_85_193# VPB sky130_fd_pr__pfet_01v8_hvt ad=0.125 pd=1.25 as=0.385 ps=2.77 w=1 l=0.15
X5 a_516_297# B1 a_414_297# VPB sky130_fd_pr__pfet_01v8_hvt ad=0.28 pd=1.56 as=0.18 ps=1.36 w=1 l=0.15
X6 a_516_297# A2 VPWR VPB sky130_fd_pr__pfet_01v8_hvt ad=0.29 pd=2.58 as=0.135 ps=1.27 w=1 l=0.15
X7 a_660_47# A1 a_85_193# VNB sky130_fd_pr__nfet_01v8 ad=0.08287 pd=0.905 as=0.18525 ps=1.22 w=0.65 l=0.15
X8 a_85_193# D1 VGND VNB sky130_fd_pr__nfet_01v8 ad=0.10075 pd=0.96 as=0.27463 ps=1.495 w=0.65 l=0.15
X9 VPWR A1 a_516_297# VPB sky130_fd_pr__pfet_01v8_hvt ad=0.135 pd=1.27 as=0.28 ps=1.56 w=1 l=0.15
X10 a_85_193# B1 VGND VNB sky130_fd_pr__nfet_01v8 ad=0.18525 pd=1.22 as=0.117 ps=1.01 w=0.65 l=0.15
X11 VPWR a_85_193# X VPB sky130_fd_pr__pfet_01v8_hvt ad=0.265 pd=2.53 as=0.29 ps=2.58 w=1 l=0.15
.ends

.subckt sky130_fd_sc_hd__dfstp_1 CLK D SET_B VGND VNB VPB VPWR Q
X0 VGND a_652_21# a_586_47# VNB sky130_fd_pr__nfet_01v8 ad=0.0882 pd=0.84 as=0.06705 ps=0.75 w=0.42 l=0.15
X1 a_956_413# a_476_47# VPWR VPB sky130_fd_pr__pfet_01v8_hvt ad=0.0483 pd=0.65 as=0.0567 ps=0.69 w=0.42 l=0.15
X2 VPWR a_476_47# a_652_21# VPB sky130_fd_pr__pfet_01v8_hvt ad=0.0567 pd=0.69 as=0.0567 ps=0.69 w=0.42 l=0.15
X3 VPWR CLK a_27_47# VPB sky130_fd_pr__pfet_01v8_hvt ad=0.0864 pd=0.91 as=0.1664 ps=1.8 w=0.64 l=0.15
X4 a_586_47# a_193_47# a_476_47# VNB sky130_fd_pr__special_nfet_01v8 ad=0.06705 pd=0.75 as=0.072 ps=0.76 w=0.36 l=0.15
X5 a_1056_47# a_476_47# VGND VNB sky130_fd_pr__nfet_01v8 ad=0.0441 pd=0.63 as=0.1092 ps=1.36 w=0.42 l=0.15
X6 a_476_47# a_27_47# a_381_47# VNB sky130_fd_pr__special_nfet_01v8 ad=0.072 pd=0.76 as=0.0935 ps=0.965 w=0.36 l=0.15
X7 a_381_47# D VPWR VPB sky130_fd_pr__pfet_01v8_hvt ad=0.12495 pd=1.175 as=0.2184 ps=2.2 w=0.84 l=0.15
X8 a_652_21# SET_B VPWR VPB sky130_fd_pr__pfet_01v8_hvt ad=0.0567 pd=0.69 as=0.0798 ps=0.8 w=0.42 l=0.15
X9 a_1224_47# a_27_47# a_1032_413# VNB sky130_fd_pr__nfet_01v8 ad=0.0441 pd=0.63 as=0.0693 ps=0.75 w=0.42 l=0.15
X10 a_562_413# a_27_47# a_476_47# VPB sky130_fd_pr__pfet_01v8_hvt ad=0.0945 pd=0.87 as=0.0567 ps=0.69 w=0.42 l=0.15
X11 VGND a_1032_413# a_1602_47# VNB sky130_fd_pr__nfet_01v8 ad=0.097 pd=0.975 as=0.1092 ps=1.36 w=0.42 l=0.15
X12 VPWR a_1182_261# a_1140_413# VPB sky130_fd_pr__pfet_01v8_hvt ad=0.1092 pd=1.36 as=0.0441 ps=0.63 w=0.42 l=0.15
X13 Q a_1602_47# VPWR VPB sky130_fd_pr__pfet_01v8_hvt ad=0.26 pd=2.52 as=0.149 ps=1.325 w=1 l=0.15
X14 a_1032_413# a_193_47# a_1056_47# VNB sky130_fd_pr__nfet_01v8 ad=0.0693 pd=0.75 as=0.0441 ps=0.63 w=0.42 l=0.15
X15 a_476_47# a_193_47# a_381_47# VPB sky130_fd_pr__pfet_01v8_hvt ad=0.0567 pd=0.69 as=0.12495 ps=1.175 w=0.42 l=0.15
X16 a_1296_47# a_1182_261# a_1224_47# VNB sky130_fd_pr__nfet_01v8 ad=0.0483 pd=0.65 as=0.0441 ps=0.63 w=0.42 l=0.15
X17 a_193_47# a_27_47# VGND VNB sky130_fd_pr__nfet_01v8 ad=0.1092 pd=1.36 as=0.0567 ps=0.69 w=0.42 l=0.15
X18 VPWR a_652_21# a_562_413# VPB sky130_fd_pr__pfet_01v8_hvt ad=0.0798 pd=0.8 as=0.0945 ps=0.87 w=0.42 l=0.15
X19 VPWR SET_B a_1032_413# VPB sky130_fd_pr__pfet_01v8_hvt ad=0.12285 pd=1.17 as=0.1092 ps=1.36 w=0.42 l=0.15
X20 a_1032_413# a_27_47# a_956_413# VPB sky130_fd_pr__pfet_01v8_hvt ad=0.0819 pd=0.81 as=0.0483 ps=0.65 w=0.42 l=0.15
X21 a_1182_261# a_1032_413# VPWR VPB sky130_fd_pr__pfet_01v8_hvt ad=0.2184 pd=2.2 as=0.12285 ps=1.17 w=0.84 l=0.15
X22 Q a_1602_47# VGND VNB sky130_fd_pr__nfet_01v8 ad=0.169 pd=1.82 as=0.097 ps=0.975 w=0.65 l=0.15
X23 a_193_47# a_27_47# VPWR VPB sky130_fd_pr__pfet_01v8_hvt ad=0.1664 pd=1.8 as=0.0864 ps=0.91 w=0.64 l=0.15
X24 a_1140_413# a_193_47# a_1032_413# VPB sky130_fd_pr__pfet_01v8_hvt ad=0.0441 pd=0.63 as=0.0819 ps=0.81 w=0.42 l=0.15
X25 VPWR a_1032_413# a_1602_47# VPB sky130_fd_pr__pfet_01v8_hvt ad=0.149 pd=1.325 as=0.1664 ps=1.8 w=0.64 l=0.15
X26 a_796_47# SET_B VGND VNB sky130_fd_pr__nfet_01v8 ad=0.0441 pd=0.63 as=0.0882 ps=0.84 w=0.42 l=0.15
X27 a_381_47# D VGND VNB sky130_fd_pr__nfet_01v8 ad=0.0935 pd=0.965 as=0.1664 ps=1.8 w=0.64 l=0.15
X28 a_1182_261# a_1032_413# VGND VNB sky130_fd_pr__nfet_01v8 ad=0.1404 pd=1.6 as=0.1137 ps=1.01 w=0.54 l=0.15
X29 a_652_21# a_476_47# a_796_47# VNB sky130_fd_pr__nfet_01v8 ad=0.1092 pd=1.36 as=0.0441 ps=0.63 w=0.42 l=0.15
X30 VGND CLK a_27_47# VNB sky130_fd_pr__nfet_01v8 ad=0.0567 pd=0.69 as=0.1092 ps=1.36 w=0.42 l=0.15
X31 VGND SET_B a_1296_47# VNB sky130_fd_pr__nfet_01v8 ad=0.1137 pd=1.01 as=0.0483 ps=0.65 w=0.42 l=0.15
.ends

.subckt sky130_fd_sc_hd__xnor2_1 A B VGND VNB VPB VPWR Y
X0 a_377_297# A VPWR VPB sky130_fd_pr__pfet_01v8_hvt ad=0.105 pd=1.21 as=0.365 ps=1.73 w=1 l=0.15
X1 a_47_47# B VPWR VPB sky130_fd_pr__pfet_01v8_hvt ad=0.135 pd=1.27 as=0.3 ps=2.6 w=1 l=0.15
X2 a_129_47# B a_47_47# VNB sky130_fd_pr__nfet_01v8 ad=0.06825 pd=0.86 as=0.169 ps=1.82 w=0.65 l=0.15
X3 a_285_47# B VGND VNB sky130_fd_pr__nfet_01v8 ad=0.08775 pd=0.92 as=0.169 ps=1.82 w=0.65 l=0.15
X4 Y a_47_47# a_285_47# VNB sky130_fd_pr__nfet_01v8 ad=0.195 pd=1.9 as=0.08775 ps=0.92 w=0.65 l=0.15
X5 VGND A a_129_47# VNB sky130_fd_pr__nfet_01v8 ad=0.08775 pd=0.92 as=0.06825 ps=0.86 w=0.65 l=0.15
X6 VPWR A a_47_47# VPB sky130_fd_pr__pfet_01v8_hvt ad=0.365 pd=1.73 as=0.135 ps=1.27 w=1 l=0.15
X7 VPWR a_47_47# Y VPB sky130_fd_pr__pfet_01v8_hvt ad=0.36 pd=2.72 as=0.165 ps=1.33 w=1 l=0.15
X8 Y B a_377_297# VPB sky130_fd_pr__pfet_01v8_hvt ad=0.165 pd=1.33 as=0.105 ps=1.21 w=1 l=0.15
X9 a_285_47# A VGND VNB sky130_fd_pr__nfet_01v8 ad=0.169 pd=1.82 as=0.08775 ps=0.92 w=0.65 l=0.15
.ends

.subckt sky130_fd_sc_hd__inv_8 A VGND VNB VPB VPWR Y
X0 VPWR A Y VPB sky130_fd_pr__pfet_01v8_hvt ad=0.135 pd=1.27 as=0.135 ps=1.27 w=1 l=0.15
X1 Y A VPWR VPB sky130_fd_pr__pfet_01v8_hvt ad=0.135 pd=1.27 as=0.135 ps=1.27 w=1 l=0.15
X2 Y A VGND VNB sky130_fd_pr__nfet_01v8 ad=0.08775 pd=0.92 as=0.08775 ps=0.92 w=0.65 l=0.15
X3 Y A VGND VNB sky130_fd_pr__nfet_01v8 ad=0.08775 pd=0.92 as=0.08775 ps=0.92 w=0.65 l=0.15
X4 VPWR A Y VPB sky130_fd_pr__pfet_01v8_hvt ad=0.135 pd=1.27 as=0.135 ps=1.27 w=1 l=0.15
X5 Y A VPWR VPB sky130_fd_pr__pfet_01v8_hvt ad=0.135 pd=1.27 as=0.26 ps=2.52 w=1 l=0.15
X6 Y A VGND VNB sky130_fd_pr__nfet_01v8 ad=0.08775 pd=0.92 as=0.169 ps=1.82 w=0.65 l=0.15
X7 VPWR A Y VPB sky130_fd_pr__pfet_01v8_hvt ad=0.26 pd=2.52 as=0.135 ps=1.27 w=1 l=0.15
X8 Y A VGND VNB sky130_fd_pr__nfet_01v8 ad=0.08775 pd=0.92 as=0.08775 ps=0.92 w=0.65 l=0.15
X9 Y A VPWR VPB sky130_fd_pr__pfet_01v8_hvt ad=0.135 pd=1.27 as=0.135 ps=1.27 w=1 l=0.15
X10 VPWR A Y VPB sky130_fd_pr__pfet_01v8_hvt ad=0.135 pd=1.27 as=0.135 ps=1.27 w=1 l=0.15
X11 VGND A Y VNB sky130_fd_pr__nfet_01v8 ad=0.08775 pd=0.92 as=0.08775 ps=0.92 w=0.65 l=0.15
X12 VGND A Y VNB sky130_fd_pr__nfet_01v8 ad=0.08775 pd=0.92 as=0.08775 ps=0.92 w=0.65 l=0.15
X13 VGND A Y VNB sky130_fd_pr__nfet_01v8 ad=0.08775 pd=0.92 as=0.08775 ps=0.92 w=0.65 l=0.15
X14 Y A VPWR VPB sky130_fd_pr__pfet_01v8_hvt ad=0.135 pd=1.27 as=0.135 ps=1.27 w=1 l=0.15
X15 VGND A Y VNB sky130_fd_pr__nfet_01v8 ad=0.169 pd=1.82 as=0.08775 ps=0.92 w=0.65 l=0.15
.ends

.subckt sky130_fd_sc_hd__dlymetal6s2s_1 A VGND VNB VPB VPWR X
X0 a_558_47# a_381_47# VPWR VPB sky130_fd_pr__pfet_01v8_hvt ad=0.26 pd=2.52 as=0.14075 ps=1.325 w=1 l=0.15
X1 VGND X a_381_47# VNB sky130_fd_pr__nfet_01v8 ad=0.097 pd=0.975 as=0.1092 ps=1.36 w=0.42 l=0.15
X2 a_841_47# a_664_47# VPWR VPB sky130_fd_pr__pfet_01v8_hvt ad=0.26 pd=2.52 as=0.14075 ps=1.325 w=1 l=0.15
X3 VPWR A a_62_47# VPB sky130_fd_pr__pfet_01v8_hvt ad=0.14075 pd=1.325 as=0.1092 ps=1.36 w=0.42 l=0.15
X4 VGND A a_62_47# VNB sky130_fd_pr__nfet_01v8 ad=0.097 pd=0.975 as=0.1092 ps=1.36 w=0.42 l=0.15
X5 a_558_47# a_381_47# VGND VNB sky130_fd_pr__nfet_01v8 ad=0.169 pd=1.82 as=0.097 ps=0.975 w=0.65 l=0.15
X6 X a_62_47# VPWR VPB sky130_fd_pr__pfet_01v8_hvt ad=0.26 pd=2.52 as=0.14075 ps=1.325 w=1 l=0.15
X7 VPWR X a_381_47# VPB sky130_fd_pr__pfet_01v8_hvt ad=0.14075 pd=1.325 as=0.1092 ps=1.36 w=0.42 l=0.15
X8 a_841_47# a_664_47# VGND VNB sky130_fd_pr__nfet_01v8 ad=0.169 pd=1.82 as=0.097 ps=0.975 w=0.65 l=0.15
X9 X a_62_47# VGND VNB sky130_fd_pr__nfet_01v8 ad=0.169 pd=1.82 as=0.097 ps=0.975 w=0.65 l=0.15
X10 VPWR a_558_47# a_664_47# VPB sky130_fd_pr__pfet_01v8_hvt ad=0.14075 pd=1.325 as=0.1092 ps=1.36 w=0.42 l=0.15
X11 VGND a_558_47# a_664_47# VNB sky130_fd_pr__nfet_01v8 ad=0.097 pd=0.975 as=0.1092 ps=1.36 w=0.42 l=0.15
.ends

.subckt sky130_fd_sc_hd__buf_1 A VGND VNB VPB VPWR X
X0 VPWR A a_27_47# VPB sky130_fd_pr__pfet_01v8_hvt ad=0.11455 pd=1.08 as=0.2054 ps=2.1 w=0.79 l=0.15
X1 X a_27_47# VGND VNB sky130_fd_pr__nfet_01v8 ad=0.1352 pd=1.56 as=0.0754 ps=0.81 w=0.52 l=0.15
X2 X a_27_47# VPWR VPB sky130_fd_pr__pfet_01v8_hvt ad=0.2054 pd=2.1 as=0.11455 ps=1.08 w=0.79 l=0.15
X3 VGND A a_27_47# VNB sky130_fd_pr__nfet_01v8 ad=0.0754 pd=0.81 as=0.1352 ps=1.56 w=0.52 l=0.15
.ends

.subckt sky130_fd_sc_hd__clkinv_4 A VGND VNB VPB VPWR Y
X0 Y A VPWR VPB sky130_fd_pr__pfet_01v8_hvt ad=0.14 pd=1.28 as=0.14 ps=1.28 w=1 l=0.15
X1 VGND A Y VNB sky130_fd_pr__nfet_01v8 ad=0.1659 pd=1.63 as=0.0588 ps=0.7 w=0.42 l=0.15
X2 VGND A Y VNB sky130_fd_pr__nfet_01v8 ad=0.0588 pd=0.7 as=0.0588 ps=0.7 w=0.42 l=0.15
X3 VPWR A Y VPB sky130_fd_pr__pfet_01v8_hvt ad=0.14 pd=1.28 as=0.14 ps=1.28 w=1 l=0.15
X4 VPWR A Y VPB sky130_fd_pr__pfet_01v8_hvt ad=0.345 pd=2.69 as=0.14 ps=1.28 w=1 l=0.15
X5 Y A VGND VNB sky130_fd_pr__nfet_01v8 ad=0.0588 pd=0.7 as=0.0588 ps=0.7 w=0.42 l=0.15
X6 Y A VPWR VPB sky130_fd_pr__pfet_01v8_hvt ad=0.14 pd=1.28 as=0.305 ps=2.61 w=1 l=0.15
X7 Y A VGND VNB sky130_fd_pr__nfet_01v8 ad=0.0588 pd=0.7 as=0.1386 ps=1.5 w=0.42 l=0.15
X8 Y A VPWR VPB sky130_fd_pr__pfet_01v8_hvt ad=0.14 pd=1.28 as=0.14 ps=1.28 w=1 l=0.15
X9 VPWR A Y VPB sky130_fd_pr__pfet_01v8_hvt ad=0.14 pd=1.28 as=0.14 ps=1.28 w=1 l=0.15
.ends

.subckt sky130_fd_sc_hd__inv_4 A VGND VNB VPB VPWR Y
X0 VPWR A Y VPB sky130_fd_pr__pfet_01v8_hvt ad=0.26 pd=2.52 as=0.135 ps=1.27 w=1 l=0.15
X1 Y A VPWR VPB sky130_fd_pr__pfet_01v8_hvt ad=0.135 pd=1.27 as=0.135 ps=1.27 w=1 l=0.15
X2 Y A VGND VNB sky130_fd_pr__nfet_01v8 ad=0.08775 pd=0.92 as=0.169 ps=1.82 w=0.65 l=0.15
X3 VPWR A Y VPB sky130_fd_pr__pfet_01v8_hvt ad=0.135 pd=1.27 as=0.135 ps=1.27 w=1 l=0.15
X4 VGND A Y VNB sky130_fd_pr__nfet_01v8 ad=0.08775 pd=0.92 as=0.08775 ps=0.92 w=0.65 l=0.15
X5 Y A VPWR VPB sky130_fd_pr__pfet_01v8_hvt ad=0.135 pd=1.27 as=0.26 ps=2.52 w=1 l=0.15
X6 VGND A Y VNB sky130_fd_pr__nfet_01v8 ad=0.169 pd=1.82 as=0.08775 ps=0.92 w=0.65 l=0.15
X7 Y A VGND VNB sky130_fd_pr__nfet_01v8 ad=0.08775 pd=0.92 as=0.08775 ps=0.92 w=0.65 l=0.15
.ends

.subckt sky130_fd_sc_hd__a21o_2 A1 A2 B1 VGND VNB VPB VPWR X
X0 VPWR a_80_199# X VPB sky130_fd_pr__pfet_01v8_hvt ad=0.265 pd=2.53 as=0.14 ps=1.28 w=1 l=0.15
X1 X a_80_199# VPWR VPB sky130_fd_pr__pfet_01v8_hvt ad=0.14 pd=1.28 as=0.265 ps=2.53 w=1 l=0.15
X2 VGND a_80_199# X VNB sky130_fd_pr__nfet_01v8 ad=0.1105 pd=0.99 as=0.091 ps=0.93 w=0.65 l=0.15
X3 a_386_297# A2 VPWR VPB sky130_fd_pr__pfet_01v8_hvt ad=0.26 pd=2.52 as=0.1575 ps=1.315 w=1 l=0.15
X4 X a_80_199# VGND VNB sky130_fd_pr__nfet_01v8 ad=0.091 pd=0.93 as=0.17225 ps=1.83 w=0.65 l=0.15
X5 a_80_199# B1 VGND VNB sky130_fd_pr__nfet_01v8 ad=0.1625 pd=1.15 as=0.1105 ps=0.99 w=0.65 l=0.15
X6 a_386_297# B1 a_80_199# VPB sky130_fd_pr__pfet_01v8_hvt ad=0.14 pd=1.28 as=0.265 ps=2.53 w=1 l=0.15
X7 a_458_47# A1 a_80_199# VNB sky130_fd_pr__nfet_01v8 ad=0.1235 pd=1.03 as=0.1625 ps=1.15 w=0.65 l=0.15
X8 VPWR A1 a_386_297# VPB sky130_fd_pr__pfet_01v8_hvt ad=0.1575 pd=1.315 as=0.14 ps=1.28 w=1 l=0.15
X9 VGND A2 a_458_47# VNB sky130_fd_pr__nfet_01v8 ad=0.17225 pd=1.83 as=0.1235 ps=1.03 w=0.65 l=0.15
.ends

.subckt sky130_fd_sc_hd__nor2_4 A B VGND VNB VPB VPWR Y
X0 VPWR A a_27_297# VPB sky130_fd_pr__pfet_01v8_hvt ad=0.135 pd=1.27 as=0.135 ps=1.27 w=1 l=0.15
X1 Y A VGND VNB sky130_fd_pr__nfet_01v8 ad=0.08775 pd=0.92 as=0.08775 ps=0.92 w=0.65 l=0.15
X2 a_27_297# A VPWR VPB sky130_fd_pr__pfet_01v8_hvt ad=0.135 pd=1.27 as=0.135 ps=1.27 w=1 l=0.15
X3 VGND A Y VNB sky130_fd_pr__nfet_01v8 ad=0.08775 pd=0.92 as=0.08775 ps=0.92 w=0.65 l=0.15
X4 a_27_297# B Y VPB sky130_fd_pr__pfet_01v8_hvt ad=0.27 pd=2.54 as=0.135 ps=1.27 w=1 l=0.15
X5 Y A VGND VNB sky130_fd_pr__nfet_01v8 ad=0.08775 pd=0.92 as=0.182 ps=1.86 w=0.65 l=0.15
X6 VGND A Y VNB sky130_fd_pr__nfet_01v8 ad=0.08775 pd=0.92 as=0.08775 ps=0.92 w=0.65 l=0.15
X7 VGND B Y VNB sky130_fd_pr__nfet_01v8 ad=0.08775 pd=0.92 as=0.08775 ps=0.92 w=0.65 l=0.15
X8 VGND B Y VNB sky130_fd_pr__nfet_01v8 ad=0.169 pd=1.82 as=0.08775 ps=0.92 w=0.65 l=0.15
X9 Y B a_27_297# VPB sky130_fd_pr__pfet_01v8_hvt ad=0.135 pd=1.27 as=0.135 ps=1.27 w=1 l=0.15
X10 VPWR A a_27_297# VPB sky130_fd_pr__pfet_01v8_hvt ad=0.135 pd=1.27 as=0.28 ps=2.56 w=1 l=0.15
X11 Y B VGND VNB sky130_fd_pr__nfet_01v8 ad=0.08775 pd=0.92 as=0.08775 ps=0.92 w=0.65 l=0.15
X12 Y B VGND VNB sky130_fd_pr__nfet_01v8 ad=0.08775 pd=0.92 as=0.08775 ps=0.92 w=0.65 l=0.15
X13 a_27_297# B Y VPB sky130_fd_pr__pfet_01v8_hvt ad=0.135 pd=1.27 as=0.135 ps=1.27 w=1 l=0.15
X14 Y B a_27_297# VPB sky130_fd_pr__pfet_01v8_hvt ad=0.135 pd=1.27 as=0.135 ps=1.27 w=1 l=0.15
X15 a_27_297# A VPWR VPB sky130_fd_pr__pfet_01v8_hvt ad=0.135 pd=1.27 as=0.135 ps=1.27 w=1 l=0.15
.ends

.subckt sky130_fd_sc_hd__and4_4 A B C D VGND VNB VPB VPWR X
X0 VPWR a_27_47# X VPB sky130_fd_pr__pfet_01v8_hvt ad=0.26 pd=2.52 as=0.135 ps=1.27 w=1 l=0.15
X1 X a_27_47# VPWR VPB sky130_fd_pr__pfet_01v8_hvt ad=0.135 pd=1.27 as=0.135 ps=1.27 w=1 l=0.15
X2 a_188_47# B a_109_47# VNB sky130_fd_pr__nfet_01v8 ad=0.10887 pd=0.985 as=0.07963 ps=0.895 w=0.65 l=0.15
X3 VPWR a_27_47# X VPB sky130_fd_pr__pfet_01v8_hvt ad=0.135 pd=1.27 as=0.135 ps=1.27 w=1 l=0.15
X4 VGND D a_285_47# VNB sky130_fd_pr__nfet_01v8 ad=0.10563 pd=0.975 as=0.14138 ps=1.085 w=0.65 l=0.15
X5 VPWR D a_27_47# VPB sky130_fd_pr__pfet_01v8_hvt ad=0.165 pd=1.33 as=0.215 ps=1.43 w=1 l=0.15
X6 X a_27_47# VPWR VPB sky130_fd_pr__pfet_01v8_hvt ad=0.135 pd=1.27 as=0.165 ps=1.33 w=1 l=0.15
X7 VGND a_27_47# X VNB sky130_fd_pr__nfet_01v8 ad=0.08775 pd=0.92 as=0.08775 ps=0.92 w=0.65 l=0.15
X8 VPWR B a_27_47# VPB sky130_fd_pr__pfet_01v8_hvt ad=0.155 pd=1.31 as=0.135 ps=1.27 w=1 l=0.15
X9 X a_27_47# VGND VNB sky130_fd_pr__nfet_01v8 ad=0.08775 pd=0.92 as=0.10563 ps=0.975 w=0.65 l=0.15
X10 X a_27_47# VGND VNB sky130_fd_pr__nfet_01v8 ad=0.08775 pd=0.92 as=0.08775 ps=0.92 w=0.65 l=0.15
X11 a_27_47# C VPWR VPB sky130_fd_pr__pfet_01v8_hvt ad=0.215 pd=1.43 as=0.155 ps=1.31 w=1 l=0.15
X12 VGND a_27_47# X VNB sky130_fd_pr__nfet_01v8 ad=0.169 pd=1.82 as=0.08775 ps=0.92 w=0.65 l=0.15
X13 a_27_47# A VPWR VPB sky130_fd_pr__pfet_01v8_hvt ad=0.135 pd=1.27 as=0.26 ps=2.52 w=1 l=0.15
X14 a_285_47# C a_188_47# VNB sky130_fd_pr__nfet_01v8 ad=0.14138 pd=1.085 as=0.10887 ps=0.985 w=0.65 l=0.15
X15 a_109_47# A a_27_47# VNB sky130_fd_pr__nfet_01v8 ad=0.07963 pd=0.895 as=0.169 ps=1.82 w=0.65 l=0.15
.ends

.subckt sky130_fd_sc_hd__o21ba_1 A1 A2 B1_N VGND VNB VPB VPWR X
X0 a_222_93# B1_N VGND VNB sky130_fd_pr__nfet_01v8 ad=0.1092 pd=1.36 as=0.10025 ps=0.985 w=0.42 l=0.15
X1 VPWR A1 a_544_297# VPB sky130_fd_pr__pfet_01v8_hvt ad=0.28 pd=2.56 as=0.105 ps=1.21 w=1 l=0.15
X2 VGND a_79_199# X VNB sky130_fd_pr__nfet_01v8 ad=0.10025 pd=0.985 as=0.169 ps=1.82 w=0.65 l=0.15
X3 a_222_93# B1_N VPWR VPB sky130_fd_pr__pfet_01v8_hvt ad=0.1176 pd=1.4 as=0.18575 ps=1.415 w=0.42 l=0.15
X4 VGND A2 a_448_47# VNB sky130_fd_pr__nfet_01v8 ad=0.08775 pd=0.92 as=0.10725 ps=0.98 w=0.65 l=0.15
X5 a_448_47# a_222_93# a_79_199# VNB sky130_fd_pr__nfet_01v8 ad=0.10725 pd=0.98 as=0.169 ps=1.82 w=0.65 l=0.15
X6 a_79_199# a_222_93# VPWR VPB sky130_fd_pr__pfet_01v8_hvt ad=0.165 pd=1.33 as=0.3 ps=2.6 w=1 l=0.15
X7 a_544_297# A2 a_79_199# VPB sky130_fd_pr__pfet_01v8_hvt ad=0.105 pd=1.21 as=0.165 ps=1.33 w=1 l=0.15
X8 a_448_47# A1 VGND VNB sky130_fd_pr__nfet_01v8 ad=0.17225 pd=1.83 as=0.08775 ps=0.92 w=0.65 l=0.15
X9 VPWR a_79_199# X VPB sky130_fd_pr__pfet_01v8_hvt ad=0.18575 pd=1.415 as=0.26 ps=2.52 w=1 l=0.15
.ends

.subckt sky130_fd_sc_hd__a311o_1 A1 A2 A3 B1 C1 VGND VNB VPB VPWR X
X0 a_75_199# C1 VGND VNB sky130_fd_pr__nfet_01v8 ad=0.169 pd=1.82 as=0.13487 ps=1.065 w=0.65 l=0.15
X1 a_208_47# A3 VGND VNB sky130_fd_pr__nfet_01v8 ad=0.12513 pd=1.035 as=0.11213 ps=0.995 w=0.65 l=0.15
X2 a_315_47# A2 a_208_47# VNB sky130_fd_pr__nfet_01v8 ad=0.169 pd=1.17 as=0.12513 ps=1.035 w=0.65 l=0.15
X3 VGND B1 a_75_199# VNB sky130_fd_pr__nfet_01v8 ad=0.13487 pd=1.065 as=0.10563 ps=0.975 w=0.65 l=0.15
X4 a_75_199# A1 a_315_47# VNB sky130_fd_pr__nfet_01v8 ad=0.10563 pd=0.975 as=0.169 ps=1.17 w=0.65 l=0.15
X5 a_75_199# C1 a_544_297# VPB sky130_fd_pr__pfet_01v8_hvt ad=0.26 pd=2.52 as=0.2075 ps=1.415 w=1 l=0.15
X6 a_544_297# B1 a_201_297# VPB sky130_fd_pr__pfet_01v8_hvt ad=0.2075 pd=1.415 as=0.1625 ps=1.325 w=1 l=0.15
X7 VPWR a_75_199# X VPB sky130_fd_pr__pfet_01v8_hvt ad=0.1425 pd=1.285 as=0.285 ps=2.57 w=1 l=0.15
X8 a_201_297# A3 VPWR VPB sky130_fd_pr__pfet_01v8_hvt ad=0.165 pd=1.33 as=0.1425 ps=1.285 w=1 l=0.15
X9 VPWR A2 a_201_297# VPB sky130_fd_pr__pfet_01v8_hvt ad=0.305 pd=1.61 as=0.165 ps=1.33 w=1 l=0.15
X10 a_201_297# A1 VPWR VPB sky130_fd_pr__pfet_01v8_hvt ad=0.1625 pd=1.325 as=0.305 ps=1.61 w=1 l=0.15
X11 VGND a_75_199# X VNB sky130_fd_pr__nfet_01v8 ad=0.11213 pd=0.995 as=0.169 ps=1.82 w=0.65 l=0.15
.ends

.subckt sky130_fd_sc_hd__clkbuf_1 A VGND VNB VPB VPWR X
X0 VPWR a_75_212# X VPB sky130_fd_pr__pfet_01v8_hvt ad=0.11455 pd=1.08 as=0.2054 ps=2.1 w=0.79 l=0.15
X1 a_75_212# A VGND VNB sky130_fd_pr__nfet_01v8 ad=0.1352 pd=1.56 as=0.0754 ps=0.81 w=0.52 l=0.15
X2 a_75_212# A VPWR VPB sky130_fd_pr__pfet_01v8_hvt ad=0.2054 pd=2.1 as=0.11455 ps=1.08 w=0.79 l=0.15
X3 VGND a_75_212# X VNB sky130_fd_pr__nfet_01v8 ad=0.0754 pd=0.81 as=0.1352 ps=1.56 w=0.52 l=0.15
.ends

.subckt sky130_fd_sc_hd__and4bb_2 A_N B_N C D VGND VNB VPB VPWR X
X0 a_174_21# C VPWR VPB sky130_fd_pr__pfet_01v8_hvt ad=0.0567 pd=0.69 as=0.0588 ps=0.7 w=0.42 l=0.15
X1 a_174_21# a_27_47# VPWR VPB sky130_fd_pr__pfet_01v8_hvt ad=0.0672 pd=0.74 as=0.33075 ps=1.705 w=0.42 l=0.15
X2 a_476_47# a_27_47# a_174_21# VNB sky130_fd_pr__nfet_01v8 ad=0.0441 pd=0.63 as=0.1092 ps=1.36 w=0.42 l=0.15
X3 VPWR a_174_21# X VPB sky130_fd_pr__pfet_01v8_hvt ad=0.33075 pd=1.705 as=0.135 ps=1.27 w=1 l=0.15
X4 X a_174_21# VPWR VPB sky130_fd_pr__pfet_01v8_hvt ad=0.135 pd=1.27 as=0.14075 ps=1.325 w=1 l=0.15
X5 a_548_47# a_505_280# a_476_47# VNB sky130_fd_pr__nfet_01v8 ad=0.06405 pd=0.725 as=0.0441 ps=0.63 w=0.42 l=0.15
X6 VPWR A_N a_27_47# VPB sky130_fd_pr__pfet_01v8_hvt ad=0.14075 pd=1.325 as=0.1092 ps=1.36 w=0.42 l=0.15
X7 X a_174_21# VGND VNB sky130_fd_pr__nfet_01v8 ad=0.08775 pd=0.92 as=0.097 ps=0.975 w=0.65 l=0.15
X8 VPWR D a_174_21# VPB sky130_fd_pr__pfet_01v8_hvt ad=0.0924 pd=0.86 as=0.0567 ps=0.69 w=0.42 l=0.15
X9 VGND D a_639_47# VNB sky130_fd_pr__nfet_01v8 ad=0.0924 pd=0.86 as=0.0567 ps=0.69 w=0.42 l=0.15
X10 VPWR a_505_280# a_174_21# VPB sky130_fd_pr__pfet_01v8_hvt ad=0.0588 pd=0.7 as=0.0672 ps=0.74 w=0.42 l=0.15
X11 a_505_280# B_N VPWR VPB sky130_fd_pr__pfet_01v8_hvt ad=0.1092 pd=1.36 as=0.0924 ps=0.86 w=0.42 l=0.15
X12 VGND a_174_21# X VNB sky130_fd_pr__nfet_01v8 ad=0.169 pd=1.82 as=0.08775 ps=0.92 w=0.65 l=0.15
X13 a_505_280# B_N VGND VNB sky130_fd_pr__nfet_01v8 ad=0.1092 pd=1.36 as=0.0924 ps=0.86 w=0.42 l=0.15
X14 a_639_47# C a_548_47# VNB sky130_fd_pr__nfet_01v8 ad=0.0567 pd=0.69 as=0.06405 ps=0.725 w=0.42 l=0.15
X15 VGND A_N a_27_47# VNB sky130_fd_pr__nfet_01v8 ad=0.097 pd=0.975 as=0.1092 ps=1.36 w=0.42 l=0.15
.ends

.subckt sky130_fd_sc_hd__nand4_1 A B C D VGND VNB VPB VPWR Y
X0 Y B VPWR VPB sky130_fd_pr__pfet_01v8_hvt ad=0.165 pd=1.33 as=0.135 ps=1.27 w=1 l=0.15
X1 VPWR A Y VPB sky130_fd_pr__pfet_01v8_hvt ad=0.3 pd=2.6 as=0.165 ps=1.33 w=1 l=0.15
X2 VPWR C Y VPB sky130_fd_pr__pfet_01v8_hvt ad=0.135 pd=1.27 as=0.135 ps=1.27 w=1 l=0.15
X3 a_193_47# C a_109_47# VNB sky130_fd_pr__nfet_01v8 ad=0.08775 pd=0.92 as=0.08775 ps=0.92 w=0.65 l=0.15
X4 Y A a_277_47# VNB sky130_fd_pr__nfet_01v8 ad=0.195 pd=1.9 as=0.10725 ps=0.98 w=0.65 l=0.15
X5 a_277_47# B a_193_47# VNB sky130_fd_pr__nfet_01v8 ad=0.10725 pd=0.98 as=0.08775 ps=0.92 w=0.65 l=0.15
X6 Y D VPWR VPB sky130_fd_pr__pfet_01v8_hvt ad=0.135 pd=1.27 as=0.26 ps=2.52 w=1 l=0.15
X7 a_109_47# D VGND VNB sky130_fd_pr__nfet_01v8 ad=0.08775 pd=0.92 as=0.169 ps=1.82 w=0.65 l=0.15
.ends

.subckt sky130_fd_sc_hd__nor3b_4 A B C_N VGND VNB VPB VPWR Y
X0 Y B VGND VNB sky130_fd_pr__nfet_01v8 ad=0.08775 pd=0.92 as=0.08775 ps=0.92 w=0.65 l=0.15
X1 VPWR A a_197_297# VPB sky130_fd_pr__pfet_01v8_hvt ad=0.135 pd=1.27 as=0.135 ps=1.27 w=1 l=0.15
X2 Y a_27_47# VGND VNB sky130_fd_pr__nfet_01v8 ad=0.08775 pd=0.92 as=0.08775 ps=0.92 w=0.65 l=0.15
X3 VGND A Y VNB sky130_fd_pr__nfet_01v8 ad=0.08775 pd=0.92 as=0.08775 ps=0.92 w=0.65 l=0.15
X4 a_555_297# a_27_47# Y VPB sky130_fd_pr__pfet_01v8_hvt ad=0.26 pd=2.52 as=0.135 ps=1.27 w=1 l=0.15
X5 a_197_297# A VPWR VPB sky130_fd_pr__pfet_01v8_hvt ad=0.135 pd=1.27 as=0.135 ps=1.27 w=1 l=0.15
X6 VGND a_27_47# Y VNB sky130_fd_pr__nfet_01v8 ad=0.08775 pd=0.92 as=0.08775 ps=0.92 w=0.65 l=0.15
X7 a_197_297# B a_555_297# VPB sky130_fd_pr__pfet_01v8_hvt ad=0.135 pd=1.27 as=0.26 ps=2.52 w=1 l=0.15
X8 VGND a_27_47# Y VNB sky130_fd_pr__nfet_01v8 ad=0.169 pd=1.82 as=0.08775 ps=0.92 w=0.65 l=0.15
X9 VGND B Y VNB sky130_fd_pr__nfet_01v8 ad=0.08775 pd=0.92 as=0.08775 ps=0.92 w=0.65 l=0.15
X10 Y A VGND VNB sky130_fd_pr__nfet_01v8 ad=0.08775 pd=0.92 as=0.08775 ps=0.92 w=0.65 l=0.15
X11 VGND C_N a_27_47# VNB sky130_fd_pr__nfet_01v8 ad=0.08775 pd=0.92 as=0.182 ps=1.86 w=0.65 l=0.15
X12 Y A VGND VNB sky130_fd_pr__nfet_01v8 ad=0.08775 pd=0.92 as=0.08775 ps=0.92 w=0.65 l=0.15
X13 Y a_27_47# a_555_297# VPB sky130_fd_pr__pfet_01v8_hvt ad=0.135 pd=1.27 as=0.135 ps=1.27 w=1 l=0.15
X14 Y a_27_47# a_555_297# VPB sky130_fd_pr__pfet_01v8_hvt ad=0.135 pd=1.27 as=0.135 ps=1.27 w=1 l=0.15
X15 VPWR C_N a_27_47# VPB sky130_fd_pr__pfet_01v8_hvt ad=0.135 pd=1.27 as=0.28 ps=2.56 w=1 l=0.15
X16 a_555_297# a_27_47# Y VPB sky130_fd_pr__pfet_01v8_hvt ad=0.135 pd=1.27 as=0.135 ps=1.27 w=1 l=0.15
X17 VGND A Y VNB sky130_fd_pr__nfet_01v8 ad=0.25675 pd=1.44 as=0.08775 ps=0.92 w=0.65 l=0.15
X18 a_555_297# B a_197_297# VPB sky130_fd_pr__pfet_01v8_hvt ad=0.135 pd=1.27 as=0.135 ps=1.27 w=1 l=0.15
X19 a_197_297# B a_555_297# VPB sky130_fd_pr__pfet_01v8_hvt ad=0.135 pd=1.27 as=0.135 ps=1.27 w=1 l=0.15
X20 VGND B Y VNB sky130_fd_pr__nfet_01v8 ad=0.08775 pd=0.92 as=0.08775 ps=0.92 w=0.65 l=0.15
X21 a_555_297# B a_197_297# VPB sky130_fd_pr__pfet_01v8_hvt ad=0.135 pd=1.27 as=0.135 ps=1.27 w=1 l=0.15
X22 VPWR A a_197_297# VPB sky130_fd_pr__pfet_01v8_hvt ad=0.26 pd=2.52 as=0.135 ps=1.27 w=1 l=0.15
X23 a_197_297# A VPWR VPB sky130_fd_pr__pfet_01v8_hvt ad=0.135 pd=1.27 as=0.135 ps=1.27 w=1 l=0.15
X24 Y B VGND VNB sky130_fd_pr__nfet_01v8 ad=0.08775 pd=0.92 as=0.25675 ps=1.44 w=0.65 l=0.15
X25 Y a_27_47# VGND VNB sky130_fd_pr__nfet_01v8 ad=0.08775 pd=0.92 as=0.08775 ps=0.92 w=0.65 l=0.15
.ends

.subckt sky130_fd_sc_hd__o311a_1 A1 A2 A3 B1 C1 VGND VNB VPB VPWR X
X0 a_585_47# B1 a_266_47# VNB sky130_fd_pr__nfet_01v8 ad=0.06825 pd=0.86 as=0.11863 ps=1.015 w=0.65 l=0.15
X1 VGND A2 a_266_47# VNB sky130_fd_pr__nfet_01v8 ad=0.1365 pd=1.07 as=0.117 ps=1.01 w=0.65 l=0.15
X2 VPWR a_81_21# X VPB sky130_fd_pr__pfet_01v8_hvt ad=0.3125 pd=1.625 as=0.26 ps=2.52 w=1 l=0.15
X3 a_81_21# C1 a_585_47# VNB sky130_fd_pr__nfet_01v8 ad=0.169 pd=1.82 as=0.06825 ps=0.86 w=0.65 l=0.15
X4 VGND a_81_21# X VNB sky130_fd_pr__nfet_01v8 ad=0.20312 pd=1.275 as=0.169 ps=1.82 w=0.65 l=0.15
X5 a_266_297# A1 VPWR VPB sky130_fd_pr__pfet_01v8_hvt ad=0.18 pd=1.36 as=0.3125 ps=1.625 w=1 l=0.15
X6 a_368_297# A2 a_266_297# VPB sky130_fd_pr__pfet_01v8_hvt ad=0.21 pd=1.42 as=0.18 ps=1.36 w=1 l=0.15
X7 a_266_47# A3 VGND VNB sky130_fd_pr__nfet_01v8 ad=0.11863 pd=1.015 as=0.1365 ps=1.07 w=0.65 l=0.15
X8 a_266_47# A1 VGND VNB sky130_fd_pr__nfet_01v8 ad=0.117 pd=1.01 as=0.20312 ps=1.275 w=0.65 l=0.15
X9 a_81_21# A3 a_368_297# VPB sky130_fd_pr__pfet_01v8_hvt ad=0.1375 pd=1.275 as=0.21 ps=1.42 w=1 l=0.15
X10 a_81_21# C1 VPWR VPB sky130_fd_pr__pfet_01v8_hvt ad=0.26 pd=2.52 as=0.15 ps=1.3 w=1 l=0.15
X11 VPWR B1 a_81_21# VPB sky130_fd_pr__pfet_01v8_hvt ad=0.15 pd=1.3 as=0.1375 ps=1.275 w=1 l=0.15
.ends

.subckt sky130_fd_sc_hd__nor3b_1 A B C_N VGND VNB VPB VPWR Y
X0 VGND a_91_199# Y VNB sky130_fd_pr__nfet_01v8 ad=0.08775 pd=0.92 as=0.221 ps=1.98 w=0.65 l=0.15
X1 Y B VGND VNB sky130_fd_pr__nfet_01v8 ad=0.08775 pd=0.92 as=0.08775 ps=0.92 w=0.65 l=0.15
X2 VPWR A a_245_297# VPB sky130_fd_pr__pfet_01v8_hvt ad=0.14575 pd=1.335 as=0.135 ps=1.27 w=1 l=0.15
X3 a_91_199# C_N VGND VNB sky130_fd_pr__nfet_01v8 ad=0.1092 pd=1.36 as=0.10025 ps=0.985 w=0.42 l=0.15
X4 VGND A Y VNB sky130_fd_pr__nfet_01v8 ad=0.10025 pd=0.985 as=0.08775 ps=0.92 w=0.65 l=0.15
X5 a_245_297# B a_161_297# VPB sky130_fd_pr__pfet_01v8_hvt ad=0.135 pd=1.27 as=0.135 ps=1.27 w=1 l=0.15
X6 a_91_199# C_N VPWR VPB sky130_fd_pr__pfet_01v8_hvt ad=0.1092 pd=1.36 as=0.14575 ps=1.335 w=0.42 l=0.15
X7 a_161_297# a_91_199# Y VPB sky130_fd_pr__pfet_01v8_hvt ad=0.135 pd=1.27 as=0.32 ps=2.64 w=1 l=0.15
.ends

.subckt sky130_fd_sc_hd__a31oi_1 A1 A2 A3 B1 VGND VNB VPB VPWR Y
X0 Y A1 a_181_47# VNB sky130_fd_pr__nfet_01v8 ad=0.10563 pd=0.975 as=0.11863 ps=1.015 w=0.65 l=0.15
X1 a_181_47# A2 a_109_47# VNB sky130_fd_pr__nfet_01v8 ad=0.11863 pd=1.015 as=0.06825 ps=0.86 w=0.65 l=0.15
X2 VGND B1 Y VNB sky130_fd_pr__nfet_01v8 ad=0.1755 pd=1.84 as=0.10563 ps=0.975 w=0.65 l=0.15
X3 VPWR A2 a_109_297# VPB sky130_fd_pr__pfet_01v8_hvt ad=0.1525 pd=1.305 as=0.135 ps=1.27 w=1 l=0.15
X4 Y B1 a_109_297# VPB sky130_fd_pr__pfet_01v8_hvt ad=0.27 pd=2.54 as=0.1625 ps=1.325 w=1 l=0.15
X5 a_109_297# A1 VPWR VPB sky130_fd_pr__pfet_01v8_hvt ad=0.1625 pd=1.325 as=0.1525 ps=1.305 w=1 l=0.15
X6 a_109_297# A3 VPWR VPB sky130_fd_pr__pfet_01v8_hvt ad=0.135 pd=1.27 as=0.26 ps=2.52 w=1 l=0.15
X7 a_109_47# A3 VGND VNB sky130_fd_pr__nfet_01v8 ad=0.06825 pd=0.86 as=0.169 ps=1.82 w=0.65 l=0.15
.ends

.subckt sky130_fd_sc_hd__o32a_1 A1 A2 A3 B1 B2 VGND VNB VPB VPWR X
X0 a_77_199# B2 a_227_47# VNB sky130_fd_pr__nfet_01v8 ad=0.13325 pd=1.06 as=0.12675 ps=1.04 w=0.65 l=0.15
X1 a_323_297# A2 a_227_297# VPB sky130_fd_pr__pfet_01v8_hvt ad=0.195 pd=1.39 as=0.165 ps=1.33 w=1 l=0.15
X2 a_227_297# A1 VPWR VPB sky130_fd_pr__pfet_01v8_hvt ad=0.165 pd=1.33 as=0.135 ps=1.27 w=1 l=0.15
X3 a_227_47# B1 a_77_199# VNB sky130_fd_pr__nfet_01v8 ad=0.1885 pd=1.88 as=0.13325 ps=1.06 w=0.65 l=0.15
X4 VGND a_77_199# X VNB sky130_fd_pr__nfet_01v8 ad=0.08775 pd=0.92 as=0.169 ps=1.82 w=0.65 l=0.15
X5 VPWR B1 a_539_297# VPB sky130_fd_pr__pfet_01v8_hvt ad=0.29 pd=2.58 as=0.205 ps=1.41 w=1 l=0.15
X6 a_227_47# A3 VGND VNB sky130_fd_pr__nfet_01v8 ad=0.12675 pd=1.04 as=0.12675 ps=1.04 w=0.65 l=0.15
X7 VPWR a_77_199# X VPB sky130_fd_pr__pfet_01v8_hvt ad=0.135 pd=1.27 as=0.335 ps=2.67 w=1 l=0.15
X8 a_77_199# A3 a_323_297# VPB sky130_fd_pr__pfet_01v8_hvt ad=0.195 pd=1.39 as=0.195 ps=1.39 w=1 l=0.15
X9 VGND A2 a_227_47# VNB sky130_fd_pr__nfet_01v8 ad=0.12675 pd=1.04 as=0.10725 ps=0.98 w=0.65 l=0.15
X10 a_227_47# A1 VGND VNB sky130_fd_pr__nfet_01v8 ad=0.10725 pd=0.98 as=0.08775 ps=0.92 w=0.65 l=0.15
X11 a_539_297# B2 a_77_199# VPB sky130_fd_pr__pfet_01v8_hvt ad=0.205 pd=1.41 as=0.195 ps=1.39 w=1 l=0.15
.ends

.subckt sky130_fd_sc_hd__and3b_1 A_N B C VGND VNB VPB VPWR X
X0 a_109_93# A_N VGND VNB sky130_fd_pr__nfet_01v8 ad=0.10785 pd=1.36 as=0.1092 ps=1.36 w=0.42 l=0.15
X1 X a_209_311# VPWR VPB sky130_fd_pr__pfet_01v8_hvt ad=0.26 pd=2.52 as=0.14222 ps=1.335 w=1 l=0.15
X2 a_109_93# A_N VPWR VPB sky130_fd_pr__pfet_01v8_hvt ad=0.1087 pd=1.36 as=0.1092 ps=1.36 w=0.42 l=0.15
X3 a_296_53# a_109_93# a_209_311# VNB sky130_fd_pr__nfet_01v8 ad=0.0441 pd=0.63 as=0.10783 ps=1.36 w=0.42 l=0.15
X4 VPWR C a_209_311# VPB sky130_fd_pr__pfet_01v8_hvt ad=0.14222 pd=1.335 as=0.07438 ps=0.815 w=0.42 l=0.15
X5 a_368_53# B a_296_53# VNB sky130_fd_pr__nfet_01v8 ad=0.05355 pd=0.675 as=0.0441 ps=0.63 w=0.42 l=0.15
X6 X a_209_311# VGND VNB sky130_fd_pr__nfet_01v8 ad=0.169 pd=1.82 as=0.12228 ps=1.08 w=0.65 l=0.15
X7 a_209_311# B VPWR VPB sky130_fd_pr__pfet_01v8_hvt ad=0.07438 pd=0.815 as=0.0567 ps=0.69 w=0.42 l=0.15
X8 VPWR a_109_93# a_209_311# VPB sky130_fd_pr__pfet_01v8_hvt ad=0.0567 pd=0.69 as=0.1085 ps=1.36 w=0.42 l=0.15
X9 VGND C a_368_53# VNB sky130_fd_pr__nfet_01v8 ad=0.12228 pd=1.08 as=0.05355 ps=0.675 w=0.42 l=0.15
.ends

.subckt sky130_fd_sc_hd__o31ai_1 A1 A2 A3 B1 VGND VNB VPB VPWR Y
X0 Y B1 a_109_47# VNB sky130_fd_pr__nfet_01v8 ad=0.221 pd=1.98 as=0.19825 ps=1.26 w=0.65 l=0.15
X1 Y A3 a_193_297# VPB sky130_fd_pr__pfet_01v8_hvt ad=0.3925 pd=1.785 as=0.135 ps=1.27 w=1 l=0.15
X2 a_193_297# A2 a_109_297# VPB sky130_fd_pr__pfet_01v8_hvt ad=0.135 pd=1.27 as=0.135 ps=1.27 w=1 l=0.15
X3 VGND A2 a_109_47# VNB sky130_fd_pr__nfet_01v8 ad=0.08775 pd=0.92 as=0.08775 ps=0.92 w=0.65 l=0.15
X4 VPWR B1 Y VPB sky130_fd_pr__pfet_01v8_hvt ad=0.3 pd=2.6 as=0.3925 ps=1.785 w=1 l=0.15
X5 a_109_47# A3 VGND VNB sky130_fd_pr__nfet_01v8 ad=0.19825 pd=1.26 as=0.08775 ps=0.92 w=0.65 l=0.15
X6 a_109_297# A1 VPWR VPB sky130_fd_pr__pfet_01v8_hvt ad=0.135 pd=1.27 as=0.26 ps=2.52 w=1 l=0.15
X7 a_109_47# A1 VGND VNB sky130_fd_pr__nfet_01v8 ad=0.08775 pd=0.92 as=0.169 ps=1.82 w=0.65 l=0.15
.ends

.subckt sky130_fd_sc_hd__diode_2 DIODE VGND VNB VPB VPWR
X0 VNB DIODE sky130_fd_pr__diode_pw2nd_05v5 perim=2.64e+06 area=4.347e+11
.ends

.subckt sky130_fd_sc_hd__nand4_2 A B C D VGND VNB VPB VPWR Y
X0 VPWR C Y VPB sky130_fd_pr__pfet_01v8_hvt ad=0.215 pd=1.43 as=0.135 ps=1.27 w=1 l=0.15
X1 a_471_47# B a_277_47# VNB sky130_fd_pr__nfet_01v8 ad=0.08775 pd=0.92 as=0.08775 ps=0.92 w=0.65 l=0.15
X2 Y C VPWR VPB sky130_fd_pr__pfet_01v8_hvt ad=0.135 pd=1.27 as=0.135 ps=1.27 w=1 l=0.15
X3 VPWR D Y VPB sky130_fd_pr__pfet_01v8_hvt ad=0.135 pd=1.27 as=0.135 ps=1.27 w=1 l=0.15
X4 VPWR A Y VPB sky130_fd_pr__pfet_01v8_hvt ad=0.42 pd=2.84 as=0.135 ps=1.27 w=1 l=0.15
X5 a_27_47# D VGND VNB sky130_fd_pr__nfet_01v8 ad=0.08775 pd=0.92 as=0.08775 ps=0.92 w=0.65 l=0.15
X6 a_27_47# C a_277_47# VNB sky130_fd_pr__nfet_01v8 ad=0.182 pd=1.86 as=0.08775 ps=0.92 w=0.65 l=0.15
X7 Y A VPWR VPB sky130_fd_pr__pfet_01v8_hvt ad=0.135 pd=1.27 as=0.335 ps=1.67 w=1 l=0.15
X8 a_277_47# B a_471_47# VNB sky130_fd_pr__nfet_01v8 ad=0.08775 pd=0.92 as=0.182 ps=1.86 w=0.65 l=0.15
X9 VPWR B Y VPB sky130_fd_pr__pfet_01v8_hvt ad=0.335 pd=1.67 as=0.135 ps=1.27 w=1 l=0.15
X10 Y A a_471_47# VNB sky130_fd_pr__nfet_01v8 ad=0.08775 pd=0.92 as=0.08775 ps=0.92 w=0.65 l=0.15
X11 a_277_47# C a_27_47# VNB sky130_fd_pr__nfet_01v8 ad=0.08775 pd=0.92 as=0.08775 ps=0.92 w=0.65 l=0.15
X12 Y B VPWR VPB sky130_fd_pr__pfet_01v8_hvt ad=0.135 pd=1.27 as=0.215 ps=1.43 w=1 l=0.15
X13 a_471_47# A Y VNB sky130_fd_pr__nfet_01v8 ad=0.234 pd=2.02 as=0.08775 ps=0.92 w=0.65 l=0.15
X14 Y D VPWR VPB sky130_fd_pr__pfet_01v8_hvt ad=0.135 pd=1.27 as=0.26 ps=2.52 w=1 l=0.15
X15 VGND D a_27_47# VNB sky130_fd_pr__nfet_01v8 ad=0.08775 pd=0.92 as=0.169 ps=1.82 w=0.65 l=0.15
.ends

.subckt sky130_fd_sc_hd__o2bb2a_1 A1_N A2_N B1 B2 VGND VNB VPB VPWR X
X0 a_206_369# A1_N VPWR VPB sky130_fd_pr__pfet_01v8_hvt ad=0.129 pd=1.18 as=0.14575 ps=1.335 w=0.42 l=0.15
X1 a_206_369# A2_N a_205_47# VNB sky130_fd_pr__nfet_01v8 ad=0.1092 pd=1.36 as=0.06615 ps=0.735 w=0.42 l=0.15
X2 VGND B2 a_489_47# VNB sky130_fd_pr__nfet_01v8 ad=0.0567 pd=0.69 as=0.0567 ps=0.69 w=0.42 l=0.15
X3 a_585_369# B2 a_76_199# VPB sky130_fd_pr__pfet_01v8_hvt ad=0.0441 pd=0.63 as=0.0672 ps=0.74 w=0.42 l=0.15
X4 a_489_47# a_206_369# a_76_199# VNB sky130_fd_pr__nfet_01v8 ad=0.0567 pd=0.69 as=0.1092 ps=1.36 w=0.42 l=0.15
X5 a_489_47# B1 VGND VNB sky130_fd_pr__nfet_01v8 ad=0.1092 pd=1.36 as=0.0567 ps=0.69 w=0.42 l=0.15
X6 VPWR A2_N a_206_369# VPB sky130_fd_pr__pfet_01v8_hvt ad=0.20925 pd=1.345 as=0.129 ps=1.18 w=0.42 l=0.15
X7 a_76_199# a_206_369# VPWR VPB sky130_fd_pr__pfet_01v8_hvt ad=0.0672 pd=0.74 as=0.20925 ps=1.345 w=0.42 l=0.15
X8 a_205_47# A1_N VGND VNB sky130_fd_pr__nfet_01v8 ad=0.06615 pd=0.735 as=0.09862 ps=0.98 w=0.42 l=0.15
X9 VPWR a_76_199# X VPB sky130_fd_pr__pfet_01v8_hvt ad=0.14575 pd=1.335 as=0.26 ps=2.52 w=1 l=0.15
X10 VPWR B1 a_585_369# VPB sky130_fd_pr__pfet_01v8_hvt ad=0.1092 pd=1.36 as=0.0441 ps=0.63 w=0.42 l=0.15
X11 VGND a_76_199# X VNB sky130_fd_pr__nfet_01v8 ad=0.09862 pd=0.98 as=0.169 ps=1.82 w=0.65 l=0.15
.ends

.subckt digital_core A8 A[0] A[1] A[2] A[3] A[4] B[0] B[1] B[2] B[3] B[4] C[0] C[1]
+ C[2] C[3] C[4] IOA_in[0] IOA_in[1] IOA_in[2] IOA_in[3] IOA_in[4] IOA_in[5] IOA_in[6]
+ IOA_in[7] IOA_oe IOA_out[0] IOA_out[1] IOA_out[2] IOA_out[3] IOA_out[4] IOA_out[5]
+ IOA_out[6] IOA_out[7] IOB_in[0] IOB_in[1] IOB_in[2] IOB_in[3] IOB_in[4] IOB_in[5]
+ IOB_in[6] IOB_in[7] IOB_oe IOB_out[0] IOB_out[1] IOB_out[2] IOB_out[3] IOB_out[4]
+ IOB_out[5] IOB_out[6] IOB_out[7] VGND VPWR bc1 bc2 bdir clk clk_en din[0] din[1]
+ din[2] din[3] din[4] din[5] din[6] din[7] dout[0] dout[1] dout[2] dout[3] dout[4]
+ dout[5] dout[6] dout[7] nA9 rst_n sample sel
XFILLER_54_203 VGND VGND VPWR VPWR sky130_fd_sc_hd__decap_4
XFILLER_52_29 VGND VPWR VPWR VGND sky130_ef_sc_hd__decap_12
XFILLER_10_339 VGND VPWR VPWR VGND sky130_ef_sc_hd__decap_12
XFILLER_22_166 VGND VGND VPWR VPWR sky130_fd_sc_hd__decap_8
XFILLER_45_225 VGND VGND VPWR VPWR sky130_fd_sc_hd__decap_4
XFILLER_26_41 VGND VGND VPWR VPWR sky130_fd_sc_hd__decap_3
XFILLER_42_62 VGND VGND VPWR VPWR sky130_fd_sc_hd__decap_4
X_1270_ _0290_ _0303_ _0291_ VGND VGND VPWR VPWR _0304_ sky130_fd_sc_hd__or3b_1
XFILLER_3_78 VGND VPWR VPWR VGND sky130_ef_sc_hd__decap_12
X_0985_ net60 net27 _0611_ VGND VGND VPWR VPWR _0010_ sky130_fd_sc_hd__mux2_1
X_1606_ clknet_leaf_20_clk _0023_ net95 VGND VGND VPWR VPWR u_jt49.u_env.rst_clr sky130_fd_sc_hd__dfrtp_1
Xfanout105 net106 VGND VGND VPWR VPWR net105 sky130_fd_sc_hd__buf_2
X_1399_ net229 _0403_ VGND VGND VPWR VPWR _0405_ sky130_fd_sc_hd__nand2_1
XFILLER_47_18 VGND VPWR VPWR VGND sky130_ef_sc_hd__decap_12
X_1468_ net71 net202 _0414_ VGND VGND VPWR VPWR _0175_ sky130_fd_sc_hd__mux2_1
X_1537_ u_jt49.periodA\[10\] net67 _0423_ VGND VGND VPWR VPWR _0235_ sky130_fd_sc_hd__mux2_1
XFILLER_63_39 VGND VPWR VPWR VGND sky130_ef_sc_hd__decap_12
XFILLER_65_309 VGND VGND VPWR VPWR sky130_fd_sc_hd__decap_4
X_1253_ _0454_ u_jt49.periodB\[11\] u_jt49.u_chB.count\[10\] _0456_ VGND VGND VPWR
+ VPWR _0287_ sky130_fd_sc_hd__a2bb2o_1
X_1322_ u_jt49.u_chA.count\[5\] u_jt49.periodA\[5\] VGND VGND VPWR VPWR _0343_ sky130_fd_sc_hd__and2b_1
XFILLER_49_361 VGND VGND VPWR VPWR sky130_fd_sc_hd__decap_3
X_1184_ _0768_ VGND VGND VPWR VPWR _0769_ sky130_fd_sc_hd__inv_2
XFILLER_24_206 VGND VGND VPWR VPWR sky130_fd_sc_hd__decap_4
X_0968_ u_jt49.eg_period\[15\] _0529_ _0531_ u_jt49.periodB\[7\] _0601_ VGND VGND
+ VPWR VPWR _0604_ sky130_fd_sc_hd__a221o_1
X_0899_ net49 net51 net53 VGND VGND VPWR VPWR _0542_ sky130_fd_sc_hd__nand3_4
XFILLER_59_169 VGND VPWR VPWR VGND sky130_ef_sc_hd__decap_12
XFILLER_59_125 VGND VGND VPWR VPWR sky130_fd_sc_hd__decap_8
XFILLER_38_309 VGND VGND VPWR VPWR sky130_fd_sc_hd__decap_4
XFILLER_65_128 VGND VPWR VPWR VGND sky130_ef_sc_hd__decap_12
XFILLER_58_191 VGND VGND VPWR VPWR sky130_fd_sc_hd__decap_4
XFILLER_0_57 VGND VPWR VPWR VGND sky130_ef_sc_hd__decap_12
X_1871_ clknet_leaf_22_clk net112 VGND VGND VPWR VPWR C[0] sky130_fd_sc_hd__dfxtp_2
XFILLER_9_77 VGND VGND VPWR VPWR sky130_fd_sc_hd__decap_4
X_0822_ u_jt49.u_chC.count\[2\] VGND VGND VPWR VPWR _0472_ sky130_fd_sc_hd__inv_2
XFILLER_50_3 VGND VPWR VPWR VGND sky130_ef_sc_hd__decap_12
X_1305_ u_jt49.u_chB.count\[9\] _0327_ VGND VGND VPWR VPWR _0330_ sky130_fd_sc_hd__nand2_1
X_1236_ u_jt49.u_ng.poly17\[15\] net176 net37 VGND VGND VPWR VPWR _0083_ sky130_fd_sc_hd__mux2_1
X_1167_ net76 net47 VGND VGND VPWR VPWR _0757_ sky130_fd_sc_hd__nand2_1
X_1098_ _0497_ u_jt49.regarray\[13\]\[2\] u_jt49.u_env.rst_latch VGND VGND VPWR VPWR
+ _0702_ sky130_fd_sc_hd__mux2_1
XFILLER_60_29 VGND VPWR VPWR VGND sky130_ef_sc_hd__decap_12
XFILLER_62_109 VGND VPWR VPWR VGND sky130_ef_sc_hd__decap_12
XFILLER_47_117 VGND VPWR VPWR VGND sky130_ef_sc_hd__decap_12
XFILLER_34_85 VGND VPWR VPWR VGND sky130_ef_sc_hd__decap_12
XFILLER_59_93 VGND VPWR VPWR VGND sky130_ef_sc_hd__decap_12
XFILLER_38_128 VGND VGND VPWR VPWR sky130_fd_sc_hd__decap_3
XFILLER_38_117 VGND VGND VPWR VPWR sky130_fd_sc_hd__decap_4
XFILLER_46_161 VGND VGND VPWR VPWR sky130_fd_sc_hd__decap_8
XFILLER_46_150 VGND VGND VPWR VPWR sky130_fd_sc_hd__decap_3
X_1021_ u_jt49.u_chC.count\[9\] _0467_ u_jt49.u_chC.count\[8\] _0468_ VGND VGND VPWR
+ VPWR _0638_ sky130_fd_sc_hd__a22o_1
X_0805_ u_jt49.u_chB.count\[10\] VGND VGND VPWR VPWR _0455_ sky130_fd_sc_hd__inv_2
X_1785_ clknet_leaf_9_clk _0198_ net88 VGND VGND VPWR VPWR u_jt49.regarray\[5\]\[7\]
+ sky130_fd_sc_hd__dfrtp_1
X_1854_ clknet_leaf_27_clk net120 VGND VGND VPWR VPWR A[1] sky130_fd_sc_hd__dfxtp_2
X_1219_ _0474_ _0792_ net32 VGND VGND VPWR VPWR _0067_ sky130_fd_sc_hd__a21boi_1
XFILLER_4_249 VGND VGND VPWR VPWR sky130_fd_sc_hd__decap_3
XFILLER_20_54 VGND VPWR VPWR VGND sky130_ef_sc_hd__decap_12
Xhold30 u_jt49.u_cen.cencnt\[3\] VGND VGND VPWR VPWR net136 sky130_fd_sc_hd__dlygate4sd3_1
Xhold41 u_jt49.regarray\[1\]\[7\] VGND VGND VPWR VPWR net147 sky130_fd_sc_hd__dlygate4sd3_1
Xhold52 u_jt49.regarray\[5\]\[5\] VGND VGND VPWR VPWR net158 sky130_fd_sc_hd__dlygate4sd3_1
Xhold63 u_jt49.u_ng.poly17\[4\] VGND VGND VPWR VPWR net169 sky130_fd_sc_hd__dlygate4sd3_1
Xhold74 _0069_ VGND VGND VPWR VPWR net180 sky130_fd_sc_hd__dlygate4sd3_1
XFILLER_45_73 VGND VGND VPWR VPWR sky130_fd_sc_hd__decap_4
Xhold85 u_jt49.u_ng.poly17\[13\] VGND VGND VPWR VPWR net191 sky130_fd_sc_hd__dlygate4sd3_1
Xhold96 u_jt49.regarray\[7\]\[0\] VGND VGND VPWR VPWR net202 sky130_fd_sc_hd__dlygate4sd3_1
XFILLER_31_337 VGND VGND VPWR VPWR sky130_fd_sc_hd__decap_3
X_1570_ u_jt49.regarray\[9\]\[2\] u_jt49.envelope\[3\] u_jt49.regarray\[9\]\[4\] VGND
+ VGND VPWR VPWR _0435_ sky130_fd_sc_hd__mux2_1
XFILLER_34_197 VGND VPWR VPWR VGND sky130_ef_sc_hd__decap_12
X_1004_ u_jt49.u_ng.u_div.count\[3\] _0623_ VGND VGND VPWR VPWR _0626_ sky130_fd_sc_hd__or2_1
X_1768_ clknet_leaf_10_clk _0181_ net98 VGND VGND VPWR VPWR IOA_oe sky130_fd_sc_hd__dfrtp_4
X_1837_ clknet_leaf_2_clk _0250_ net81 VGND VGND VPWR VPWR u_jt49.periodA\[4\] sky130_fd_sc_hd__dfrtp_1
X_1699_ clknet_leaf_15_clk _0114_ net103 VGND VGND VPWR VPWR u_jt49.u_cen.cencnt\[0\]
+ sky130_fd_sc_hd__dfrtp_1
XFILLER_17_109 VGND VGND VPWR VPWR sky130_fd_sc_hd__decap_3
XFILLER_13_337 VGND VPWR VPWR VGND sky130_ef_sc_hd__decap_12
XFILLER_21_381 VGND VGND VPWR VPWR sky130_fd_sc_hd__decap_6
XFILLER_31_97 VGND VGND VPWR VPWR sky130_fd_sc_hd__decap_3
XFILLER_63_237 VGND VPWR VPWR VGND sky130_ef_sc_hd__decap_12
XFILLER_48_289 VGND VGND VPWR VPWR sky130_fd_sc_hd__decap_3
XFILLER_16_175 VGND VPWR VPWR VGND sky130_ef_sc_hd__decap_12
XFILLER_16_197 VGND VGND VPWR VPWR sky130_fd_sc_hd__decap_4
X_1622_ clknet_leaf_21_clk _0039_ net97 VGND VGND VPWR VPWR u_jt49.u_env.stop sky130_fd_sc_hd__dfrtp_1
X_1484_ net159 net57 _0415_ VGND VGND VPWR VPWR _0190_ sky130_fd_sc_hd__mux2_1
X_1553_ net73 net111 _0425_ _0429_ VGND VGND VPWR VPWR _0245_ sky130_fd_sc_hd__a22o_1
XFILLER_42_85 VGND VGND VPWR VPWR sky130_fd_sc_hd__decap_8
XFILLER_3_57 VGND VPWR VPWR VGND sky130_ef_sc_hd__decap_12
X_0984_ net62 net26 _0611_ VGND VGND VPWR VPWR _0009_ sky130_fd_sc_hd__mux2_1
X_1605_ clknet_leaf_14_clk _0022_ VGND VGND VPWR VPWR cs_n sky130_fd_sc_hd__dfxtp_1
X_1536_ u_jt49.periodA\[9\] net69 _0423_ VGND VGND VPWR VPWR _0234_ sky130_fd_sc_hd__mux2_1
Xfanout106 net29 VGND VGND VPWR VPWR net106 sky130_fd_sc_hd__clkbuf_4
X_1398_ _0403_ _0404_ VGND VGND VPWR VPWR _0115_ sky130_fd_sc_hd__nor2_1
X_1467_ net42 _0522_ VGND VGND VPWR VPWR _0414_ sky130_fd_sc_hd__nand2_4
XFILLER_35_281 VGND VPWR VPWR VGND sky130_ef_sc_hd__decap_12
XFILLER_53_51 VGND VGND VPWR VPWR sky130_fd_sc_hd__decap_4
X_1252_ _0286_ net220 _0662_ VGND VGND VPWR VPWR _0087_ sky130_fd_sc_hd__mux2_1
X_1321_ _0340_ _0341_ VGND VGND VPWR VPWR _0342_ sky130_fd_sc_hd__nor2_1
XFILLER_64_365 VGND VPWR VPWR VGND sky130_ef_sc_hd__decap_12
XFILLER_64_321 VGND VPWR VPWR VGND sky130_ef_sc_hd__decap_12
X_1183_ _0482_ _0767_ VGND VGND VPWR VPWR _0768_ sky130_fd_sc_hd__nor2_1
X_0967_ u_jt49.regarray\[10\]\[7\] _0523_ _0524_ u_jt49.eg_period\[7\] _0602_ VGND
+ VGND VPWR VPWR _0603_ sky130_fd_sc_hd__a221o_1
XFILLER_58_29 VGND VPWR VPWR VGND sky130_ef_sc_hd__decap_12
XFILLER_58_18 VGND VGND VPWR VPWR sky130_fd_sc_hd__decap_8
X_1519_ net171 net59 _0419_ VGND VGND VPWR VPWR _0221_ sky130_fd_sc_hd__mux2_1
XPHY_EDGE_ROW_12_Right_12 VGND VGND VPWR VPWR sky130_fd_sc_hd__decap_3
X_0898_ _0536_ _0538_ _0540_ VGND VGND VPWR VPWR _0541_ sky130_fd_sc_hd__or3_1
XPHY_EDGE_ROW_21_Right_21 VGND VGND VPWR VPWR sky130_fd_sc_hd__decap_3
XPHY_EDGE_ROW_30_Right_30 VGND VGND VPWR VPWR sky130_fd_sc_hd__decap_3
XFILLER_2_177 VGND VPWR VPWR VGND sky130_ef_sc_hd__decap_12
XFILLER_0_69 VGND VPWR VPWR VGND sky130_ef_sc_hd__decap_12
X_1870_ clknet_leaf_28_clk _0273_ net80 VGND VGND VPWR VPWR dout[7] sky130_fd_sc_hd__dfrtp_4
X_0821_ u_jt49.u_chC.count\[3\] VGND VGND VPWR VPWR _0471_ sky130_fd_sc_hd__inv_2
XFILLER_43_3 VGND VGND VPWR VPWR sky130_fd_sc_hd__decap_6
X_1304_ net31 _0328_ _0329_ VGND VGND VPWR VPWR _0096_ sky130_fd_sc_hd__and3_1
X_1166_ net132 _0756_ net45 VGND VGND VPWR VPWR _0050_ sky130_fd_sc_hd__mux2_1
X_1235_ net188 u_jt49.u_ng.poly17\[15\] net37 VGND VGND VPWR VPWR _0082_ sky130_fd_sc_hd__mux2_1
X_1097_ u_jt49.u_env.rst_latch _0697_ _0700_ _0696_ VGND VGND VPWR VPWR _0701_ sky130_fd_sc_hd__o211a_1
XFILLER_20_298 VGND VGND VPWR VPWR sky130_fd_sc_hd__decap_8
XFILLER_47_107 VGND VGND VPWR VPWR sky130_fd_sc_hd__decap_4
XFILLER_47_129 VGND VGND VPWR VPWR sky130_fd_sc_hd__decap_4
XFILLER_28_365 VGND VPWR VPWR VGND sky130_ef_sc_hd__decap_12
XFILLER_50_41 VGND VPWR VPWR VGND sky130_ef_sc_hd__decap_12
XFILLER_34_97 VGND VPWR VPWR VGND sky130_ef_sc_hd__decap_12
XFILLER_7_225 VGND VGND VPWR VPWR sky130_fd_sc_hd__decap_4
XFILLER_11_276 VGND VGND VPWR VPWR sky130_fd_sc_hd__decap_4
XFILLER_59_50 VGND VGND VPWR VPWR sky130_fd_sc_hd__decap_6
XFILLER_50_85 VGND VGND VPWR VPWR sky130_fd_sc_hd__decap_3
X_1020_ _0631_ _0632_ _0634_ _0635_ VGND VGND VPWR VPWR _0637_ sky130_fd_sc_hd__or4_1
XFILLER_19_332 VGND VGND VPWR VPWR sky130_fd_sc_hd__decap_4
X_0804_ net200 VGND VGND VPWR VPWR _0454_ sky130_fd_sc_hd__inv_2
X_1784_ clknet_leaf_9_clk _0197_ net88 VGND VGND VPWR VPWR u_jt49.regarray\[5\]\[6\]
+ sky130_fd_sc_hd__dfrtp_1
X_1853_ clknet_leaf_27_clk net121 VGND VGND VPWR VPWR A[0] sky130_fd_sc_hd__dfxtp_2
X_1218_ net32 _0791_ _0792_ VGND VGND VPWR VPWR _0066_ sky130_fd_sc_hd__and3_1
X_1149_ _0739_ _0733_ _0732_ _0737_ VGND VGND VPWR VPWR _0745_ sky130_fd_sc_hd__and4bb_1
XFILLER_52_187 VGND VGND VPWR VPWR sky130_fd_sc_hd__decap_8
XFILLER_40_327 VGND VGND VPWR VPWR sky130_fd_sc_hd__decap_3
XFILLER_20_66 VGND VGND VPWR VPWR sky130_fd_sc_hd__decap_8
XFILLER_20_99 VGND VGND VPWR VPWR sky130_fd_sc_hd__decap_6
Xhold42 u_jt49.regarray\[5\]\[6\] VGND VGND VPWR VPWR net148 sky130_fd_sc_hd__dlygate4sd3_1
Xhold53 u_jt49.regarray\[6\]\[7\] VGND VGND VPWR VPWR net159 sky130_fd_sc_hd__dlygate4sd3_1
Xhold75 u_jt49.u_ng.poly17\[5\] VGND VGND VPWR VPWR net181 sky130_fd_sc_hd__dlygate4sd3_1
Xhold31 u_jt49.regarray\[9\]\[0\] VGND VGND VPWR VPWR net137 sky130_fd_sc_hd__dlygate4sd3_1
Xhold64 _0072_ VGND VGND VPWR VPWR net170 sky130_fd_sc_hd__dlygate4sd3_1
Xhold97 u_jt49.u_env.gain\[4\] VGND VGND VPWR VPWR net203 sky130_fd_sc_hd__dlygate4sd3_1
Xhold86 u_jt49.u_env.rst_clr VGND VGND VPWR VPWR net192 sky130_fd_sc_hd__dlygate4sd3_1
Xhold20 u_jt49.eg_restart VGND VGND VPWR VPWR net126 sky130_fd_sc_hd__dlygate4sd3_1
XFILLER_43_165 VGND VGND VPWR VPWR sky130_fd_sc_hd__decap_3
XFILLER_61_51 VGND VGND VPWR VPWR sky130_fd_sc_hd__decap_4
X_1003_ u_jt49.u_ng.u_div.count\[3\] _0623_ VGND VGND VPWR VPWR _0625_ sky130_fd_sc_hd__nand2_1
XFILLER_22_305 VGND VGND VPWR VPWR sky130_fd_sc_hd__decap_3
X_1836_ clknet_leaf_1_clk _0249_ net81 VGND VGND VPWR VPWR u_jt49.periodA\[3\] sky130_fd_sc_hd__dfrtp_1
X_1767_ clknet_leaf_18_clk _0180_ net92 VGND VGND VPWR VPWR u_jt49.regarray\[7\]\[5\]
+ sky130_fd_sc_hd__dfrtp_1
XPHY_EDGE_ROW_6_Right_6 VGND VGND VPWR VPWR sky130_fd_sc_hd__decap_3
X_1698_ clknet_leaf_1_clk _0113_ net78 VGND VGND VPWR VPWR u_jt49.bitA sky130_fd_sc_hd__dfrtp_1
XFILLER_13_349 VGND VPWR VPWR VGND sky130_ef_sc_hd__decap_12
XFILLER_31_65 VGND VGND VPWR VPWR sky130_fd_sc_hd__decap_3
XFILLER_0_253 VGND VPWR VPWR VGND sky130_ef_sc_hd__decap_12
XFILLER_63_249 VGND VPWR VPWR VGND sky130_ef_sc_hd__decap_12
XFILLER_63_205 VGND VPWR VPWR VGND sky130_ef_sc_hd__decap_12
XFILLER_48_235 VGND VPWR VPWR VGND sky130_ef_sc_hd__decap_12
XPHY_EDGE_ROW_59_Right_59 VGND VGND VPWR VPWR sky130_fd_sc_hd__decap_3
XFILLER_31_113 VGND VPWR VPWR VGND sky130_ef_sc_hd__decap_12
X_1621_ clknet_leaf_17_clk net143 VGND VGND VPWR VPWR u_jt49.u_env.last_step sky130_fd_sc_hd__dfxtp_1
X_1552_ u_jt49.regarray\[8\]\[3\] u_jt49.envelope\[4\] u_jt49.regarray\[8\]\[4\] VGND
+ VGND VPWR VPWR _0429_ sky130_fd_sc_hd__mux2_1
X_1483_ net153 net59 _0415_ VGND VGND VPWR VPWR _0189_ sky130_fd_sc_hd__mux2_1
X_1819_ clknet_leaf_23_clk _0232_ VGND VGND VPWR VPWR u_jt49.Bmix sky130_fd_sc_hd__dfxtp_1
XFILLER_3_69 VGND VGND VPWR VPWR sky130_fd_sc_hd__decap_3
X_0983_ net64 net25 _0611_ VGND VGND VPWR VPWR _0008_ sky130_fd_sc_hd__mux2_1
X_1604_ clknet_leaf_14_clk _0021_ VGND VGND VPWR VPWR addr_ok sky130_fd_sc_hd__dfxtp_1
X_1535_ u_jt49.periodA\[8\] net71 _0423_ VGND VGND VPWR VPWR _0233_ sky130_fd_sc_hd__mux2_1
X_1397_ net228 net20 net172 VGND VGND VPWR VPWR _0404_ sky130_fd_sc_hd__a21oi_1
X_1466_ net146 net58 _0413_ VGND VGND VPWR VPWR _0174_ sky130_fd_sc_hd__mux2_1
XFILLER_35_293 VGND VPWR VPWR VGND sky130_ef_sc_hd__decap_12
XPHY_EDGE_ROW_19_Left_85 VGND VGND VPWR VPWR sky130_fd_sc_hd__decap_3
XFILLER_5_6 VGND VPWR VPWR VGND sky130_ef_sc_hd__decap_12
X_1320_ u_jt49.periodA\[7\] u_jt49.u_chA.count\[7\] VGND VGND VPWR VPWR _0341_ sky130_fd_sc_hd__and2b_1
XFILLER_64_333 VGND VPWR VPWR VGND sky130_ef_sc_hd__decap_12
X_1182_ net32 _0765_ _0767_ VGND VGND VPWR VPWR _0055_ sky130_fd_sc_hd__and3_1
X_1251_ _0283_ _0284_ _0285_ _0498_ VGND VGND VPWR VPWR _0286_ sky130_fd_sc_hd__o31a_1
X_0897_ u_jt49.eg_period\[8\] _0529_ _0531_ u_jt49.periodB\[0\] _0539_ VGND VGND VPWR
+ VPWR _0540_ sky130_fd_sc_hd__a221o_1
X_0966_ u_jt49.regarray\[13\]\[7\] _0527_ _0533_ u_jt49.regarray\[9\]\[7\] VGND VGND
+ VPWR VPWR _0602_ sky130_fd_sc_hd__a22o_1
XFILLER_59_105 VGND VGND VPWR VPWR sky130_fd_sc_hd__decap_6
X_1518_ net155 net61 _0419_ VGND VGND VPWR VPWR _0220_ sky130_fd_sc_hd__mux2_1
X_1449_ net42 _0545_ VGND VGND VPWR VPWR _0412_ sky130_fd_sc_hd__nand2_4
XFILLER_3_3 VGND VPWR VPWR VGND sky130_ef_sc_hd__decap_12
XFILLER_2_189 VGND VGND VPWR VPWR sky130_fd_sc_hd__decap_6
X_0820_ u_jt49.periodC\[5\] VGND VGND VPWR VPWR _0470_ sky130_fd_sc_hd__inv_2
X_1303_ u_jt49.u_chB.count\[8\] _0324_ VGND VGND VPWR VPWR _0329_ sky130_fd_sc_hd__or2_1
XFILLER_64_141 VGND VPWR VPWR VGND sky130_ef_sc_hd__decap_12
XFILLER_37_366 VGND VPWR VPWR VGND sky130_ef_sc_hd__decap_12
X_1234_ net191 net188 net37 VGND VGND VPWR VPWR _0081_ sky130_fd_sc_hd__mux2_1
X_1165_ u_jt49.u_env.gain\[4\] u_jt49.u_env.inv VGND VGND VPWR VPWR _0756_ sky130_fd_sc_hd__xor2_1
X_1096_ u_jt49.u_env.gain\[4\] _0699_ u_jt49.u_env.rst_latch VGND VGND VPWR VPWR _0700_
+ sky130_fd_sc_hd__o21bai_1
X_0949_ u_jt49.regarray\[8\]\[5\] _0525_ _0529_ u_jt49.eg_period\[13\] VGND VGND VPWR
+ VPWR _0587_ sky130_fd_sc_hd__a22o_1
XFILLER_50_75 VGND VGND VPWR VPWR sky130_fd_sc_hd__decap_3
XFILLER_50_53 VGND VGND VPWR VPWR sky130_fd_sc_hd__decap_8
XFILLER_7_204 VGND VPWR VPWR VGND sky130_ef_sc_hd__decap_12
X_1852_ clknet_leaf_19_clk net42 net95 VGND VGND VPWR VPWR u_jt49.last_write sky130_fd_sc_hd__dfrtp_1
X_1783_ clknet_leaf_10_clk _0196_ net98 VGND VGND VPWR VPWR u_jt49.regarray\[5\]\[5\]
+ sky130_fd_sc_hd__dfrtp_1
XFILLER_6_292 VGND VPWR VPWR VGND sky130_ef_sc_hd__decap_12
X_0803_ u_jt49.regarray\[13\]\[0\] VGND VGND VPWR VPWR _0453_ sky130_fd_sc_hd__inv_2
X_1217_ _0475_ _0476_ _0786_ VGND VGND VPWR VPWR _0792_ sky130_fd_sc_hd__or3b_1
X_1148_ _0736_ _0742_ _0743_ _0738_ VGND VGND VPWR VPWR _0744_ sky130_fd_sc_hd__a22o_1
X_1079_ u_jt49.u_chC.count\[10\] u_jt49.u_chC.count\[9\] _0681_ VGND VGND VPWR VPWR
+ _0686_ sky130_fd_sc_hd__and3_1
Xhold65 u_jt49.regarray\[3\]\[6\] VGND VGND VPWR VPWR net171 sky130_fd_sc_hd__dlygate4sd3_1
XFILLER_45_31 VGND VGND VPWR VPWR sky130_fd_sc_hd__decap_8
Xhold54 u_jt49.regarray\[10\]\[5\] VGND VGND VPWR VPWR net160 sky130_fd_sc_hd__dlygate4sd3_1
Xhold32 u_jt49.envelope\[1\] VGND VGND VPWR VPWR net138 sky130_fd_sc_hd__dlygate4sd3_1
Xhold10 u_jt49.logA\[2\] VGND VGND VPWR VPWR net116 sky130_fd_sc_hd__dlygate4sd3_1
Xhold76 _0073_ VGND VGND VPWR VPWR net182 sky130_fd_sc_hd__dlygate4sd3_1
Xhold87 u_jt49.u_ng.poly17\[2\] VGND VGND VPWR VPWR net193 sky130_fd_sc_hd__dlygate4sd3_1
Xhold21 _0036_ VGND VGND VPWR VPWR net127 sky130_fd_sc_hd__dlygate4sd3_1
Xhold43 u_jt49.regarray\[1\]\[4\] VGND VGND VPWR VPWR net149 sky130_fd_sc_hd__dlygate4sd3_1
Xhold98 u_jt49.u_chC.count\[0\] VGND VGND VPWR VPWR net204 sky130_fd_sc_hd__dlygate4sd3_1
XFILLER_45_53 VGND VGND VPWR VPWR sky130_fd_sc_hd__decap_3
XPHY_EDGE_ROW_7_Left_73 VGND VGND VPWR VPWR sky130_fd_sc_hd__decap_3
XFILLER_3_273 VGND VGND VPWR VPWR sky130_fd_sc_hd__decap_6
X_1002_ net47 _0617_ _0623_ _0624_ VGND VGND VPWR VPWR _0014_ sky130_fd_sc_hd__a211oi_1
XFILLER_19_163 VGND VGND VPWR VPWR sky130_fd_sc_hd__decap_4
X_1835_ clknet_leaf_1_clk _0248_ net79 VGND VGND VPWR VPWR u_jt49.periodA\[2\] sky130_fd_sc_hd__dfrtp_1
X_1697_ clknet_leaf_30_clk _0112_ net78 VGND VGND VPWR VPWR u_jt49.u_chA.count\[11\]
+ sky130_fd_sc_hd__dfrtp_1
X_1766_ clknet_leaf_25_clk _0179_ net92 VGND VGND VPWR VPWR u_jt49.regarray\[7\]\[4\]
+ sky130_fd_sc_hd__dfrtp_1
XFILLER_57_236 VGND VGND VPWR VPWR sky130_fd_sc_hd__decap_3
XPHY_EDGE_ROW_33_Left_99 VGND VGND VPWR VPWR sky130_fd_sc_hd__decap_3
XFILLER_48_214 VGND VPWR VPWR VGND sky130_ef_sc_hd__decap_12
XFILLER_0_221 VGND VGND VPWR VPWR sky130_fd_sc_hd__decap_3
XFILLER_0_265 VGND VPWR VPWR VGND sky130_ef_sc_hd__decap_12
XFILLER_63_217 VGND VGND VPWR VPWR sky130_fd_sc_hd__decap_6
XFILLER_56_85 VGND VPWR VPWR VGND sky130_ef_sc_hd__decap_12
XFILLER_56_41 VGND VPWR VPWR VGND sky130_ef_sc_hd__decap_12
XFILLER_48_247 VGND VGND VPWR VPWR sky130_fd_sc_hd__decap_4
XFILLER_31_169 VGND VGND VPWR VPWR sky130_fd_sc_hd__decap_6
XFILLER_31_125 VGND VGND VPWR VPWR sky130_fd_sc_hd__decap_6
XFILLER_8_321 VGND VPWR VPWR VGND sky130_ef_sc_hd__decap_12
X_1482_ net161 net61 _0415_ VGND VGND VPWR VPWR _0188_ sky130_fd_sc_hd__mux2_1
X_1551_ net73 net115 _0425_ _0428_ VGND VGND VPWR VPWR _0244_ sky130_fd_sc_hd__a22o_1
XFILLER_8_365 VGND VPWR VPWR VGND sky130_ef_sc_hd__decap_12
X_1620_ clknet_leaf_19_clk _0037_ net95 VGND VGND VPWR VPWR u_jt49.u_env.inv sky130_fd_sc_hd__dfrtp_4
X_1818_ clknet_leaf_9_clk _0231_ net87 VGND VGND VPWR VPWR u_jt49.periodB\[7\] sky130_fd_sc_hd__dfrtp_1
XFILLER_10_309 VGND VGND VPWR VPWR sky130_fd_sc_hd__decap_8
X_1749_ clknet_leaf_16_clk _0162_ net102 VGND VGND VPWR VPWR IOA_out[3] sky130_fd_sc_hd__dfrtp_4
XFILLER_13_169 VGND VGND VPWR VPWR sky130_fd_sc_hd__decap_4
XFILLER_3_15 VGND VPWR VPWR VGND sky130_ef_sc_hd__decap_12
X_0982_ net65 net24 _0611_ VGND VGND VPWR VPWR _0007_ sky130_fd_sc_hd__mux2_1
X_1603_ clknet_leaf_7_clk _0020_ VGND VGND VPWR VPWR addr\[3\] sky130_fd_sc_hd__dfxtp_1
X_1465_ net144 net59 _0413_ VGND VGND VPWR VPWR _0173_ sky130_fd_sc_hd__mux2_1
X_1534_ net41 net35 VGND VGND VPWR VPWR _0423_ sky130_fd_sc_hd__and2_2
X_1396_ u_jt49.u_cen.cencnt\[0\] u_jt49.u_cen.cencnt\[1\] net20 VGND VGND VPWR VPWR
+ _0403_ sky130_fd_sc_hd__and3_1
XFILLER_50_253 VGND VPWR VPWR VGND sky130_ef_sc_hd__decap_12
XFILLER_50_220 VGND VGND VPWR VPWR sky130_fd_sc_hd__decap_8
XFILLER_10_128 VGND VGND VPWR VPWR sky130_fd_sc_hd__decap_6
XFILLER_12_79 VGND VGND VPWR VPWR sky130_fd_sc_hd__decap_4
XFILLER_18_206 VGND VGND VPWR VPWR sky130_fd_sc_hd__decap_4
XFILLER_41_264 VGND VPWR VPWR VGND sky130_ef_sc_hd__decap_12
XFILLER_64_345 VGND VPWR VPWR VGND sky130_ef_sc_hd__decap_12
XFILLER_64_301 VGND VGND VPWR VPWR sky130_fd_sc_hd__decap_6
X_1181_ _0759_ _0766_ VGND VGND VPWR VPWR _0767_ sky130_fd_sc_hd__nand2_1
X_1250_ u_jt49.periodC\[11\] u_jt49.periodC\[10\] u_jt49.periodC\[9\] u_jt49.periodC\[8\]
+ VGND VGND VPWR VPWR _0285_ sky130_fd_sc_hd__or4_1
XPHY_EDGE_ROW_20_Left_86 VGND VGND VPWR VPWR sky130_fd_sc_hd__decap_3
X_0965_ u_jt49.periodC\[7\] _0518_ _0525_ u_jt49.regarray\[8\]\[7\] VGND VGND VPWR
+ VPWR _0601_ sky130_fd_sc_hd__a22o_1
X_0896_ u_jt49.regarray\[8\]\[0\] _0525_ _0532_ u_jt49.periodB\[8\] VGND VGND VPWR
+ VPWR _0539_ sky130_fd_sc_hd__a22o_1
X_1517_ net195 net63 _0419_ VGND VGND VPWR VPWR _0219_ sky130_fd_sc_hd__mux2_1
X_1448_ net152 net58 _0411_ VGND VGND VPWR VPWR _0158_ sky130_fd_sc_hd__mux2_1
XFILLER_55_312 VGND VPWR VPWR VGND sky130_ef_sc_hd__decap_12
X_1379_ _0391_ VGND VGND VPWR VPWR _0392_ sky130_fd_sc_hd__inv_2
XFILLER_65_109 VGND VGND VPWR VPWR sky130_fd_sc_hd__decap_3
XFILLER_64_85 VGND VPWR VPWR VGND sky130_ef_sc_hd__decap_12
XFILLER_64_41 VGND VPWR VPWR VGND sky130_ef_sc_hd__decap_12
XFILLER_61_337 VGND VPWR VPWR VGND sky130_ef_sc_hd__decap_12
XFILLER_14_297 VGND VGND VPWR VPWR sky130_fd_sc_hd__decap_8
Xfanout90 net91 VGND VGND VPWR VPWR net90 sky130_fd_sc_hd__buf_2
XFILLER_56_109 VGND VGND VPWR VPWR sky130_fd_sc_hd__decap_8
X_1302_ _0327_ VGND VGND VPWR VPWR _0328_ sky130_fd_sc_hd__inv_2
X_1233_ net183 u_jt49.u_ng.poly17\[13\] net37 VGND VGND VPWR VPWR _0080_ sky130_fd_sc_hd__mux2_1
XFILLER_64_197 VGND VPWR VPWR VGND sky130_ef_sc_hd__decap_12
XFILLER_64_153 VGND VPWR VPWR VGND sky130_ef_sc_hd__decap_12
XFILLER_37_378 VGND VGND VPWR VPWR sky130_fd_sc_hd__decap_8
X_1164_ net133 _0755_ net45 VGND VGND VPWR VPWR _0049_ sky130_fd_sc_hd__mux2_1
X_1095_ u_jt49.u_env.gain\[0\] u_jt49.u_env.gain\[1\] u_jt49.u_env.gain\[3\] u_jt49.u_env.gain\[2\]
+ VGND VGND VPWR VPWR _0699_ sky130_fd_sc_hd__or4_1
X_0948_ u_jt49.periodC\[5\] net40 _0523_ u_jt49.regarray\[10\]\[5\] _0520_ VGND VGND
+ VPWR VPWR _0586_ sky130_fd_sc_hd__a221o_1
XFILLER_20_234 VGND VGND VPWR VPWR sky130_fd_sc_hd__decap_8
X_0879_ net50 net52 net54 net56 VGND VGND VPWR VPWR _0522_ sky130_fd_sc_hd__and4b_4
XFILLER_43_337 VGND VGND VPWR VPWR sky130_fd_sc_hd__decap_4
XFILLER_43_315 VGND VPWR VPWR VGND sky130_ef_sc_hd__decap_12
XFILLER_46_197 VGND VPWR VPWR VGND sky130_ef_sc_hd__decap_12
X_1851_ clknet_leaf_21_clk _0264_ VGND VGND VPWR VPWR u_jt49.logC\[4\] sky130_fd_sc_hd__dfxtp_1
X_0802_ u_jt49.u_env.stop VGND VGND VPWR VPWR _0452_ sky130_fd_sc_hd__inv_2
X_1782_ clknet_leaf_2_clk _0195_ net88 VGND VGND VPWR VPWR u_jt49.regarray\[5\]\[4\]
+ sky130_fd_sc_hd__dfrtp_1
X_1216_ u_jt49.u_envdiv.count\[13\] u_jt49.u_envdiv.count\[12\] _0783_ u_jt49.u_envdiv.count\[14\]
+ VGND VGND VPWR VPWR _0791_ sky130_fd_sc_hd__a31o_1
X_1147_ _0447_ u_jt49.u_envdiv.count\[3\] u_jt49.u_envdiv.count\[2\] _0448_ VGND VGND
+ VPWR VPWR _0743_ sky130_fd_sc_hd__a22o_1
X_1078_ u_jt49.u_chC.count\[9\] _0681_ u_jt49.u_chC.count\[10\] VGND VGND VPWR VPWR
+ _0685_ sky130_fd_sc_hd__a21o_1
XPHY_EDGE_ROW_42_Left_108 VGND VGND VPWR VPWR sky130_fd_sc_hd__decap_3
Xhold11 u_jt49.logB\[3\] VGND VGND VPWR VPWR net117 sky130_fd_sc_hd__dlygate4sd3_1
Xhold22 u_jt49.u_ng.last_en VGND VGND VPWR VPWR net128 sky130_fd_sc_hd__dlygate4sd3_1
Xhold66 u_jt49.u_cen.cencnt\[1\] VGND VGND VPWR VPWR net172 sky130_fd_sc_hd__dlygate4sd3_1
Xhold44 u_jt49.regarray\[9\]\[6\] VGND VGND VPWR VPWR net150 sky130_fd_sc_hd__dlygate4sd3_1
Xhold33 u_jt49.regarray\[5\]\[4\] VGND VGND VPWR VPWR net139 sky130_fd_sc_hd__dlygate4sd3_1
Xhold99 u_jt49.regarray\[7\]\[5\] VGND VGND VPWR VPWR net205 sky130_fd_sc_hd__dlygate4sd3_1
Xhold55 u_jt49.regarray\[6\]\[5\] VGND VGND VPWR VPWR net161 sky130_fd_sc_hd__dlygate4sd3_1
Xhold88 u_jt49.u_chA.count\[3\] VGND VGND VPWR VPWR net194 sky130_fd_sc_hd__dlygate4sd3_1
Xhold77 u_jt49.u_ng.poly17\[12\] VGND VGND VPWR VPWR net183 sky130_fd_sc_hd__dlygate4sd3_1
XFILLER_16_315 VGND VGND VPWR VPWR sky130_fd_sc_hd__decap_8
XPHY_EDGE_ROW_51_Left_117 VGND VGND VPWR VPWR sky130_fd_sc_hd__decap_3
XFILLER_24_370 VGND VPWR VPWR VGND sky130_ef_sc_hd__decap_12
XPHY_EDGE_ROW_60_Left_126 VGND VGND VPWR VPWR sky130_fd_sc_hd__decap_3
XFILLER_6_15 VGND VPWR VPWR VGND sky130_ef_sc_hd__decap_12
XFILLER_13_6 VGND VPWR VPWR VGND sky130_ef_sc_hd__decap_12
X_1001_ u_jt49.u_ng.u_div.count\[2\] _0620_ VGND VGND VPWR VPWR _0624_ sky130_fd_sc_hd__nor2_1
XFILLER_15_381 VGND VGND VPWR VPWR sky130_fd_sc_hd__decap_3
X_1765_ clknet_leaf_26_clk _0178_ net82 VGND VGND VPWR VPWR u_jt49.regarray\[7\]\[3\]
+ sky130_fd_sc_hd__dfrtp_1
X_1834_ clknet_leaf_1_clk _0247_ net81 VGND VGND VPWR VPWR u_jt49.periodA\[1\] sky130_fd_sc_hd__dfrtp_1
X_1696_ clknet_leaf_30_clk _0111_ net78 VGND VGND VPWR VPWR u_jt49.u_chA.count\[10\]
+ sky130_fd_sc_hd__dfrtp_1
XFILLER_40_137 VGND VGND VPWR VPWR sky130_fd_sc_hd__decap_3
XFILLER_0_277 VGND VGND VPWR VPWR sky130_fd_sc_hd__decap_3
XFILLER_56_97 VGND VPWR VPWR VGND sky130_ef_sc_hd__decap_12
XFILLER_56_53 VGND VPWR VPWR VGND sky130_ef_sc_hd__decap_12
XFILLER_8_333 VGND VPWR VPWR VGND sky130_ef_sc_hd__decap_12
XFILLER_8_377 VGND VGND VPWR VPWR sky130_fd_sc_hd__decap_6
X_1550_ u_jt49.regarray\[8\]\[2\] u_jt49.envelope\[3\] u_jt49.regarray\[8\]\[4\] VGND
+ VGND VPWR VPWR _0428_ sky130_fd_sc_hd__mux2_1
X_1481_ u_jt49.regarray\[6\]\[4\] net63 _0415_ VGND VGND VPWR VPWR _0187_ sky130_fd_sc_hd__mux2_1
XFILLER_47_281 VGND VPWR VPWR VGND sky130_ef_sc_hd__decap_12
XFILLER_11_3 VGND VPWR VPWR VGND sky130_ef_sc_hd__decap_12
XFILLER_22_148 VGND VGND VPWR VPWR sky130_fd_sc_hd__decap_8
X_1817_ clknet_leaf_5_clk _0230_ net85 VGND VGND VPWR VPWR u_jt49.periodB\[6\] sky130_fd_sc_hd__dfrtp_1
X_1748_ clknet_leaf_16_clk _0161_ net102 VGND VGND VPWR VPWR IOA_out[2] sky130_fd_sc_hd__dfrtp_4
X_1679_ clknet_leaf_5_clk _0094_ net86 VGND VGND VPWR VPWR u_jt49.u_chB.count\[6\]
+ sky130_fd_sc_hd__dfrtp_1
XFILLER_13_159 VGND VGND VPWR VPWR sky130_fd_sc_hd__decap_8
XFILLER_3_27 VGND VPWR VPWR VGND sky130_ef_sc_hd__decap_12
XFILLER_29_281 VGND VGND VPWR VPWR sky130_fd_sc_hd__decap_6
X_0981_ net67 net23 _0611_ VGND VGND VPWR VPWR _0006_ sky130_fd_sc_hd__mux2_1
X_1602_ clknet_leaf_7_clk _0019_ VGND VGND VPWR VPWR addr\[2\] sky130_fd_sc_hd__dfxtp_1
XFILLER_8_141 VGND VPWR VPWR VGND sky130_ef_sc_hd__decap_12
X_1464_ net145 net61 _0413_ VGND VGND VPWR VPWR _0172_ sky130_fd_sc_hd__mux2_1
X_1395_ net173 net20 VGND VGND VPWR VPWR _0114_ sky130_fd_sc_hd__xor2_1
X_1533_ net124 net73 _0422_ VGND VGND VPWR VPWR _0232_ sky130_fd_sc_hd__a21o_1
XFILLER_50_265 VGND VGND VPWR VPWR sky130_fd_sc_hd__decap_3
Xclkbuf_leaf_30_clk clknet_2_0__leaf_clk VGND VGND VPWR VPWR clknet_leaf_30_clk sky130_fd_sc_hd__clkbuf_8
XFILLER_2_317 VGND VPWR VPWR VGND sky130_ef_sc_hd__decap_12
XFILLER_41_276 VGND VGND VPWR VPWR sky130_fd_sc_hd__decap_4
Xclkbuf_leaf_21_clk clknet_2_2__leaf_clk VGND VGND VPWR VPWR clknet_leaf_21_clk sky130_fd_sc_hd__clkbuf_8
XFILLER_64_357 VGND VGND VPWR VPWR sky130_fd_sc_hd__decap_6
X_1180_ u_jt49.u_envdiv.count\[3\] u_jt49.u_envdiv.count\[2\] VGND VGND VPWR VPWR
+ _0766_ sky130_fd_sc_hd__and2_1
XFILLER_17_273 VGND VGND VPWR VPWR sky130_fd_sc_hd__decap_6
Xclkbuf_leaf_12_clk clknet_2_3__leaf_clk VGND VGND VPWR VPWR clknet_leaf_12_clk sky130_fd_sc_hd__clkbuf_8
X_0964_ net15 _0544_ _0545_ net7 _0600_ VGND VGND VPWR VPWR _0272_ sky130_fd_sc_hd__a221o_1
X_1516_ u_jt49.periodB\[11\] net65 _0419_ VGND VGND VPWR VPWR _0218_ sky130_fd_sc_hd__mux2_1
X_0895_ u_jt49.regarray\[6\]\[0\] _0526_ net35 u_jt49.periodA\[8\] _0537_ VGND VGND
+ VPWR VPWR _0538_ sky130_fd_sc_hd__a221o_1
XFILLER_55_324 VGND VPWR VPWR VGND sky130_ef_sc_hd__decap_12
X_1447_ net150 net60 _0411_ VGND VGND VPWR VPWR _0157_ sky130_fd_sc_hd__mux2_1
X_1378_ net46 u_jt49.u_chA.count\[8\] _0387_ VGND VGND VPWR VPWR _0391_ sky130_fd_sc_hd__and3_1
XFILLER_23_210 VGND VPWR VPWR VGND sky130_ef_sc_hd__decap_12
XFILLER_23_57 VGND VGND VPWR VPWR sky130_fd_sc_hd__decap_3
XFILLER_64_53 VGND VPWR VPWR VGND sky130_ef_sc_hd__decap_12
XFILLER_61_305 VGND VPWR VPWR VGND sky130_ef_sc_hd__decap_12
XFILLER_64_97 VGND VPWR VPWR VGND sky130_ef_sc_hd__decap_12
XFILLER_61_349 VGND VPWR VPWR VGND sky130_ef_sc_hd__decap_12
Xfanout91 net106 VGND VGND VPWR VPWR net91 sky130_fd_sc_hd__clkbuf_2
Xfanout80 net83 VGND VGND VPWR VPWR net80 sky130_fd_sc_hd__clkbuf_4
X_1301_ u_jt49.u_chB.count\[8\] _0324_ VGND VGND VPWR VPWR _0327_ sky130_fd_sc_hd__and2_1
XFILLER_49_140 VGND VGND VPWR VPWR sky130_fd_sc_hd__decap_8
X_1232_ net190 net183 net37 VGND VGND VPWR VPWR _0079_ sky130_fd_sc_hd__mux2_1
Xclkbuf_leaf_1_clk clknet_2_0__leaf_clk VGND VGND VPWR VPWR clknet_leaf_1_clk sky130_fd_sc_hd__clkbuf_8
XFILLER_64_165 VGND VPWR VPWR VGND sky130_ef_sc_hd__decap_12
XFILLER_64_121 VGND VPWR VPWR VGND sky130_ef_sc_hd__decap_12
X_1163_ u_jt49.u_env.gain\[3\] u_jt49.u_env.inv VGND VGND VPWR VPWR _0755_ sky130_fd_sc_hd__xor2_1
X_1094_ u_jt49.u_env.gain\[0\] u_jt49.u_env.gain\[1\] u_jt49.u_env.gain\[2\] VGND
+ VGND VPWR VPWR _0698_ sky130_fd_sc_hd__nor3_1
X_0947_ u_jt49.regarray\[5\]\[5\] _0528_ _0582_ _0584_ VGND VGND VPWR VPWR _0585_
+ sky130_fd_sc_hd__a211o_1
X_0878_ net49 net51 net53 net55 VGND VGND VPWR VPWR _0521_ sky130_fd_sc_hd__or4_4
XFILLER_43_327 VGND VGND VPWR VPWR sky130_fd_sc_hd__decap_8
Xclkload0 clknet_2_2__leaf_clk VGND VGND VPWR VPWR clkload0/X sky130_fd_sc_hd__clkbuf_8
XFILLER_61_113 VGND VPWR VPWR VGND sky130_ef_sc_hd__decap_12
X_0801_ u_jt49.eg_period\[14\] VGND VGND VPWR VPWR _0451_ sky130_fd_sc_hd__inv_2
X_1781_ clknet_leaf_17_clk _0194_ net99 VGND VGND VPWR VPWR u_jt49.periodC\[11\] sky130_fd_sc_hd__dfrtp_1
X_1850_ clknet_leaf_21_clk _0263_ VGND VGND VPWR VPWR u_jt49.logC\[3\] sky130_fd_sc_hd__dfxtp_1
XFILLER_41_3 VGND VPWR VPWR VGND sky130_ef_sc_hd__decap_12
X_1215_ net33 _0789_ _0790_ VGND VGND VPWR VPWR _0065_ sky130_fd_sc_hd__and3_1
X_1146_ _0448_ u_jt49.u_envdiv.count\[2\] u_jt49.u_envdiv.count\[1\] _0445_ _0738_
+ VGND VGND VPWR VPWR _0742_ sky130_fd_sc_hd__o221a_1
XFILLER_52_157 VGND VGND VPWR VPWR sky130_fd_sc_hd__decap_8
X_1077_ _0660_ _0683_ _0684_ net211 net44 VGND VGND VPWR VPWR _0033_ sky130_fd_sc_hd__a32o_1
XFILLER_4_209 VGND VPWR VPWR VGND sky130_ef_sc_hd__decap_12
Xhold45 u_jt49.u_cen.cencnt\[2\] VGND VGND VPWR VPWR net151 sky130_fd_sc_hd__dlygate4sd3_1
Xhold34 u_jt49.regarray\[1\]\[6\] VGND VGND VPWR VPWR net140 sky130_fd_sc_hd__dlygate4sd3_1
Xhold12 u_jt49.logB\[4\] VGND VGND VPWR VPWR net118 sky130_fd_sc_hd__dlygate4sd3_1
Xhold23 _0051_ VGND VGND VPWR VPWR net129 sky130_fd_sc_hd__dlygate4sd3_1
Xhold56 u_jt49.regarray\[13\]\[4\] VGND VGND VPWR VPWR net162 sky130_fd_sc_hd__dlygate4sd3_1
Xhold89 u_jt49.regarray\[3\]\[4\] VGND VGND VPWR VPWR net195 sky130_fd_sc_hd__dlygate4sd3_1
XFILLER_43_113 VGND VPWR VPWR VGND sky130_ef_sc_hd__decap_12
Xhold67 u_jt49.u_cen.cencnt\[0\] VGND VGND VPWR VPWR net173 sky130_fd_sc_hd__dlygate4sd3_1
Xhold78 _0080_ VGND VGND VPWR VPWR net184 sky130_fd_sc_hd__dlygate4sd3_1
XFILLER_24_382 VGND VGND VPWR VPWR sky130_fd_sc_hd__decap_4
XFILLER_3_220 VGND VGND VPWR VPWR sky130_fd_sc_hd__decap_4
X_1000_ u_jt49.u_ng.u_div.count\[2\] _0620_ VGND VGND VPWR VPWR _0623_ sky130_fd_sc_hd__and2_1
X_1764_ clknet_leaf_24_clk _0177_ net92 VGND VGND VPWR VPWR u_jt49.regarray\[7\]\[2\]
+ sky130_fd_sc_hd__dfrtp_1
X_1833_ clknet_leaf_1_clk _0246_ net79 VGND VGND VPWR VPWR u_jt49.periodA\[0\] sky130_fd_sc_hd__dfrtp_1
XFILLER_57_205 VGND VGND VPWR VPWR sky130_fd_sc_hd__decap_6
X_1695_ clknet_leaf_0_clk _0110_ net78 VGND VGND VPWR VPWR u_jt49.u_chA.count\[9\]
+ sky130_fd_sc_hd__dfrtp_1
X_1129_ _0723_ _0724_ VGND VGND VPWR VPWR _0725_ sky130_fd_sc_hd__nor2_1
XFILLER_31_57 VGND VGND VPWR VPWR sky130_fd_sc_hd__decap_8
XFILLER_56_65 VGND VPWR VPWR VGND sky130_ef_sc_hd__decap_12
XPHY_EDGE_ROW_19_Right_19 VGND VGND VPWR VPWR sky130_fd_sc_hd__decap_3
XFILLER_8_301 VGND VGND VPWR VPWR sky130_fd_sc_hd__decap_6
XFILLER_8_345 VGND VPWR VPWR VGND sky130_ef_sc_hd__decap_12
XPHY_EDGE_ROW_28_Right_28 VGND VGND VPWR VPWR sky130_fd_sc_hd__decap_3
X_1480_ u_jt49.regarray\[6\]\[3\] net65 _0415_ VGND VGND VPWR VPWR _0186_ sky130_fd_sc_hd__mux2_1
XPHY_EDGE_ROW_37_Right_37 VGND VGND VPWR VPWR sky130_fd_sc_hd__decap_3
XPHY_EDGE_ROW_46_Right_46 VGND VGND VPWR VPWR sky130_fd_sc_hd__decap_3
X_1816_ clknet_leaf_3_clk _0229_ net87 VGND VGND VPWR VPWR u_jt49.periodB\[5\] sky130_fd_sc_hd__dfrtp_1
X_1678_ clknet_leaf_5_clk _0093_ net85 VGND VGND VPWR VPWR u_jt49.u_chB.count\[5\]
+ sky130_fd_sc_hd__dfrtp_1
X_1747_ clknet_leaf_20_clk _0160_ net96 VGND VGND VPWR VPWR IOA_out[1] sky130_fd_sc_hd__dfrtp_4
XPHY_EDGE_ROW_55_Right_55 VGND VGND VPWR VPWR sky130_fd_sc_hd__decap_3
XPHY_EDGE_ROW_64_Right_64 VGND VGND VPWR VPWR sky130_fd_sc_hd__decap_3
XFILLER_5_337 VGND VPWR VPWR VGND sky130_ef_sc_hd__decap_12
XFILLER_5_304 VGND VPWR VPWR VGND sky130_ef_sc_hd__decap_12
XFILLER_9_109 VGND VGND VPWR VPWR sky130_fd_sc_hd__decap_3
XFILLER_3_39 VGND VPWR VPWR VGND sky130_ef_sc_hd__decap_12
X_0980_ net69 net22 _0611_ VGND VGND VPWR VPWR _0005_ sky130_fd_sc_hd__mux2_1
XFILLER_44_296 VGND VGND VPWR VPWR sky130_fd_sc_hd__decap_3
X_1601_ clknet_leaf_7_clk _0018_ VGND VGND VPWR VPWR addr\[1\] sky130_fd_sc_hd__dfxtp_1
XFILLER_8_153 VGND VPWR VPWR VGND sky130_ef_sc_hd__decap_12
X_1532_ u_jt49.bitB u_jt49.regarray\[7\]\[1\] u_jt49.regarray\[7\]\[4\] u_jt49.noise
+ net20 VGND VGND VPWR VPWR _0422_ sky130_fd_sc_hd__o221a_1
X_1463_ u_jt49.regarray\[8\]\[4\] net63 _0413_ VGND VGND VPWR VPWR _0171_ sky130_fd_sc_hd__mux2_1
X_1394_ _0402_ u_jt49.bitA _0370_ VGND VGND VPWR VPWR _0113_ sky130_fd_sc_hd__mux2_1
XFILLER_35_274 VGND VGND VPWR VPWR sky130_fd_sc_hd__decap_6
XFILLER_12_15 VGND VPWR VPWR VGND sky130_ef_sc_hd__decap_12
XFILLER_2_329 VGND VPWR VPWR VGND sky130_ef_sc_hd__decap_12
Xhold120 u_jt49.regarray\[13\]\[0\] VGND VGND VPWR VPWR net226 sky130_fd_sc_hd__dlygate4sd3_1
XFILLER_37_78 VGND VGND VPWR VPWR sky130_fd_sc_hd__decap_6
XFILLER_53_99 VGND VPWR VPWR VGND sky130_ef_sc_hd__decap_12
X_0963_ u_jt49.periodA\[6\] _0521_ _0542_ _0599_ u_jt49.read_mask\[5\] VGND VGND VPWR
+ VPWR _0600_ sky130_fd_sc_hd__o2111a_1
X_0894_ u_jt49.regarray\[7\]\[0\] _0522_ _0528_ u_jt49.periodC\[8\] VGND VGND VPWR
+ VPWR _0537_ sky130_fd_sc_hd__a22o_1
X_1515_ u_jt49.periodB\[10\] net67 _0419_ VGND VGND VPWR VPWR _0217_ sky130_fd_sc_hd__mux2_1
X_1446_ net154 net62 _0411_ VGND VGND VPWR VPWR _0156_ sky130_fd_sc_hd__mux2_1
X_1377_ net46 _0387_ u_jt49.u_chA.count\[8\] VGND VGND VPWR VPWR _0390_ sky130_fd_sc_hd__a21o_1
XFILLER_23_277 VGND VGND VPWR VPWR sky130_fd_sc_hd__decap_3
XFILLER_64_65 VGND VPWR VPWR VGND sky130_ef_sc_hd__decap_12
XFILLER_61_317 VGND VPWR VPWR VGND sky130_ef_sc_hd__decap_12
XFILLER_46_314 VGND VGND VPWR VPWR sky130_fd_sc_hd__decap_8
Xfanout70 din_latch\[1\] VGND VGND VPWR VPWR net70 sky130_fd_sc_hd__buf_2
Xfanout81 net83 VGND VGND VPWR VPWR net81 sky130_fd_sc_hd__clkbuf_4
Xfanout92 net106 VGND VGND VPWR VPWR net92 sky130_fd_sc_hd__clkbuf_4
XFILLER_64_133 VGND VGND VPWR VPWR sky130_fd_sc_hd__decap_6
X_1300_ net31 _0325_ _0326_ VGND VGND VPWR VPWR _0095_ sky130_fd_sc_hd__and3_1
X_1231_ net186 net190 net36 VGND VGND VPWR VPWR _0078_ sky130_fd_sc_hd__mux2_1
XFILLER_1_192 VGND VPWR VPWR VGND sky130_ef_sc_hd__decap_12
X_1162_ net134 _0754_ net45 VGND VGND VPWR VPWR _0048_ sky130_fd_sc_hd__mux2_1
XFILLER_64_177 VGND VPWR VPWR VGND sky130_ef_sc_hd__decap_12
X_1093_ u_jt49.regarray\[13\]\[2\] u_jt49.regarray\[13\]\[1\] u_jt49.regarray\[13\]\[3\]
+ VGND VGND VPWR VPWR _0697_ sky130_fd_sc_hd__mux2_1
X_0877_ _0517_ _0519_ VGND VGND VPWR VPWR _0520_ sky130_fd_sc_hd__nor2_2
X_0946_ u_jt49.eg_period\[5\] _0524_ _0530_ u_jt49.regarray\[1\]\[5\] _0583_ VGND
+ VGND VPWR VPWR _0584_ sky130_fd_sc_hd__a221o_1
X_1429_ net59 u_jt49.eg_period\[6\] _0409_ VGND VGND VPWR VPWR _0141_ sky130_fd_sc_hd__mux2_1
XFILLER_51_361 VGND VPWR VPWR VGND sky130_ef_sc_hd__decap_12
XFILLER_11_225 VGND VGND VPWR VPWR sky130_fd_sc_hd__decap_4
Xclkload1 clknet_leaf_0_clk VGND VGND VPWR VPWR clkload1/Y sky130_fd_sc_hd__inv_6
XFILLER_50_67 VGND VGND VPWR VPWR sky130_fd_sc_hd__decap_8
XFILLER_61_169 VGND VPWR VPWR VGND sky130_ef_sc_hd__decap_12
XFILLER_61_125 VGND VPWR VPWR VGND sky130_ef_sc_hd__decap_12
XFILLER_27_380 VGND VGND VPWR VPWR sky130_fd_sc_hd__decap_6
X_0800_ u_jt49.eg_period\[12\] VGND VGND VPWR VPWR _0450_ sky130_fd_sc_hd__inv_2
X_1780_ clknet_leaf_17_clk _0193_ net99 VGND VGND VPWR VPWR u_jt49.periodC\[10\] sky130_fd_sc_hd__dfrtp_2
XFILLER_34_3 VGND VPWR VPWR VGND sky130_ef_sc_hd__decap_12
X_1214_ u_jt49.u_envdiv.count\[13\] _0786_ VGND VGND VPWR VPWR _0790_ sky130_fd_sc_hd__nand2_1
X_1145_ _0722_ _0731_ VGND VGND VPWR VPWR _0741_ sky130_fd_sc_hd__nor2_1
X_1076_ u_jt49.u_chC.count\[9\] _0681_ VGND VGND VPWR VPWR _0684_ sky130_fd_sc_hd__or2_1
X_0929_ u_jt49.periodC\[3\] _0518_ _0531_ u_jt49.periodB\[3\] VGND VGND VPWR VPWR
+ _0569_ sky130_fd_sc_hd__a22o_1
XFILLER_20_15 VGND VPWR VPWR VGND sky130_ef_sc_hd__decap_12
XFILLER_20_37 VGND VGND VPWR VPWR sky130_fd_sc_hd__decap_3
Xhold57 u_jt49.regarray\[10\]\[7\] VGND VGND VPWR VPWR net163 sky130_fd_sc_hd__dlygate4sd3_1
Xhold46 u_jt49.regarray\[9\]\[7\] VGND VGND VPWR VPWR net152 sky130_fd_sc_hd__dlygate4sd3_1
Xhold35 u_jt49.regarray\[1\]\[5\] VGND VGND VPWR VPWR net141 sky130_fd_sc_hd__dlygate4sd3_1
Xhold79 u_jt49.u_ng.poly17\[9\] VGND VGND VPWR VPWR net185 sky130_fd_sc_hd__dlygate4sd3_1
Xhold13 u_jt49.logC\[4\] VGND VGND VPWR VPWR net119 sky130_fd_sc_hd__dlygate4sd3_1
Xhold24 u_jt49.envelope\[0\] VGND VGND VPWR VPWR net130 sky130_fd_sc_hd__dlygate4sd3_1
Xhold68 u_jt49.u_ng.poly17\[7\] VGND VGND VPWR VPWR net174 sky130_fd_sc_hd__dlygate4sd3_1
XFILLER_43_169 VGND VGND VPWR VPWR sky130_fd_sc_hd__decap_6
XFILLER_43_125 VGND VPWR VPWR VGND sky130_ef_sc_hd__decap_12
XFILLER_3_232 VGND VGND VPWR VPWR sky130_fd_sc_hd__decap_3
XFILLER_19_122 VGND VPWR VPWR VGND sky130_ef_sc_hd__decap_12
X_1832_ clknet_leaf_27_clk _0245_ VGND VGND VPWR VPWR u_jt49.logA\[4\] sky130_fd_sc_hd__dfxtp_1
XFILLER_15_361 VGND VPWR VPWR VGND sky130_ef_sc_hd__decap_12
XFILLER_22_309 VGND VGND VPWR VPWR sky130_fd_sc_hd__decap_6
X_1694_ clknet_leaf_30_clk _0109_ net78 VGND VGND VPWR VPWR u_jt49.u_chA.count\[8\]
+ sky130_fd_sc_hd__dfrtp_1
X_1763_ clknet_leaf_24_clk _0176_ net92 VGND VGND VPWR VPWR u_jt49.regarray\[7\]\[1\]
+ sky130_fd_sc_hd__dfrtp_1
X_1128_ u_jt49.eg_period\[11\] u_jt49.u_envdiv.count\[11\] VGND VGND VPWR VPWR _0724_
+ sky130_fd_sc_hd__and2b_1
X_1059_ net48 _0668_ u_jt49.u_chC.count\[4\] VGND VGND VPWR VPWR _0672_ sky130_fd_sc_hd__a21o_1
XFILLER_15_15 VGND VPWR VPWR VGND sky130_ef_sc_hd__decap_12
XFILLER_31_47 VGND VGND VPWR VPWR sky130_fd_sc_hd__decap_8
XFILLER_56_283 VGND VPWR VPWR VGND sky130_ef_sc_hd__decap_12
XFILLER_56_77 VGND VGND VPWR VPWR sky130_fd_sc_hd__decap_6
XFILLER_24_180 VGND VGND VPWR VPWR sky130_fd_sc_hd__decap_3
XFILLER_8_357 VGND VGND VPWR VPWR sky130_fd_sc_hd__decap_6
XFILLER_62_253 VGND VPWR VPWR VGND sky130_ef_sc_hd__decap_12
X_1815_ clknet_leaf_2_clk _0228_ net87 VGND VGND VPWR VPWR u_jt49.periodB\[4\] sky130_fd_sc_hd__dfrtp_2
XFILLER_30_150 VGND VGND VPWR VPWR sky130_fd_sc_hd__decap_8
XFILLER_22_128 VGND VPWR VPWR VGND sky130_ef_sc_hd__decap_12
X_1677_ clknet_leaf_4_clk _0092_ net84 VGND VGND VPWR VPWR u_jt49.u_chB.count\[4\]
+ sky130_fd_sc_hd__dfrtp_1
X_1746_ clknet_leaf_20_clk _0159_ net96 VGND VGND VPWR VPWR IOA_out[0] sky130_fd_sc_hd__dfrtp_4
XFILLER_45_209 VGND VGND VPWR VPWR sky130_fd_sc_hd__decap_4
XFILLER_26_47 VGND VGND VPWR VPWR sky130_fd_sc_hd__decap_4
XPHY_EDGE_ROW_39_Left_105 VGND VGND VPWR VPWR sky130_fd_sc_hd__decap_3
XFILLER_5_349 VGND VPWR VPWR VGND sky130_ef_sc_hd__decap_12
XFILLER_5_316 VGND VPWR VPWR VGND sky130_ef_sc_hd__decap_12
XPHY_EDGE_ROW_48_Left_114 VGND VGND VPWR VPWR sky130_fd_sc_hd__decap_3
XFILLER_44_242 VGND VGND VPWR VPWR sky130_fd_sc_hd__decap_8
XFILLER_44_253 VGND VGND VPWR VPWR sky130_fd_sc_hd__decap_3
XPHY_EDGE_ROW_57_Left_123 VGND VGND VPWR VPWR sky130_fd_sc_hd__decap_3
X_1600_ clknet_leaf_7_clk _0017_ VGND VGND VPWR VPWR addr\[0\] sky130_fd_sc_hd__dfxtp_1
X_1531_ u_jt49.periodB\[7\] net57 _0421_ VGND VGND VPWR VPWR _0231_ sky130_fd_sc_hd__mux2_1
XFILLER_8_165 VGND VGND VPWR VPWR sky130_fd_sc_hd__decap_8
X_1462_ net224 net65 _0413_ VGND VGND VPWR VPWR _0170_ sky130_fd_sc_hd__mux2_1
X_1393_ _0399_ _0400_ _0401_ _0500_ VGND VGND VPWR VPWR _0402_ sky130_fd_sc_hd__o31a_1
XFILLER_50_289 VGND VGND VPWR VPWR sky130_fd_sc_hd__decap_4
Xhold110 u_jt49.u_chC.count\[3\] VGND VGND VPWR VPWR net216 sky130_fd_sc_hd__dlygate4sd3_1
X_1729_ clknet_leaf_11_clk _0142_ net101 VGND VGND VPWR VPWR u_jt49.eg_period\[7\]
+ sky130_fd_sc_hd__dfrtp_1
Xhold121 u_jt49.periodA\[4\] VGND VGND VPWR VPWR net227 sky130_fd_sc_hd__dlygate4sd3_1
XFILLER_58_378 VGND VGND VPWR VPWR sky130_fd_sc_hd__decap_8
XFILLER_26_253 VGND VGND VPWR VPWR sky130_fd_sc_hd__decap_4
XFILLER_53_78 VGND VPWR VPWR VGND sky130_ef_sc_hd__decap_12
XFILLER_53_67 VGND VGND VPWR VPWR sky130_fd_sc_hd__decap_6
XFILLER_26_297 VGND VGND VPWR VPWR sky130_fd_sc_hd__decap_8
XFILLER_5_113 VGND VPWR VPWR VGND sky130_ef_sc_hd__decap_12
XFILLER_64_3 VGND VPWR VPWR VGND sky130_ef_sc_hd__decap_12
X_0962_ _0593_ _0595_ _0598_ VGND VGND VPWR VPWR _0599_ sky130_fd_sc_hd__or3_1
X_0893_ u_jt49.regarray\[10\]\[0\] _0523_ _0534_ _0535_ VGND VGND VPWR VPWR _0536_
+ sky130_fd_sc_hd__a211o_1
X_1514_ u_jt49.periodB\[9\] net69 _0419_ VGND VGND VPWR VPWR _0216_ sky130_fd_sc_hd__mux2_1
XFILLER_4_190 VGND VGND VPWR VPWR sky130_fd_sc_hd__decap_6
X_1445_ u_jt49.regarray\[9\]\[4\] net64 _0411_ VGND VGND VPWR VPWR _0155_ sky130_fd_sc_hd__mux2_1
XFILLER_55_337 VGND VPWR VPWR VGND sky130_ef_sc_hd__decap_12
X_1376_ _0368_ _0388_ _0389_ net208 net44 VGND VGND VPWR VPWR _0108_ sky130_fd_sc_hd__a32o_1
XFILLER_64_77 VGND VGND VPWR VPWR sky130_fd_sc_hd__decap_6
XFILLER_61_329 VGND VGND VPWR VPWR sky130_fd_sc_hd__decap_6
XFILLER_58_197 VGND VPWR VPWR VGND sky130_ef_sc_hd__decap_12
XFILLER_14_234 VGND VPWR VPWR VGND sky130_ef_sc_hd__decap_12
Xfanout71 din_latch\[0\] VGND VGND VPWR VPWR net71 sky130_fd_sc_hd__clkbuf_4
Xfanout60 din_latch\[6\] VGND VGND VPWR VPWR net60 sky130_fd_sc_hd__buf_2
Xfanout82 net83 VGND VGND VPWR VPWR net82 sky130_fd_sc_hd__buf_2
Xfanout93 net94 VGND VGND VPWR VPWR net93 sky130_fd_sc_hd__clkbuf_4
XFILLER_29_6 VGND VGND VPWR VPWR sky130_fd_sc_hd__decap_8
X_1230_ net185 net186 net36 VGND VGND VPWR VPWR _0077_ sky130_fd_sc_hd__mux2_1
X_1161_ u_jt49.u_env.gain\[2\] u_jt49.u_env.inv VGND VGND VPWR VPWR _0754_ sky130_fd_sc_hd__xor2_1
X_1092_ _0452_ net45 _0695_ _0630_ VGND VGND VPWR VPWR _0696_ sky130_fd_sc_hd__a31o_2
XFILLER_64_189 VGND VGND VPWR VPWR sky130_fd_sc_hd__decap_6
XFILLER_60_373 VGND VGND VPWR VPWR sky130_fd_sc_hd__decap_3
XFILLER_52_329 VGND VPWR VPWR VGND sky130_ef_sc_hd__decap_12
X_0876_ net49 net51 VGND VGND VPWR VPWR _0519_ sky130_fd_sc_hd__or2_2
X_0945_ u_jt49.regarray\[6\]\[5\] _0526_ _0527_ u_jt49.regarray\[13\]\[5\] VGND VGND
+ VPWR VPWR _0583_ sky130_fd_sc_hd__a22o_1
X_1428_ net62 u_jt49.eg_period\[5\] _0409_ VGND VGND VPWR VPWR _0140_ sky130_fd_sc_hd__mux2_1
XFILLER_18_15 VGND VPWR VPWR VGND sky130_ef_sc_hd__decap_12
XFILLER_55_178 VGND VPWR VPWR VGND sky130_ef_sc_hd__decap_12
X_1359_ _0376_ VGND VGND VPWR VPWR _0377_ sky130_fd_sc_hd__inv_2
XFILLER_51_373 VGND VPWR VPWR VGND sky130_ef_sc_hd__decap_12
Xclkload2 clknet_leaf_1_clk VGND VGND VPWR VPWR clkload2/X sky130_fd_sc_hd__clkbuf_8
XFILLER_19_348 VGND VPWR VPWR VGND sky130_ef_sc_hd__decap_12
XFILLER_61_137 VGND VPWR VPWR VGND sky130_ef_sc_hd__decap_12
XFILLER_34_329 VGND VGND VPWR VPWR sky130_fd_sc_hd__decap_4
XFILLER_10_292 VGND VPWR VPWR VGND sky130_ef_sc_hd__decap_12
X_1213_ u_jt49.u_envdiv.count\[13\] _0786_ VGND VGND VPWR VPWR _0789_ sky130_fd_sc_hd__or2_1
XFILLER_52_137 VGND VGND VPWR VPWR sky130_fd_sc_hd__decap_3
X_1144_ u_jt49.eg_period\[7\] _0479_ VGND VGND VPWR VPWR _0740_ sky130_fd_sc_hd__nand2_1
X_1075_ u_jt49.u_chC.count\[9\] u_jt49.u_chC.count\[8\] _0677_ VGND VGND VPWR VPWR
+ _0683_ sky130_fd_sc_hd__nand3_1
XFILLER_25_307 VGND VGND VPWR VPWR sky130_fd_sc_hd__decap_4
X_0859_ net23 net52 _0507_ VGND VGND VPWR VPWR _0508_ sky130_fd_sc_hd__mux2_1
X_0928_ u_jt49.regarray\[8\]\[3\] _0525_ _0533_ u_jt49.regarray\[9\]\[3\] _0520_ VGND
+ VGND VPWR VPWR _0568_ sky130_fd_sc_hd__a221o_1
Xhold36 u_jt49.u_env.last_step VGND VGND VPWR VPWR net142 sky130_fd_sc_hd__dlygate4sd3_1
Xhold47 u_jt49.regarray\[6\]\[6\] VGND VGND VPWR VPWR net153 sky130_fd_sc_hd__dlygate4sd3_1
XFILLER_29_14 VGND VGND VPWR VPWR sky130_fd_sc_hd__decap_3
Xhold58 u_jt49.regarray\[13\]\[5\] VGND VGND VPWR VPWR net164 sky130_fd_sc_hd__dlygate4sd3_1
Xhold69 _0074_ VGND VGND VPWR VPWR net175 sky130_fd_sc_hd__dlygate4sd3_1
Xhold14 u_jt49.logA\[1\] VGND VGND VPWR VPWR net120 sky130_fd_sc_hd__dlygate4sd3_1
Xhold25 u_jt49.regarray\[9\]\[1\] VGND VGND VPWR VPWR net131 sky130_fd_sc_hd__dlygate4sd3_1
XFILLER_43_137 VGND VGND VPWR VPWR sky130_fd_sc_hd__decap_8
XFILLER_3_288 VGND VGND VPWR VPWR sky130_fd_sc_hd__decap_4
XFILLER_59_281 VGND VPWR VPWR VGND sky130_ef_sc_hd__decap_12
XFILLER_19_134 VGND VGND VPWR VPWR sky130_fd_sc_hd__decap_8
XFILLER_19_178 VGND VGND VPWR VPWR sky130_fd_sc_hd__decap_6
XFILLER_30_365 VGND VPWR VPWR VGND sky130_ef_sc_hd__decap_12
X_1831_ clknet_leaf_23_clk _0244_ VGND VGND VPWR VPWR u_jt49.logA\[3\] sky130_fd_sc_hd__dfxtp_1
XFILLER_15_373 VGND VGND VPWR VPWR sky130_fd_sc_hd__decap_8
X_1693_ clknet_leaf_0_clk _0108_ net78 VGND VGND VPWR VPWR u_jt49.u_chA.count\[7\]
+ sky130_fd_sc_hd__dfrtp_1
X_1762_ clknet_leaf_26_clk _0175_ net82 VGND VGND VPWR VPWR u_jt49.regarray\[7\]\[0\]
+ sky130_fd_sc_hd__dfrtp_1
XPHY_EDGE_ROW_27_Left_93 VGND VGND VPWR VPWR sky130_fd_sc_hd__decap_3
XFILLER_65_284 VGND VPWR VPWR VGND sky130_ef_sc_hd__decap_12
X_1127_ u_jt49.eg_period\[10\] u_jt49.u_envdiv.count\[10\] VGND VGND VPWR VPWR _0723_
+ sky130_fd_sc_hd__and2b_1
X_1058_ _0670_ VGND VGND VPWR VPWR _0671_ sky130_fd_sc_hd__inv_2
XPHY_EDGE_ROW_11_Left_77 VGND VGND VPWR VPWR sky130_fd_sc_hd__decap_3
XFILLER_15_27 VGND VPWR VPWR VGND sky130_ef_sc_hd__decap_12
XFILLER_0_225 VGND VGND VPWR VPWR sky130_fd_sc_hd__decap_6
XPHY_EDGE_ROW_1_Right_1 VGND VGND VPWR VPWR sky130_fd_sc_hd__decap_3
XFILLER_12_365 VGND VPWR VPWR VGND sky130_ef_sc_hd__decap_12
XFILLER_62_265 VGND VPWR VPWR VGND sky130_ef_sc_hd__decap_12
XFILLER_62_221 VGND VPWR VPWR VGND sky130_ef_sc_hd__decap_12
X_1814_ clknet_leaf_3_clk _0227_ net85 VGND VGND VPWR VPWR u_jt49.periodB\[3\] sky130_fd_sc_hd__dfrtp_1
X_1745_ clknet_leaf_18_clk _0158_ net98 VGND VGND VPWR VPWR u_jt49.regarray\[9\]\[7\]
+ sky130_fd_sc_hd__dfrtp_1
XFILLER_30_184 VGND VPWR VPWR VGND sky130_ef_sc_hd__decap_12
XFILLER_15_181 VGND VGND VPWR VPWR sky130_fd_sc_hd__decap_4
X_1676_ clknet_leaf_4_clk _0091_ net84 VGND VGND VPWR VPWR u_jt49.u_chB.count\[3\]
+ sky130_fd_sc_hd__dfrtp_1
XFILLER_42_69 VGND VGND VPWR VPWR sky130_fd_sc_hd__decap_4
XFILLER_5_328 VGND VGND VPWR VPWR sky130_fd_sc_hd__decap_8
XFILLER_16_81 VGND VGND VPWR VPWR sky130_fd_sc_hd__decap_3
Xclkbuf_leaf_24_clk clknet_2_2__leaf_clk VGND VGND VPWR VPWR clknet_leaf_24_clk sky130_fd_sc_hd__clkbuf_8
X_1530_ u_jt49.periodB\[6\] net59 _0421_ VGND VGND VPWR VPWR _0230_ sky130_fd_sc_hd__mux2_1
XFILLER_4_361 VGND VGND VPWR VPWR sky130_fd_sc_hd__decap_3
X_1461_ net214 net68 _0413_ VGND VGND VPWR VPWR _0169_ sky130_fd_sc_hd__mux2_1
X_1392_ u_jt49.periodA\[11\] u_jt49.periodA\[10\] u_jt49.periodA\[9\] u_jt49.periodA\[8\]
+ VGND VGND VPWR VPWR _0401_ sky130_fd_sc_hd__or4_1
Xclkbuf_leaf_15_clk clknet_2_3__leaf_clk VGND VGND VPWR VPWR clknet_leaf_15_clk sky130_fd_sc_hd__clkbuf_8
X_1728_ clknet_leaf_11_clk _0141_ net98 VGND VGND VPWR VPWR u_jt49.eg_period\[6\]
+ sky130_fd_sc_hd__dfrtp_1
Xhold122 u_jt49.u_cen.cencnt\[0\] VGND VGND VPWR VPWR net228 sky130_fd_sc_hd__dlygate4sd3_1
Xhold111 u_jt49.u_chA.count\[5\] VGND VGND VPWR VPWR net217 sky130_fd_sc_hd__dlygate4sd3_1
Xhold100 u_jt49.u_chC.count\[7\] VGND VGND VPWR VPWR net206 sky130_fd_sc_hd__dlygate4sd3_1
X_1659_ clknet_leaf_28_clk _0076_ net75 VGND VGND VPWR VPWR u_jt49.u_ng.poly17\[8\]
+ sky130_fd_sc_hd__dfrtp_1
XFILLER_53_57 VGND VGND VPWR VPWR sky130_fd_sc_hd__decap_6
XPHY_EDGE_ROW_14_Left_80 VGND VGND VPWR VPWR sky130_fd_sc_hd__decap_3
XFILLER_5_125 VGND VPWR VPWR VGND sky130_ef_sc_hd__decap_12
X_0961_ u_jt49.regarray\[1\]\[6\] _0530_ _0596_ _0597_ VGND VGND VPWR VPWR _0598_
+ sky130_fd_sc_hd__a211o_1
XFILLER_17_265 VGND VGND VPWR VPWR sky130_fd_sc_hd__decap_4
XFILLER_57_3 VGND VPWR VPWR VGND sky130_ef_sc_hd__decap_12
X_0892_ u_jt49.periodC\[0\] net40 _0524_ u_jt49.eg_period\[0\] _0520_ VGND VGND VPWR
+ VPWR _0535_ sky130_fd_sc_hd__a221o_1
X_1513_ u_jt49.periodB\[8\] net71 _0419_ VGND VGND VPWR VPWR _0215_ sky130_fd_sc_hd__mux2_1
Xclkbuf_leaf_4_clk clknet_2_1__leaf_clk VGND VGND VPWR VPWR clknet_leaf_4_clk sky130_fd_sc_hd__clkbuf_8
X_1375_ net43 _0491_ _0385_ VGND VGND VPWR VPWR _0389_ sky130_fd_sc_hd__o21ai_1
X_1444_ u_jt49.regarray\[9\]\[3\] net66 _0411_ VGND VGND VPWR VPWR _0154_ sky130_fd_sc_hd__mux2_1
XFILLER_55_349 VGND VPWR VPWR VGND sky130_ef_sc_hd__decap_12
XFILLER_9_18 VGND VPWR VPWR VGND sky130_ef_sc_hd__decap_12
XFILLER_14_246 VGND VGND VPWR VPWR sky130_fd_sc_hd__decap_6
Xfanout50 addr\[3\] VGND VGND VPWR VPWR net50 sky130_fd_sc_hd__clkbuf_2
Xfanout61 din_latch\[5\] VGND VGND VPWR VPWR net61 sky130_fd_sc_hd__buf_4
Xfanout72 din_latch\[0\] VGND VGND VPWR VPWR net72 sky130_fd_sc_hd__clkbuf_2
Xfanout94 net106 VGND VGND VPWR VPWR net94 sky130_fd_sc_hd__clkbuf_4
Xfanout83 net106 VGND VGND VPWR VPWR net83 sky130_fd_sc_hd__clkbuf_2
X_1091_ _0692_ net39 net38 u_jt49.eg_step _0444_ VGND VGND VPWR VPWR _0695_ sky130_fd_sc_hd__a32o_1
XFILLER_37_316 VGND VGND VPWR VPWR sky130_fd_sc_hd__decap_3
X_1160_ net138 _0753_ net45 VGND VGND VPWR VPWR _0047_ sky130_fd_sc_hd__mux2_1
X_0944_ u_jt49.regarray\[7\]\[5\] _0522_ _0533_ u_jt49.regarray\[9\]\[5\] VGND VGND
+ VPWR VPWR _0582_ sky130_fd_sc_hd__a22o_1
X_0875_ net50 net54 net56 net52 VGND VGND VPWR VPWR _0518_ sky130_fd_sc_hd__nor4b_2
Xclkload20 clknet_leaf_24_clk VGND VGND VPWR VPWR clkload20/X sky130_fd_sc_hd__clkbuf_4
X_1427_ net64 u_jt49.eg_period\[4\] _0409_ VGND VGND VPWR VPWR _0139_ sky130_fd_sc_hd__mux2_1
XFILLER_28_327 VGND VGND VPWR VPWR sky130_fd_sc_hd__decap_6
X_1358_ u_jt49.u_chA.count\[3\] u_jt49.u_chA.count\[2\] u_jt49.u_chA.count\[1\] u_jt49.u_chA.count\[0\]
+ VGND VGND VPWR VPWR _0376_ sky130_fd_sc_hd__and4_1
XFILLER_51_330 VGND VGND VPWR VPWR sky130_fd_sc_hd__decap_6
X_1289_ net31 _0317_ _0318_ VGND VGND VPWR VPWR _0092_ sky130_fd_sc_hd__and3_1
XFILLER_34_15 VGND VPWR VPWR VGND sky130_ef_sc_hd__decap_12
Xclkload3 clknet_leaf_25_clk VGND VGND VPWR VPWR clkload3/Y sky130_fd_sc_hd__inv_6
XFILLER_61_105 VGND VGND VPWR VPWR sky130_fd_sc_hd__decap_6
XFILLER_46_113 VGND VGND VPWR VPWR sky130_fd_sc_hd__decap_3
XFILLER_61_149 VGND VPWR VPWR VGND sky130_ef_sc_hd__decap_12
XFILLER_40_80 VGND VGND VPWR VPWR sky130_fd_sc_hd__decap_4
XFILLER_6_253 VGND VGND VPWR VPWR sky130_fd_sc_hd__decap_4
X_1212_ net33 _0787_ _0788_ VGND VGND VPWR VPWR _0064_ sky130_fd_sc_hd__and3_1
X_1143_ u_jt49.eg_period\[7\] _0479_ VGND VGND VPWR VPWR _0739_ sky130_fd_sc_hd__and2_1
X_1074_ _0662_ _0680_ _0682_ VGND VGND VPWR VPWR _0032_ sky130_fd_sc_hd__and3_1
X_0927_ u_jt49.eg_period\[3\] _0524_ _0564_ _0566_ VGND VGND VPWR VPWR _0567_ sky130_fd_sc_hd__a211o_1
X_0858_ net18 _0505_ _0506_ VGND VGND VPWR VPWR _0507_ sky130_fd_sc_hd__o21ai_4
Xhold37 _0038_ VGND VGND VPWR VPWR net143 sky130_fd_sc_hd__dlygate4sd3_1
Xhold59 u_jt49.regarray\[5\]\[7\] VGND VGND VPWR VPWR net165 sky130_fd_sc_hd__dlygate4sd3_1
Xhold48 u_jt49.regarray\[9\]\[5\] VGND VGND VPWR VPWR net154 sky130_fd_sc_hd__dlygate4sd3_1
Xhold15 u_jt49.logA\[0\] VGND VGND VPWR VPWR net121 sky130_fd_sc_hd__dlygate4sd3_1
Xhold26 u_jt49.envelope\[4\] VGND VGND VPWR VPWR net132 sky130_fd_sc_hd__dlygate4sd3_1
XFILLER_61_57 VGND VPWR VPWR VGND sky130_ef_sc_hd__decap_12
XFILLER_51_193 VGND VPWR VPWR VGND sky130_ef_sc_hd__decap_12
XFILLER_10_72 VGND VGND VPWR VPWR sky130_fd_sc_hd__decap_4
XFILLER_42_193 VGND VGND VPWR VPWR sky130_fd_sc_hd__decap_3
X_1761_ clknet_leaf_10_clk _0174_ net98 VGND VGND VPWR VPWR u_jt49.regarray\[8\]\[7\]
+ sky130_fd_sc_hd__dfrtp_1
XFILLER_30_377 VGND VGND VPWR VPWR sky130_fd_sc_hd__decap_8
X_1830_ clknet_leaf_27_clk _0243_ VGND VGND VPWR VPWR u_jt49.logA\[2\] sky130_fd_sc_hd__dfxtp_1
X_1692_ clknet_leaf_3_clk _0107_ net85 VGND VGND VPWR VPWR u_jt49.u_chA.count\[6\]
+ sky130_fd_sc_hd__dfrtp_1
X_1126_ _0714_ _0716_ _0718_ _0721_ VGND VGND VPWR VPWR _0722_ sky130_fd_sc_hd__or4_1
XFILLER_65_296 VGND VPWR VPWR VGND sky130_ef_sc_hd__decap_12
X_1057_ sample u_jt49.u_chC.count\[4\] _0668_ VGND VGND VPWR VPWR _0670_ sky130_fd_sc_hd__and3_1
XFILLER_12_344 VGND VPWR VPWR VGND sky130_ef_sc_hd__decap_12
XFILLER_12_377 VGND VGND VPWR VPWR sky130_fd_sc_hd__decap_6
XFILLER_62_277 VGND VPWR VPWR VGND sky130_ef_sc_hd__decap_12
XFILLER_62_233 VGND VPWR VPWR VGND sky130_ef_sc_hd__decap_12
Xclkbuf_0_clk clk VGND VGND VPWR VPWR clknet_0_clk sky130_fd_sc_hd__clkbuf_16
X_1813_ clknet_leaf_3_clk _0226_ net85 VGND VGND VPWR VPWR u_jt49.periodB\[2\] sky130_fd_sc_hd__dfrtp_2
X_1744_ clknet_leaf_10_clk _0157_ net98 VGND VGND VPWR VPWR u_jt49.regarray\[9\]\[6\]
+ sky130_fd_sc_hd__dfrtp_1
XFILLER_30_163 VGND VPWR VPWR VGND sky130_ef_sc_hd__decap_12
X_1675_ clknet_leaf_4_clk _0090_ net84 VGND VGND VPWR VPWR u_jt49.u_chB.count\[2\]
+ sky130_fd_sc_hd__dfrtp_1
XPHY_EDGE_ROW_15_Right_15 VGND VGND VPWR VPWR sky130_fd_sc_hd__decap_3
X_1109_ u_jt49.u_env.gain\[0\] u_jt49.u_env.gain\[1\] _0706_ VGND VGND VPWR VPWR _0709_
+ sky130_fd_sc_hd__or3_1
XPHY_EDGE_ROW_24_Right_24 VGND VGND VPWR VPWR sky130_fd_sc_hd__decap_3
XFILLER_42_15 VGND VPWR VPWR VGND sky130_ef_sc_hd__decap_12
XFILLER_13_108 VGND VGND VPWR VPWR sky130_fd_sc_hd__decap_4
XPHY_EDGE_ROW_33_Right_33 VGND VGND VPWR VPWR sky130_fd_sc_hd__decap_3
XPHY_EDGE_ROW_42_Right_42 VGND VGND VPWR VPWR sky130_fd_sc_hd__decap_3
XPHY_EDGE_ROW_51_Right_51 VGND VGND VPWR VPWR sky130_fd_sc_hd__decap_3
XFILLER_8_134 VGND VGND VPWR VPWR sky130_fd_sc_hd__decap_6
XFILLER_8_178 VGND VGND VPWR VPWR sky130_fd_sc_hd__decap_4
XFILLER_8_189 VGND VGND VPWR VPWR sky130_fd_sc_hd__decap_6
XFILLER_12_141 VGND VPWR VPWR VGND sky130_ef_sc_hd__decap_12
X_1391_ u_jt49.periodA\[7\] u_jt49.periodA\[6\] u_jt49.periodA\[5\] u_jt49.periodA\[4\]
+ VGND VGND VPWR VPWR _0400_ sky130_fd_sc_hd__or4_1
X_1460_ net209 net69 _0413_ VGND VGND VPWR VPWR _0168_ sky130_fd_sc_hd__mux2_1
XPHY_EDGE_ROW_60_Right_60 VGND VGND VPWR VPWR sky130_fd_sc_hd__decap_3
Xhold101 u_jt49.u_envdiv.count\[15\] VGND VGND VPWR VPWR net207 sky130_fd_sc_hd__dlygate4sd3_1
Xhold123 u_jt49.u_cen.cencnt\[2\] VGND VGND VPWR VPWR net229 sky130_fd_sc_hd__dlygate4sd3_1
X_1727_ clknet_leaf_11_clk _0140_ net100 VGND VGND VPWR VPWR u_jt49.eg_period\[5\]
+ sky130_fd_sc_hd__dfrtp_2
Xhold112 u_jt49.periodC\[0\] VGND VGND VPWR VPWR net218 sky130_fd_sc_hd__dlygate4sd3_1
X_1658_ clknet_leaf_29_clk _0075_ net75 VGND VGND VPWR VPWR u_jt49.u_ng.poly17\[7\]
+ sky130_fd_sc_hd__dfrtp_1
X_1589_ clknet_leaf_8_clk _0006_ VGND VGND VPWR VPWR din_latch\[2\] sky130_fd_sc_hd__dfxtp_1
XFILLER_37_15 VGND VPWR VPWR VGND sky130_ef_sc_hd__decap_12
XFILLER_5_137 VGND VPWR VPWR VGND sky130_ef_sc_hd__decap_12
XFILLER_1_354 VGND VPWR VPWR VGND sky130_ef_sc_hd__decap_12
XFILLER_27_81 VGND VPWR VPWR VGND sky130_ef_sc_hd__decap_12
X_0960_ u_jt49.regarray\[10\]\[6\] _0523_ _0529_ u_jt49.eg_period\[14\] _0591_ VGND
+ VGND VPWR VPWR _0597_ sky130_fd_sc_hd__a221o_1
X_1512_ net41 _0532_ VGND VGND VPWR VPWR _0419_ sky130_fd_sc_hd__and2_2
X_0891_ u_jt49.regarray\[13\]\[0\] _0527_ _0533_ u_jt49.regarray\[9\]\[0\] VGND VGND
+ VPWR VPWR _0534_ sky130_fd_sc_hd__a22o_1
X_1374_ _0387_ VGND VGND VPWR VPWR _0388_ sky130_fd_sc_hd__inv_2
X_1443_ net210 net68 _0411_ VGND VGND VPWR VPWR _0153_ sky130_fd_sc_hd__mux2_1
XFILLER_63_361 VGND VPWR VPWR VGND sky130_ef_sc_hd__decap_12
XFILLER_2_118 VGND VPWR VPWR VGND sky130_ef_sc_hd__decap_12
XFILLER_46_339 VGND VGND VPWR VPWR sky130_fd_sc_hd__decap_4
Xfanout62 din_latch\[5\] VGND VGND VPWR VPWR net62 sky130_fd_sc_hd__clkbuf_2
Xfanout51 net52 VGND VGND VPWR VPWR net51 sky130_fd_sc_hd__clkbuf_4
Xfanout73 net74 VGND VGND VPWR VPWR net73 sky130_fd_sc_hd__buf_2
Xfanout84 net86 VGND VGND VPWR VPWR net84 sky130_fd_sc_hd__clkbuf_4
Xfanout95 net97 VGND VGND VPWR VPWR net95 sky130_fd_sc_hd__clkbuf_4
XFILLER_1_162 VGND VGND VPWR VPWR sky130_fd_sc_hd__decap_6
X_1090_ u_jt49.eg_period\[13\] u_jt49.eg_period\[12\] u_jt49.eg_period\[15\] u_jt49.eg_period\[14\]
+ VGND VGND VPWR VPWR _0694_ sky130_fd_sc_hd__nor4_1
X_0874_ net53 net55 VGND VGND VPWR VPWR _0517_ sky130_fd_sc_hd__or2_1
Xclkload10 clknet_leaf_4_clk VGND VGND VPWR VPWR clkload10/Y sky130_fd_sc_hd__clkinv_2
X_0943_ net13 _0544_ _0545_ net5 _0581_ VGND VGND VPWR VPWR _0270_ sky130_fd_sc_hd__a221o_1
Xclkload21 clknet_leaf_10_clk VGND VGND VPWR VPWR clkload21/X sky130_fd_sc_hd__clkbuf_8
X_1426_ net66 u_jt49.eg_period\[3\] _0409_ VGND VGND VPWR VPWR _0138_ sky130_fd_sc_hd__mux2_1
X_1288_ _0462_ _0314_ VGND VGND VPWR VPWR _0318_ sky130_fd_sc_hd__nand2_1
X_1357_ _0370_ _0374_ _0375_ VGND VGND VPWR VPWR _0103_ sky130_fd_sc_hd__and3_1
XFILLER_50_15 VGND VPWR VPWR VGND sky130_ef_sc_hd__decap_12
Xclkload4 clknet_leaf_27_clk VGND VGND VPWR VPWR clkload4/X sky130_fd_sc_hd__clkbuf_4
XFILLER_59_57 VGND VPWR VPWR VGND sky130_ef_sc_hd__decap_12
XFILLER_46_125 VGND VPWR VPWR VGND sky130_ef_sc_hd__decap_12
XFILLER_34_309 VGND VGND VPWR VPWR sky130_fd_sc_hd__decap_3
XFILLER_54_191 VGND VGND VPWR VPWR sky130_fd_sc_hd__decap_4
X_1211_ u_jt49.u_envdiv.count\[12\] _0783_ VGND VGND VPWR VPWR _0788_ sky130_fd_sc_hd__or2_1
X_1142_ u_jt49.u_envdiv.count\[3\] u_jt49.eg_period\[3\] VGND VGND VPWR VPWR _0738_
+ sky130_fd_sc_hd__nand2b_1
XFILLER_37_169 VGND VGND VPWR VPWR sky130_fd_sc_hd__decap_6
XFILLER_37_158 VGND VGND VPWR VPWR sky130_fd_sc_hd__decap_3
X_1073_ _0681_ VGND VGND VPWR VPWR _0682_ sky130_fd_sc_hd__inv_2
XFILLER_33_331 VGND VGND VPWR VPWR sky130_fd_sc_hd__decap_4
X_0857_ net17 net19 net18 VGND VGND VPWR VPWR _0506_ sky130_fd_sc_hd__a21bo_1
XFILLER_20_29 VGND VGND VPWR VPWR sky130_fd_sc_hd__decap_8
X_0926_ u_jt49.regarray\[10\]\[3\] _0523_ net35 u_jt49.periodA\[11\] _0565_ VGND VGND
+ VPWR VPWR _0566_ sky130_fd_sc_hd__a221o_1
Xhold16 addr_ok VGND VGND VPWR VPWR net122 sky130_fd_sc_hd__dlygate4sd3_1
Xhold38 u_jt49.regarray\[8\]\[6\] VGND VGND VPWR VPWR net144 sky130_fd_sc_hd__dlygate4sd3_1
Xhold27 u_jt49.envelope\[3\] VGND VGND VPWR VPWR net133 sky130_fd_sc_hd__dlygate4sd3_1
X_1409_ net63 net162 _0407_ VGND VGND VPWR VPWR _0123_ sky130_fd_sc_hd__mux2_1
Xhold49 u_jt49.regarray\[3\]\[5\] VGND VGND VPWR VPWR net155 sky130_fd_sc_hd__dlygate4sd3_1
XFILLER_43_106 VGND VGND VPWR VPWR sky130_fd_sc_hd__decap_6
XFILLER_61_69 VGND VPWR VPWR VGND sky130_ef_sc_hd__decap_12
XFILLER_19_71 VGND VPWR VPWR VGND sky130_ef_sc_hd__decap_12
XFILLER_35_81 VGND VGND VPWR VPWR sky130_fd_sc_hd__decap_4
X_1760_ clknet_leaf_9_clk _0173_ net88 VGND VGND VPWR VPWR u_jt49.regarray\[8\]\[6\]
+ sky130_fd_sc_hd__dfrtp_1
X_1691_ clknet_leaf_4_clk _0106_ net84 VGND VGND VPWR VPWR u_jt49.u_chA.count\[5\]
+ sky130_fd_sc_hd__dfrtp_2
XFILLER_65_253 VGND VPWR VPWR VGND sky130_ef_sc_hd__decap_12
X_1125_ _0450_ u_jt49.u_envdiv.count\[12\] _0717_ VGND VGND VPWR VPWR _0721_ sky130_fd_sc_hd__o21bai_1
XFILLER_40_109 VGND VGND VPWR VPWR sky130_fd_sc_hd__decap_4
X_1056_ net44 net216 _0660_ _0669_ VGND VGND VPWR VPWR _0027_ sky130_fd_sc_hd__a22o_1
X_0909_ u_jt49.periodC\[1\] net40 _0529_ u_jt49.eg_period\[9\] VGND VGND VPWR VPWR
+ _0551_ sky130_fd_sc_hd__a22o_1
XFILLER_0_249 VGND VGND VPWR VPWR sky130_fd_sc_hd__decap_3
XFILLER_31_109 VGND VGND VPWR VPWR sky130_fd_sc_hd__decap_3
XFILLER_12_356 VGND VGND VPWR VPWR sky130_fd_sc_hd__decap_8
XFILLER_62_289 VGND VPWR VPWR VGND sky130_ef_sc_hd__decap_12
XFILLER_62_245 VGND VGND VPWR VPWR sky130_fd_sc_hd__decap_6
XFILLER_15_161 VGND VGND VPWR VPWR sky130_fd_sc_hd__decap_6
X_1674_ clknet_leaf_4_clk _0089_ net84 VGND VGND VPWR VPWR u_jt49.u_chB.count\[1\]
+ sky130_fd_sc_hd__dfrtp_1
X_1812_ clknet_leaf_3_clk _0225_ net85 VGND VGND VPWR VPWR u_jt49.periodB\[1\] sky130_fd_sc_hd__dfrtp_1
X_1743_ clknet_leaf_18_clk _0156_ net92 VGND VGND VPWR VPWR u_jt49.regarray\[9\]\[5\]
+ sky130_fd_sc_hd__dfrtp_1
XFILLER_38_253 VGND VGND VPWR VPWR sky130_fd_sc_hd__decap_4
X_1039_ _0637_ _0638_ _0636_ VGND VGND VPWR VPWR _0656_ sky130_fd_sc_hd__nand3b_1
X_1108_ u_jt49.u_env.gain\[0\] _0706_ u_jt49.u_env.gain\[1\] VGND VGND VPWR VPWR _0708_
+ sky130_fd_sc_hd__o21a_1
XFILLER_29_297 VGND VGND VPWR VPWR sky130_fd_sc_hd__decap_3
XFILLER_12_153 VGND VPWR VPWR VGND sky130_ef_sc_hd__decap_12
XFILLER_32_71 VGND VGND VPWR VPWR sky130_fd_sc_hd__decap_4
X_1390_ u_jt49.periodA\[3\] u_jt49.periodA\[2\] u_jt49.periodA\[1\] u_jt49.periodA\[0\]
+ VGND VGND VPWR VPWR _0399_ sky130_fd_sc_hd__or4_1
XFILLER_35_234 VGND VGND VPWR VPWR sky130_fd_sc_hd__decap_4
XPHY_EDGE_ROW_35_Left_101 VGND VGND VPWR VPWR sky130_fd_sc_hd__decap_3
X_1588_ clknet_leaf_7_clk _0005_ VGND VGND VPWR VPWR din_latch\[1\] sky130_fd_sc_hd__dfxtp_1
X_1726_ clknet_leaf_11_clk _0139_ net100 VGND VGND VPWR VPWR u_jt49.eg_period\[4\]
+ sky130_fd_sc_hd__dfrtp_2
XPHY_EDGE_ROW_44_Left_110 VGND VGND VPWR VPWR sky130_fd_sc_hd__decap_3
Xhold113 u_jt49.u_chB.count\[0\] VGND VGND VPWR VPWR net219 sky130_fd_sc_hd__dlygate4sd3_1
Xhold102 u_jt49.u_chA.count\[7\] VGND VGND VPWR VPWR net208 sky130_fd_sc_hd__dlygate4sd3_1
X_1657_ clknet_leaf_29_clk net175 net75 VGND VGND VPWR VPWR u_jt49.u_ng.poly17\[6\]
+ sky130_fd_sc_hd__dfrtp_1
XFILLER_37_27 VGND VGND VPWR VPWR sky130_fd_sc_hd__decap_8
XFILLER_53_15 VGND VPWR VPWR VGND sky130_ef_sc_hd__decap_12
XFILLER_26_223 VGND VPWR VPWR VGND sky130_ef_sc_hd__decap_12
XFILLER_5_149 VGND VPWR VPWR VGND sky130_ef_sc_hd__decap_12
XFILLER_49_337 VGND VPWR VPWR VGND sky130_ef_sc_hd__decap_12
XFILLER_1_366 VGND VPWR VPWR VGND sky130_ef_sc_hd__decap_12
XFILLER_57_381 VGND VGND VPWR VPWR sky130_fd_sc_hd__decap_6
XFILLER_27_93 VGND VGND VPWR VPWR sky130_fd_sc_hd__decap_8
Xclkbuf_2_0__f_clk clknet_0_clk VGND VGND VPWR VPWR clknet_2_0__leaf_clk sky130_fd_sc_hd__clkbuf_16
XFILLER_32_248 VGND VGND VPWR VPWR sky130_fd_sc_hd__decap_4
X_0890_ net51 net53 net55 net49 VGND VGND VPWR VPWR _0533_ sky130_fd_sc_hd__and4bb_4
X_1511_ net57 IOB_out[7] _0418_ VGND VGND VPWR VPWR _0214_ sky130_fd_sc_hd__mux2_1
X_1442_ net131 net70 _0411_ VGND VGND VPWR VPWR _0152_ sky130_fd_sc_hd__mux2_1
X_1373_ u_jt49.u_chA.count\[7\] u_jt49.u_chA.count\[6\] _0382_ VGND VGND VPWR VPWR
+ _0387_ sky130_fd_sc_hd__and3_1
XFILLER_63_373 VGND VPWR VPWR VGND sky130_ef_sc_hd__decap_12
XFILLER_58_123 VGND VGND VPWR VPWR sky130_fd_sc_hd__decap_8
X_1709_ clknet_leaf_24_clk _0122_ net93 VGND VGND VPWR VPWR u_jt49.regarray\[13\]\[3\]
+ sky130_fd_sc_hd__dfrtp_1
Xfanout52 addr\[2\] VGND VGND VPWR VPWR net52 sky130_fd_sc_hd__clkbuf_2
XFILLER_54_384 VGND VGND VPWR VPWR sky130_fd_sc_hd__decap_3
Xfanout41 net42 VGND VGND VPWR VPWR net41 sky130_fd_sc_hd__clkbuf_4
Xfanout63 net64 VGND VGND VPWR VPWR net63 sky130_fd_sc_hd__clkbuf_4
Xfanout85 net86 VGND VGND VPWR VPWR net85 sky130_fd_sc_hd__clkbuf_4
Xfanout96 net97 VGND VGND VPWR VPWR net96 sky130_fd_sc_hd__clkbuf_2
Xfanout74 _0504_ VGND VGND VPWR VPWR net74 sky130_fd_sc_hd__buf_2
XFILLER_38_81 VGND VGND VPWR VPWR sky130_fd_sc_hd__decap_3
XFILLER_60_365 VGND VGND VPWR VPWR sky130_fd_sc_hd__decap_8
XFILLER_60_321 VGND VGND VPWR VPWR sky130_fd_sc_hd__decap_6
XFILLER_62_3 VGND VPWR VPWR VGND sky130_ef_sc_hd__decap_12
X_0873_ _0510_ _0513_ _0515_ _0516_ VGND VGND VPWR VPWR _0001_ sky130_fd_sc_hd__o22a_1
Xclkload22 clknet_leaf_11_clk VGND VGND VPWR VPWR clkload22/Y sky130_fd_sc_hd__clkinvlp_4
Xclkload11 clknet_leaf_5_clk VGND VGND VPWR VPWR clkload11/Y sky130_fd_sc_hd__inv_6
X_0942_ u_jt49.periodA\[4\] _0521_ _0542_ _0580_ u_jt49.read_mask\[4\] VGND VGND VPWR
+ VPWR _0581_ sky130_fd_sc_hd__o2111a_1
X_1425_ net67 u_jt49.eg_period\[2\] _0409_ VGND VGND VPWR VPWR _0137_ sky130_fd_sc_hd__mux2_1
X_1287_ _0316_ VGND VGND VPWR VPWR _0317_ sky130_fd_sc_hd__inv_2
X_1356_ u_jt49.u_chA.count\[2\] _0371_ VGND VGND VPWR VPWR _0375_ sky130_fd_sc_hd__nand2_1
XFILLER_63_181 VGND VPWR VPWR VGND sky130_ef_sc_hd__decap_12
Xclkload5 clknet_leaf_28_clk VGND VGND VPWR VPWR clkload5/X sky130_fd_sc_hd__clkbuf_4
XFILLER_59_69 VGND VPWR VPWR VGND sky130_ef_sc_hd__decap_12
XFILLER_46_137 VGND VGND VPWR VPWR sky130_fd_sc_hd__decap_3
XFILLER_42_365 VGND VPWR VPWR VGND sky130_ef_sc_hd__decap_12
XFILLER_24_50 VGND VPWR VPWR VGND sky130_ef_sc_hd__decap_12
X_1210_ _0786_ VGND VGND VPWR VPWR _0787_ sky130_fd_sc_hd__inv_2
X_1141_ u_jt49.eg_period\[4\] _0482_ VGND VGND VPWR VPWR _0737_ sky130_fd_sc_hd__nand2_1
X_1072_ sample u_jt49.u_chC.count\[8\] _0677_ VGND VGND VPWR VPWR _0681_ sky130_fd_sc_hd__and3_1
XFILLER_52_129 VGND VGND VPWR VPWR sky130_fd_sc_hd__decap_8
X_0856_ net17 net19 VGND VGND VPWR VPWR _0505_ sky130_fd_sc_hd__xor2_2
X_0925_ u_jt49.regarray\[7\]\[3\] _0522_ _0527_ u_jt49.regarray\[13\]\[3\] VGND VGND
+ VPWR VPWR _0565_ sky130_fd_sc_hd__a22o_1
Xhold39 u_jt49.regarray\[8\]\[5\] VGND VGND VPWR VPWR net145 sky130_fd_sc_hd__dlygate4sd3_1
Xhold17 u_jt49.Amix VGND VGND VPWR VPWR net123 sky130_fd_sc_hd__dlygate4sd3_1
Xhold28 u_jt49.envelope\[2\] VGND VGND VPWR VPWR net134 sky130_fd_sc_hd__dlygate4sd3_1
X_1408_ net66 u_jt49.regarray\[13\]\[3\] _0407_ VGND VGND VPWR VPWR _0122_ sky130_fd_sc_hd__mux2_1
X_1339_ _0346_ _0347_ _0341_ _0343_ _0344_ VGND VGND VPWR VPWR _0360_ sky130_fd_sc_hd__a2111o_1
XFILLER_28_148 VGND VGND VPWR VPWR sky130_fd_sc_hd__decap_4
XFILLER_61_15 VGND VPWR VPWR VGND sky130_ef_sc_hd__decap_12
XFILLER_19_83 VGND VGND VPWR VPWR sky130_fd_sc_hd__decap_8
XFILLER_42_173 VGND VPWR VPWR VGND sky130_ef_sc_hd__decap_12
XFILLER_30_302 VGND VGND VPWR VPWR sky130_fd_sc_hd__decap_6
XFILLER_27_181 VGND VPWR VPWR VGND sky130_ef_sc_hd__decap_12
X_1690_ clknet_leaf_4_clk _0105_ net84 VGND VGND VPWR VPWR u_jt49.u_chA.count\[4\]
+ sky130_fd_sc_hd__dfrtp_1
XFILLER_65_265 VGND VPWR VPWR VGND sky130_ef_sc_hd__decap_12
X_1124_ _0717_ _0719_ VGND VGND VPWR VPWR _0720_ sky130_fd_sc_hd__or2_1
X_1055_ _0471_ _0666_ _0668_ VGND VGND VPWR VPWR _0669_ sky130_fd_sc_hd__a21oi_1
XFILLER_21_357 VGND VPWR VPWR VGND sky130_ef_sc_hd__decap_12
X_0839_ u_jt49.u_chA.count\[9\] VGND VGND VPWR VPWR _0489_ sky130_fd_sc_hd__inv_2
X_0908_ u_jt49.regarray\[13\]\[1\] _0527_ _0533_ u_jt49.regarray\[9\]\[1\] _0549_
+ VGND VGND VPWR VPWR _0550_ sky130_fd_sc_hd__a221o_1
XFILLER_56_232 VGND VPWR VPWR VGND sky130_ef_sc_hd__decap_12
Xclkbuf_leaf_27_clk clknet_2_0__leaf_clk VGND VGND VPWR VPWR clknet_leaf_27_clk sky130_fd_sc_hd__clkbuf_8
X_1811_ clknet_leaf_3_clk _0224_ net85 VGND VGND VPWR VPWR u_jt49.periodB\[0\] sky130_fd_sc_hd__dfrtp_1
XFILLER_30_132 VGND VGND VPWR VPWR sky130_fd_sc_hd__decap_8
X_1673_ clknet_leaf_3_clk _0088_ net85 VGND VGND VPWR VPWR u_jt49.u_chB.count\[0\]
+ sky130_fd_sc_hd__dfstp_1
XFILLER_7_361 VGND VPWR VPWR VGND sky130_ef_sc_hd__decap_12
X_1742_ clknet_leaf_24_clk _0155_ net92 VGND VGND VPWR VPWR u_jt49.regarray\[9\]\[4\]
+ sky130_fd_sc_hd__dfrtp_4
XFILLER_38_232 VGND VPWR VPWR VGND sky130_ef_sc_hd__decap_12
XFILLER_53_268 VGND VPWR VPWR VGND sky130_ef_sc_hd__decap_12
XFILLER_38_298 VGND VGND VPWR VPWR sky130_fd_sc_hd__decap_8
Xclkbuf_leaf_18_clk clknet_2_2__leaf_clk VGND VGND VPWR VPWR clknet_leaf_18_clk sky130_fd_sc_hd__clkbuf_8
X_1038_ _0648_ _0649_ _0653_ _0654_ VGND VGND VPWR VPWR _0655_ sky130_fd_sc_hd__a211o_1
XPHY_EDGE_ROW_5_Right_5 VGND VGND VPWR VPWR sky130_fd_sc_hd__decap_3
X_1107_ u_jt49.u_env.gain\[0\] _0706_ _0707_ VGND VGND VPWR VPWR _0040_ sky130_fd_sc_hd__o21bai_1
XFILLER_21_198 VGND VGND VPWR VPWR sky130_fd_sc_hd__decap_6
XFILLER_12_165 VGND VGND VPWR VPWR sky130_fd_sc_hd__decap_4
X_1725_ clknet_leaf_10_clk _0138_ net98 VGND VGND VPWR VPWR u_jt49.eg_period\[3\]
+ sky130_fd_sc_hd__dfrtp_2
X_1587_ clknet_leaf_7_clk _0004_ VGND VGND VPWR VPWR din_latch\[0\] sky130_fd_sc_hd__dfxtp_1
Xclkbuf_leaf_7_clk clknet_2_1__leaf_clk VGND VGND VPWR VPWR clknet_leaf_7_clk sky130_fd_sc_hd__clkbuf_8
X_1656_ clknet_leaf_29_clk net182 net77 VGND VGND VPWR VPWR u_jt49.u_ng.poly17\[5\]
+ sky130_fd_sc_hd__dfrtp_1
Xhold103 u_jt49.regarray\[8\]\[1\] VGND VGND VPWR VPWR net209 sky130_fd_sc_hd__dlygate4sd3_1
Xhold114 u_jt49.bitC VGND VGND VPWR VPWR net220 sky130_fd_sc_hd__dlygate4sd3_1
XFILLER_53_27 VGND VPWR VPWR VGND sky130_ef_sc_hd__decap_12
XFILLER_5_106 VGND VGND VPWR VPWR sky130_fd_sc_hd__decap_6
XFILLER_49_349 VGND VPWR VPWR VGND sky130_ef_sc_hd__decap_12
XFILLER_49_316 VGND VPWR VPWR VGND sky130_ef_sc_hd__decap_12
XFILLER_1_378 VGND VGND VPWR VPWR sky130_fd_sc_hd__decap_6
XFILLER_32_227 VGND VGND VPWR VPWR sky130_fd_sc_hd__decap_3
XFILLER_43_82 VGND VPWR VPWR VGND sky130_ef_sc_hd__decap_12
X_1510_ net59 IOB_out[6] _0418_ VGND VGND VPWR VPWR _0213_ sky130_fd_sc_hd__mux2_1
X_1441_ net137 net72 _0411_ VGND VGND VPWR VPWR _0151_ sky130_fd_sc_hd__mux2_1
X_1372_ _0370_ _0385_ _0386_ VGND VGND VPWR VPWR _0107_ sky130_fd_sc_hd__and3_1
XFILLER_31_271 VGND VGND VPWR VPWR sky130_fd_sc_hd__decap_8
XFILLER_23_249 VGND VGND VPWR VPWR sky130_fd_sc_hd__decap_8
X_1708_ clknet_leaf_19_clk _0121_ net93 VGND VGND VPWR VPWR u_jt49.regarray\[13\]\[2\]
+ sky130_fd_sc_hd__dfrtp_1
X_1639_ clknet_leaf_15_clk _0056_ net104 VGND VGND VPWR VPWR u_jt49.u_envdiv.count\[4\]
+ sky130_fd_sc_hd__dfrtp_1
XPHY_EDGE_ROW_18_Left_84 VGND VGND VPWR VPWR sky130_fd_sc_hd__decap_3
XFILLER_64_15 VGND VPWR VPWR VGND sky130_ef_sc_hd__decap_12
XFILLER_58_179 VGND VPWR VPWR VGND sky130_ef_sc_hd__decap_12
Xfanout64 din_latch\[4\] VGND VGND VPWR VPWR net64 sky130_fd_sc_hd__clkbuf_4
Xfanout86 net91 VGND VGND VPWR VPWR net86 sky130_fd_sc_hd__clkbuf_4
Xfanout31 _0308_ VGND VGND VPWR VPWR net31 sky130_fd_sc_hd__clkbuf_2
Xfanout53 net54 VGND VGND VPWR VPWR net53 sky130_fd_sc_hd__buf_2
Xfanout97 net106 VGND VGND VPWR VPWR net97 sky130_fd_sc_hd__buf_2
Xfanout42 u_jt49.write VGND VGND VPWR VPWR net42 sky130_fd_sc_hd__buf_4
Xfanout75 net77 VGND VGND VPWR VPWR net75 sky130_fd_sc_hd__clkbuf_4
XFILLER_22_271 VGND VGND VPWR VPWR sky130_fd_sc_hd__decap_8
XPHY_EDGE_ROW_63_Left_129 VGND VGND VPWR VPWR sky130_fd_sc_hd__decap_3
XFILLER_13_96 VGND VPWR VPWR VGND sky130_ef_sc_hd__decap_12
XFILLER_37_308 VGND VGND VPWR VPWR sky130_fd_sc_hd__decap_8
XFILLER_60_333 VGND VPWR VPWR VGND sky130_ef_sc_hd__decap_12
X_0941_ _0576_ _0577_ _0579_ VGND VGND VPWR VPWR _0580_ sky130_fd_sc_hd__or3_1
XFILLER_20_219 VGND VGND VPWR VPWR sky130_fd_sc_hd__decap_8
Xclkload23 clknet_leaf_12_clk VGND VGND VPWR VPWR clkload23/Y sky130_fd_sc_hd__inv_6
XFILLER_55_3 VGND VGND VPWR VPWR sky130_fd_sc_hd__decap_6
X_0872_ _0512_ _0017_ VGND VGND VPWR VPWR _0516_ sky130_fd_sc_hd__xnor2_1
Xclkload12 clknet_leaf_6_clk VGND VGND VPWR VPWR clkload12/Y sky130_fd_sc_hd__inv_8
X_1424_ net70 u_jt49.eg_period\[1\] _0409_ VGND VGND VPWR VPWR _0136_ sky130_fd_sc_hd__mux2_1
X_1355_ u_jt49.u_chA.count\[2\] _0371_ VGND VGND VPWR VPWR _0374_ sky130_fd_sc_hd__or2_1
X_1286_ _0462_ _0314_ VGND VGND VPWR VPWR _0316_ sky130_fd_sc_hd__nor2_1
XFILLER_63_193 VGND VPWR VPWR VGND sky130_ef_sc_hd__decap_12
Xclkload6 clknet_leaf_29_clk VGND VGND VPWR VPWR clkload6/Y sky130_fd_sc_hd__clkinv_2
XFILLER_59_26 VGND VPWR VPWR VGND sky130_ef_sc_hd__decap_12
XPHY_EDGE_ROW_3_Left_69 VGND VGND VPWR VPWR sky130_fd_sc_hd__decap_3
XFILLER_42_355 VGND VGND VPWR VPWR sky130_fd_sc_hd__decap_8
XFILLER_27_330 VGND VGND VPWR VPWR sky130_fd_sc_hd__decap_6
XFILLER_24_62 VGND VPWR VPWR VGND sky130_ef_sc_hd__decap_12
X_1140_ _0445_ u_jt49.u_envdiv.count\[1\] u_jt49.u_envdiv.count\[0\] _0446_ VGND VGND
+ VPWR VPWR _0736_ sky130_fd_sc_hd__a211o_1
X_1071_ sample _0677_ u_jt49.u_chC.count\[8\] VGND VGND VPWR VPWR _0680_ sky130_fd_sc_hd__a21o_1
XFILLER_60_141 VGND VPWR VPWR VGND sky130_ef_sc_hd__decap_12
XFILLER_33_377 VGND VGND VPWR VPWR sky130_fd_sc_hd__decap_8
X_0924_ u_jt49.regarray\[6\]\[3\] _0526_ _0528_ u_jt49.periodC\[11\] VGND VGND VPWR
+ VPWR _0564_ sky130_fd_sc_hd__a22o_1
X_0855_ u_jt49.wr_n cs_n VGND VGND VPWR VPWR u_jt49.write sky130_fd_sc_hd__nor2_1
X_1338_ _0492_ u_jt49.periodA\[4\] _0340_ _0348_ _0358_ VGND VGND VPWR VPWR _0359_
+ sky130_fd_sc_hd__a2111o_1
Xhold18 u_jt49.Bmix VGND VGND VPWR VPWR net124 sky130_fd_sc_hd__dlygate4sd3_1
Xhold29 u_jt49.regarray\[10\]\[0\] VGND VGND VPWR VPWR net135 sky130_fd_sc_hd__dlygate4sd3_1
X_1407_ net67 u_jt49.regarray\[13\]\[2\] _0407_ VGND VGND VPWR VPWR _0121_ sky130_fd_sc_hd__mux2_1
X_1269_ _0458_ u_jt49.periodB\[8\] VGND VGND VPWR VPWR _0303_ sky130_fd_sc_hd__and2_1
XFILLER_61_27 VGND VPWR VPWR VGND sky130_ef_sc_hd__decap_12
XFILLER_59_274 VGND VGND VPWR VPWR sky130_fd_sc_hd__decap_6
XFILLER_27_160 VGND VGND VPWR VPWR sky130_fd_sc_hd__decap_8
XFILLER_42_185 VGND VGND VPWR VPWR sky130_fd_sc_hd__decap_8
XFILLER_18_3 VGND VPWR VPWR VGND sky130_ef_sc_hd__decap_12
XFILLER_65_277 VGND VGND VPWR VPWR sky130_fd_sc_hd__decap_3
X_1123_ _0715_ _0718_ _0714_ VGND VGND VPWR VPWR _0719_ sky130_fd_sc_hd__a21oi_1
XFILLER_21_303 VGND VPWR VPWR VGND sky130_ef_sc_hd__decap_12
X_1054_ u_jt49.u_chC.count\[3\] u_jt49.u_chC.count\[2\] u_jt49.u_chC.count\[1\] u_jt49.u_chC.count\[0\]
+ VGND VGND VPWR VPWR _0668_ sky130_fd_sc_hd__and4_1
XFILLER_21_369 VGND VPWR VPWR VGND sky130_ef_sc_hd__decap_12
X_0907_ u_jt49.regarray\[7\]\[1\] _0522_ _0528_ u_jt49.periodC\[9\] VGND VGND VPWR
+ VPWR _0549_ sky130_fd_sc_hd__a22o_1
X_0838_ u_jt49.u_chA.count\[11\] VGND VGND VPWR VPWR _0488_ sky130_fd_sc_hd__inv_2
XFILLER_56_244 VGND VGND VPWR VPWR sky130_fd_sc_hd__decap_8
XFILLER_21_30 VGND VGND VPWR VPWR sky130_fd_sc_hd__decap_3
XFILLER_21_41 VGND VGND VPWR VPWR sky130_fd_sc_hd__decap_4
XFILLER_46_71 VGND VGND VPWR VPWR sky130_fd_sc_hd__decap_3
XPHY_EDGE_ROW_6_Left_72 VGND VGND VPWR VPWR sky130_fd_sc_hd__decap_3
X_1810_ clknet_leaf_26_clk _0223_ VGND VGND VPWR VPWR u_jt49.Amix sky130_fd_sc_hd__dfxtp_1
X_1741_ clknet_leaf_24_clk _0154_ net92 VGND VGND VPWR VPWR u_jt49.regarray\[9\]\[3\]
+ sky130_fd_sc_hd__dfrtp_1
XFILLER_7_373 VGND VPWR VPWR VGND sky130_ef_sc_hd__decap_12
X_1672_ clknet_leaf_19_clk _0087_ net92 VGND VGND VPWR VPWR u_jt49.bitC sky130_fd_sc_hd__dfrtp_1
XFILLER_38_244 VGND VGND VPWR VPWR sky130_fd_sc_hd__decap_8
X_1106_ u_jt49.u_env.rst_latch _0706_ u_jt49.u_env.gain\[0\] VGND VGND VPWR VPWR _0707_
+ sky130_fd_sc_hd__o21a_1
XFILLER_42_29 VGND VGND VPWR VPWR sky130_fd_sc_hd__decap_8
X_1037_ u_jt49.u_chC.count\[5\] _0470_ _0639_ _0642_ _0651_ VGND VGND VPWR VPWR _0654_
+ sky130_fd_sc_hd__a2111o_1
XFILLER_21_144 VGND VGND VPWR VPWR sky130_fd_sc_hd__decap_4
XPHY_EDGE_ROW_32_Left_98 VGND VGND VPWR VPWR sky130_fd_sc_hd__decap_3
XPHY_EDGE_ROW_11_Right_11 VGND VGND VPWR VPWR sky130_fd_sc_hd__decap_3
XFILLER_12_133 VGND VGND VPWR VPWR sky130_fd_sc_hd__decap_6
XFILLER_16_85 VGND VGND VPWR VPWR sky130_fd_sc_hd__decap_4
XFILLER_4_365 VGND VPWR VPWR VGND sky130_ef_sc_hd__decap_12
XPHY_EDGE_ROW_20_Right_20 VGND VGND VPWR VPWR sky130_fd_sc_hd__decap_3
XFILLER_57_81 VGND VPWR VPWR VGND sky130_ef_sc_hd__decap_12
XFILLER_50_228 VGND VGND VPWR VPWR sky130_fd_sc_hd__decap_3
X_1724_ clknet_leaf_10_clk _0137_ net98 VGND VGND VPWR VPWR u_jt49.eg_period\[2\]
+ sky130_fd_sc_hd__dfrtp_2
Xhold104 u_jt49.regarray\[9\]\[2\] VGND VGND VPWR VPWR net210 sky130_fd_sc_hd__dlygate4sd3_1
Xhold115 u_jt49.periodA\[0\] VGND VGND VPWR VPWR net221 sky130_fd_sc_hd__dlygate4sd3_1
X_1586_ net122 _0611_ VGND VGND VPWR VPWR _0265_ sky130_fd_sc_hd__nand2_1
X_1655_ clknet_leaf_29_clk net170 net77 VGND VGND VPWR VPWR u_jt49.u_ng.poly17\[4\]
+ sky130_fd_sc_hd__dfrtp_1
XFILLER_53_39 VGND VPWR VPWR VGND sky130_ef_sc_hd__decap_12
XFILLER_64_309 VGND VPWR VPWR VGND sky130_ef_sc_hd__decap_12
XFILLER_49_328 VGND VGND VPWR VPWR sky130_fd_sc_hd__decap_8
XFILLER_43_94 VGND VPWR VPWR VGND sky130_ef_sc_hd__decap_12
X_1371_ u_jt49.u_chA.count\[5\] _0379_ u_jt49.u_chA.count\[6\] VGND VGND VPWR VPWR
+ _0386_ sky130_fd_sc_hd__a21o_1
X_1440_ net41 _0533_ VGND VGND VPWR VPWR _0411_ sky130_fd_sc_hd__and2_2
XFILLER_48_361 VGND VGND VPWR VPWR sky130_fd_sc_hd__decap_3
X_1638_ clknet_leaf_15_clk _0055_ net103 VGND VGND VPWR VPWR u_jt49.u_envdiv.count\[3\]
+ sky130_fd_sc_hd__dfrtp_1
X_1707_ clknet_leaf_19_clk _0120_ net93 VGND VGND VPWR VPWR u_jt49.regarray\[13\]\[1\]
+ sky130_fd_sc_hd__dfrtp_1
XFILLER_39_361 VGND VGND VPWR VPWR sky130_fd_sc_hd__decap_3
X_1569_ net73 net109 _0432_ _0434_ VGND VGND VPWR VPWR _0256_ sky130_fd_sc_hd__a22o_1
Xfanout65 din_latch\[3\] VGND VGND VPWR VPWR net65 sky130_fd_sc_hd__clkbuf_4
Xfanout32 _0750_ VGND VGND VPWR VPWR net32 sky130_fd_sc_hd__clkbuf_2
Xfanout98 net105 VGND VGND VPWR VPWR net98 sky130_fd_sc_hd__clkbuf_4
Xfanout87 net91 VGND VGND VPWR VPWR net87 sky130_fd_sc_hd__clkbuf_4
Xfanout54 addr\[1\] VGND VGND VPWR VPWR net54 sky130_fd_sc_hd__dlymetal6s2s_1
XFILLER_13_53 VGND VGND VPWR VPWR sky130_fd_sc_hd__decap_3
Xfanout76 net77 VGND VGND VPWR VPWR net76 sky130_fd_sc_hd__clkbuf_4
Xfanout43 net44 VGND VGND VPWR VPWR net43 sky130_fd_sc_hd__buf_2
XFILLER_49_169 VGND VGND VPWR VPWR sky130_fd_sc_hd__decap_4
XFILLER_60_345 VGND VPWR VPWR VGND sky130_ef_sc_hd__decap_12
XFILLER_60_301 VGND VGND VPWR VPWR sky130_fd_sc_hd__decap_6
X_0940_ u_jt49.regarray\[13\]\[4\] _0527_ _0578_ _0520_ VGND VGND VPWR VPWR _0579_
+ sky130_fd_sc_hd__a211o_1
Xclkload24 clknet_leaf_13_clk VGND VGND VPWR VPWR clkload24/X sky130_fd_sc_hd__clkbuf_8
X_0871_ net89 _0509_ _0511_ VGND VGND VPWR VPWR _0515_ sky130_fd_sc_hd__and3_1
Xclkload13 clknet_leaf_7_clk VGND VGND VPWR VPWR clkload13/X sky130_fd_sc_hd__clkbuf_4
XFILLER_9_276 VGND VGND VPWR VPWR sky130_fd_sc_hd__decap_4
X_1285_ net31 _0314_ _0315_ VGND VGND VPWR VPWR _0091_ sky130_fd_sc_hd__and3_1
X_1423_ net72 u_jt49.eg_period\[0\] _0409_ VGND VGND VPWR VPWR _0135_ sky130_fd_sc_hd__mux2_1
XFILLER_28_309 VGND VGND VPWR VPWR sky130_fd_sc_hd__decap_6
X_1354_ _0370_ _0372_ _0373_ VGND VGND VPWR VPWR _0102_ sky130_fd_sc_hd__and3_1
XFILLER_63_161 VGND VGND VPWR VPWR sky130_fd_sc_hd__decap_6
XFILLER_50_29 VGND VPWR VPWR VGND sky130_ef_sc_hd__decap_12
Xclkload7 clknet_leaf_30_clk VGND VGND VPWR VPWR clkload7/Y sky130_fd_sc_hd__inv_6
XFILLER_59_38 VGND VPWR VPWR VGND sky130_ef_sc_hd__decap_12
XFILLER_54_161 VGND VGND VPWR VPWR sky130_fd_sc_hd__decap_8
XFILLER_24_85 VGND VGND VPWR VPWR sky130_fd_sc_hd__decap_6
XFILLER_10_231 VGND VGND VPWR VPWR sky130_fd_sc_hd__decap_4
X_1070_ _0660_ _0678_ _0679_ net206 net44 VGND VGND VPWR VPWR _0031_ sky130_fd_sc_hd__a32o_1
XFILLER_60_197 VGND VGND VPWR VPWR sky130_fd_sc_hd__decap_8
XFILLER_60_153 VGND VPWR VPWR VGND sky130_ef_sc_hd__decap_12
X_0923_ net11 _0544_ _0545_ net3 _0563_ VGND VGND VPWR VPWR _0268_ sky130_fd_sc_hd__a221o_1
X_0854_ net20 VGND VGND VPWR VPWR _0504_ sky130_fd_sc_hd__inv_2
XPHY_EDGE_ROW_49_Right_49 VGND VGND VPWR VPWR sky130_fd_sc_hd__decap_3
XPHY_EDGE_ROW_58_Right_58 VGND VGND VPWR VPWR sky130_fd_sc_hd__decap_3
X_1268_ _0459_ u_jt49.periodB\[7\] _0460_ u_jt49.periodB\[6\] VGND VGND VPWR VPWR
+ _0302_ sky130_fd_sc_hd__o22a_1
XFILLER_28_106 VGND VGND VPWR VPWR sky130_fd_sc_hd__decap_4
X_1337_ _0491_ u_jt49.periodA\[7\] _0493_ u_jt49.periodA\[3\] VGND VGND VPWR VPWR
+ _0358_ sky130_fd_sc_hd__a22o_1
Xhold19 u_jt49.Cmix VGND VGND VPWR VPWR net125 sky130_fd_sc_hd__dlygate4sd3_1
X_1406_ net69 net212 _0407_ VGND VGND VPWR VPWR _0120_ sky130_fd_sc_hd__mux2_1
XFILLER_61_39 VGND VPWR VPWR VGND sky130_ef_sc_hd__decap_12
X_1199_ net33 _0778_ _0779_ VGND VGND VPWR VPWR _0060_ sky130_fd_sc_hd__and3_1
XFILLER_24_334 VGND VGND VPWR VPWR sky130_fd_sc_hd__decap_3
XFILLER_34_109 VGND VGND VPWR VPWR sky130_fd_sc_hd__decap_4
XFILLER_19_52 VGND VGND VPWR VPWR sky130_fd_sc_hd__decap_4
XFILLER_19_106 VGND VGND VPWR VPWR sky130_fd_sc_hd__decap_6
XFILLER_35_95 VGND VGND VPWR VPWR sky130_fd_sc_hd__decap_8
XFILLER_30_359 VGND VGND VPWR VPWR sky130_fd_sc_hd__decap_4
X_1122_ _0449_ u_jt49.u_envdiv.count\[13\] u_jt49.u_envdiv.count\[12\] _0450_ VGND
+ VGND VPWR VPWR _0718_ sky130_fd_sc_hd__a22o_1
XFILLER_21_315 VGND VPWR VPWR VGND sky130_ef_sc_hd__decap_12
X_1053_ _0662_ _0666_ _0667_ VGND VGND VPWR VPWR _0026_ sky130_fd_sc_hd__and3_1
X_0837_ u_jt49.regarray\[6\]\[4\] VGND VGND VPWR VPWR _0487_ sky130_fd_sc_hd__inv_2
X_0906_ u_jt49.periodA\[9\] net35 _0546_ _0547_ VGND VGND VPWR VPWR _0548_ sky130_fd_sc_hd__a211o_1
XFILLER_21_53 VGND VGND VPWR VPWR sky130_fd_sc_hd__decap_3
X_1671_ clknet_leaf_7_clk _0001_ VGND VGND VPWR VPWR u_jt49.read_mask\[5\] sky130_fd_sc_hd__dfxtp_1
X_1740_ clknet_leaf_23_clk _0153_ net94 VGND VGND VPWR VPWR u_jt49.regarray\[9\]\[2\]
+ sky130_fd_sc_hd__dfrtp_1
XFILLER_30_3 VGND VPWR VPWR VGND sky130_ef_sc_hd__decap_12
X_1105_ _0696_ _0704_ VGND VGND VPWR VPWR _0706_ sky130_fd_sc_hd__nand2_1
XFILLER_61_281 VGND VPWR VPWR VGND sky130_ef_sc_hd__decap_12
X_1036_ _0471_ u_jt49.periodC\[3\] _0640_ _0644_ _0650_ VGND VGND VPWR VPWR _0653_
+ sky130_fd_sc_hd__a2111o_1
X_1869_ clknet_leaf_27_clk _0272_ net76 VGND VGND VPWR VPWR dout[6] sky130_fd_sc_hd__dfrtp_4
XFILLER_29_234 VGND VGND VPWR VPWR sky130_fd_sc_hd__decap_4
XFILLER_32_85 VGND VGND VPWR VPWR sky130_fd_sc_hd__decap_4
XFILLER_12_189 VGND VGND VPWR VPWR sky130_fd_sc_hd__decap_6
XFILLER_4_377 VGND VGND VPWR VPWR sky130_fd_sc_hd__decap_8
XFILLER_57_93 VGND VPWR VPWR VGND sky130_ef_sc_hd__decap_12
XFILLER_35_259 VGND VGND VPWR VPWR sky130_fd_sc_hd__decap_6
X_1723_ clknet_leaf_10_clk _0136_ net99 VGND VGND VPWR VPWR u_jt49.eg_period\[1\]
+ sky130_fd_sc_hd__dfrtp_1
Xhold105 u_jt49.u_chC.count\[9\] VGND VGND VPWR VPWR net211 sky130_fd_sc_hd__dlygate4sd3_1
Xhold116 u_jt49.periodA\[5\] VGND VGND VPWR VPWR net222 sky130_fd_sc_hd__dlygate4sd3_1
X_1654_ clknet_leaf_29_clk _0071_ net75 VGND VGND VPWR VPWR u_jt49.u_ng.poly17\[3\]
+ sky130_fd_sc_hd__dfrtp_1
X_1585_ net74 net119 _0438_ _0442_ VGND VGND VPWR VPWR _0264_ sky130_fd_sc_hd__a22o_1
X_1019_ u_jt49.u_chC.count\[9\] u_jt49.periodC\[9\] VGND VGND VPWR VPWR _0636_ sky130_fd_sc_hd__nand2b_1
XFILLER_17_237 VGND VGND VPWR VPWR sky130_fd_sc_hd__decap_4
XFILLER_4_141 VGND VGND VPWR VPWR sky130_fd_sc_hd__decap_4
X_1370_ u_jt49.u_chA.count\[6\] u_jt49.u_chA.count\[5\] _0379_ VGND VGND VPWR VPWR
+ _0385_ sky130_fd_sc_hd__nand3_1
XFILLER_48_373 VGND VGND VPWR VPWR sky130_fd_sc_hd__decap_3
X_1637_ clknet_leaf_15_clk _0054_ net103 VGND VGND VPWR VPWR u_jt49.u_envdiv.count\[2\]
+ sky130_fd_sc_hd__dfrtp_1
X_1706_ clknet_leaf_24_clk _0119_ net93 VGND VGND VPWR VPWR u_jt49.regarray\[13\]\[0\]
+ sky130_fd_sc_hd__dfrtp_1
XFILLER_58_159 VGND VPWR VPWR VGND sky130_ef_sc_hd__decap_12
XFILLER_54_321 VGND VPWR VPWR VGND sky130_ef_sc_hd__decap_12
XFILLER_48_29 VGND VGND VPWR VPWR sky130_fd_sc_hd__decap_4
X_1499_ u_jt49.periodC\[4\] net64 _0417_ VGND VGND VPWR VPWR _0203_ sky130_fd_sc_hd__mux2_1
X_1568_ u_jt49.regarray\[9\]\[1\] u_jt49.envelope\[2\] u_jt49.regarray\[9\]\[4\] VGND
+ VGND VPWR VPWR _0434_ sky130_fd_sc_hd__mux2_1
Xfanout33 _0750_ VGND VGND VPWR VPWR net33 sky130_fd_sc_hd__buf_1
XFILLER_54_376 VGND VGND VPWR VPWR sky130_fd_sc_hd__decap_8
Xfanout55 net56 VGND VGND VPWR VPWR net55 sky130_fd_sc_hd__buf_2
Xfanout44 _0466_ VGND VGND VPWR VPWR net44 sky130_fd_sc_hd__clkbuf_4
Xfanout88 net91 VGND VGND VPWR VPWR net88 sky130_fd_sc_hd__clkbuf_2
Xfanout99 net105 VGND VGND VPWR VPWR net99 sky130_fd_sc_hd__clkbuf_4
Xfanout66 din_latch\[3\] VGND VGND VPWR VPWR net66 sky130_fd_sc_hd__buf_2
Xfanout77 net79 VGND VGND VPWR VPWR net77 sky130_fd_sc_hd__clkbuf_2
XFILLER_8_3 VGND VPWR VPWR VGND sky130_ef_sc_hd__decap_12
XFILLER_38_40 VGND VGND VPWR VPWR sky130_fd_sc_hd__decap_3
XFILLER_60_357 VGND VGND VPWR VPWR sky130_fd_sc_hd__decap_6
X_0870_ _0512_ _0514_ VGND VGND VPWR VPWR _0000_ sky130_fd_sc_hd__or2_1
Xclkload25 clknet_leaf_14_clk VGND VGND VPWR VPWR clkload25/Y sky130_fd_sc_hd__inv_6
X_1422_ net42 _0524_ VGND VGND VPWR VPWR _0409_ sky130_fd_sc_hd__nand2_4
Xclkload14 clknet_leaf_9_clk VGND VGND VPWR VPWR clkload14/Y sky130_fd_sc_hd__clkinv_4
XFILLER_9_288 VGND VPWR VPWR VGND sky130_ef_sc_hd__decap_12
X_1284_ u_jt49.u_chB.count\[3\] _0311_ VGND VGND VPWR VPWR _0315_ sky130_fd_sc_hd__or2_1
X_1353_ u_jt49.u_chA.count\[1\] _0369_ VGND VGND VPWR VPWR _0373_ sky130_fd_sc_hd__or2_1
Xclkload8 clknet_leaf_2_clk VGND VGND VPWR VPWR clkload8/Y sky130_fd_sc_hd__clkinvlp_4
X_0999_ _0619_ _0621_ _0622_ VGND VGND VPWR VPWR _0013_ sky130_fd_sc_hd__and3_1
XFILLER_40_85 VGND VGND VPWR VPWR sky130_fd_sc_hd__decap_4
XFILLER_60_165 VGND VPWR VPWR VGND sky130_ef_sc_hd__decap_12
XFILLER_60_121 VGND VPWR VPWR VGND sky130_ef_sc_hd__decap_12
XFILLER_18_365 VGND VPWR VPWR VGND sky130_ef_sc_hd__decap_12
XFILLER_60_3 VGND VGND VPWR VPWR sky130_fd_sc_hd__decap_6
X_0853_ net30 VGND VGND VPWR VPWR _0503_ sky130_fd_sc_hd__inv_2
X_0922_ u_jt49.periodA\[2\] _0521_ _0542_ _0562_ VGND VGND VPWR VPWR _0563_ sky130_fd_sc_hd__o211a_1
X_1405_ net72 net226 _0407_ VGND VGND VPWR VPWR _0119_ sky130_fd_sc_hd__mux2_1
X_1198_ _0478_ _0776_ VGND VGND VPWR VPWR _0779_ sky130_fd_sc_hd__nand2_1
XFILLER_45_19 VGND VPWR VPWR VGND sky130_ef_sc_hd__decap_12
X_1267_ _0298_ _0299_ _0300_ VGND VGND VPWR VPWR _0301_ sky130_fd_sc_hd__a21o_1
Xinput1 IOA_in[0] VGND VGND VPWR VPWR net1 sky130_fd_sc_hd__buf_1
X_1336_ _0356_ _0355_ _0353_ VGND VGND VPWR VPWR _0357_ sky130_fd_sc_hd__or3b_1
XFILLER_24_302 VGND VGND VPWR VPWR sky130_fd_sc_hd__decap_6
XFILLER_35_30 VGND VPWR VPWR VGND sky130_ef_sc_hd__decap_12
XFILLER_15_324 VGND VPWR VPWR VGND sky130_ef_sc_hd__decap_12
XFILLER_30_327 VGND VPWR VPWR VGND sky130_ef_sc_hd__decap_12
X_1121_ u_jt49.u_envdiv.count\[15\] u_jt49.eg_period\[15\] VGND VGND VPWR VPWR _0717_
+ sky130_fd_sc_hd__and2b_1
X_1052_ u_jt49.u_chC.count\[2\] _0663_ VGND VGND VPWR VPWR _0667_ sky130_fd_sc_hd__or2_1
XFILLER_25_6 VGND VGND VPWR VPWR sky130_fd_sc_hd__decap_8
XFILLER_33_165 VGND VGND VPWR VPWR sky130_fd_sc_hd__decap_3
XFILLER_21_327 VGND VGND VPWR VPWR sky130_fd_sc_hd__decap_8
X_0905_ u_jt49.eg_period\[1\] _0524_ _0532_ u_jt49.periodB\[9\] _0520_ VGND VGND VPWR
+ VPWR _0547_ sky130_fd_sc_hd__a221o_1
X_0836_ u_jt49.regarray\[6\]\[2\] VGND VGND VPWR VPWR _0486_ sky130_fd_sc_hd__inv_2
XFILLER_56_29 VGND VPWR VPWR VGND sky130_ef_sc_hd__decap_12
XFILLER_0_209 VGND VPWR VPWR VGND sky130_ef_sc_hd__decap_12
X_1319_ u_jt49.periodA\[6\] u_jt49.u_chA.count\[6\] VGND VGND VPWR VPWR _0340_ sky130_fd_sc_hd__and2b_1
XFILLER_8_309 VGND VGND VPWR VPWR sky130_fd_sc_hd__decap_6
XFILLER_46_51 VGND VGND VPWR VPWR sky130_fd_sc_hd__decap_4
X_1670_ clknet_leaf_7_clk _0000_ VGND VGND VPWR VPWR u_jt49.read_mask\[4\] sky130_fd_sc_hd__dfxtp_1
XFILLER_23_3 VGND VPWR VPWR VGND sky130_ef_sc_hd__decap_12
X_1035_ _0639_ _0643_ _0650_ _0651_ VGND VGND VPWR VPWR _0652_ sky130_fd_sc_hd__or4_1
X_1104_ _0452_ _0630_ _0696_ _0705_ VGND VGND VPWR VPWR _0039_ sky130_fd_sc_hd__a2bb2o_1
XFILLER_61_293 VGND VPWR VPWR VGND sky130_ef_sc_hd__decap_12
X_1799_ clknet_leaf_6_clk _0212_ net86 VGND VGND VPWR VPWR IOB_out[5] sky130_fd_sc_hd__dfrtp_4
X_0819_ u_jt49.u_chC.count\[7\] VGND VGND VPWR VPWR _0469_ sky130_fd_sc_hd__inv_2
X_1868_ clknet_leaf_28_clk _0271_ net76 VGND VGND VPWR VPWR dout[5] sky130_fd_sc_hd__dfrtp_4
X_1722_ clknet_leaf_11_clk _0135_ net99 VGND VGND VPWR VPWR u_jt49.eg_period\[0\]
+ sky130_fd_sc_hd__dfrtp_1
Xhold117 u_jt49.periodB\[0\] VGND VGND VPWR VPWR net223 sky130_fd_sc_hd__dlygate4sd3_1
X_1584_ u_jt49.regarray\[10\]\[3\] u_jt49.envelope\[4\] u_jt49.regarray\[10\]\[4\]
+ VGND VGND VPWR VPWR _0442_ sky130_fd_sc_hd__mux2_1
XPHY_EDGE_ROW_9_Right_9 VGND VGND VPWR VPWR sky130_fd_sc_hd__decap_3
X_1653_ clknet_leaf_29_clk _0070_ net75 VGND VGND VPWR VPWR u_jt49.u_ng.poly17\[2\]
+ sky130_fd_sc_hd__dfrtp_1
Xhold106 u_jt49.regarray\[13\]\[1\] VGND VGND VPWR VPWR net212 sky130_fd_sc_hd__dlygate4sd3_1
XFILLER_41_219 VGND VGND VPWR VPWR sky130_fd_sc_hd__decap_4
X_1018_ u_jt49.u_chC.count\[10\] u_jt49.periodC\[10\] VGND VGND VPWR VPWR _0635_ sky130_fd_sc_hd__and2b_1
XFILLER_1_315 VGND VGND VPWR VPWR sky130_fd_sc_hd__decap_4
XFILLER_43_30 VGND VGND VPWR VPWR sky130_fd_sc_hd__decap_4
XFILLER_48_341 VGND VPWR VPWR VGND sky130_ef_sc_hd__decap_12
XFILLER_4_197 VGND VPWR VPWR VGND sky130_ef_sc_hd__decap_12
XFILLER_4_57 VGND VGND VPWR VPWR sky130_fd_sc_hd__decap_4
X_1705_ clknet_leaf_23_clk _0118_ VGND VGND VPWR VPWR u_jt49.Cmix sky130_fd_sc_hd__dfxtp_1
X_1636_ clknet_leaf_17_clk _0053_ net99 VGND VGND VPWR VPWR u_jt49.u_envdiv.count\[1\]
+ sky130_fd_sc_hd__dfrtp_1
X_1567_ net74 net114 _0432_ _0433_ VGND VGND VPWR VPWR _0255_ sky130_fd_sc_hd__a22o_1
XFILLER_64_29 VGND VPWR VPWR VGND sky130_ef_sc_hd__decap_12
XFILLER_54_333 VGND VPWR VPWR VGND sky130_ef_sc_hd__decap_12
XFILLER_54_300 VGND VGND VPWR VPWR sky130_fd_sc_hd__decap_8
X_1498_ u_jt49.periodC\[3\] net66 _0417_ VGND VGND VPWR VPWR _0202_ sky130_fd_sc_hd__mux2_1
Xfanout67 din_latch\[2\] VGND VGND VPWR VPWR net67 sky130_fd_sc_hd__clkbuf_4
Xfanout89 net91 VGND VGND VPWR VPWR net89 sky130_fd_sc_hd__buf_2
Xfanout45 u_jt49.u_env.cen VGND VGND VPWR VPWR net45 sky130_fd_sc_hd__clkbuf_4
Xfanout56 addr\[0\] VGND VGND VPWR VPWR net56 sky130_fd_sc_hd__clkbuf_2
Xfanout78 net79 VGND VGND VPWR VPWR net78 sky130_fd_sc_hd__clkbuf_4
XFILLER_22_230 VGND VGND VPWR VPWR sky130_fd_sc_hd__decap_8
XFILLER_49_116 VGND VGND VPWR VPWR sky130_fd_sc_hd__decap_4
XFILLER_45_333 VGND VGND VPWR VPWR sky130_fd_sc_hd__decap_3
XPHY_EDGE_ROW_41_Left_107 VGND VGND VPWR VPWR sky130_fd_sc_hd__decap_3
Xclkload26 clknet_leaf_16_clk VGND VGND VPWR VPWR clkload26/Y sky130_fd_sc_hd__clkinvlp_4
Xclkload15 clknet_leaf_18_clk VGND VGND VPWR VPWR clkload15/Y sky130_fd_sc_hd__inv_4
XFILLER_13_252 VGND VPWR VPWR VGND sky130_ef_sc_hd__decap_12
X_1421_ u_jt49.eg_period\[15\] net57 _0408_ VGND VGND VPWR VPWR _0134_ sky130_fd_sc_hd__mux2_1
XPHY_EDGE_ROW_50_Left_116 VGND VGND VPWR VPWR sky130_fd_sc_hd__decap_3
X_1283_ u_jt49.u_chB.count\[3\] _0311_ VGND VGND VPWR VPWR _0314_ sky130_fd_sc_hd__nand2_1
X_1352_ _0371_ VGND VGND VPWR VPWR _0372_ sky130_fd_sc_hd__inv_2
Xclkload9 clknet_leaf_3_clk VGND VGND VPWR VPWR clkload9/Y sky130_fd_sc_hd__clkinv_2
X_0998_ net47 u_jt49.u_ng.u_div.count\[0\] u_jt49.u_ng.u_div.count\[1\] VGND VGND
+ VPWR VPWR _0622_ sky130_fd_sc_hd__a21o_1
X_1619_ clknet_leaf_20_clk net127 VGND VGND VPWR VPWR u_jt49.u_env.rst_latch sky130_fd_sc_hd__dfxtp_2
XFILLER_42_325 VGND VGND VPWR VPWR sky130_fd_sc_hd__decap_8
XFILLER_6_248 VGND VGND VPWR VPWR sky130_fd_sc_hd__decap_4
XFILLER_49_51 VGND VGND VPWR VPWR sky130_fd_sc_hd__decap_4
XFILLER_18_344 VGND VPWR VPWR VGND sky130_ef_sc_hd__decap_12
XFILLER_60_177 VGND VPWR VPWR VGND sky130_ef_sc_hd__decap_12
XFILLER_60_133 VGND VGND VPWR VPWR sky130_fd_sc_hd__decap_6
XFILLER_18_377 VGND VGND VPWR VPWR sky130_fd_sc_hd__decap_8
X_0921_ _0557_ _0558_ _0561_ VGND VGND VPWR VPWR _0562_ sky130_fd_sc_hd__or3_1
XFILLER_53_3 VGND VPWR VPWR VGND sky130_ef_sc_hd__decap_12
X_0852_ u_jt49.u_ng.poly17\[3\] VGND VGND VPWR VPWR _0502_ sky130_fd_sc_hd__inv_2
XFILLER_5_292 VGND VGND VPWR VPWR sky130_fd_sc_hd__decap_8
X_1335_ u_jt49.u_chA.count\[10\] u_jt49.periodA\[10\] VGND VGND VPWR VPWR _0356_ sky130_fd_sc_hd__xor2_1
X_1404_ net41 _0527_ VGND VGND VPWR VPWR _0407_ sky130_fd_sc_hd__nand2_4
X_1197_ _0777_ VGND VGND VPWR VPWR _0778_ sky130_fd_sc_hd__inv_2
X_1266_ _0460_ u_jt49.periodB\[6\] _0461_ u_jt49.periodB\[5\] VGND VGND VPWR VPWR
+ _0300_ sky130_fd_sc_hd__a22o_1
Xinput2 IOA_in[1] VGND VGND VPWR VPWR net2 sky130_fd_sc_hd__buf_1
XFILLER_19_65 VGND VGND VPWR VPWR sky130_fd_sc_hd__decap_3
XFILLER_35_42 VGND VPWR VPWR VGND sky130_ef_sc_hd__decap_12
XFILLER_51_85 VGND VGND VPWR VPWR sky130_fd_sc_hd__decap_8
XFILLER_51_30 VGND VPWR VPWR VGND sky130_ef_sc_hd__decap_12
XFILLER_30_339 VGND VGND VPWR VPWR sky130_fd_sc_hd__decap_6
XFILLER_2_273 VGND VGND VPWR VPWR sky130_fd_sc_hd__decap_3
XFILLER_65_225 VGND VPWR VPWR VGND sky130_ef_sc_hd__decap_12
X_1120_ u_jt49.eg_period\[14\] _0475_ _0476_ u_jt49.eg_period\[13\] VGND VGND VPWR
+ VPWR _0716_ sky130_fd_sc_hd__a22o_1
XFILLER_18_141 VGND VPWR VPWR VGND sky130_ef_sc_hd__decap_12
XFILLER_18_163 VGND VPWR VPWR VGND sky130_ef_sc_hd__decap_12
X_1051_ u_jt49.u_chC.count\[2\] _0663_ VGND VGND VPWR VPWR _0666_ sky130_fd_sc_hd__nand2_1
X_0904_ u_jt49.regarray\[10\]\[1\] _0523_ _0526_ u_jt49.regarray\[6\]\[1\] VGND VGND
+ VPWR VPWR _0546_ sky130_fd_sc_hd__a22o_1
X_0835_ u_jt49.regarray\[6\]\[3\] VGND VGND VPWR VPWR _0485_ sky130_fd_sc_hd__inv_2
X_1318_ _0489_ u_jt49.periodA\[9\] _0490_ u_jt49.periodA\[8\] VGND VGND VPWR VPWR
+ _0339_ sky130_fd_sc_hd__o22a_1
X_1249_ u_jt49.periodC\[7\] u_jt49.periodC\[6\] u_jt49.periodC\[5\] u_jt49.periodC\[4\]
+ VGND VGND VPWR VPWR _0284_ sky130_fd_sc_hd__or4_1
XFILLER_24_133 VGND VGND VPWR VPWR sky130_fd_sc_hd__decap_6
XFILLER_20_361 VGND VGND VPWR VPWR sky130_fd_sc_hd__decap_3
XFILLER_24_188 VGND VGND VPWR VPWR sky130_fd_sc_hd__decap_8
XFILLER_46_85 VGND VPWR VPWR VGND sky130_ef_sc_hd__decap_12
XFILLER_46_63 VGND VGND VPWR VPWR sky130_fd_sc_hd__decap_8
XFILLER_46_41 VGND VGND VPWR VPWR sky130_fd_sc_hd__decap_6
XFILLER_11_361 VGND VPWR VPWR VGND sky130_ef_sc_hd__decap_12
XFILLER_16_3 VGND VPWR VPWR VGND sky130_ef_sc_hd__decap_12
X_1034_ u_jt49.u_chC.count\[6\] u_jt49.periodC\[6\] VGND VGND VPWR VPWR _0651_ sky130_fd_sc_hd__and2b_1
X_1103_ _0704_ VGND VGND VPWR VPWR _0705_ sky130_fd_sc_hd__inv_2
X_1867_ clknet_leaf_28_clk _0270_ net76 VGND VGND VPWR VPWR dout[4] sky130_fd_sc_hd__dfrtp_4
X_1798_ clknet_leaf_5_clk _0211_ net86 VGND VGND VPWR VPWR IOB_out[4] sky130_fd_sc_hd__dfrtp_4
X_0818_ u_jt49.periodC\[8\] VGND VGND VPWR VPWR _0468_ sky130_fd_sc_hd__inv_2
XFILLER_52_272 VGND VPWR VPWR VGND sky130_ef_sc_hd__decap_12
XFILLER_57_51 VGND VGND VPWR VPWR sky130_fd_sc_hd__decap_4
XFILLER_35_217 VGND VGND VPWR VPWR sky130_fd_sc_hd__decap_6
X_1721_ clknet_leaf_8_clk _0134_ net90 VGND VGND VPWR VPWR u_jt49.eg_period\[15\]
+ sky130_fd_sc_hd__dfrtp_1
Xhold107 u_jt49.eg_step VGND VGND VPWR VPWR net213 sky130_fd_sc_hd__dlygate4sd3_1
X_1583_ net74 net113 _0438_ _0441_ VGND VGND VPWR VPWR _0263_ sky130_fd_sc_hd__a22o_1
X_1652_ clknet_leaf_29_clk net180 net76 VGND VGND VPWR VPWR u_jt49.u_ng.poly17\[1\]
+ sky130_fd_sc_hd__dfrtp_1
Xhold118 u_jt49.regarray\[8\]\[3\] VGND VGND VPWR VPWR net224 sky130_fd_sc_hd__dlygate4sd3_1
X_1017_ u_jt49.u_chC.count\[11\] u_jt49.periodC\[11\] VGND VGND VPWR VPWR _0634_ sky130_fd_sc_hd__and2b_1
XFILLER_34_272 VGND VPWR VPWR VGND sky130_ef_sc_hd__decap_12
XFILLER_40_231 VGND VPWR VPWR VGND sky130_ef_sc_hd__decap_12
XFILLER_4_121 VGND VPWR VPWR VGND sky130_ef_sc_hd__decap_12
XFILLER_48_353 VGND VGND VPWR VPWR sky130_fd_sc_hd__decap_8
X_1704_ clknet_leaf_15_clk _0003_ VGND VGND VPWR VPWR u_jt49.u_env.cen sky130_fd_sc_hd__dfxtp_1
X_1635_ clknet_leaf_13_clk _0052_ net100 VGND VGND VPWR VPWR u_jt49.u_envdiv.count\[0\]
+ sky130_fd_sc_hd__dfstp_1
X_1497_ u_jt49.periodC\[2\] net68 _0417_ VGND VGND VPWR VPWR _0201_ sky130_fd_sc_hd__mux2_1
X_1566_ u_jt49.regarray\[9\]\[0\] u_jt49.envelope\[1\] u_jt49.regarray\[9\]\[4\] VGND
+ VGND VPWR VPWR _0433_ sky130_fd_sc_hd__mux2_1
XFILLER_54_345 VGND VPWR VPWR VGND sky130_ef_sc_hd__decap_12
XFILLER_39_320 VGND VPWR VPWR VGND sky130_ef_sc_hd__decap_12
XFILLER_14_209 VGND VGND VPWR VPWR sky130_fd_sc_hd__decap_4
Xfanout57 din_latch\[7\] VGND VGND VPWR VPWR net57 sky130_fd_sc_hd__clkbuf_4
Xfanout68 din_latch\[2\] VGND VGND VPWR VPWR net68 sky130_fd_sc_hd__clkbuf_2
Xfanout46 sample VGND VGND VPWR VPWR net46 sky130_fd_sc_hd__buf_2
Xfanout79 net83 VGND VGND VPWR VPWR net79 sky130_fd_sc_hd__clkbuf_2
XFILLER_22_253 VGND VGND VPWR VPWR sky130_fd_sc_hd__decap_8
XFILLER_22_297 VGND VGND VPWR VPWR sky130_fd_sc_hd__decap_8
XFILLER_1_113 VGND VPWR VPWR VGND sky130_ef_sc_hd__decap_12
XFILLER_64_109 VGND VPWR VPWR VGND sky130_ef_sc_hd__decap_12
XFILLER_38_53 VGND VGND VPWR VPWR sky130_fd_sc_hd__decap_8
XFILLER_54_85 VGND VPWR VPWR VGND sky130_ef_sc_hd__decap_12
XFILLER_54_41 VGND VPWR VPWR VGND sky130_ef_sc_hd__decap_12
Xclkload27 clknet_leaf_17_clk VGND VGND VPWR VPWR clkload27/X sky130_fd_sc_hd__clkbuf_4
XFILLER_13_264 VGND VGND VPWR VPWR sky130_fd_sc_hd__decap_6
Xclkload16 clknet_leaf_19_clk VGND VGND VPWR VPWR clkload16/Y sky130_fd_sc_hd__inv_4
X_1420_ u_jt49.eg_period\[14\] net60 _0408_ VGND VGND VPWR VPWR _0133_ sky130_fd_sc_hd__mux2_1
X_1351_ net46 u_jt49.u_chA.count\[1\] u_jt49.u_chA.count\[0\] VGND VGND VPWR VPWR
+ _0371_ sky130_fd_sc_hd__and3_1
X_1282_ net31 _0312_ _0313_ VGND VGND VPWR VPWR _0090_ sky130_fd_sc_hd__and3_1
XFILLER_51_337 VGND VPWR VPWR VGND sky130_ef_sc_hd__decap_12
X_1618_ clknet_leaf_17_clk _0035_ net103 VGND VGND VPWR VPWR u_jt49.u_chC.count\[11\]
+ sky130_fd_sc_hd__dfrtp_1
X_0997_ _0620_ VGND VGND VPWR VPWR _0621_ sky130_fd_sc_hd__inv_2
X_1549_ net73 net116 _0425_ _0427_ VGND VGND VPWR VPWR _0243_ sky130_fd_sc_hd__a22o_1
XFILLER_54_120 VGND VGND VPWR VPWR sky130_fd_sc_hd__decap_4
XFILLER_18_356 VGND VGND VPWR VPWR sky130_fd_sc_hd__decap_8
XFILLER_60_189 VGND VGND VPWR VPWR sky130_fd_sc_hd__decap_6
XFILLER_45_197 VGND VPWR VPWR VGND sky130_ef_sc_hd__decap_12
XFILLER_41_381 VGND VGND VPWR VPWR sky130_fd_sc_hd__decap_6
XPHY_EDGE_ROW_23_Left_89 VGND VGND VPWR VPWR sky130_fd_sc_hd__decap_3
X_0920_ u_jt49.periodC\[2\] net40 _0520_ _0560_ VGND VGND VPWR VPWR _0561_ sky130_fd_sc_hd__a211o_1
X_0851_ u_jt49.u_ng.poly17\[0\] VGND VGND VPWR VPWR _0501_ sky130_fd_sc_hd__inv_2
XFILLER_46_3 VGND VPWR VPWR VGND sky130_ef_sc_hd__decap_12
X_1265_ _0461_ u_jt49.periodB\[5\] _0462_ u_jt49.periodB\[4\] VGND VGND VPWR VPWR
+ _0299_ sky130_fd_sc_hd__o22a_1
X_1403_ net125 net73 _0406_ VGND VGND VPWR VPWR _0118_ sky130_fd_sc_hd__a21o_1
XPHY_EDGE_ROW_18_Right_18 VGND VGND VPWR VPWR sky130_fd_sc_hd__decap_3
X_1334_ _0488_ u_jt49.periodA\[11\] VGND VGND VPWR VPWR _0355_ sky130_fd_sc_hd__and2_1
X_1196_ _0478_ _0479_ _0480_ _0771_ VGND VGND VPWR VPWR _0777_ sky130_fd_sc_hd__nor4_1
XFILLER_36_197 VGND VGND VPWR VPWR sky130_fd_sc_hd__decap_4
XPHY_EDGE_ROW_27_Right_27 VGND VGND VPWR VPWR sky130_fd_sc_hd__decap_3
Xinput3 IOA_in[2] VGND VGND VPWR VPWR net3 sky130_fd_sc_hd__buf_1
XFILLER_24_326 VGND VGND VPWR VPWR sky130_fd_sc_hd__decap_4
XPHY_EDGE_ROW_36_Right_36 VGND VGND VPWR VPWR sky130_fd_sc_hd__decap_3
XFILLER_59_245 VGND VPWR VPWR VGND sky130_ef_sc_hd__decap_12
XPHY_EDGE_ROW_45_Right_45 VGND VGND VPWR VPWR sky130_fd_sc_hd__decap_3
XFILLER_15_337 VGND VPWR VPWR VGND sky130_ef_sc_hd__decap_12
XPHY_EDGE_ROW_54_Right_54 VGND VGND VPWR VPWR sky130_fd_sc_hd__decap_3
XFILLER_51_42 VGND VGND VPWR VPWR sky130_fd_sc_hd__decap_8
XFILLER_65_237 VGND VGND VPWR VPWR sky130_fd_sc_hd__decap_8
XFILLER_65_215 VGND VGND VPWR VPWR sky130_fd_sc_hd__decap_8
XPHY_EDGE_ROW_63_Right_63 VGND VGND VPWR VPWR sky130_fd_sc_hd__decap_3
XFILLER_18_175 VGND VGND VPWR VPWR sky130_fd_sc_hd__decap_4
X_1050_ _0662_ _0664_ _0665_ VGND VGND VPWR VPWR _0025_ sky130_fd_sc_hd__and3_1
X_0903_ net9 _0544_ _0545_ net1 _0543_ VGND VGND VPWR VPWR _0266_ sky130_fd_sc_hd__a221o_1
X_0834_ u_jt49.regarray\[6\]\[0\] VGND VGND VPWR VPWR _0484_ sky130_fd_sc_hd__inv_2
X_1248_ u_jt49.periodC\[3\] u_jt49.periodC\[2\] u_jt49.periodC\[1\] u_jt49.periodC\[0\]
+ VGND VGND VPWR VPWR _0283_ sky130_fd_sc_hd__or4_1
X_1317_ net46 net215 VGND VGND VPWR VPWR _0338_ sky130_fd_sc_hd__nor2_1
X_1179_ u_jt49.u_envdiv.count\[3\] _0763_ VGND VGND VPWR VPWR _0765_ sky130_fd_sc_hd__or2_1
XFILLER_47_259 VGND VGND VPWR VPWR sky130_fd_sc_hd__decap_3
XFILLER_46_97 VGND VGND VPWR VPWR sky130_fd_sc_hd__decap_6
XFILLER_62_85 VGND VPWR VPWR VGND sky130_ef_sc_hd__decap_12
XFILLER_62_41 VGND VPWR VPWR VGND sky130_ef_sc_hd__decap_12
XFILLER_11_373 VGND VPWR VPWR VGND sky130_ef_sc_hd__decap_12
X_1102_ u_jt49.regarray\[13\]\[3\] _0453_ u_jt49.u_env.gain\[4\] _0699_ u_jt49.u_env.rst_latch
+ VGND VGND VPWR VPWR _0704_ sky130_fd_sc_hd__a2111o_1
XFILLER_53_207 VGND VGND VPWR VPWR sky130_fd_sc_hd__decap_4
X_1033_ u_jt49.u_chC.count\[5\] u_jt49.periodC\[5\] VGND VGND VPWR VPWR _0650_ sky130_fd_sc_hd__and2b_1
X_1797_ clknet_leaf_4_clk _0210_ net84 VGND VGND VPWR VPWR IOB_out[3] sky130_fd_sc_hd__dfrtp_4
X_0817_ u_jt49.periodC\[9\] VGND VGND VPWR VPWR _0467_ sky130_fd_sc_hd__inv_2
X_1866_ clknet_leaf_28_clk _0269_ net75 VGND VGND VPWR VPWR dout[3] sky130_fd_sc_hd__dfrtp_4
XPHY_EDGE_ROW_26_Left_92 VGND VGND VPWR VPWR sky130_fd_sc_hd__decap_3
XPHY_EDGE_ROW_10_Left_76 VGND VGND VPWR VPWR sky130_fd_sc_hd__decap_3
XFILLER_52_284 VGND VGND VPWR VPWR sky130_fd_sc_hd__decap_4
XFILLER_52_262 VGND VGND VPWR VPWR sky130_fd_sc_hd__decap_3
XPHY_EDGE_ROW_0_Right_0 VGND VGND VPWR VPWR sky130_fd_sc_hd__decap_3
XFILLER_4_325 VGND VPWR VPWR VGND sky130_ef_sc_hd__decap_12
XFILLER_4_303 VGND VGND VPWR VPWR sky130_fd_sc_hd__decap_4
X_1720_ clknet_leaf_12_clk _0133_ net100 VGND VGND VPWR VPWR u_jt49.eg_period\[14\]
+ sky130_fd_sc_hd__dfrtp_2
X_1651_ clknet_leaf_30_clk _0068_ net76 VGND VGND VPWR VPWR u_jt49.u_ng.poly17\[0\]
+ sky130_fd_sc_hd__dfrtp_1
Xhold108 u_jt49.regarray\[8\]\[2\] VGND VGND VPWR VPWR net214 sky130_fd_sc_hd__dlygate4sd3_1
Xhold119 u_jt49.u_env.cen VGND VGND VPWR VPWR net225 sky130_fd_sc_hd__dlygate4sd3_1
X_1582_ u_jt49.regarray\[10\]\[2\] u_jt49.envelope\[3\] u_jt49.regarray\[10\]\[4\]
+ VGND VGND VPWR VPWR _0441_ sky130_fd_sc_hd__mux2_1
X_1016_ _0631_ _0632_ VGND VGND VPWR VPWR _0633_ sky130_fd_sc_hd__nor2_1
XFILLER_34_284 VGND VPWR VPWR VGND sky130_ef_sc_hd__decap_12
X_1849_ clknet_leaf_22_clk _0262_ VGND VGND VPWR VPWR u_jt49.logC\[2\] sky130_fd_sc_hd__dfxtp_1
XFILLER_17_207 VGND VGND VPWR VPWR sky130_fd_sc_hd__decap_6
Xclkbuf_leaf_20_clk clknet_2_2__leaf_clk VGND VGND VPWR VPWR clknet_leaf_20_clk sky130_fd_sc_hd__clkbuf_8
XFILLER_4_133 VGND VGND VPWR VPWR sky130_fd_sc_hd__decap_6
XFILLER_4_15 VGND VPWR VPWR VGND sky130_ef_sc_hd__decap_12
XFILLER_48_365 VGND VGND VPWR VPWR sky130_fd_sc_hd__decap_8
XFILLER_0_361 VGND VGND VPWR VPWR sky130_fd_sc_hd__decap_3
XFILLER_16_262 VGND VPWR VPWR VGND sky130_ef_sc_hd__decap_12
XFILLER_16_295 VGND VGND VPWR VPWR sky130_fd_sc_hd__decap_6
Xclkbuf_leaf_11_clk clknet_2_3__leaf_clk VGND VGND VPWR VPWR clknet_leaf_11_clk sky130_fd_sc_hd__clkbuf_8
X_1703_ clknet_leaf_15_clk _0002_ VGND VGND VPWR VPWR net48 sky130_fd_sc_hd__dfxtp_1
X_1634_ clknet_leaf_30_clk net129 VGND VGND VPWR VPWR u_jt49.u_ng.last_en sky130_fd_sc_hd__dfxtp_1
XFILLER_39_332 VGND VGND VPWR VPWR sky130_fd_sc_hd__decap_4
X_1565_ net73 net107 _0431_ _0432_ VGND VGND VPWR VPWR _0254_ sky130_fd_sc_hd__a22o_1
X_1496_ u_jt49.periodC\[1\] net70 _0417_ VGND VGND VPWR VPWR _0200_ sky130_fd_sc_hd__mux2_1
Xfanout69 din_latch\[1\] VGND VGND VPWR VPWR net69 sky130_fd_sc_hd__clkbuf_4
Xfanout58 din_latch\[7\] VGND VGND VPWR VPWR net58 sky130_fd_sc_hd__clkbuf_2
Xfanout47 sample VGND VGND VPWR VPWR net47 sky130_fd_sc_hd__buf_2
Xfanout36 _0274_ VGND VGND VPWR VPWR net36 sky130_fd_sc_hd__clkbuf_4
XFILLER_1_103 VGND VGND VPWR VPWR sky130_fd_sc_hd__decap_8
XFILLER_1_125 VGND VGND VPWR VPWR sky130_fd_sc_hd__decap_3
XFILLER_1_169 VGND VGND VPWR VPWR sky130_fd_sc_hd__decap_6
XFILLER_54_97 VGND VPWR VPWR VGND sky130_ef_sc_hd__decap_12
XFILLER_54_53 VGND VPWR VPWR VGND sky130_ef_sc_hd__decap_12
XFILLER_13_287 VGND VPWR VPWR VGND sky130_ef_sc_hd__decap_12
Xclkload17 clknet_leaf_20_clk VGND VGND VPWR VPWR clkload17/Y sky130_fd_sc_hd__inv_4
X_1281_ u_jt49.u_chB.count\[1\] u_jt49.u_chB.count\[0\] net47 u_jt49.u_chB.count\[2\]
+ VGND VGND VPWR VPWR _0313_ sky130_fd_sc_hd__a31o_1
X_1350_ _0364_ _0367_ net43 VGND VGND VPWR VPWR _0370_ sky130_fd_sc_hd__a21o_2
XFILLER_51_305 VGND VGND VPWR VPWR sky130_fd_sc_hd__decap_8
XFILLER_36_368 VGND VGND VPWR VPWR sky130_fd_sc_hd__decap_8
Xclkbuf_leaf_0_clk clknet_2_0__leaf_clk VGND VGND VPWR VPWR clknet_leaf_0_clk sky130_fd_sc_hd__clkbuf_8
XFILLER_51_349 VGND VPWR VPWR VGND sky130_ef_sc_hd__decap_12
X_0996_ net47 u_jt49.u_ng.u_div.count\[1\] u_jt49.u_ng.u_div.count\[0\] VGND VGND
+ VPWR VPWR _0620_ sky130_fd_sc_hd__and3_1
X_1617_ clknet_leaf_16_clk _0034_ net103 VGND VGND VPWR VPWR u_jt49.u_chC.count\[10\]
+ sky130_fd_sc_hd__dfrtp_1
X_1548_ u_jt49.regarray\[8\]\[1\] u_jt49.envelope\[2\] u_jt49.regarray\[8\]\[4\] VGND
+ VGND VPWR VPWR _0427_ sky130_fd_sc_hd__mux2_1
X_1479_ u_jt49.regarray\[6\]\[2\] net67 _0415_ VGND VGND VPWR VPWR _0185_ sky130_fd_sc_hd__mux2_1
XFILLER_42_305 VGND VGND VPWR VPWR sky130_fd_sc_hd__decap_3
XFILLER_6_206 VGND VGND VPWR VPWR sky130_fd_sc_hd__decap_3
XFILLER_10_257 VGND VGND VPWR VPWR sky130_fd_sc_hd__decap_3
XFILLER_6_3 VGND VPWR VPWR VGND sky130_ef_sc_hd__decap_12
XFILLER_65_85 VGND VPWR VPWR VGND sky130_ef_sc_hd__decap_12
XFILLER_65_41 VGND VPWR VPWR VGND sky130_ef_sc_hd__decap_12
X_0850_ u_jt49.bitA VGND VGND VPWR VPWR _0500_ sky130_fd_sc_hd__inv_2
X_1402_ u_jt49.bitC u_jt49.regarray\[7\]\[2\] u_jt49.regarray\[7\]\[5\] u_jt49.noise
+ net20 VGND VGND VPWR VPWR _0406_ sky130_fd_sc_hd__o221a_1
X_1264_ _0295_ _0296_ _0297_ VGND VGND VPWR VPWR _0298_ sky130_fd_sc_hd__a21o_1
XFILLER_39_3 VGND VGND VPWR VPWR sky130_fd_sc_hd__decap_4
Xinput4 IOA_in[3] VGND VGND VPWR VPWR net4 sky130_fd_sc_hd__buf_1
X_1333_ _0489_ u_jt49.periodA\[9\] VGND VGND VPWR VPWR _0354_ sky130_fd_sc_hd__and2_1
X_1195_ net33 _0775_ _0776_ VGND VGND VPWR VPWR _0059_ sky130_fd_sc_hd__and3_1
XFILLER_51_113 VGND VPWR VPWR VGND sky130_ef_sc_hd__decap_12
Xclkbuf_2_1__f_clk clknet_0_clk VGND VGND VPWR VPWR clknet_2_1__leaf_clk sky130_fd_sc_hd__clkbuf_16
X_0979_ net71 net21 _0611_ VGND VGND VPWR VPWR _0004_ sky130_fd_sc_hd__mux2_1
XFILLER_59_257 VGND VGND VPWR VPWR sky130_fd_sc_hd__decap_4
XFILLER_15_349 VGND VPWR VPWR VGND sky130_ef_sc_hd__decap_12
XFILLER_2_253 VGND VGND VPWR VPWR sky130_fd_sc_hd__decap_4
XFILLER_65_249 VGND VGND VPWR VPWR sky130_fd_sc_hd__decap_3
XPHY_EDGE_ROW_38_Left_104 VGND VGND VPWR VPWR sky130_fd_sc_hd__decap_3
X_0902_ net55 _0542_ VGND VGND VPWR VPWR _0545_ sky130_fd_sc_hd__nor2_4
X_0833_ u_jt49.regarray\[6\]\[1\] VGND VGND VPWR VPWR _0483_ sky130_fd_sc_hd__inv_2
XPHY_EDGE_ROW_47_Left_113 VGND VGND VPWR VPWR sky130_fd_sc_hd__decap_3
XPHY_EDGE_ROW_56_Left_122 VGND VGND VPWR VPWR sky130_fd_sc_hd__decap_3
X_1178_ net32 _0762_ _0764_ VGND VGND VPWR VPWR _0054_ sky130_fd_sc_hd__and3_1
X_1316_ _0337_ u_jt49.bitB net31 VGND VGND VPWR VPWR _0100_ sky130_fd_sc_hd__mux2_1
X_1247_ _0282_ net198 _0619_ VGND VGND VPWR VPWR _0086_ sky130_fd_sc_hd__mux2_1
XFILLER_24_157 VGND VPWR VPWR VGND sky130_ef_sc_hd__decap_12
XPHY_EDGE_ROW_65_Left_131 VGND VGND VPWR VPWR sky130_fd_sc_hd__decap_3
XFILLER_55_260 VGND VPWR VPWR VGND sky130_ef_sc_hd__decap_12
XFILLER_62_97 VGND VPWR VPWR VGND sky130_ef_sc_hd__decap_12
XFILLER_62_53 VGND VPWR VPWR VGND sky130_ef_sc_hd__decap_12
XFILLER_7_15 VGND VPWR VPWR VGND sky130_ef_sc_hd__decap_12
XFILLER_7_312 VGND VGND VPWR VPWR sky130_fd_sc_hd__decap_3
X_1101_ u_jt49.eg_step net142 _0703_ VGND VGND VPWR VPWR _0038_ sky130_fd_sc_hd__mux2_1
XFILLER_38_205 VGND VGND VPWR VPWR sky130_fd_sc_hd__decap_4
X_1032_ _0471_ u_jt49.periodC\[3\] _0472_ u_jt49.periodC\[2\] VGND VGND VPWR VPWR
+ _0649_ sky130_fd_sc_hd__o22a_1
X_1796_ clknet_leaf_4_clk _0209_ net84 VGND VGND VPWR VPWR IOB_out[2] sky130_fd_sc_hd__dfrtp_4
X_1865_ clknet_leaf_28_clk _0268_ net75 VGND VGND VPWR VPWR dout[2] sky130_fd_sc_hd__dfrtp_4
X_0816_ net48 VGND VGND VPWR VPWR _0466_ sky130_fd_sc_hd__inv_2
XFILLER_12_105 VGND VGND VPWR VPWR sky130_fd_sc_hd__decap_8
XFILLER_4_337 VGND VPWR VPWR VGND sky130_ef_sc_hd__decap_12
XFILLER_43_274 VGND VGND VPWR VPWR sky130_fd_sc_hd__decap_6
X_1650_ clknet_leaf_8_clk _0067_ net100 VGND VGND VPWR VPWR u_jt49.u_envdiv.count\[15\]
+ sky130_fd_sc_hd__dfrtp_1
X_1581_ net74 net108 _0438_ _0440_ VGND VGND VPWR VPWR _0262_ sky130_fd_sc_hd__a22o_1
Xhold109 u_jt49.u_chA.count\[0\] VGND VGND VPWR VPWR net215 sky130_fd_sc_hd__dlygate4sd3_1
XFILLER_3_381 VGND VGND VPWR VPWR sky130_fd_sc_hd__decap_6
X_1015_ u_jt49.periodC\[11\] u_jt49.u_chC.count\[11\] VGND VGND VPWR VPWR _0632_ sky130_fd_sc_hd__and2b_1
XFILLER_34_296 VGND VPWR VPWR VGND sky130_ef_sc_hd__decap_12
X_1779_ clknet_leaf_17_clk _0192_ net99 VGND VGND VPWR VPWR u_jt49.periodC\[9\] sky130_fd_sc_hd__dfrtp_2
X_1848_ clknet_leaf_22_clk _0261_ VGND VGND VPWR VPWR u_jt49.logC\[1\] sky130_fd_sc_hd__dfxtp_1
XFILLER_27_23 VGND VGND VPWR VPWR sky130_fd_sc_hd__decap_6
XFILLER_31_233 VGND VGND VPWR VPWR sky130_fd_sc_hd__decap_6
X_1702_ clknet_leaf_15_clk _0117_ net102 VGND VGND VPWR VPWR u_jt49.u_cen.cencnt\[3\]
+ sky130_fd_sc_hd__dfrtp_1
X_1633_ clknet_leaf_22_clk _0050_ VGND VGND VPWR VPWR u_jt49.envelope\[4\] sky130_fd_sc_hd__dfxtp_1
X_1564_ u_jt49.Bmix net20 VGND VGND VPWR VPWR _0432_ sky130_fd_sc_hd__and2_1
X_1495_ net218 net72 _0417_ VGND VGND VPWR VPWR _0199_ sky130_fd_sc_hd__mux2_1
Xfanout37 _0274_ VGND VGND VPWR VPWR net37 sky130_fd_sc_hd__buf_2
Xfanout59 din_latch\[6\] VGND VGND VPWR VPWR net59 sky130_fd_sc_hd__clkbuf_4
Xfanout48 net48 VGND VGND VPWR VPWR sample sky130_fd_sc_hd__clkbuf_8
XFILLER_54_65 VGND VPWR VPWR VGND sky130_ef_sc_hd__decap_12
XFILLER_9_215 VGND VGND VPWR VPWR sky130_fd_sc_hd__decap_8
XFILLER_13_299 VGND VGND VPWR VPWR sky130_fd_sc_hd__decap_3
Xclkload18 clknet_leaf_21_clk VGND VGND VPWR VPWR clkload18/X sky130_fd_sc_hd__clkbuf_4
XFILLER_48_141 VGND VPWR VPWR VGND sky130_ef_sc_hd__decap_12
X_1280_ _0311_ VGND VGND VPWR VPWR _0312_ sky130_fd_sc_hd__inv_2
XFILLER_0_181 VGND VPWR VPWR VGND sky130_ef_sc_hd__decap_12
X_0995_ net47 _0617_ VGND VGND VPWR VPWR _0619_ sky130_fd_sc_hd__nand2_1
X_1616_ clknet_leaf_16_clk _0033_ net102 VGND VGND VPWR VPWR u_jt49.u_chC.count\[9\]
+ sky130_fd_sc_hd__dfrtp_2
X_1547_ net73 net120 _0425_ _0426_ VGND VGND VPWR VPWR _0242_ sky130_fd_sc_hd__a22o_1
X_1478_ u_jt49.regarray\[6\]\[1\] net69 _0415_ VGND VGND VPWR VPWR _0184_ sky130_fd_sc_hd__mux2_1
XFILLER_50_350 VGND VPWR VPWR VGND sky130_ef_sc_hd__decap_12
XFILLER_40_56 VGND VGND VPWR VPWR sky130_fd_sc_hd__decap_6
XFILLER_6_229 VGND VGND VPWR VPWR sky130_fd_sc_hd__decap_3
XFILLER_65_97 VGND VPWR VPWR VGND sky130_ef_sc_hd__decap_12
XFILLER_65_53 VGND VGND VPWR VPWR sky130_fd_sc_hd__decap_3
XFILLER_45_133 VGND VGND VPWR VPWR sky130_fd_sc_hd__decap_6
X_1401_ net136 _0405_ VGND VGND VPWR VPWR _0117_ sky130_fd_sc_hd__xnor2_1
X_1194_ _0479_ _0480_ _0771_ VGND VGND VPWR VPWR _0776_ sky130_fd_sc_hd__or3_1
X_1263_ _0462_ u_jt49.periodB\[4\] _0463_ u_jt49.periodB\[3\] VGND VGND VPWR VPWR
+ _0297_ sky130_fd_sc_hd__a22o_1
Xinput5 IOA_in[4] VGND VGND VPWR VPWR net5 sky130_fd_sc_hd__buf_1
X_1332_ _0488_ u_jt49.periodA\[11\] VGND VGND VPWR VPWR _0353_ sky130_fd_sc_hd__or2_1
XFILLER_51_125 VGND VGND VPWR VPWR sky130_fd_sc_hd__decap_4
X_0978_ net17 net19 net104 net18 VGND VGND VPWR VPWR _0611_ sky130_fd_sc_hd__and4b_4
XFILLER_10_15 VGND VPWR VPWR VGND sky130_ef_sc_hd__decap_12
XFILLER_42_125 VGND VPWR VPWR VGND sky130_ef_sc_hd__decap_12
XFILLER_42_103 VGND VPWR VPWR VGND sky130_ef_sc_hd__decap_12
XFILLER_19_57 VGND VGND VPWR VPWR sky130_fd_sc_hd__decap_8
XFILLER_30_309 VGND VGND VPWR VPWR sky130_fd_sc_hd__decap_3
XFILLER_23_372 VGND VPWR VPWR VGND sky130_ef_sc_hd__decap_12
XFILLER_14_361 VGND VGND VPWR VPWR sky130_fd_sc_hd__decap_3
X_0832_ u_jt49.u_envdiv.count\[4\] VGND VGND VPWR VPWR _0482_ sky130_fd_sc_hd__inv_2
X_0901_ net49 net51 net53 net55 VGND VGND VPWR VPWR _0544_ sky130_fd_sc_hd__and4_4
XFILLER_51_3 VGND VGND VPWR VPWR sky130_fd_sc_hd__decap_6
X_1315_ _0334_ _0335_ _0336_ _0499_ VGND VGND VPWR VPWR _0337_ sky130_fd_sc_hd__o31a_1
X_1177_ _0763_ VGND VGND VPWR VPWR _0764_ sky130_fd_sc_hd__inv_2
X_1246_ u_jt49.regarray\[6\]\[1\] _0281_ u_jt49.u_ng.noise_en VGND VGND VPWR VPWR
+ _0282_ sky130_fd_sc_hd__o21ba_1
XFILLER_24_169 VGND VGND VPWR VPWR sky130_fd_sc_hd__decap_4
XFILLER_62_209 VGND VPWR VPWR VGND sky130_ef_sc_hd__decap_12
Xmax_cap34 _0777_ VGND VGND VPWR VPWR net34 sky130_fd_sc_hd__buf_1
XFILLER_55_272 VGND VGND VPWR VPWR sky130_fd_sc_hd__decap_3
XFILLER_15_169 VGND VPWR VPWR VGND sky130_ef_sc_hd__decap_12
XFILLER_62_65 VGND VPWR VPWR VGND sky130_ef_sc_hd__decap_12
XFILLER_23_180 VGND VGND VPWR VPWR sky130_fd_sc_hd__decap_4
XFILLER_23_191 VGND VGND VPWR VPWR sky130_fd_sc_hd__decap_8
X_1100_ net103 net45 VGND VGND VPWR VPWR _0703_ sky130_fd_sc_hd__nand2_1
X_1031_ u_jt49.periodC\[0\] _0473_ _0645_ _0646_ _0647_ VGND VGND VPWR VPWR _0648_
+ sky130_fd_sc_hd__a311o_1
XFILLER_61_231 VGND VPWR VPWR VGND sky130_ef_sc_hd__decap_12
Xinput30 sel VGND VGND VPWR VPWR net30 sky130_fd_sc_hd__buf_1
X_0815_ net219 VGND VGND VPWR VPWR _0465_ sky130_fd_sc_hd__inv_2
X_1795_ clknet_leaf_4_clk _0208_ net84 VGND VGND VPWR VPWR IOB_out[1] sky130_fd_sc_hd__dfrtp_4
X_1864_ clknet_leaf_29_clk _0267_ net75 VGND VGND VPWR VPWR dout[1] sky130_fd_sc_hd__dfrtp_4
X_1229_ net178 net185 net36 VGND VGND VPWR VPWR _0076_ sky130_fd_sc_hd__mux2_1
XFILLER_16_69 VGND VPWR VPWR VGND sky130_ef_sc_hd__decap_12
XFILLER_4_349 VGND VPWR VPWR VGND sky130_ef_sc_hd__decap_12
XFILLER_11_183 VGND VPWR VPWR VGND sky130_ef_sc_hd__decap_12
X_1580_ u_jt49.regarray\[10\]\[1\] u_jt49.envelope\[2\] u_jt49.regarray\[10\]\[4\]
+ VGND VGND VPWR VPWR _0440_ sky130_fd_sc_hd__mux2_1
XFILLER_14_3 VGND VPWR VPWR VGND sky130_ef_sc_hd__decap_12
X_1014_ u_jt49.periodC\[10\] u_jt49.u_chC.count\[10\] VGND VGND VPWR VPWR _0631_ sky130_fd_sc_hd__and2b_1
X_1847_ clknet_leaf_22_clk _0260_ VGND VGND VPWR VPWR u_jt49.logC\[0\] sky130_fd_sc_hd__dfxtp_1
X_1778_ clknet_leaf_17_clk _0191_ net99 VGND VGND VPWR VPWR u_jt49.periodC\[8\] sky130_fd_sc_hd__dfrtp_2
XFILLER_25_220 VGND VGND VPWR VPWR sky130_fd_sc_hd__decap_4
XFILLER_63_337 VGND VPWR VPWR VGND sky130_ef_sc_hd__decap_12
X_1701_ clknet_leaf_15_clk _0116_ net102 VGND VGND VPWR VPWR u_jt49.u_cen.cencnt\[2\]
+ sky130_fd_sc_hd__dfrtp_1
X_1494_ net42 net40 VGND VGND VPWR VPWR _0417_ sky130_fd_sc_hd__and2_2
X_1563_ u_jt49.regarray\[9\]\[3\] u_jt49.envelope\[0\] u_jt49.regarray\[9\]\[4\] VGND
+ VGND VPWR VPWR _0431_ sky130_fd_sc_hd__mux2_1
X_1632_ clknet_leaf_22_clk _0049_ VGND VGND VPWR VPWR u_jt49.envelope\[3\] sky130_fd_sc_hd__dfxtp_1
XFILLER_58_109 VGND VGND VPWR VPWR sky130_fd_sc_hd__decap_8
Xfanout49 net50 VGND VGND VPWR VPWR net49 sky130_fd_sc_hd__buf_2
XFILLER_22_212 VGND VGND VPWR VPWR sky130_fd_sc_hd__decap_3
XFILLER_13_26 VGND VGND VPWR VPWR sky130_fd_sc_hd__decap_3
XFILLER_57_153 VGND VPWR VPWR VGND sky130_ef_sc_hd__decap_12
XFILLER_54_77 VGND VGND VPWR VPWR sky130_fd_sc_hd__decap_6
Xclkload19 clknet_leaf_22_clk VGND VGND VPWR VPWR clkload19/Y sky130_fd_sc_hd__clkinvlp_4
XFILLER_0_193 VGND VGND VPWR VPWR sky130_fd_sc_hd__decap_3
XFILLER_51_318 VGND VPWR VPWR VGND sky130_ef_sc_hd__decap_12
XFILLER_48_197 VGND VGND VPWR VPWR sky130_fd_sc_hd__decap_8
X_0994_ _0617_ _0618_ _0612_ VGND VGND VPWR VPWR _0012_ sky130_fd_sc_hd__o21a_1
X_1615_ clknet_leaf_16_clk _0032_ net102 VGND VGND VPWR VPWR u_jt49.u_chC.count\[8\]
+ sky130_fd_sc_hd__dfrtp_1
X_1546_ u_jt49.regarray\[8\]\[0\] u_jt49.envelope\[1\] u_jt49.regarray\[8\]\[4\] VGND
+ VGND VPWR VPWR _0426_ sky130_fd_sc_hd__mux2_1
X_1477_ u_jt49.regarray\[6\]\[0\] net71 _0415_ VGND VGND VPWR VPWR _0183_ sky130_fd_sc_hd__mux2_1
X_1400_ net151 _0403_ VGND VGND VPWR VPWR _0116_ sky130_fd_sc_hd__xor2_1
X_1331_ _0494_ u_jt49.periodA\[2\] _0349_ _0350_ _0351_ VGND VGND VPWR VPWR _0352_
+ sky130_fd_sc_hd__o221a_1
X_1193_ _0479_ _0773_ VGND VGND VPWR VPWR _0775_ sky130_fd_sc_hd__nand2_1
X_1262_ _0463_ u_jt49.periodB\[3\] _0464_ u_jt49.periodB\[2\] VGND VGND VPWR VPWR
+ _0296_ sky130_fd_sc_hd__o22a_1
Xinput6 IOA_in[5] VGND VGND VPWR VPWR net6 sky130_fd_sc_hd__buf_1
XFILLER_51_104 VGND VGND VPWR VPWR sky130_fd_sc_hd__decap_8
X_0977_ net151 _0503_ _0610_ VGND VGND VPWR VPWR _0003_ sky130_fd_sc_hd__a21oi_1
X_1529_ u_jt49.periodB\[5\] net61 _0421_ VGND VGND VPWR VPWR _0229_ sky130_fd_sc_hd__mux2_1
XFILLER_27_101 VGND VGND VPWR VPWR sky130_fd_sc_hd__decap_3
XFILLER_42_137 VGND VGND VPWR VPWR sky130_fd_sc_hd__decap_3
XFILLER_42_115 VGND VGND VPWR VPWR sky130_fd_sc_hd__decap_4
XFILLER_35_57 VGND VPWR VPWR VGND sky130_ef_sc_hd__decap_12
XPHY_EDGE_ROW_14_Right_14 VGND VGND VPWR VPWR sky130_fd_sc_hd__decap_3
XFILLER_23_384 VGND VGND VPWR VPWR sky130_fd_sc_hd__decap_3
XPHY_EDGE_ROW_23_Right_23 VGND VGND VPWR VPWR sky130_fd_sc_hd__decap_3
XFILLER_18_101 VGND VPWR VPWR VGND sky130_ef_sc_hd__decap_12
XFILLER_41_192 VGND VPWR VPWR VGND sky130_ef_sc_hd__decap_12
XPHY_EDGE_ROW_32_Right_32 VGND VGND VPWR VPWR sky130_fd_sc_hd__decap_3
XFILLER_18_189 VGND VGND VPWR VPWR sky130_fd_sc_hd__decap_6
X_0900_ u_jt49.periodA\[0\] _0521_ _0541_ _0542_ VGND VGND VPWR VPWR _0543_ sky130_fd_sc_hd__o211a_1
X_0831_ u_jt49.u_envdiv.count\[5\] VGND VGND VPWR VPWR _0481_ sky130_fd_sc_hd__inv_2
XPHY_EDGE_ROW_41_Right_41 VGND VGND VPWR VPWR sky130_fd_sc_hd__decap_3
X_1314_ u_jt49.periodB\[11\] u_jt49.periodB\[10\] u_jt49.periodB\[9\] u_jt49.periodB\[8\]
+ VGND VGND VPWR VPWR _0336_ sky130_fd_sc_hd__or4_1
XPHY_EDGE_ROW_50_Right_50 VGND VGND VPWR VPWR sky130_fd_sc_hd__decap_3
XFILLER_49_281 VGND VGND VPWR VPWR sky130_fd_sc_hd__decap_6
X_1176_ u_jt49.u_envdiv.count\[2\] _0759_ VGND VGND VPWR VPWR _0763_ sky130_fd_sc_hd__and2_1
X_1245_ u_jt49.regarray\[6\]\[0\] u_jt49.regarray\[6\]\[3\] u_jt49.regarray\[6\]\[2\]
+ u_jt49.regarray\[6\]\[4\] VGND VGND VPWR VPWR _0281_ sky130_fd_sc_hd__or4_1
XFILLER_24_148 VGND VGND VPWR VPWR sky130_fd_sc_hd__decap_3
XFILLER_20_365 VGND VPWR VPWR VGND sky130_ef_sc_hd__decap_12
Xmax_cap35 _0530_ VGND VGND VPWR VPWR net35 sky130_fd_sc_hd__clkbuf_2
XFILLER_62_77 VGND VGND VPWR VPWR sky130_fd_sc_hd__decap_6
XFILLER_11_332 VGND VGND VPWR VPWR sky130_fd_sc_hd__decap_4
XFILLER_61_243 VGND VPWR VPWR VGND sky130_ef_sc_hd__decap_12
X_1030_ u_jt49.u_chC.count\[1\] u_jt49.periodC\[1\] VGND VGND VPWR VPWR _0647_ sky130_fd_sc_hd__and2b_1
Xinput20 clk_en VGND VGND VPWR VPWR net20 sky130_fd_sc_hd__buf_4
X_0814_ u_jt49.u_chB.count\[2\] VGND VGND VPWR VPWR _0464_ sky130_fd_sc_hd__inv_2
X_1863_ clknet_leaf_29_clk _0266_ net75 VGND VGND VPWR VPWR dout[0] sky130_fd_sc_hd__dfrtp_4
X_1794_ clknet_leaf_4_clk _0207_ net84 VGND VGND VPWR VPWR IOB_out[0] sky130_fd_sc_hd__dfrtp_4
XFILLER_29_218 VGND VGND VPWR VPWR sky130_fd_sc_hd__decap_6
X_1228_ net174 net178 net36 VGND VGND VPWR VPWR _0075_ sky130_fd_sc_hd__mux2_1
X_1159_ u_jt49.u_env.gain\[1\] u_jt49.u_env.inv VGND VGND VPWR VPWR _0753_ sky130_fd_sc_hd__xor2_1
XFILLER_16_15 VGND VPWR VPWR VGND sky130_ef_sc_hd__decap_12
XFILLER_43_221 VGND VGND VPWR VPWR sky130_fd_sc_hd__decap_3
XFILLER_43_287 VGND VPWR VPWR VGND sky130_ef_sc_hd__decap_12
Xclkbuf_leaf_23_clk clknet_2_2__leaf_clk VGND VGND VPWR VPWR clknet_leaf_23_clk sky130_fd_sc_hd__clkbuf_8
XFILLER_7_177 VGND VPWR VPWR VGND sky130_ef_sc_hd__decap_12
XFILLER_7_144 VGND VPWR VPWR VGND sky130_ef_sc_hd__decap_12
XFILLER_11_195 VGND VGND VPWR VPWR sky130_fd_sc_hd__decap_8
X_1013_ net192 u_jt49.u_env.rst_latch net45 VGND VGND VPWR VPWR _0023_ sky130_fd_sc_hd__mux2_1
Xclkbuf_leaf_14_clk clknet_2_3__leaf_clk VGND VGND VPWR VPWR clknet_leaf_14_clk sky130_fd_sc_hd__clkbuf_8
X_1777_ clknet_leaf_2_clk _0190_ net87 VGND VGND VPWR VPWR u_jt49.regarray\[6\]\[7\]
+ sky130_fd_sc_hd__dfrtp_1
X_1846_ clknet_leaf_19_clk _0259_ net95 VGND VGND VPWR VPWR u_jt49.eg_restart sky130_fd_sc_hd__dfrtp_1
XPHY_EDGE_ROW_4_Right_4 VGND VGND VPWR VPWR sky130_fd_sc_hd__decap_3
XFILLER_27_69 VGND VPWR VPWR VGND sky130_ef_sc_hd__decap_12
XFILLER_43_57 VGND VPWR VPWR VGND sky130_ef_sc_hd__decap_12
XFILLER_63_349 VGND VPWR VPWR VGND sky130_ef_sc_hd__decap_12
XFILLER_63_305 VGND VPWR VPWR VGND sky130_ef_sc_hd__decap_12
XFILLER_16_221 VGND VGND VPWR VPWR sky130_fd_sc_hd__decap_4
XFILLER_16_232 VGND VPWR VPWR VGND sky130_ef_sc_hd__decap_12
X_1700_ clknet_leaf_15_clk _0115_ net102 VGND VGND VPWR VPWR u_jt49.u_cen.cencnt\[1\]
+ sky130_fd_sc_hd__dfrtp_1
X_1631_ clknet_leaf_22_clk _0048_ VGND VGND VPWR VPWR u_jt49.envelope\[2\] sky130_fd_sc_hd__dfxtp_1
X_1493_ net165 net57 _0416_ VGND VGND VPWR VPWR _0198_ sky130_fd_sc_hd__mux2_1
Xclkbuf_leaf_3_clk clknet_2_1__leaf_clk VGND VGND VPWR VPWR clknet_leaf_3_clk sky130_fd_sc_hd__clkbuf_8
X_1562_ u_jt49.periodA\[7\] net57 _0430_ VGND VGND VPWR VPWR _0253_ sky130_fd_sc_hd__mux2_1
XFILLER_30_290 VGND VPWR VPWR VGND sky130_ef_sc_hd__decap_12
X_1829_ clknet_leaf_27_clk _0242_ VGND VGND VPWR VPWR u_jt49.logA\[1\] sky130_fd_sc_hd__dfxtp_1
XFILLER_38_24 VGND VGND VPWR VPWR sky130_fd_sc_hd__decap_4
XFILLER_57_165 VGND VGND VPWR VPWR sky130_fd_sc_hd__decap_3
XFILLER_63_113 VGND VPWR VPWR VGND sky130_ef_sc_hd__decap_12
XFILLER_36_327 VGND VGND VPWR VPWR sky130_fd_sc_hd__decap_6
X_0993_ net47 u_jt49.u_ng.u_div.count\[0\] VGND VGND VPWR VPWR _0618_ sky130_fd_sc_hd__nand2_1
X_1614_ clknet_leaf_16_clk _0031_ net102 VGND VGND VPWR VPWR u_jt49.u_chC.count\[7\]
+ sky130_fd_sc_hd__dfrtp_1
XFILLER_39_132 VGND VGND VPWR VPWR sky130_fd_sc_hd__decap_8
X_1545_ net73 net121 _0424_ _0425_ VGND VGND VPWR VPWR _0241_ sky130_fd_sc_hd__a22o_1
X_1476_ net41 _0526_ VGND VGND VPWR VPWR _0415_ sky130_fd_sc_hd__and2_2
XFILLER_27_305 VGND VGND VPWR VPWR sky130_fd_sc_hd__decap_3
XPHY_EDGE_ROW_17_Left_83 VGND VGND VPWR VPWR sky130_fd_sc_hd__decap_3
XFILLER_65_11 VGND VPWR VPWR VGND sky130_ef_sc_hd__decap_12
XFILLER_18_305 VGND VGND VPWR VPWR sky130_fd_sc_hd__decap_3
X_1261_ u_jt49.periodB\[0\] _0465_ _0292_ _0293_ _0294_ VGND VGND VPWR VPWR _0295_
+ sky130_fd_sc_hd__a311o_1
X_1330_ _0493_ u_jt49.periodA\[3\] VGND VGND VPWR VPWR _0351_ sky130_fd_sc_hd__or2_1
X_1192_ net33 _0773_ _0774_ VGND VGND VPWR VPWR _0058_ sky130_fd_sc_hd__and3_1
Xinput7 IOA_in[6] VGND VGND VPWR VPWR net7 sky130_fd_sc_hd__buf_1
XFILLER_51_138 VGND VGND VPWR VPWR sky130_fd_sc_hd__decap_8
X_0976_ net136 _0503_ _0610_ net151 VGND VGND VPWR VPWR _0002_ sky130_fd_sc_hd__a211oi_1
XFILLER_59_205 VGND VGND VPWR VPWR sky130_fd_sc_hd__decap_6
X_1528_ u_jt49.periodB\[4\] net63 _0421_ VGND VGND VPWR VPWR _0228_ sky130_fd_sc_hd__mux2_1
XFILLER_27_113 VGND VPWR VPWR VGND sky130_ef_sc_hd__decap_12
X_1459_ u_jt49.regarray\[8\]\[0\] net71 _0413_ VGND VGND VPWR VPWR _0167_ sky130_fd_sc_hd__mux2_1
XFILLER_19_15 VGND VGND VPWR VPWR sky130_fd_sc_hd__decap_4
XFILLER_35_69 VGND VPWR VPWR VGND sky130_ef_sc_hd__decap_12
XPHY_EDGE_ROW_2_Left_68 VGND VGND VPWR VPWR sky130_fd_sc_hd__decap_3
XFILLER_4_3 VGND VPWR VPWR VGND sky130_ef_sc_hd__decap_12
XFILLER_18_113 VGND VPWR VPWR VGND sky130_ef_sc_hd__decap_12
X_0830_ u_jt49.u_envdiv.count\[6\] VGND VGND VPWR VPWR _0480_ sky130_fd_sc_hd__inv_2
XFILLER_14_341 VGND VPWR VPWR VGND sky130_ef_sc_hd__decap_12
X_1313_ u_jt49.periodB\[7\] u_jt49.periodB\[6\] u_jt49.periodB\[5\] u_jt49.periodB\[4\]
+ VGND VGND VPWR VPWR _0335_ sky130_fd_sc_hd__or4_1
XFILLER_37_3 VGND VPWR VPWR VGND sky130_ef_sc_hd__decap_12
X_1244_ _0501_ u_jt49.noise net43 VGND VGND VPWR VPWR _0085_ sky130_fd_sc_hd__mux2_1
X_1175_ u_jt49.u_envdiv.count\[2\] _0759_ VGND VGND VPWR VPWR _0762_ sky130_fd_sc_hd__or2_1
X_0959_ u_jt49.eg_period\[6\] _0524_ _0533_ u_jt49.regarray\[9\]\[6\] VGND VGND VPWR
+ VPWR _0596_ sky130_fd_sc_hd__a22o_1
XFILLER_20_377 VGND VGND VPWR VPWR sky130_fd_sc_hd__decap_8
XPHY_EDGE_ROW_34_Left_100 VGND VGND VPWR VPWR sky130_fd_sc_hd__decap_3
XFILLER_15_127 VGND VGND VPWR VPWR sky130_fd_sc_hd__decap_3
XFILLER_7_326 VGND VGND VPWR VPWR sky130_fd_sc_hd__decap_8
XFILLER_7_337 VGND VPWR VPWR VGND sky130_ef_sc_hd__decap_12
XFILLER_61_255 VGND VPWR VPWR VGND sky130_ef_sc_hd__decap_12
XFILLER_46_274 VGND VPWR VPWR VGND sky130_ef_sc_hd__decap_12
Xinput21 din[0] VGND VGND VPWR VPWR net21 sky130_fd_sc_hd__clkbuf_1
X_0813_ u_jt49.u_chB.count\[3\] VGND VGND VPWR VPWR _0463_ sky130_fd_sc_hd__inv_2
X_1793_ clknet_leaf_17_clk _0206_ net103 VGND VGND VPWR VPWR u_jt49.periodC\[7\] sky130_fd_sc_hd__dfrtp_1
Xinput10 IOB_in[1] VGND VGND VPWR VPWR net10 sky130_fd_sc_hd__buf_1
X_1862_ clknet_leaf_22_clk net118 VGND VGND VPWR VPWR B[4] sky130_fd_sc_hd__dfxtp_2
X_1227_ u_jt49.u_ng.poly17\[6\] net174 net36 VGND VGND VPWR VPWR _0074_ sky130_fd_sc_hd__mux2_1
X_1158_ net130 _0752_ net45 VGND VGND VPWR VPWR _0046_ sky130_fd_sc_hd__mux2_1
XFILLER_52_233 VGND VPWR VPWR VGND sky130_ef_sc_hd__decap_12
X_1089_ u_jt49.eg_period\[9\] u_jt49.eg_period\[8\] u_jt49.eg_period\[11\] u_jt49.eg_period\[10\]
+ VGND VGND VPWR VPWR _0693_ sky130_fd_sc_hd__nor4_1
XFILLER_20_141 VGND VPWR VPWR VGND sky130_ef_sc_hd__decap_12
XFILLER_43_255 VGND VGND VPWR VPWR sky130_fd_sc_hd__decap_6
XFILLER_43_299 VGND VGND VPWR VPWR sky130_fd_sc_hd__decap_8
XFILLER_7_156 VGND VPWR VPWR VGND sky130_ef_sc_hd__decap_12
XFILLER_7_101 VGND VGND VPWR VPWR sky130_fd_sc_hd__decap_8
XFILLER_7_189 VGND VGND VPWR VPWR sky130_fd_sc_hd__decap_6
XPHY_EDGE_ROW_5_Left_71 VGND VGND VPWR VPWR sky130_fd_sc_hd__decap_3
X_1012_ u_jt49.u_env.rst_latch net45 VGND VGND VPWR VPWR _0630_ sky130_fd_sc_hd__and2_1
XFILLER_21_6 VGND VPWR VPWR VGND sky130_ef_sc_hd__decap_12
X_1776_ clknet_leaf_2_clk _0189_ net88 VGND VGND VPWR VPWR u_jt49.regarray\[6\]\[6\]
+ sky130_fd_sc_hd__dfrtp_1
X_1845_ clknet_leaf_23_clk _0258_ VGND VGND VPWR VPWR u_jt49.logB\[4\] sky130_fd_sc_hd__dfxtp_1
XFILLER_25_233 VGND VGND VPWR VPWR sky130_fd_sc_hd__decap_8
XFILLER_43_69 VGND VGND VPWR VPWR sky130_fd_sc_hd__decap_6
XFILLER_63_317 VGND VPWR VPWR VGND sky130_ef_sc_hd__decap_12
XPHY_EDGE_ROW_31_Left_97 VGND VGND VPWR VPWR sky130_fd_sc_hd__decap_3
XFILLER_0_365 VGND VPWR VPWR VGND sky130_ef_sc_hd__decap_12
XFILLER_56_380 VGND VGND VPWR VPWR sky130_fd_sc_hd__decap_6
XFILLER_16_244 VGND VGND VPWR VPWR sky130_fd_sc_hd__decap_8
X_1630_ clknet_leaf_21_clk _0047_ VGND VGND VPWR VPWR u_jt49.envelope\[1\] sky130_fd_sc_hd__dfxtp_1
X_1492_ net148 net59 _0416_ VGND VGND VPWR VPWR _0197_ sky130_fd_sc_hd__mux2_1
X_1561_ u_jt49.periodA\[6\] net59 _0430_ VGND VGND VPWR VPWR _0252_ sky130_fd_sc_hd__mux2_1
XFILLER_3_192 VGND VPWR VPWR VGND sky130_ef_sc_hd__decap_12
XFILLER_3_181 VGND VGND VPWR VPWR sky130_fd_sc_hd__decap_3
XFILLER_47_380 VGND VGND VPWR VPWR sky130_fd_sc_hd__decap_6
X_1759_ clknet_leaf_9_clk _0172_ net87 VGND VGND VPWR VPWR u_jt49.regarray\[8\]\[5\]
+ sky130_fd_sc_hd__dfrtp_1
X_1828_ clknet_leaf_23_clk _0241_ VGND VGND VPWR VPWR u_jt49.logA\[0\] sky130_fd_sc_hd__dfxtp_1
XFILLER_60_309 VGND VPWR VPWR VGND sky130_ef_sc_hd__decap_12
XFILLER_53_361 VGND VPWR VPWR VGND sky130_ef_sc_hd__decap_12
XFILLER_21_291 VGND VPWR VPWR VGND sky130_ef_sc_hd__decap_12
XFILLER_63_169 VGND VPWR VPWR VGND sky130_ef_sc_hd__decap_12
XFILLER_63_125 VGND VPWR VPWR VGND sky130_ef_sc_hd__decap_12
XFILLER_28_80 VGND VGND VPWR VPWR sky130_fd_sc_hd__decap_4
XFILLER_44_361 VGND VGND VPWR VPWR sky130_fd_sc_hd__decap_3
X_0992_ _0487_ u_jt49.u_ng.u_div.count\[4\] _0615_ _0616_ VGND VGND VPWR VPWR _0617_
+ sky130_fd_sc_hd__a22o_1
X_1613_ clknet_leaf_16_clk _0030_ net102 VGND VGND VPWR VPWR u_jt49.u_chC.count\[6\]
+ sky130_fd_sc_hd__dfrtp_1
XFILLER_5_51 VGND VGND VPWR VPWR sky130_fd_sc_hd__decap_4
X_1544_ u_jt49.Amix net20 VGND VGND VPWR VPWR _0425_ sky130_fd_sc_hd__and2_1
X_1475_ net57 IOB_oe _0414_ VGND VGND VPWR VPWR _0182_ sky130_fd_sc_hd__mux2_1
XFILLER_49_68 VGND VPWR VPWR VGND sky130_ef_sc_hd__decap_12
XFILLER_65_23 VGND VGND VPWR VPWR sky130_fd_sc_hd__decap_4
XFILLER_33_309 VGND VGND VPWR VPWR sky130_fd_sc_hd__decap_4
X_1191_ _0480_ _0771_ VGND VGND VPWR VPWR _0774_ sky130_fd_sc_hd__nand2_1
X_1260_ u_jt49.u_chB.count\[1\] u_jt49.periodB\[1\] VGND VGND VPWR VPWR _0294_ sky130_fd_sc_hd__and2b_1
Xinput8 IOA_in[7] VGND VGND VPWR VPWR net8 sky130_fd_sc_hd__dlymetal6s2s_1
XFILLER_17_361 VGND VPWR VPWR VGND sky130_ef_sc_hd__decap_12
XFILLER_24_309 VGND VGND VPWR VPWR sky130_fd_sc_hd__decap_3
X_0975_ u_jt49.u_cen.cencnt\[0\] u_jt49.u_cen.cencnt\[1\] _0504_ VGND VGND VPWR VPWR
+ _0610_ sky130_fd_sc_hd__or3_1
X_1527_ u_jt49.periodB\[3\] net65 _0421_ VGND VGND VPWR VPWR _0227_ sky130_fd_sc_hd__mux2_1
XFILLER_10_29 VGND VGND VPWR VPWR sky130_fd_sc_hd__decap_4
X_1458_ net41 _0525_ VGND VGND VPWR VPWR _0413_ sky130_fd_sc_hd__and2_2
XFILLER_27_136 VGND VPWR VPWR VGND sky130_ef_sc_hd__decap_12
X_1389_ _0370_ _0397_ _0398_ VGND VGND VPWR VPWR _0112_ sky130_fd_sc_hd__and3_1
XFILLER_27_169 VGND VPWR VPWR VGND sky130_ef_sc_hd__decap_12
XFILLER_65_209 VGND VGND VPWR VPWR sky130_fd_sc_hd__decap_3
XFILLER_33_106 VGND VGND VPWR VPWR sky130_fd_sc_hd__decap_6
XFILLER_18_125 VGND VPWR VPWR VGND sky130_ef_sc_hd__decap_12
XFILLER_14_353 VGND VGND VPWR VPWR sky130_fd_sc_hd__decap_8
XFILLER_56_209 VGND VGND VPWR VPWR sky130_fd_sc_hd__decap_3
X_1174_ net32 _0760_ _0761_ VGND VGND VPWR VPWR _0053_ sky130_fd_sc_hd__and3_1
X_1312_ u_jt49.periodB\[3\] u_jt49.periodB\[2\] u_jt49.periodB\[1\] u_jt49.periodB\[0\]
+ VGND VGND VPWR VPWR _0334_ sky130_fd_sc_hd__or4_1
XFILLER_2_85 VGND VGND VPWR VPWR sky130_fd_sc_hd__decap_8
XFILLER_2_41 VGND VGND VPWR VPWR sky130_fd_sc_hd__decap_8
X_1243_ net176 _0280_ net37 VGND VGND VPWR VPWR _0084_ sky130_fd_sc_hd__mux2_1
XFILLER_64_253 VGND VPWR VPWR VGND sky130_ef_sc_hd__decap_12
X_0889_ net50 net52 addr\[1\] addr\[0\] VGND VGND VPWR VPWR _0532_ sky130_fd_sc_hd__and4bb_2
X_0958_ u_jt49.regarray\[8\]\[6\] _0525_ _0532_ u_jt49.regarray\[3\]\[6\] _0594_ VGND
+ VGND VPWR VPWR _0595_ sky130_fd_sc_hd__a221o_1
XFILLER_7_349 VGND VPWR VPWR VGND sky130_ef_sc_hd__decap_12
XFILLER_61_267 VGND VPWR VPWR VGND sky130_ef_sc_hd__decap_12
XFILLER_46_253 VGND VPWR VPWR VGND sky130_ef_sc_hd__decap_12
Xinput22 din[1] VGND VGND VPWR VPWR net22 sky130_fd_sc_hd__clkbuf_1
X_0812_ u_jt49.u_chB.count\[4\] VGND VGND VPWR VPWR _0462_ sky130_fd_sc_hd__inv_2
X_1792_ clknet_leaf_17_clk _0205_ net103 VGND VGND VPWR VPWR u_jt49.periodC\[6\] sky130_fd_sc_hd__dfrtp_2
X_1861_ clknet_leaf_23_clk net117 VGND VGND VPWR VPWR B[3] sky130_fd_sc_hd__dfxtp_2
Xinput11 IOB_in[2] VGND VGND VPWR VPWR net11 sky130_fd_sc_hd__buf_1
X_1157_ u_jt49.u_env.gain\[0\] u_jt49.u_env.inv VGND VGND VPWR VPWR _0752_ sky130_fd_sc_hd__xor2_1
X_1226_ net181 u_jt49.u_ng.poly17\[6\] net36 VGND VGND VPWR VPWR _0073_ sky130_fd_sc_hd__mux2_1
XFILLER_52_245 VGND VGND VPWR VPWR sky130_fd_sc_hd__decap_3
X_1088_ _0690_ _0691_ VGND VGND VPWR VPWR _0692_ sky130_fd_sc_hd__nor2_1
XFILLER_20_153 VGND VGND VPWR VPWR sky130_fd_sc_hd__decap_4
XFILLER_20_197 VGND VGND VPWR VPWR sky130_fd_sc_hd__decap_4
XFILLER_57_57 VGND VPWR VPWR VGND sky130_ef_sc_hd__decap_12
X_1011_ net122 net104 net18 _0505_ VGND VGND VPWR VPWR _0022_ sky130_fd_sc_hd__nand4_1
XPHY_EDGE_ROW_53_Left_119 VGND VGND VPWR VPWR sky130_fd_sc_hd__decap_3
XFILLER_47_90 VGND VPWR VPWR VGND sky130_ef_sc_hd__decap_12
XPHY_EDGE_ROW_62_Left_128 VGND VGND VPWR VPWR sky130_fd_sc_hd__decap_3
X_1775_ clknet_leaf_2_clk _0188_ net82 VGND VGND VPWR VPWR u_jt49.regarray\[6\]\[5\]
+ sky130_fd_sc_hd__dfrtp_1
X_1844_ clknet_leaf_23_clk _0257_ VGND VGND VPWR VPWR u_jt49.logB\[3\] sky130_fd_sc_hd__dfxtp_1
X_1209_ u_jt49.u_envdiv.count\[12\] _0783_ VGND VGND VPWR VPWR _0786_ sky130_fd_sc_hd__and2_1
XFILLER_27_49 VGND VGND VPWR VPWR sky130_fd_sc_hd__decap_6
XFILLER_63_329 VGND VGND VPWR VPWR sky130_fd_sc_hd__decap_6
XFILLER_0_377 VGND VGND VPWR VPWR sky130_fd_sc_hd__decap_6
XFILLER_31_259 VGND VGND VPWR VPWR sky130_fd_sc_hd__decap_3
XFILLER_31_215 VGND VGND VPWR VPWR sky130_fd_sc_hd__decap_8
X_1560_ net222 net61 _0430_ VGND VGND VPWR VPWR _0251_ sky130_fd_sc_hd__mux2_1
XFILLER_39_337 VGND VPWR VPWR VGND sky130_ef_sc_hd__decap_12
X_1491_ net158 net62 _0416_ VGND VGND VPWR VPWR _0196_ sky130_fd_sc_hd__mux2_1
XFILLER_12_3 VGND VPWR VPWR VGND sky130_ef_sc_hd__decap_12
X_1827_ clknet_leaf_2_clk _0240_ net87 VGND VGND VPWR VPWR u_jt49.regarray\[1\]\[7\]
+ sky130_fd_sc_hd__dfrtp_1
XFILLER_13_18 VGND VGND VPWR VPWR sky130_fd_sc_hd__decap_8
X_1689_ clknet_leaf_0_clk _0104_ net78 VGND VGND VPWR VPWR u_jt49.u_chA.count\[3\]
+ sky130_fd_sc_hd__dfrtp_1
X_1758_ clknet_leaf_25_clk _0171_ net82 VGND VGND VPWR VPWR u_jt49.regarray\[8\]\[4\]
+ sky130_fd_sc_hd__dfrtp_4
XFILLER_57_178 VGND VGND VPWR VPWR sky130_fd_sc_hd__decap_4
XFILLER_38_15 VGND VGND VPWR VPWR sky130_fd_sc_hd__decap_4
XFILLER_53_373 VGND VPWR VPWR VGND sky130_ef_sc_hd__decap_12
XFILLER_48_123 VGND VGND VPWR VPWR sky130_fd_sc_hd__decap_3
XFILLER_0_141 VGND VPWR VPWR VGND sky130_ef_sc_hd__decap_12
XFILLER_63_137 VGND VPWR VPWR VGND sky130_ef_sc_hd__decap_12
XFILLER_48_189 VGND VGND VPWR VPWR sky130_fd_sc_hd__decap_6
X_0991_ _0487_ u_jt49.u_ng.u_div.count\[4\] u_jt49.u_ng.u_div.count\[3\] _0485_ VGND
+ VGND VPWR VPWR _0616_ sky130_fd_sc_hd__o22a_1
X_1474_ net60 IOA_oe _0414_ VGND VGND VPWR VPWR _0181_ sky130_fd_sc_hd__mux2_1
X_1612_ clknet_leaf_20_clk _0029_ net96 VGND VGND VPWR VPWR u_jt49.u_chC.count\[5\]
+ sky130_fd_sc_hd__dfrtp_2
X_1543_ u_jt49.regarray\[8\]\[3\] u_jt49.envelope\[0\] u_jt49.regarray\[8\]\[4\] VGND
+ VGND VPWR VPWR _0424_ sky130_fd_sc_hd__mux2_1
XFILLER_50_365 VGND VPWR VPWR VGND sky130_ef_sc_hd__decap_12
XFILLER_65_57 VGND VPWR VPWR VGND sky130_ef_sc_hd__decap_12
XFILLER_5_244 VGND VGND VPWR VPWR sky130_fd_sc_hd__decap_8
X_1190_ _0480_ _0771_ VGND VGND VPWR VPWR _0773_ sky130_fd_sc_hd__or2_1
Xinput9 IOB_in[0] VGND VGND VPWR VPWR net9 sky130_fd_sc_hd__clkbuf_1
XFILLER_44_181 VGND VPWR VPWR VGND sky130_ef_sc_hd__decap_12
XFILLER_32_365 VGND VPWR VPWR VGND sky130_ef_sc_hd__decap_12
XFILLER_32_321 VGND VPWR VPWR VGND sky130_ef_sc_hd__decap_12
XFILLER_17_373 VGND VPWR VPWR VGND sky130_ef_sc_hd__decap_12
X_0974_ net16 _0544_ _0545_ net8 _0609_ VGND VGND VPWR VPWR _0273_ sky130_fd_sc_hd__a221o_1
X_1457_ net58 IOA_out[7] _0412_ VGND VGND VPWR VPWR _0166_ sky130_fd_sc_hd__mux2_1
X_1526_ u_jt49.periodB\[2\] net67 _0421_ VGND VGND VPWR VPWR _0226_ sky130_fd_sc_hd__mux2_1
XFILLER_27_148 VGND VPWR VPWR VGND sky130_ef_sc_hd__decap_12
X_1388_ _0488_ _0396_ VGND VGND VPWR VPWR _0398_ sky130_fd_sc_hd__or2_1
XFILLER_2_247 VGND VGND VPWR VPWR sky130_fd_sc_hd__decap_4
XFILLER_14_365 VGND VPWR VPWR VGND sky130_ef_sc_hd__decap_12
XFILLER_18_137 VGND VGND VPWR VPWR sky130_fd_sc_hd__decap_3
X_1311_ _0454_ _0333_ _0308_ VGND VGND VPWR VPWR _0099_ sky130_fd_sc_hd__a21boi_1
XFILLER_64_265 VGND VPWR VPWR VGND sky130_ef_sc_hd__decap_12
XFILLER_64_221 VGND VPWR VPWR VGND sky130_ef_sc_hd__decap_12
X_1173_ u_jt49.u_env.cen u_jt49.u_envdiv.count\[0\] u_jt49.u_envdiv.count\[1\] VGND
+ VGND VPWR VPWR _0761_ sky130_fd_sc_hd__a21o_1
XFILLER_2_75 VGND VGND VPWR VPWR sky130_fd_sc_hd__decap_8
XPHY_EDGE_ROW_10_Right_10 VGND VGND VPWR VPWR sky130_fd_sc_hd__decap_3
X_1242_ u_jt49.u_ng.poly17\[0\] u_jt49.u_ng.poly17\[3\] _0279_ VGND VGND VPWR VPWR
+ _0280_ sky130_fd_sc_hd__a21oi_1
X_0957_ u_jt49.periodC\[6\] _0518_ _0531_ u_jt49.periodB\[6\] VGND VGND VPWR VPWR
+ _0594_ sky130_fd_sc_hd__a22o_1
X_0888_ net56 _0519_ net54 VGND VGND VPWR VPWR _0531_ sky130_fd_sc_hd__nor3b_4
XFILLER_21_18 VGND VPWR VPWR VGND sky130_ef_sc_hd__decap_12
X_1509_ net61 IOB_out[5] _0418_ VGND VGND VPWR VPWR _0212_ sky130_fd_sc_hd__mux2_1
XFILLER_46_15 VGND VPWR VPWR VGND sky130_ef_sc_hd__decap_12
XFILLER_55_221 VGND VGND VPWR VPWR sky130_fd_sc_hd__decap_3
XFILLER_11_95 VGND VPWR VPWR VGND sky130_ef_sc_hd__decap_12
XFILLER_46_265 VGND VGND VPWR VPWR sky130_fd_sc_hd__decap_6
XFILLER_46_232 VGND VGND VPWR VPWR sky130_fd_sc_hd__decap_4
X_1860_ clknet_leaf_23_clk net109 VGND VGND VPWR VPWR B[2] sky130_fd_sc_hd__dfxtp_2
Xclkbuf_leaf_26_clk clknet_2_0__leaf_clk VGND VGND VPWR VPWR clknet_leaf_26_clk sky130_fd_sc_hd__clkbuf_8
Xinput23 din[2] VGND VGND VPWR VPWR net23 sky130_fd_sc_hd__clkbuf_1
X_0811_ u_jt49.u_chB.count\[5\] VGND VGND VPWR VPWR _0461_ sky130_fd_sc_hd__inv_2
X_1791_ clknet_leaf_18_clk _0204_ net93 VGND VGND VPWR VPWR u_jt49.periodC\[5\] sky130_fd_sc_hd__dfrtp_1
Xinput12 IOB_in[3] VGND VGND VPWR VPWR net12 sky130_fd_sc_hd__buf_1
XFILLER_42_3 VGND VPWR VPWR VGND sky130_ef_sc_hd__decap_12
X_1156_ _0751_ net213 net32 VGND VGND VPWR VPWR _0045_ sky130_fd_sc_hd__mux2_1
X_1087_ u_jt49.eg_period\[1\] u_jt49.eg_period\[0\] u_jt49.eg_period\[3\] u_jt49.eg_period\[2\]
+ VGND VGND VPWR VPWR _0691_ sky130_fd_sc_hd__or4_1
Xclkbuf_leaf_17_clk clknet_2_3__leaf_clk VGND VGND VPWR VPWR clknet_leaf_17_clk sky130_fd_sc_hd__clkbuf_8
XFILLER_37_254 VGND VGND VPWR VPWR sky130_fd_sc_hd__decap_4
X_1225_ net169 u_jt49.u_ng.poly17\[5\] net36 VGND VGND VPWR VPWR _0072_ sky130_fd_sc_hd__mux2_1
XFILLER_16_29 VGND VPWR VPWR VGND sky130_ef_sc_hd__decap_12
XFILLER_57_69 VGND VPWR VPWR VGND sky130_ef_sc_hd__decap_12
XFILLER_28_232 VGND VGND VPWR VPWR sky130_fd_sc_hd__decap_4
X_1010_ net122 _0507_ _0629_ VGND VGND VPWR VPWR _0021_ sky130_fd_sc_hd__a21o_1
XFILLER_19_221 VGND VGND VPWR VPWR sky130_fd_sc_hd__decap_3
X_1843_ clknet_leaf_23_clk _0256_ VGND VGND VPWR VPWR u_jt49.logB\[2\] sky130_fd_sc_hd__dfxtp_1
Xclkbuf_leaf_6_clk clknet_2_1__leaf_clk VGND VGND VPWR VPWR clknet_leaf_6_clk sky130_fd_sc_hd__clkbuf_8
X_1774_ clknet_leaf_26_clk _0187_ net82 VGND VGND VPWR VPWR u_jt49.regarray\[6\]\[4\]
+ sky130_fd_sc_hd__dfrtp_1
X_1208_ net32 _0784_ _0785_ VGND VGND VPWR VPWR _0063_ sky130_fd_sc_hd__and3_1
X_1139_ _0732_ _0733_ _0734_ VGND VGND VPWR VPWR _0735_ sky130_fd_sc_hd__o21ai_1
X_1490_ net139 net63 _0416_ VGND VGND VPWR VPWR _0195_ sky130_fd_sc_hd__mux2_1
XFILLER_39_349 VGND VPWR VPWR VGND sky130_ef_sc_hd__decap_12
XFILLER_39_305 VGND VPWR VPWR VGND sky130_ef_sc_hd__decap_12
Xhold1 u_jt49.logB\[0\] VGND VGND VPWR VPWR net107 sky130_fd_sc_hd__dlygate4sd3_1
XPHY_EDGE_ROW_8_Right_8 VGND VGND VPWR VPWR sky130_fd_sc_hd__decap_3
XFILLER_22_249 VGND VGND VPWR VPWR sky130_fd_sc_hd__decap_3
X_1826_ clknet_leaf_10_clk _0239_ net98 VGND VGND VPWR VPWR u_jt49.regarray\[1\]\[6\]
+ sky130_fd_sc_hd__dfrtp_1
XFILLER_15_290 VGND VGND VPWR VPWR sky130_fd_sc_hd__decap_8
XPHY_EDGE_ROW_39_Right_39 VGND VGND VPWR VPWR sky130_fd_sc_hd__decap_3
X_1688_ clknet_leaf_0_clk _0103_ net78 VGND VGND VPWR VPWR u_jt49.u_chA.count\[2\]
+ sky130_fd_sc_hd__dfrtp_1
X_1757_ clknet_leaf_25_clk _0170_ net94 VGND VGND VPWR VPWR u_jt49.regarray\[8\]\[3\]
+ sky130_fd_sc_hd__dfrtp_1
XFILLER_54_15 VGND VGND VPWR VPWR sky130_fd_sc_hd__decap_4
XFILLER_53_330 VGND VGND VPWR VPWR sky130_fd_sc_hd__decap_6
XPHY_EDGE_ROW_48_Right_48 VGND VGND VPWR VPWR sky130_fd_sc_hd__decap_3
XPHY_EDGE_ROW_57_Right_57 VGND VGND VPWR VPWR sky130_fd_sc_hd__decap_3
XFILLER_48_135 VGND VGND VPWR VPWR sky130_fd_sc_hd__decap_4
XFILLER_0_131 VGND VGND VPWR VPWR sky130_fd_sc_hd__decap_8
XFILLER_0_153 VGND VPWR VPWR VGND sky130_ef_sc_hd__decap_12
XFILLER_0_197 VGND VPWR VPWR VGND sky130_ef_sc_hd__decap_12
XFILLER_63_149 VGND VPWR VPWR VGND sky130_ef_sc_hd__decap_12
XFILLER_63_105 VGND VGND VPWR VPWR sky130_fd_sc_hd__decap_6
X_1611_ clknet_leaf_20_clk _0028_ net96 VGND VGND VPWR VPWR u_jt49.u_chC.count\[4\]
+ sky130_fd_sc_hd__dfrtp_1
XFILLER_12_293 VGND VGND VPWR VPWR sky130_fd_sc_hd__decap_4
X_0990_ _0485_ u_jt49.u_ng.u_div.count\[3\] u_jt49.u_ng.u_div.count\[2\] _0486_ _0614_
+ VGND VGND VPWR VPWR _0615_ sky130_fd_sc_hd__a221o_1
X_1542_ net147 net57 _0423_ VGND VGND VPWR VPWR _0240_ sky130_fd_sc_hd__mux2_1
X_1473_ net62 net205 _0414_ VGND VGND VPWR VPWR _0180_ sky130_fd_sc_hd__mux2_1
XFILLER_39_113 VGND VGND VPWR VPWR sky130_fd_sc_hd__decap_4
XFILLER_50_377 VGND VGND VPWR VPWR sky130_fd_sc_hd__decap_4
XFILLER_10_219 VGND VGND VPWR VPWR sky130_fd_sc_hd__decap_4
X_1809_ clknet_leaf_9_clk _0222_ net87 VGND VGND VPWR VPWR u_jt49.regarray\[3\]\[7\]
+ sky130_fd_sc_hd__dfrtp_1
XFILLER_49_15 VGND VPWR VPWR VGND sky130_ef_sc_hd__decap_12
XFILLER_65_69 VGND VGND VPWR VPWR sky130_fd_sc_hd__decap_6
XFILLER_53_182 VGND VGND VPWR VPWR sky130_fd_sc_hd__decap_4
XFILLER_53_160 VGND VGND VPWR VPWR sky130_fd_sc_hd__decap_8
XFILLER_36_105 VGND VGND VPWR VPWR sky130_fd_sc_hd__decap_8
XFILLER_44_193 VGND VGND VPWR VPWR sky130_fd_sc_hd__decap_3
X_0973_ u_jt49.periodA\[7\] _0521_ _0542_ _0608_ u_jt49.read_mask\[5\] VGND VGND VPWR
+ VPWR _0609_ sky130_fd_sc_hd__o2111a_1
X_1456_ net60 IOA_out[6] _0412_ VGND VGND VPWR VPWR _0165_ sky130_fd_sc_hd__mux2_1
X_1525_ u_jt49.periodB\[1\] net69 _0421_ VGND VGND VPWR VPWR _0225_ sky130_fd_sc_hd__mux2_1
X_1387_ _0488_ _0396_ VGND VGND VPWR VPWR _0397_ sky130_fd_sc_hd__nand2_1
XFILLER_50_141 VGND VGND VPWR VPWR sky130_fd_sc_hd__decap_8
XFILLER_14_377 VGND VGND VPWR VPWR sky130_fd_sc_hd__decap_8
X_1310_ net31 _0332_ _0333_ VGND VGND VPWR VPWR _0098_ sky130_fd_sc_hd__and3_1
X_1241_ _0276_ _0277_ _0278_ _0502_ _0501_ VGND VGND VPWR VPWR _0279_ sky130_fd_sc_hd__o311a_1
XFILLER_64_277 VGND VPWR VPWR VGND sky130_ef_sc_hd__decap_12
XFILLER_64_233 VGND VPWR VPWR VGND sky130_ef_sc_hd__decap_12
X_1172_ _0759_ VGND VGND VPWR VPWR _0760_ sky130_fd_sc_hd__inv_2
X_0956_ u_jt49.regarray\[13\]\[6\] _0527_ _0528_ u_jt49.regarray\[5\]\[6\] _0592_
+ VGND VGND VPWR VPWR _0593_ sky130_fd_sc_hd__a221o_1
XFILLER_20_325 VGND VPWR VPWR VGND sky130_ef_sc_hd__decap_12
X_0887_ _0519_ net53 net55 VGND VGND VPWR VPWR _0530_ sky130_fd_sc_hd__nor3b_1
X_1508_ net63 IOB_out[4] _0418_ VGND VGND VPWR VPWR _0211_ sky130_fd_sc_hd__mux2_1
X_1439_ net163 net58 _0410_ VGND VGND VPWR VPWR _0150_ sky130_fd_sc_hd__mux2_1
XFILLER_62_15 VGND VPWR VPWR VGND sky130_ef_sc_hd__decap_12
XFILLER_15_119 VGND VGND VPWR VPWR sky130_fd_sc_hd__decap_8
XFILLER_2_3 VGND VPWR VPWR VGND sky130_ef_sc_hd__decap_12
X_0810_ u_jt49.u_chB.count\[6\] VGND VGND VPWR VPWR _0460_ sky130_fd_sc_hd__inv_2
X_1790_ clknet_leaf_18_clk _0203_ net93 VGND VGND VPWR VPWR u_jt49.periodC\[4\] sky130_fd_sc_hd__dfrtp_1
Xinput13 IOB_in[4] VGND VGND VPWR VPWR net13 sky130_fd_sc_hd__buf_1
Xinput24 din[3] VGND VGND VPWR VPWR net24 sky130_fd_sc_hd__buf_1
XFILLER_35_3 VGND VGND VPWR VPWR sky130_fd_sc_hd__decap_6
X_1224_ u_jt49.u_ng.poly17\[3\] net169 net36 VGND VGND VPWR VPWR _0071_ sky130_fd_sc_hd__mux2_1
X_1155_ _0692_ net39 net38 u_jt49.eg_step VGND VGND VPWR VPWR _0751_ sky130_fd_sc_hd__a31oi_1
X_1086_ u_jt49.eg_period\[5\] u_jt49.eg_period\[4\] u_jt49.eg_period\[7\] u_jt49.eg_period\[6\]
+ VGND VGND VPWR VPWR _0690_ sky130_fd_sc_hd__or4_1
X_0939_ u_jt49.regarray\[8\]\[4\] _0525_ _0531_ u_jt49.periodB\[4\] _0573_ VGND VGND
+ VPWR VPWR _0578_ sky130_fd_sc_hd__a221o_1
XFILLER_57_15 VGND VPWR VPWR VGND sky130_ef_sc_hd__decap_12
XFILLER_43_225 VGND VPWR VPWR VGND sky130_ef_sc_hd__decap_12
Xclkbuf_2_2__f_clk clknet_0_clk VGND VGND VPWR VPWR clknet_2_2__leaf_clk sky130_fd_sc_hd__clkbuf_16
XFILLER_19_277 VGND VGND VPWR VPWR sky130_fd_sc_hd__decap_3
XFILLER_42_291 VGND VGND VPWR VPWR sky130_fd_sc_hd__decap_6
X_1842_ clknet_leaf_23_clk _0255_ VGND VGND VPWR VPWR u_jt49.logB\[1\] sky130_fd_sc_hd__dfxtp_1
X_1773_ clknet_leaf_26_clk _0186_ net83 VGND VGND VPWR VPWR u_jt49.regarray\[6\]\[3\]
+ sky130_fd_sc_hd__dfrtp_1
X_1207_ u_jt49.u_envdiv.count\[10\] u_jt49.u_envdiv.count\[9\] net34 u_jt49.u_envdiv.count\[11\]
+ VGND VGND VPWR VPWR _0785_ sky130_fd_sc_hd__a31o_1
X_1138_ u_jt49.eg_period\[7\] _0479_ _0480_ u_jt49.eg_period\[6\] VGND VGND VPWR VPWR
+ _0734_ sky130_fd_sc_hd__o22a_1
XFILLER_40_217 VGND VGND VPWR VPWR sky130_fd_sc_hd__decap_4
X_1069_ _0469_ _0675_ VGND VGND VPWR VPWR _0679_ sky130_fd_sc_hd__nand2_1
XFILLER_56_350 VGND VPWR VPWR VGND sky130_ef_sc_hd__decap_12
XPHY_EDGE_ROW_9_Left_75 VGND VGND VPWR VPWR sky130_fd_sc_hd__decap_3
XFILLER_17_40 VGND VGND VPWR VPWR sky130_fd_sc_hd__decap_6
XFILLER_54_309 VGND VPWR VPWR VGND sky130_ef_sc_hd__decap_12
XFILLER_47_361 VGND VGND VPWR VPWR sky130_fd_sc_hd__decap_8
Xhold2 u_jt49.logC\[2\] VGND VGND VPWR VPWR net108 sky130_fd_sc_hd__dlygate4sd3_1
XFILLER_30_261 VGND VGND VPWR VPWR sky130_fd_sc_hd__decap_3
X_1825_ clknet_leaf_25_clk _0238_ net92 VGND VGND VPWR VPWR u_jt49.regarray\[1\]\[5\]
+ sky130_fd_sc_hd__dfrtp_1
X_1756_ clknet_leaf_24_clk _0169_ net94 VGND VGND VPWR VPWR u_jt49.regarray\[8\]\[2\]
+ sky130_fd_sc_hd__dfrtp_1
X_1687_ clknet_leaf_0_clk _0102_ net78 VGND VGND VPWR VPWR u_jt49.u_chA.count\[1\]
+ sky130_fd_sc_hd__dfrtp_1
XFILLER_21_250 VGND VGND VPWR VPWR sky130_fd_sc_hd__decap_8
XFILLER_0_165 VGND VGND VPWR VPWR sky130_fd_sc_hd__decap_3
X_1610_ clknet_leaf_20_clk _0027_ net96 VGND VGND VPWR VPWR u_jt49.u_chC.count\[3\]
+ sky130_fd_sc_hd__dfrtp_1
X_1541_ net140 net59 _0423_ VGND VGND VPWR VPWR _0239_ sky130_fd_sc_hd__mux2_1
X_1472_ net63 net196 _0414_ VGND VGND VPWR VPWR _0179_ sky130_fd_sc_hd__mux2_1
XPHY_EDGE_ROW_59_Left_125 VGND VGND VPWR VPWR sky130_fd_sc_hd__decap_3
XFILLER_39_169 VGND VPWR VPWR VGND sky130_ef_sc_hd__decap_12
XFILLER_49_27 VGND VPWR VPWR VGND sky130_ef_sc_hd__decap_12
X_1808_ clknet_leaf_8_clk _0221_ net90 VGND VGND VPWR VPWR u_jt49.regarray\[3\]\[6\]
+ sky130_fd_sc_hd__dfrtp_1
XFILLER_40_29 VGND VGND VPWR VPWR sky130_fd_sc_hd__decap_3
X_1739_ clknet_leaf_24_clk _0152_ net94 VGND VGND VPWR VPWR u_jt49.regarray\[9\]\[1\]
+ sky130_fd_sc_hd__dfrtp_1
XFILLER_18_309 VGND VGND VPWR VPWR sky130_fd_sc_hd__decap_8
XFILLER_60_109 VGND VPWR VPWR VGND sky130_ef_sc_hd__decap_12
XFILLER_5_202 VGND VGND VPWR VPWR sky130_fd_sc_hd__decap_6
XFILLER_55_81 VGND VPWR VPWR VGND sky130_ef_sc_hd__decap_12
XFILLER_44_161 VGND VGND VPWR VPWR sky130_fd_sc_hd__decap_6
X_0972_ _0603_ _0604_ _0607_ VGND VGND VPWR VPWR _0608_ sky130_fd_sc_hd__or3_1
XFILLER_65_3 VGND VGND VPWR VPWR sky130_fd_sc_hd__decap_4
X_1524_ net223 net71 _0421_ VGND VGND VPWR VPWR _0224_ sky130_fd_sc_hd__mux2_1
X_1455_ net61 IOA_out[5] _0412_ VGND VGND VPWR VPWR _0164_ sky130_fd_sc_hd__mux2_1
X_1386_ _0370_ _0395_ _0396_ VGND VGND VPWR VPWR _0111_ sky130_fd_sc_hd__and3_1
XFILLER_35_18 VGND VPWR VPWR VGND sky130_ef_sc_hd__decap_12
XFILLER_41_153 VGND VGND VPWR VPWR sky130_fd_sc_hd__decap_3
X_1171_ u_jt49.u_env.cen u_jt49.u_envdiv.count\[1\] u_jt49.u_envdiv.count\[0\] VGND
+ VGND VPWR VPWR _0759_ sky130_fd_sc_hd__and3_1
X_1240_ u_jt49.u_ng.poly17\[1\] u_jt49.u_ng.poly17\[2\] u_jt49.u_ng.poly17\[5\] u_jt49.u_ng.poly17\[4\]
+ VGND VGND VPWR VPWR _0278_ sky130_fd_sc_hd__or4_1
XPHY_EDGE_ROW_22_Left_88 VGND VGND VPWR VPWR sky130_fd_sc_hd__decap_3
XFILLER_64_289 VGND VPWR VPWR VGND sky130_ef_sc_hd__decap_12
XFILLER_64_245 VGND VGND VPWR VPWR sky130_fd_sc_hd__decap_6
X_0886_ addr\[1\] addr\[0\] net50 net52 VGND VGND VPWR VPWR _0529_ sky130_fd_sc_hd__and4bb_4
X_0955_ IOA_oe _0522_ _0526_ u_jt49.regarray\[6\]\[6\] VGND VGND VPWR VPWR _0592_
+ sky130_fd_sc_hd__a22o_1
XFILLER_20_337 VGND VPWR VPWR VGND sky130_ef_sc_hd__decap_12
X_1507_ net65 IOB_out[3] _0418_ VGND VGND VPWR VPWR _0210_ sky130_fd_sc_hd__mux2_1
X_1438_ net157 net60 _0410_ VGND VGND VPWR VPWR _0149_ sky130_fd_sc_hd__mux2_1
X_1369_ _0368_ _0383_ _0384_ net217 net43 VGND VGND VPWR VPWR _0106_ sky130_fd_sc_hd__a32o_1
XFILLER_11_337 VGND VPWR VPWR VGND sky130_ef_sc_hd__decap_12
XFILLER_23_142 VGND VGND VPWR VPWR sky130_fd_sc_hd__decap_4
XFILLER_46_289 VGND VPWR VPWR VGND sky130_ef_sc_hd__decap_12
XFILLER_36_72 VGND VPWR VPWR VGND sky130_ef_sc_hd__decap_12
Xinput25 din[4] VGND VGND VPWR VPWR net25 sky130_fd_sc_hd__buf_1
XFILLER_14_197 VGND VPWR VPWR VGND sky130_ef_sc_hd__decap_12
Xinput14 IOB_in[5] VGND VGND VPWR VPWR net14 sky130_fd_sc_hd__buf_1
X_1154_ _0720_ _0749_ net45 VGND VGND VPWR VPWR _0750_ sky130_fd_sc_hd__a21bo_1
X_1223_ net193 u_jt49.u_ng.poly17\[3\] net36 VGND VGND VPWR VPWR _0070_ sky130_fd_sc_hd__mux2_1
X_1085_ u_jt49.u_env.rst_latch _0443_ net126 VGND VGND VPWR VPWR _0036_ sky130_fd_sc_hd__a21o_1
X_0869_ _0510_ _0017_ VGND VGND VPWR VPWR _0514_ sky130_fd_sc_hd__nand2_1
X_0938_ u_jt49.eg_period\[4\] _0524_ _0533_ u_jt49.regarray\[9\]\[4\] _0574_ VGND
+ VGND VPWR VPWR _0577_ sky130_fd_sc_hd__a221o_1
XFILLER_57_27 VGND VPWR VPWR VGND sky130_ef_sc_hd__decap_12
XFILLER_43_237 VGND VPWR VPWR VGND sky130_ef_sc_hd__decap_12
XFILLER_43_204 VGND VGND VPWR VPWR sky130_fd_sc_hd__decap_4
XFILLER_51_281 VGND VPWR VPWR VGND sky130_ef_sc_hd__decap_12
XFILLER_22_41 VGND VGND VPWR VPWR sky130_fd_sc_hd__decap_6
XFILLER_22_85 VGND VGND VPWR VPWR sky130_fd_sc_hd__decap_3
XFILLER_63_81 VGND VPWR VPWR VGND sky130_ef_sc_hd__decap_12
XFILLER_42_270 VGND VPWR VPWR VGND sky130_ef_sc_hd__decap_12
X_1841_ clknet_leaf_23_clk _0254_ VGND VGND VPWR VPWR u_jt49.logB\[0\] sky130_fd_sc_hd__dfxtp_1
XFILLER_8_65 VGND VGND VPWR VPWR sky130_fd_sc_hd__decap_4
X_1772_ clknet_leaf_26_clk _0185_ net80 VGND VGND VPWR VPWR u_jt49.regarray\[6\]\[2\]
+ sky130_fd_sc_hd__dfrtp_1
XFILLER_65_351 VGND VPWR VPWR VGND sky130_ef_sc_hd__decap_12
X_1206_ _0783_ VGND VGND VPWR VPWR _0784_ sky130_fd_sc_hd__inv_2
X_1137_ u_jt49.eg_period\[6\] _0480_ _0481_ u_jt49.eg_period\[5\] VGND VGND VPWR VPWR
+ _0733_ sky130_fd_sc_hd__a22o_1
XPHY_EDGE_ROW_40_Left_106 VGND VGND VPWR VPWR sky130_fd_sc_hd__decap_3
XPHY_EDGE_ROW_25_Left_91 VGND VGND VPWR VPWR sky130_fd_sc_hd__decap_3
XFILLER_43_18 VGND VPWR VPWR VGND sky130_ef_sc_hd__decap_12
XFILLER_33_281 VGND VGND VPWR VPWR sky130_fd_sc_hd__decap_4
X_1068_ _0677_ VGND VGND VPWR VPWR _0678_ sky130_fd_sc_hd__inv_2
XFILLER_48_329 VGND VPWR VPWR VGND sky130_ef_sc_hd__decap_12
XFILLER_62_321 VGND VPWR VPWR VGND sky130_ef_sc_hd__decap_12
Xhold3 u_jt49.logB\[2\] VGND VGND VPWR VPWR net109 sky130_fd_sc_hd__dlygate4sd3_1
XFILLER_62_365 VGND VPWR VPWR VGND sky130_ef_sc_hd__decap_12
X_1755_ clknet_leaf_26_clk _0168_ net80 VGND VGND VPWR VPWR u_jt49.regarray\[8\]\[1\]
+ sky130_fd_sc_hd__dfrtp_1
X_1824_ clknet_leaf_25_clk _0237_ net82 VGND VGND VPWR VPWR u_jt49.regarray\[1\]\[4\]
+ sky130_fd_sc_hd__dfrtp_1
X_1686_ clknet_leaf_0_clk _0101_ net78 VGND VGND VPWR VPWR u_jt49.u_chA.count\[0\]
+ sky130_fd_sc_hd__dfstp_1
XFILLER_65_181 VGND VPWR VPWR VGND sky130_ef_sc_hd__decap_12
XFILLER_48_115 VGND VGND VPWR VPWR sky130_fd_sc_hd__decap_8
X_1540_ net141 net62 _0423_ VGND VGND VPWR VPWR _0238_ sky130_fd_sc_hd__mux2_1
XFILLER_8_266 VGND VPWR VPWR VGND sky130_ef_sc_hd__decap_12
XFILLER_10_3 VGND VPWR VPWR VGND sky130_ef_sc_hd__decap_12
X_1471_ net65 net197 _0414_ VGND VGND VPWR VPWR _0178_ sky130_fd_sc_hd__mux2_1
X_1807_ clknet_leaf_8_clk _0220_ net88 VGND VGND VPWR VPWR u_jt49.regarray\[3\]\[5\]
+ sky130_fd_sc_hd__dfrtp_1
XFILLER_49_39 VGND VPWR VPWR VGND sky130_ef_sc_hd__decap_12
X_1669_ clknet_leaf_26_clk _0086_ net80 VGND VGND VPWR VPWR u_jt49.u_ng.noise_en sky130_fd_sc_hd__dfrtp_1
X_1738_ clknet_leaf_24_clk _0151_ net94 VGND VGND VPWR VPWR u_jt49.regarray\[9\]\[0\]
+ sky130_fd_sc_hd__dfrtp_1
XFILLER_45_107 VGND VGND VPWR VPWR sky130_fd_sc_hd__decap_4
XFILLER_41_357 VGND VPWR VPWR VGND sky130_ef_sc_hd__decap_12
XFILLER_26_365 VGND VPWR VPWR VGND sky130_ef_sc_hd__decap_12
XFILLER_30_41 VGND VPWR VPWR VGND sky130_ef_sc_hd__decap_12
XFILLER_30_85 VGND VPWR VPWR VGND sky130_ef_sc_hd__decap_12
X_0971_ u_jt49.regarray\[5\]\[7\] _0528_ _0605_ _0606_ VGND VGND VPWR VPWR _0607_
+ sky130_fd_sc_hd__a211o_1
XFILLER_58_3 VGND VGND VPWR VPWR sky130_fd_sc_hd__decap_6
X_1454_ net64 IOA_out[4] _0412_ VGND VGND VPWR VPWR _0163_ sky130_fd_sc_hd__mux2_1
X_1523_ net42 _0531_ VGND VGND VPWR VPWR _0421_ sky130_fd_sc_hd__and2_2
X_1385_ u_jt49.u_chA.count\[10\] u_jt49.u_chA.count\[9\] _0391_ VGND VGND VPWR VPWR
+ _0396_ sky130_fd_sc_hd__nand3_1
XFILLER_51_18 VGND VPWR VPWR VGND sky130_ef_sc_hd__decap_12
XFILLER_35_162 VGND VGND VPWR VPWR sky130_fd_sc_hd__decap_6
XFILLER_2_217 VGND VGND VPWR VPWR sky130_fd_sc_hd__decap_6
XFILLER_41_84 VGND VGND VPWR VPWR sky130_fd_sc_hd__decap_6
XFILLER_41_51 VGND VGND VPWR VPWR sky130_fd_sc_hd__decap_4
X_1170_ net225 u_jt49.u_envdiv.count\[0\] _0758_ VGND VGND VPWR VPWR _0052_ sky130_fd_sc_hd__o21ba_1
XFILLER_49_276 VGND VGND VPWR VPWR sky130_fd_sc_hd__decap_4
Xclkbuf_leaf_29_clk clknet_2_0__leaf_clk VGND VGND VPWR VPWR clknet_leaf_29_clk sky130_fd_sc_hd__clkbuf_8
X_0885_ net49 net53 net55 net51 VGND VGND VPWR VPWR _0528_ sky130_fd_sc_hd__and4bb_4
X_0954_ _0521_ _0542_ VGND VGND VPWR VPWR _0591_ sky130_fd_sc_hd__nand2_1
XFILLER_9_361 VGND VPWR VPWR VGND sky130_ef_sc_hd__decap_12
XFILLER_20_349 VGND VPWR VPWR VGND sky130_ef_sc_hd__decap_12
X_1506_ net67 IOB_out[2] _0418_ VGND VGND VPWR VPWR _0209_ sky130_fd_sc_hd__mux2_1
X_1437_ net160 net62 _0410_ VGND VGND VPWR VPWR _0148_ sky130_fd_sc_hd__mux2_1
X_1299_ _0459_ _0322_ VGND VGND VPWR VPWR _0326_ sky130_fd_sc_hd__nand2_1
XFILLER_46_29 VGND VPWR VPWR VGND sky130_ef_sc_hd__decap_12
X_1368_ net46 u_jt49.u_chA.count\[5\] _0379_ VGND VGND VPWR VPWR _0384_ sky130_fd_sc_hd__a21o_1
XFILLER_11_349 VGND VPWR VPWR VGND sky130_ef_sc_hd__decap_12
XFILLER_61_205 VGND VGND VPWR VPWR sky130_fd_sc_hd__decap_8
XFILLER_36_51 VGND VPWR VPWR VGND sky130_ef_sc_hd__decap_12
Xinput26 din[5] VGND VGND VPWR VPWR net26 sky130_fd_sc_hd__clkbuf_1
Xinput15 IOB_in[6] VGND VGND VPWR VPWR net15 sky130_fd_sc_hd__buf_1
X_1153_ _0746_ _0748_ _0741_ VGND VGND VPWR VPWR _0749_ sky130_fd_sc_hd__a21oi_1
X_1084_ _0662_ _0688_ _0689_ VGND VGND VPWR VPWR _0035_ sky130_fd_sc_hd__and3_1
X_1222_ net179 u_jt49.u_ng.poly17\[2\] net36 VGND VGND VPWR VPWR _0069_ sky130_fd_sc_hd__mux2_1
X_0868_ net89 _0513_ VGND VGND VPWR VPWR _0017_ sky130_fd_sc_hd__and2_1
X_0799_ u_jt49.eg_period\[13\] VGND VGND VPWR VPWR _0449_ sky130_fd_sc_hd__inv_2
Xclkbuf_leaf_9_clk clknet_2_1__leaf_clk VGND VGND VPWR VPWR clknet_leaf_9_clk sky130_fd_sc_hd__clkbuf_8
X_0937_ u_jt49.regarray\[10\]\[4\] _0523_ _0529_ u_jt49.eg_period\[12\] _0575_ VGND
+ VGND VPWR VPWR _0576_ sky130_fd_sc_hd__a221o_1
XFILLER_57_39 VGND VPWR VPWR VGND sky130_ef_sc_hd__decap_12
XFILLER_51_293 VGND VPWR VPWR VGND sky130_ef_sc_hd__decap_12
XFILLER_3_345 VGND VPWR VPWR VGND sky130_ef_sc_hd__decap_12
XFILLER_19_213 VGND VGND VPWR VPWR sky130_fd_sc_hd__decap_8
XFILLER_63_93 VGND VPWR VPWR VGND sky130_ef_sc_hd__decap_12
X_1840_ clknet_leaf_3_clk _0253_ net85 VGND VGND VPWR VPWR u_jt49.periodA\[7\] sky130_fd_sc_hd__dfrtp_1
XFILLER_27_290 VGND VGND VPWR VPWR sky130_fd_sc_hd__decap_8
X_1771_ clknet_leaf_26_clk _0184_ net81 VGND VGND VPWR VPWR u_jt49.regarray\[6\]\[1\]
+ sky130_fd_sc_hd__dfrtp_1
X_1205_ u_jt49.u_envdiv.count\[11\] u_jt49.u_envdiv.count\[10\] u_jt49.u_envdiv.count\[9\]
+ net34 VGND VGND VPWR VPWR _0783_ sky130_fd_sc_hd__and4_1
X_1136_ u_jt49.eg_period\[5\] _0481_ _0482_ u_jt49.eg_period\[4\] VGND VGND VPWR VPWR
+ _0732_ sky130_fd_sc_hd__o22a_1
X_1067_ u_jt49.u_chC.count\[7\] u_jt49.u_chC.count\[6\] _0673_ VGND VGND VPWR VPWR
+ _0677_ sky130_fd_sc_hd__and3_1
XFILLER_0_326 VGND VGND VPWR VPWR sky130_fd_sc_hd__decap_8
XFILLER_0_337 VGND VPWR VPWR VGND sky130_ef_sc_hd__decap_12
XFILLER_17_97 VGND VPWR VPWR VGND sky130_ef_sc_hd__decap_12
Xhold4 u_jt49.logC\[1\] VGND VGND VPWR VPWR net110 sky130_fd_sc_hd__dlygate4sd3_1
XFILLER_62_333 VGND VPWR VPWR VGND sky130_ef_sc_hd__decap_12
XFILLER_62_377 VGND VGND VPWR VPWR sky130_fd_sc_hd__decap_8
X_1823_ clknet_leaf_1_clk _0236_ net81 VGND VGND VPWR VPWR u_jt49.periodA\[11\] sky130_fd_sc_hd__dfrtp_1
X_1685_ clknet_leaf_3_clk _0100_ net87 VGND VGND VPWR VPWR u_jt49.bitB sky130_fd_sc_hd__dfrtp_1
X_1754_ clknet_leaf_26_clk _0167_ net80 VGND VGND VPWR VPWR u_jt49.regarray\[8\]\[0\]
+ sky130_fd_sc_hd__dfrtp_1
XFILLER_57_105 VGND VGND VPWR VPWR sky130_fd_sc_hd__decap_6
XFILLER_65_193 VGND VGND VPWR VPWR sky130_fd_sc_hd__decap_3
XFILLER_54_29 VGND VPWR VPWR VGND sky130_ef_sc_hd__decap_12
X_1119_ _0451_ u_jt49.u_envdiv.count\[14\] u_jt49.u_envdiv.count\[13\] _0449_ VGND
+ VGND VPWR VPWR _0715_ sky130_fd_sc_hd__o22a_1
XPHY_EDGE_ROW_17_Right_17 VGND VGND VPWR VPWR sky130_fd_sc_hd__decap_3
XPHY_EDGE_ROW_26_Right_26 VGND VGND VPWR VPWR sky130_fd_sc_hd__decap_3
XFILLER_56_182 VGND VGND VPWR VPWR sky130_fd_sc_hd__decap_4
XFILLER_29_330 VGND VGND VPWR VPWR sky130_fd_sc_hd__decap_6
XPHY_EDGE_ROW_35_Right_35 VGND VGND VPWR VPWR sky130_fd_sc_hd__decap_3
XFILLER_8_278 VGND VGND VPWR VPWR sky130_fd_sc_hd__decap_4
XFILLER_8_289 VGND VGND VPWR VPWR sky130_fd_sc_hd__decap_4
X_1470_ net68 net199 _0414_ VGND VGND VPWR VPWR _0177_ sky130_fd_sc_hd__mux2_1
XPHY_EDGE_ROW_44_Right_44 VGND VGND VPWR VPWR sky130_fd_sc_hd__decap_3
XFILLER_62_141 VGND VPWR VPWR VGND sky130_ef_sc_hd__decap_12
XPHY_EDGE_ROW_53_Right_53 VGND VGND VPWR VPWR sky130_fd_sc_hd__decap_3
XFILLER_50_314 VGND VPWR VPWR VGND sky130_ef_sc_hd__decap_12
XFILLER_47_193 VGND VGND VPWR VPWR sky130_fd_sc_hd__decap_3
X_1806_ clknet_leaf_8_clk _0219_ net90 VGND VGND VPWR VPWR u_jt49.regarray\[3\]\[4\]
+ sky130_fd_sc_hd__dfrtp_1
XPHY_EDGE_ROW_62_Right_62 VGND VGND VPWR VPWR sky130_fd_sc_hd__decap_3
X_1737_ clknet_leaf_17_clk _0150_ net99 VGND VGND VPWR VPWR u_jt49.regarray\[10\]\[7\]
+ sky130_fd_sc_hd__dfrtp_1
X_1599_ clknet_leaf_26_clk _0016_ net80 VGND VGND VPWR VPWR u_jt49.u_ng.u_div.count\[4\]
+ sky130_fd_sc_hd__dfrtp_1
X_1668_ clknet_leaf_1_clk _0085_ VGND VGND VPWR VPWR u_jt49.noise sky130_fd_sc_hd__dfxtp_1
XFILLER_26_322 VGND VPWR VPWR VGND sky130_ef_sc_hd__decap_12
XFILLER_41_369 VGND VPWR VPWR VGND sky130_ef_sc_hd__decap_12
XFILLER_30_97 VGND VGND VPWR VPWR sky130_fd_sc_hd__decap_3
XFILLER_30_53 VGND VGND VPWR VPWR sky130_fd_sc_hd__decap_4
X_0970_ IOB_oe _0522_ _0532_ u_jt49.regarray\[3\]\[7\] _0591_ VGND VGND VPWR VPWR
+ _0606_ sky130_fd_sc_hd__a221o_1
X_1453_ net66 IOA_out[3] _0412_ VGND VGND VPWR VPWR _0162_ sky130_fd_sc_hd__mux2_1
X_1522_ net123 net73 _0420_ VGND VGND VPWR VPWR _0223_ sky130_fd_sc_hd__a21o_1
X_1384_ u_jt49.u_chA.count\[9\] _0391_ u_jt49.u_chA.count\[10\] VGND VGND VPWR VPWR
+ _0395_ sky130_fd_sc_hd__a21o_1
XFILLER_35_152 VGND VGND VPWR VPWR sky130_fd_sc_hd__decap_3
XFILLER_49_266 VGND VGND VPWR VPWR sky130_fd_sc_hd__decap_3
X_0884_ net53 net55 net49 net51 VGND VGND VPWR VPWR _0527_ sky130_fd_sc_hd__and4b_4
XFILLER_9_373 VGND VPWR VPWR VGND sky130_ef_sc_hd__decap_12
X_0953_ net14 _0544_ _0545_ net6 _0590_ VGND VGND VPWR VPWR _0271_ sky130_fd_sc_hd__a221o_1
X_1505_ net69 IOB_out[1] _0418_ VGND VGND VPWR VPWR _0208_ sky130_fd_sc_hd__mux2_1
X_1367_ _0382_ VGND VGND VPWR VPWR _0383_ sky130_fd_sc_hd__inv_2
X_1436_ u_jt49.regarray\[10\]\[4\] net64 _0410_ VGND VGND VPWR VPWR _0147_ sky130_fd_sc_hd__mux2_1
X_1298_ _0324_ VGND VGND VPWR VPWR _0325_ sky130_fd_sc_hd__inv_2
XFILLER_62_29 VGND VPWR VPWR VGND sky130_ef_sc_hd__decap_12
XFILLER_23_199 VGND VGND VPWR VPWR sky130_fd_sc_hd__decap_3
XFILLER_36_63 VGND VGND VPWR VPWR sky130_fd_sc_hd__decap_4
Xinput27 din[6] VGND VGND VPWR VPWR net27 sky130_fd_sc_hd__clkbuf_1
Xinput16 IOB_in[7] VGND VGND VPWR VPWR net16 sky130_fd_sc_hd__clkbuf_1
XFILLER_6_321 VGND VPWR VPWR VGND sky130_ef_sc_hd__decap_12
XFILLER_6_365 VGND VPWR VPWR VGND sky130_ef_sc_hd__decap_12
X_1221_ net187 net179 net37 VGND VGND VPWR VPWR _0068_ sky130_fd_sc_hd__mux2_1
X_1152_ _0722_ _0727_ _0730_ _0747_ VGND VGND VPWR VPWR _0748_ sky130_fd_sc_hd__and4bb_1
XFILLER_52_206 VGND VGND VPWR VPWR sky130_fd_sc_hd__decap_8
X_1083_ u_jt49.u_chC.count\[11\] _0686_ VGND VGND VPWR VPWR _0689_ sky130_fd_sc_hd__nand2_1
X_0936_ u_jt49.regarray\[5\]\[4\] _0528_ _0532_ u_jt49.regarray\[3\]\[4\] VGND VGND
+ VPWR VPWR _0575_ sky130_fd_sc_hd__a22o_1
XFILLER_20_136 VGND VGND VPWR VPWR sky130_fd_sc_hd__decap_4
X_0867_ net21 addr\[0\] _0507_ VGND VGND VPWR VPWR _0513_ sky130_fd_sc_hd__mux2_1
X_0798_ u_jt49.eg_period\[2\] VGND VGND VPWR VPWR _0448_ sky130_fd_sc_hd__inv_2
X_1419_ u_jt49.eg_period\[13\] net61 _0408_ VGND VGND VPWR VPWR _0132_ sky130_fd_sc_hd__mux2_1
Xwire40 _0518_ VGND VGND VPWR VPWR net40 sky130_fd_sc_hd__clkbuf_2
XFILLER_11_169 VGND VGND VPWR VPWR sky130_fd_sc_hd__decap_6
XFILLER_3_357 VGND VPWR VPWR VGND sky130_ef_sc_hd__decap_12
XFILLER_34_239 VGND VGND VPWR VPWR sky130_fd_sc_hd__decap_4
XFILLER_19_225 VGND VGND VPWR VPWR sky130_fd_sc_hd__decap_3
X_1770_ clknet_leaf_26_clk _0183_ net81 VGND VGND VPWR VPWR u_jt49.regarray\[6\]\[0\]
+ sky130_fd_sc_hd__dfrtp_1
X_1204_ net32 _0782_ VGND VGND VPWR VPWR _0062_ sky130_fd_sc_hd__and2_1
XFILLER_33_3 VGND VGND VPWR VPWR sky130_fd_sc_hd__decap_4
X_1135_ _0727_ _0729_ _0730_ _0726_ _0725_ VGND VGND VPWR VPWR _0731_ sky130_fd_sc_hd__o32a_1
X_1066_ _0662_ _0675_ _0676_ VGND VGND VPWR VPWR _0030_ sky130_fd_sc_hd__and3_1
XFILLER_18_280 VGND VGND VPWR VPWR sky130_fd_sc_hd__decap_8
X_0919_ u_jt49.regarray\[8\]\[2\] _0525_ _0533_ u_jt49.regarray\[9\]\[2\] _0559_ VGND
+ VGND VPWR VPWR _0560_ sky130_fd_sc_hd__a221o_1
XFILLER_0_305 VGND VGND VPWR VPWR sky130_fd_sc_hd__decap_3
XFILLER_0_349 VGND VPWR VPWR VGND sky130_ef_sc_hd__decap_12
Xhold5 u_jt49.logA\[4\] VGND VGND VPWR VPWR net111 sky130_fd_sc_hd__dlygate4sd3_1
XFILLER_62_345 VGND VPWR VPWR VGND sky130_ef_sc_hd__decap_12
XFILLER_62_301 VGND VGND VPWR VPWR sky130_fd_sc_hd__decap_6
X_1753_ clknet_leaf_14_clk _0166_ net105 VGND VGND VPWR VPWR IOA_out[7] sky130_fd_sc_hd__dfrtp_4
X_1822_ clknet_leaf_1_clk _0235_ net81 VGND VGND VPWR VPWR u_jt49.periodA\[10\] sky130_fd_sc_hd__dfrtp_1
X_1684_ clknet_leaf_7_clk _0099_ net89 VGND VGND VPWR VPWR u_jt49.u_chB.count\[11\]
+ sky130_fd_sc_hd__dfrtp_1
X_1118_ u_jt49.eg_period\[15\] _0474_ u_jt49.u_envdiv.count\[14\] _0451_ VGND VGND
+ VPWR VPWR _0714_ sky130_fd_sc_hd__a2bb2o_1
X_1049_ sample u_jt49.u_chC.count\[0\] u_jt49.u_chC.count\[1\] VGND VGND VPWR VPWR
+ _0665_ sky130_fd_sc_hd__a21o_1
XFILLER_28_53 VGND VGND VPWR VPWR sky130_fd_sc_hd__decap_4
XFILLER_12_253 VGND VGND VPWR VPWR sky130_fd_sc_hd__decap_8
XFILLER_54_109 VGND VGND VPWR VPWR sky130_fd_sc_hd__decap_4
XFILLER_62_197 VGND VPWR VPWR VGND sky130_ef_sc_hd__decap_12
XFILLER_62_153 VGND VPWR VPWR VGND sky130_ef_sc_hd__decap_12
XFILLER_50_326 VGND VPWR VPWR VGND sky130_ef_sc_hd__decap_12
X_1805_ clknet_leaf_8_clk _0218_ net90 VGND VGND VPWR VPWR u_jt49.periodB\[11\] sky130_fd_sc_hd__dfrtp_1
X_1736_ clknet_leaf_10_clk _0149_ net98 VGND VGND VPWR VPWR u_jt49.regarray\[10\]\[6\]
+ sky130_fd_sc_hd__dfrtp_1
XPHY_EDGE_ROW_37_Left_103 VGND VGND VPWR VPWR sky130_fd_sc_hd__decap_3
X_1667_ clknet_leaf_29_clk _0084_ net77 VGND VGND VPWR VPWR u_jt49.u_ng.poly17\[16\]
+ sky130_fd_sc_hd__dfrtp_1
X_1598_ clknet_leaf_26_clk _0015_ net80 VGND VGND VPWR VPWR u_jt49.u_ng.u_div.count\[3\]
+ sky130_fd_sc_hd__dfrtp_1
XFILLER_65_29 VGND VPWR VPWR VGND sky130_ef_sc_hd__decap_12
XFILLER_38_183 VGND VPWR VPWR VGND sky130_ef_sc_hd__decap_12
XFILLER_38_161 VGND VGND VPWR VPWR sky130_fd_sc_hd__decap_4
XFILLER_26_334 VGND VPWR VPWR VGND sky130_ef_sc_hd__decap_12
XPHY_EDGE_ROW_46_Left_112 VGND VGND VPWR VPWR sky130_fd_sc_hd__decap_3
XPHY_EDGE_ROW_55_Left_121 VGND VGND VPWR VPWR sky130_fd_sc_hd__decap_3
XFILLER_39_30 VGND VGND VPWR VPWR sky130_fd_sc_hd__decap_8
XPHY_EDGE_ROW_64_Left_130 VGND VGND VPWR VPWR sky130_fd_sc_hd__decap_3
X_1452_ net68 IOA_out[2] _0412_ VGND VGND VPWR VPWR _0161_ sky130_fd_sc_hd__mux2_1
X_1383_ _0368_ _0393_ _0394_ u_jt49.u_chA.count\[9\] net43 VGND VGND VPWR VPWR _0110_
+ sky130_fd_sc_hd__a32o_1
X_1521_ u_jt49.bitA u_jt49.regarray\[7\]\[0\] u_jt49.regarray\[7\]\[3\] u_jt49.noise
+ net20 VGND VGND VPWR VPWR _0420_ sky130_fd_sc_hd__o221a_1
XFILLER_50_101 VGND VGND VPWR VPWR sky130_fd_sc_hd__decap_8
XFILLER_35_197 VGND VPWR VPWR VGND sky130_ef_sc_hd__decap_12
X_1719_ clknet_leaf_8_clk _0132_ net100 VGND VGND VPWR VPWR u_jt49.eg_period\[13\]
+ sky130_fd_sc_hd__dfrtp_2
XFILLER_26_186 VGND VGND VPWR VPWR sky130_fd_sc_hd__decap_8
X_0952_ u_jt49.periodA\[5\] _0521_ _0542_ _0589_ u_jt49.read_mask\[5\] VGND VGND VPWR
+ VPWR _0590_ sky130_fd_sc_hd__o2111a_1
XFILLER_63_3 VGND VPWR VPWR VGND sky130_ef_sc_hd__decap_12
X_0883_ net49 net55 net53 net51 VGND VGND VPWR VPWR _0526_ sky130_fd_sc_hd__and4bb_2
X_1504_ net71 IOB_out[0] _0418_ VGND VGND VPWR VPWR _0207_ sky130_fd_sc_hd__mux2_1
X_1366_ u_jt49.u_chA.count\[5\] u_jt49.u_chA.count\[4\] _0376_ VGND VGND VPWR VPWR
+ _0382_ sky130_fd_sc_hd__and3_1
X_1435_ u_jt49.regarray\[10\]\[3\] net66 _0410_ VGND VGND VPWR VPWR _0146_ sky130_fd_sc_hd__mux2_1
XFILLER_63_281 VGND VPWR VPWR VGND sky130_ef_sc_hd__decap_12
X_1297_ u_jt49.u_chB.count\[7\] u_jt49.u_chB.count\[6\] _0319_ VGND VGND VPWR VPWR
+ _0324_ sky130_fd_sc_hd__and3_1
XFILLER_52_85 VGND VGND VPWR VPWR sky130_fd_sc_hd__decap_4
XFILLER_52_41 VGND VPWR VPWR VGND sky130_ef_sc_hd__decap_12
Xinput28 din[7] VGND VGND VPWR VPWR net28 sky130_fd_sc_hd__clkbuf_1
Xinput17 bc1 VGND VGND VPWR VPWR net17 sky130_fd_sc_hd__dlymetal6s2s_1
XFILLER_6_333 VGND VPWR VPWR VGND sky130_ef_sc_hd__decap_12
XFILLER_6_377 VGND VGND VPWR VPWR sky130_fd_sc_hd__decap_8
XFILLER_10_351 VGND VPWR VPWR VGND sky130_ef_sc_hd__decap_12
X_1151_ u_jt49.eg_period\[8\] _0478_ _0729_ VGND VGND VPWR VPWR _0747_ sky130_fd_sc_hd__a21oi_1
X_1220_ u_jt49.u_ng.last_en u_jt49.u_ng.noise_en net47 VGND VGND VPWR VPWR _0274_
+ sky130_fd_sc_hd__and3b_1
X_1082_ u_jt49.u_chC.count\[11\] _0686_ VGND VGND VPWR VPWR _0688_ sky130_fd_sc_hd__or2_1
X_0866_ net89 _0508_ _0511_ VGND VGND VPWR VPWR _0512_ sky130_fd_sc_hd__and3_1
X_0935_ u_jt49.regarray\[7\]\[4\] _0522_ net35 u_jt49.regarray\[1\]\[4\] VGND VGND
+ VPWR VPWR _0574_ sky130_fd_sc_hd__a22o_1
X_0797_ u_jt49.eg_period\[3\] VGND VGND VPWR VPWR _0447_ sky130_fd_sc_hd__inv_2
X_1418_ u_jt49.eg_period\[12\] net64 _0408_ VGND VGND VPWR VPWR _0131_ sky130_fd_sc_hd__mux2_1
XFILLER_3_90 VGND VGND VPWR VPWR sky130_fd_sc_hd__decap_8
X_1349_ _0368_ _0369_ _0338_ VGND VGND VPWR VPWR _0101_ sky130_fd_sc_hd__a21oi_1
XFILLER_11_137 VGND VGND VPWR VPWR sky130_fd_sc_hd__decap_3
XFILLER_47_30 VGND VPWR VPWR VGND sky130_ef_sc_hd__decap_12
XFILLER_3_369 VGND VPWR VPWR VGND sky130_ef_sc_hd__decap_12
XFILLER_63_51 VGND VGND VPWR VPWR sky130_fd_sc_hd__decap_4
XFILLER_42_262 VGND VGND VPWR VPWR sky130_fd_sc_hd__decap_4
XFILLER_6_174 VGND VGND VPWR VPWR sky130_fd_sc_hd__decap_4
XFILLER_6_141 VGND VPWR VPWR VGND sky130_ef_sc_hd__decap_12
XFILLER_65_365 VGND VPWR VPWR VGND sky130_ef_sc_hd__decap_12
X_1203_ u_jt49.u_envdiv.count\[10\] _0780_ VGND VGND VPWR VPWR _0782_ sky130_fd_sc_hd__xnor2_1
X_1134_ u_jt49.eg_period\[9\] _0477_ _0478_ u_jt49.eg_period\[8\] VGND VGND VPWR VPWR
+ _0730_ sky130_fd_sc_hd__o22a_1
XFILLER_26_3 VGND VPWR VPWR VGND sky130_ef_sc_hd__decap_12
X_1065_ u_jt49.u_chC.count\[5\] _0670_ u_jt49.u_chC.count\[6\] VGND VGND VPWR VPWR
+ _0676_ sky130_fd_sc_hd__a21o_1
X_0849_ u_jt49.bitB VGND VGND VPWR VPWR _0499_ sky130_fd_sc_hd__inv_2
X_0918_ u_jt49.regarray\[7\]\[2\] _0522_ _0529_ u_jt49.eg_period\[10\] VGND VGND VPWR
+ VPWR _0559_ sky130_fd_sc_hd__a22o_1
XFILLER_59_181 VGND VPWR VPWR VGND sky130_ef_sc_hd__decap_12
Xhold6 u_jt49.logC\[0\] VGND VGND VPWR VPWR net112 sky130_fd_sc_hd__dlygate4sd3_1
XFILLER_62_357 VGND VGND VPWR VPWR sky130_fd_sc_hd__decap_6
X_1683_ clknet_leaf_7_clk _0098_ net89 VGND VGND VPWR VPWR u_jt49.u_chB.count\[10\]
+ sky130_fd_sc_hd__dfrtp_1
X_1752_ clknet_leaf_14_clk _0165_ net105 VGND VGND VPWR VPWR IOA_out[6] sky130_fd_sc_hd__dfrtp_4
Xclkbuf_leaf_10_clk clknet_2_3__leaf_clk VGND VGND VPWR VPWR clknet_leaf_10_clk sky130_fd_sc_hd__clkbuf_8
XPHY_EDGE_ROW_29_Left_95 VGND VGND VPWR VPWR sky130_fd_sc_hd__decap_3
X_1821_ clknet_leaf_1_clk _0234_ net81 VGND VGND VPWR VPWR u_jt49.periodA\[9\] sky130_fd_sc_hd__dfrtp_1
XPHY_EDGE_ROW_13_Left_79 VGND VGND VPWR VPWR sky130_fd_sc_hd__decap_3
XFILLER_38_365 VGND VPWR VPWR VGND sky130_ef_sc_hd__decap_12
X_1117_ _0696_ _0700_ _0704_ _0713_ net203 VGND VGND VPWR VPWR _0044_ sky130_fd_sc_hd__a32o_1
XPHY_EDGE_ROW_3_Right_3 VGND VGND VPWR VPWR sky130_fd_sc_hd__decap_3
X_1048_ _0663_ VGND VGND VPWR VPWR _0664_ sky130_fd_sc_hd__inv_2
XFILLER_0_169 VGND VPWR VPWR VGND sky130_ef_sc_hd__decap_12
XFILLER_60_85 VGND VPWR VPWR VGND sky130_ef_sc_hd__decap_12
XFILLER_60_41 VGND VPWR VPWR VGND sky130_ef_sc_hd__decap_12
XFILLER_62_121 VGND VPWR VPWR VGND sky130_ef_sc_hd__decap_12
XFILLER_35_324 VGND VPWR VPWR VGND sky130_ef_sc_hd__decap_12
XFILLER_62_165 VGND VPWR VPWR VGND sky130_ef_sc_hd__decap_12
XFILLER_50_338 VGND VPWR VPWR VGND sky130_ef_sc_hd__decap_12
X_1804_ clknet_leaf_8_clk _0217_ net89 VGND VGND VPWR VPWR u_jt49.periodB\[10\] sky130_fd_sc_hd__dfrtp_2
X_1735_ clknet_leaf_18_clk _0148_ net93 VGND VGND VPWR VPWR u_jt49.regarray\[10\]\[5\]
+ sky130_fd_sc_hd__dfrtp_1
X_1666_ clknet_leaf_28_clk net177 net77 VGND VGND VPWR VPWR u_jt49.u_ng.poly17\[15\]
+ sky130_fd_sc_hd__dfrtp_1
X_1597_ clknet_leaf_27_clk _0014_ net80 VGND VGND VPWR VPWR u_jt49.u_ng.u_div.count\[2\]
+ sky130_fd_sc_hd__dfrtp_1
XFILLER_26_346 VGND VGND VPWR VPWR sky130_fd_sc_hd__decap_6
XFILLER_55_30 VGND VPWR VPWR VGND sky130_ef_sc_hd__decap_12
XFILLER_29_140 VGND VGND VPWR VPWR sky130_fd_sc_hd__decap_6
X_1520_ net156 net57 _0419_ VGND VGND VPWR VPWR _0222_ sky130_fd_sc_hd__mux2_1
X_1451_ net70 IOA_out[1] _0412_ VGND VGND VPWR VPWR _0160_ sky130_fd_sc_hd__mux2_1
XFILLER_4_261 VGND VGND VPWR VPWR sky130_fd_sc_hd__decap_8
X_1382_ net46 u_jt49.u_chA.count\[9\] _0391_ VGND VGND VPWR VPWR _0394_ sky130_fd_sc_hd__a21o_1
X_1649_ clknet_leaf_12_clk _0066_ net100 VGND VGND VPWR VPWR u_jt49.u_envdiv.count\[14\]
+ sky130_fd_sc_hd__dfrtp_1
X_1718_ clknet_leaf_8_clk _0131_ net90 VGND VGND VPWR VPWR u_jt49.eg_period\[12\]
+ sky130_fd_sc_hd__dfrtp_2
XPHY_EDGE_ROW_16_Left_82 VGND VGND VPWR VPWR sky130_fd_sc_hd__decap_3
XFILLER_26_165 VGND VGND VPWR VPWR sky130_fd_sc_hd__decap_6
XFILLER_14_305 VGND VGND VPWR VPWR sky130_fd_sc_hd__decap_3
XFILLER_49_246 VGND VPWR VPWR VGND sky130_ef_sc_hd__decap_12
XFILLER_2_15 VGND VPWR VPWR VGND sky130_ef_sc_hd__decap_12
XFILLER_1_242 VGND VGND VPWR VPWR sky130_fd_sc_hd__decap_3
X_0882_ net51 _0517_ net49 VGND VGND VPWR VPWR _0525_ sky130_fd_sc_hd__nor3b_4
X_0951_ _0585_ _0586_ _0588_ VGND VGND VPWR VPWR _0589_ sky130_fd_sc_hd__or3_1
X_1503_ net41 _0544_ VGND VGND VPWR VPWR _0418_ sky130_fd_sc_hd__nand2_4
XFILLER_55_238 VGND VGND VPWR VPWR sky130_fd_sc_hd__decap_4
X_1296_ net31 _0322_ _0323_ VGND VGND VPWR VPWR _0094_ sky130_fd_sc_hd__and3_1
X_1365_ _0370_ _0380_ _0381_ VGND VGND VPWR VPWR _0105_ sky130_fd_sc_hd__and3_1
X_1434_ u_jt49.regarray\[10\]\[2\] net68 _0410_ VGND VGND VPWR VPWR _0145_ sky130_fd_sc_hd__mux2_1
XFILLER_63_293 VGND VPWR VPWR VGND sky130_ef_sc_hd__decap_12
XPHY_EDGE_ROW_1_Left_67 VGND VGND VPWR VPWR sky130_fd_sc_hd__decap_3
Xinput18 bc2 VGND VGND VPWR VPWR net18 sky130_fd_sc_hd__clkbuf_2
XFILLER_54_282 VGND VGND VPWR VPWR sky130_fd_sc_hd__decap_3
XFILLER_52_53 VGND VGND VPWR VPWR sky130_fd_sc_hd__decap_6
XFILLER_14_124 VGND VGND VPWR VPWR sky130_fd_sc_hd__decap_4
Xinput29 rst_n VGND VGND VPWR VPWR net29 sky130_fd_sc_hd__clkbuf_1
XFILLER_6_345 VGND VPWR VPWR VGND sky130_ef_sc_hd__decap_12
X_1150_ _0734_ _0744_ _0745_ _0735_ _0740_ VGND VGND VPWR VPWR _0746_ sky130_fd_sc_hd__a32o_1
XFILLER_60_230 VGND VPWR VPWR VGND sky130_ef_sc_hd__decap_12
X_1081_ _0662_ _0685_ _0687_ VGND VGND VPWR VPWR _0034_ sky130_fd_sc_hd__and3_1
X_0865_ net89 _0511_ VGND VGND VPWR VPWR _0018_ sky130_fd_sc_hd__and2_1
X_0934_ u_jt49.periodC\[4\] net40 _0526_ u_jt49.regarray\[6\]\[4\] VGND VGND VPWR
+ VPWR _0573_ sky130_fd_sc_hd__a22o_1
XFILLER_9_161 VGND VGND VPWR VPWR sky130_fd_sc_hd__decap_6
X_1417_ u_jt49.eg_period\[11\] net65 _0408_ VGND VGND VPWR VPWR _0130_ sky130_fd_sc_hd__mux2_1
X_0796_ u_jt49.eg_period\[0\] VGND VGND VPWR VPWR _0446_ sky130_fd_sc_hd__inv_2
X_1279_ u_jt49.u_chB.count\[2\] u_jt49.u_chB.count\[1\] u_jt49.u_chB.count\[0\] net47
+ VGND VGND VPWR VPWR _0311_ sky130_fd_sc_hd__and4_1
X_1348_ net43 _0496_ VGND VGND VPWR VPWR _0369_ sky130_fd_sc_hd__nor2_1
XFILLER_7_109 VGND VGND VPWR VPWR sky130_fd_sc_hd__decap_3
XFILLER_6_153 VGND VGND VPWR VPWR sky130_fd_sc_hd__decap_4
XFILLER_65_377 VGND VGND VPWR VPWR sky130_fd_sc_hd__decap_3
X_1202_ net33 _0780_ _0781_ VGND VGND VPWR VPWR _0061_ sky130_fd_sc_hd__and3_1
X_1133_ _0723_ _0724_ _0726_ _0728_ VGND VGND VPWR VPWR _0729_ sky130_fd_sc_hd__or4_1
X_1064_ u_jt49.u_chC.count\[6\] u_jt49.u_chC.count\[5\] _0670_ VGND VGND VPWR VPWR
+ _0675_ sky130_fd_sc_hd__nand3_1
XFILLER_19_3 VGND VPWR VPWR VGND sky130_ef_sc_hd__decap_12
X_0917_ u_jt49.regarray\[13\]\[2\] _0527_ _0532_ u_jt49.periodB\[10\] _0556_ VGND
+ VGND VPWR VPWR _0558_ sky130_fd_sc_hd__a221o_1
X_0848_ u_jt49.bitC VGND VGND VPWR VPWR _0498_ sky130_fd_sc_hd__inv_2
XFILLER_59_193 VGND VPWR VPWR VGND sky130_ef_sc_hd__decap_12
XFILLER_58_85 VGND VPWR VPWR VGND sky130_ef_sc_hd__decap_12
XFILLER_58_41 VGND VPWR VPWR VGND sky130_ef_sc_hd__decap_12
Xhold7 u_jt49.logC\[3\] VGND VGND VPWR VPWR net113 sky130_fd_sc_hd__dlygate4sd3_1
XPHY_EDGE_ROW_4_Left_70 VGND VGND VPWR VPWR sky130_fd_sc_hd__decap_3
X_1820_ clknet_leaf_1_clk _0233_ net81 VGND VGND VPWR VPWR u_jt49.periodA\[8\] sky130_fd_sc_hd__dfrtp_1
X_1682_ clknet_leaf_6_clk _0097_ net86 VGND VGND VPWR VPWR u_jt49.u_chB.count\[9\]
+ sky130_fd_sc_hd__dfrtp_1
X_1751_ clknet_leaf_15_clk _0164_ net104 VGND VGND VPWR VPWR IOA_out[5] sky130_fd_sc_hd__dfrtp_4
XFILLER_65_141 VGND VGND VPWR VPWR sky130_fd_sc_hd__decap_3
XFILLER_38_333 VGND VPWR VPWR VGND sky130_ef_sc_hd__decap_12
XFILLER_0_81 VGND VGND VPWR VPWR sky130_fd_sc_hd__decap_3
X_1116_ _0699_ _0696_ VGND VGND VPWR VPWR _0713_ sky130_fd_sc_hd__nand2b_1
X_1047_ sample u_jt49.u_chC.count\[1\] u_jt49.u_chC.count\[0\] VGND VGND VPWR VPWR
+ _0663_ sky130_fd_sc_hd__and3_1
XFILLER_21_233 VGND VGND VPWR VPWR sky130_fd_sc_hd__decap_3
XFILLER_56_141 VGND VGND VPWR VPWR sky130_fd_sc_hd__decap_8
XFILLER_60_97 VGND VPWR VPWR VGND sky130_ef_sc_hd__decap_12
XFILLER_60_53 VGND VPWR VPWR VGND sky130_ef_sc_hd__decap_12
XPHY_EDGE_ROW_30_Left_96 VGND VGND VPWR VPWR sky130_fd_sc_hd__decap_3
XFILLER_62_133 VGND VGND VPWR VPWR sky130_fd_sc_hd__decap_6
XPHY_EDGE_ROW_13_Right_13 VGND VGND VPWR VPWR sky130_fd_sc_hd__decap_3
XFILLER_62_177 VGND VPWR VPWR VGND sky130_ef_sc_hd__decap_12
X_1803_ clknet_leaf_7_clk _0216_ net89 VGND VGND VPWR VPWR u_jt49.periodB\[9\] sky130_fd_sc_hd__dfrtp_1
XPHY_EDGE_ROW_22_Right_22 VGND VGND VPWR VPWR sky130_fd_sc_hd__decap_3
XFILLER_7_292 VGND VGND VPWR VPWR sky130_fd_sc_hd__decap_4
X_1665_ clknet_leaf_28_clk net189 net77 VGND VGND VPWR VPWR u_jt49.u_ng.poly17\[14\]
+ sky130_fd_sc_hd__dfrtp_1
X_1596_ clknet_leaf_28_clk _0013_ net80 VGND VGND VPWR VPWR u_jt49.u_ng.u_div.count\[1\]
+ sky130_fd_sc_hd__dfrtp_1
X_1734_ clknet_leaf_24_clk _0147_ net93 VGND VGND VPWR VPWR u_jt49.regarray\[10\]\[4\]
+ sky130_fd_sc_hd__dfrtp_4
XPHY_EDGE_ROW_31_Right_31 VGND VGND VPWR VPWR sky130_fd_sc_hd__decap_3
XFILLER_26_358 VGND VGND VPWR VPWR sky130_fd_sc_hd__decap_6
XPHY_EDGE_ROW_40_Right_40 VGND VGND VPWR VPWR sky130_fd_sc_hd__decap_3
XFILLER_55_42 VGND VPWR VPWR VGND sky130_ef_sc_hd__decap_12
X_1450_ net72 IOA_out[0] _0412_ VGND VGND VPWR VPWR _0159_ sky130_fd_sc_hd__mux2_1
X_1381_ _0489_ _0490_ _0388_ VGND VGND VPWR VPWR _0393_ sky130_fd_sc_hd__or3_1
XFILLER_23_306 VGND VGND VPWR VPWR sky130_fd_sc_hd__decap_8
X_1648_ clknet_leaf_12_clk _0065_ net100 VGND VGND VPWR VPWR u_jt49.u_envdiv.count\[13\]
+ sky130_fd_sc_hd__dfrtp_2
X_1717_ clknet_leaf_8_clk _0130_ net90 VGND VGND VPWR VPWR u_jt49.eg_period\[11\]
+ sky130_fd_sc_hd__dfrtp_2
X_1579_ net74 net110 _0438_ _0439_ VGND VGND VPWR VPWR _0261_ sky130_fd_sc_hd__a22o_1
XFILLER_14_317 VGND VPWR VPWR VGND sky130_ef_sc_hd__decap_12
XFILLER_49_258 VGND VGND VPWR VPWR sky130_fd_sc_hd__decap_4
XFILLER_49_214 VGND VGND VPWR VPWR sky130_fd_sc_hd__decap_8
XFILLER_2_49 VGND VGND VPWR VPWR sky130_fd_sc_hd__decap_3
XFILLER_1_221 VGND VGND VPWR VPWR sky130_fd_sc_hd__decap_3
X_0950_ u_jt49.periodB\[5\] _0531_ _0532_ u_jt49.regarray\[3\]\[5\] _0587_ VGND VGND
+ VPWR VPWR _0588_ sky130_fd_sc_hd__a221o_1
X_0881_ net52 net54 net56 net50 VGND VGND VPWR VPWR _0524_ sky130_fd_sc_hd__and4b_4
XFILLER_13_361 VGND VPWR VPWR VGND sky130_ef_sc_hd__decap_12
XFILLER_49_3 VGND VPWR VPWR VGND sky130_ef_sc_hd__decap_12
X_1502_ u_jt49.periodC\[7\] net58 _0417_ VGND VGND VPWR VPWR _0206_ sky130_fd_sc_hd__mux2_1
X_1433_ u_jt49.regarray\[10\]\[1\] net70 _0410_ VGND VGND VPWR VPWR _0144_ sky130_fd_sc_hd__mux2_1
X_1295_ u_jt49.u_chB.count\[6\] _0319_ VGND VGND VPWR VPWR _0323_ sky130_fd_sc_hd__or2_1
X_1364_ net46 _0376_ u_jt49.u_chA.count\[4\] VGND VGND VPWR VPWR _0381_ sky130_fd_sc_hd__a21o_1
XFILLER_63_261 VGND VPWR VPWR VGND sky130_ef_sc_hd__decap_12
XFILLER_23_169 VGND VGND VPWR VPWR sky130_fd_sc_hd__decap_6
XFILLER_14_136 VGND VGND VPWR VPWR sky130_fd_sc_hd__decap_4
Xinput19 bdir VGND VGND VPWR VPWR net19 sky130_fd_sc_hd__buf_1
XFILLER_6_357 VGND VGND VPWR VPWR sky130_fd_sc_hd__decap_6
X_1080_ _0686_ VGND VGND VPWR VPWR _0687_ sky130_fd_sc_hd__inv_2
XFILLER_60_242 VGND VGND VPWR VPWR sky130_fd_sc_hd__decap_8
XFILLER_60_253 VGND VPWR VPWR VGND sky130_ef_sc_hd__decap_12
XFILLER_45_250 VGND VPWR VPWR VGND sky130_ef_sc_hd__decap_12
X_0864_ net90 _0508_ VGND VGND VPWR VPWR _0019_ sky130_fd_sc_hd__and2_1
X_0795_ u_jt49.eg_period\[1\] VGND VGND VPWR VPWR _0445_ sky130_fd_sc_hd__inv_2
X_0933_ net12 _0544_ _0545_ net4 _0572_ VGND VGND VPWR VPWR _0269_ sky130_fd_sc_hd__a221o_1
XFILLER_9_195 VGND VGND VPWR VPWR sky130_fd_sc_hd__decap_4
X_1416_ u_jt49.eg_period\[10\] net67 _0408_ VGND VGND VPWR VPWR _0129_ sky130_fd_sc_hd__mux2_1
X_1347_ _0364_ _0367_ VGND VGND VPWR VPWR _0368_ sky130_fd_sc_hd__and2_1
XFILLER_51_220 VGND VGND VPWR VPWR sky130_fd_sc_hd__decap_4
X_1278_ net31 _0309_ _0310_ VGND VGND VPWR VPWR _0089_ sky130_fd_sc_hd__and3_1
XFILLER_28_206 VGND VGND VPWR VPWR sky130_fd_sc_hd__decap_4
XFILLER_3_327 VGND VGND VPWR VPWR sky130_fd_sc_hd__decap_8
XFILLER_22_79 VGND VGND VPWR VPWR sky130_fd_sc_hd__decap_4
XFILLER_59_331 VGND VGND VPWR VPWR sky130_fd_sc_hd__decap_4
XFILLER_42_253 VGND VGND VPWR VPWR sky130_fd_sc_hd__decap_6
XFILLER_8_15 VGND VPWR VPWR VGND sky130_ef_sc_hd__decap_12
XFILLER_10_150 VGND VPWR VPWR VGND sky130_ef_sc_hd__decap_12
X_1201_ u_jt49.u_envdiv.count\[9\] net34 VGND VGND VPWR VPWR _0781_ sky130_fd_sc_hd__or2_1
XFILLER_65_345 VGND VGND VPWR VPWR sky130_fd_sc_hd__decap_3
X_1132_ u_jt49.u_envdiv.count\[10\] u_jt49.eg_period\[10\] VGND VGND VPWR VPWR _0728_
+ sky130_fd_sc_hd__and2b_1
X_1063_ net44 u_jt49.u_chC.count\[5\] _0660_ _0674_ VGND VGND VPWR VPWR _0029_ sky130_fd_sc_hd__a22o_1
X_0916_ u_jt49.regarray\[10\]\[2\] _0523_ _0531_ u_jt49.periodB\[2\] _0555_ VGND VGND
+ VPWR VPWR _0557_ sky130_fd_sc_hd__a221o_1
X_0847_ u_jt49.u_env.inv VGND VGND VPWR VPWR _0497_ sky130_fd_sc_hd__inv_2
XFILLER_58_53 VGND VPWR VPWR VGND sky130_ef_sc_hd__decap_12
XFILLER_3_135 VGND VGND VPWR VPWR sky130_fd_sc_hd__decap_8
XFILLER_3_113 VGND VPWR VPWR VGND sky130_ef_sc_hd__decap_12
XFILLER_58_97 VGND VPWR VPWR VGND sky130_ef_sc_hd__decap_12
Xhold8 u_jt49.logB\[1\] VGND VGND VPWR VPWR net114 sky130_fd_sc_hd__dlygate4sd3_1
X_1750_ clknet_leaf_15_clk _0163_ net102 VGND VGND VPWR VPWR IOA_out[4] sky130_fd_sc_hd__dfrtp_4
XFILLER_30_278 VGND VPWR VPWR VGND sky130_ef_sc_hd__decap_12
X_1681_ clknet_leaf_5_clk _0096_ net86 VGND VGND VPWR VPWR u_jt49.u_chB.count\[8\]
+ sky130_fd_sc_hd__dfrtp_1
XFILLER_38_345 VGND VPWR VPWR VGND sky130_ef_sc_hd__decap_12
XFILLER_31_3 VGND VGND VPWR VPWR sky130_fd_sc_hd__decap_8
XFILLER_65_197 VGND VPWR VPWR VGND sky130_ef_sc_hd__decap_12
XFILLER_61_381 VGND VGND VPWR VPWR sky130_fd_sc_hd__decap_3
XFILLER_53_337 VGND VPWR VPWR VGND sky130_ef_sc_hd__decap_12
X_1046_ net44 _0660_ VGND VGND VPWR VPWR _0662_ sky130_fd_sc_hd__or2_2
X_1115_ u_jt49.u_env.gain\[3\] u_jt49.u_env.gain\[2\] _0709_ _0712_ VGND VGND VPWR
+ VPWR _0043_ sky130_fd_sc_hd__o31ai_1
XFILLER_56_197 VGND VPWR VPWR VGND sky130_ef_sc_hd__decap_12
XFILLER_8_216 VGND VGND VPWR VPWR sky130_fd_sc_hd__decap_6
XFILLER_12_278 VGND VGND VPWR VPWR sky130_fd_sc_hd__decap_8
XFILLER_60_65 VGND VPWR VPWR VGND sky130_ef_sc_hd__decap_12
XFILLER_8_249 VGND VGND VPWR VPWR sky130_fd_sc_hd__decap_3
XFILLER_62_189 VGND VGND VPWR VPWR sky130_fd_sc_hd__decap_6
Xclkbuf_2_3__f_clk clknet_0_clk VGND VGND VPWR VPWR clknet_2_3__leaf_clk sky130_fd_sc_hd__clkbuf_16
X_1802_ clknet_leaf_7_clk _0215_ net89 VGND VGND VPWR VPWR u_jt49.periodB\[8\] sky130_fd_sc_hd__dfrtp_1
X_1733_ clknet_leaf_24_clk _0146_ net92 VGND VGND VPWR VPWR u_jt49.regarray\[10\]\[3\]
+ sky130_fd_sc_hd__dfrtp_1
X_1664_ clknet_leaf_28_clk _0081_ net76 VGND VGND VPWR VPWR u_jt49.u_ng.poly17\[13\]
+ sky130_fd_sc_hd__dfrtp_1
X_1595_ clknet_leaf_27_clk _0012_ net80 VGND VGND VPWR VPWR u_jt49.u_ng.u_div.count\[0\]
+ sky130_fd_sc_hd__dfstp_1
XFILLER_34_370 VGND VPWR VPWR VGND sky130_ef_sc_hd__decap_12
X_1029_ u_jt49.u_chC.count\[2\] u_jt49.periodC\[2\] VGND VGND VPWR VPWR _0646_ sky130_fd_sc_hd__and2b_1
XFILLER_30_79 VGND VGND VPWR VPWR sky130_fd_sc_hd__decap_4
XFILLER_17_304 VGND VPWR VPWR VGND sky130_ef_sc_hd__decap_12
X_1380_ _0370_ _0390_ _0392_ VGND VGND VPWR VPWR _0109_ sky130_fd_sc_hd__and3_1
X_1716_ clknet_leaf_11_clk _0129_ net100 VGND VGND VPWR VPWR u_jt49.eg_period\[10\]
+ sky130_fd_sc_hd__dfrtp_2
X_1647_ clknet_leaf_12_clk _0064_ net100 VGND VGND VPWR VPWR u_jt49.u_envdiv.count\[12\]
+ sky130_fd_sc_hd__dfrtp_1
XFILLER_58_237 VGND VGND VPWR VPWR sky130_fd_sc_hd__decap_6
X_1578_ u_jt49.regarray\[10\]\[0\] u_jt49.envelope\[1\] u_jt49.regarray\[10\]\[4\]
+ VGND VGND VPWR VPWR _0439_ sky130_fd_sc_hd__mux2_1
XFILLER_14_329 VGND VPWR VPWR VGND sky130_ef_sc_hd__decap_12
XFILLER_9_300 VGND VGND VPWR VPWR sky130_fd_sc_hd__decap_4
X_0880_ net51 net55 net53 net49 VGND VGND VPWR VPWR _0523_ sky130_fd_sc_hd__and4bb_4
XFILLER_13_373 VGND VPWR VPWR VGND sky130_ef_sc_hd__decap_12
X_1501_ u_jt49.periodC\[6\] net60 _0417_ VGND VGND VPWR VPWR _0205_ sky130_fd_sc_hd__mux2_1
X_1363_ _0379_ VGND VGND VPWR VPWR _0380_ sky130_fd_sc_hd__inv_2
X_1432_ net135 net72 _0410_ VGND VGND VPWR VPWR _0143_ sky130_fd_sc_hd__mux2_1
XFILLER_63_273 VGND VGND VPWR VPWR sky130_fd_sc_hd__decap_6
X_1294_ u_jt49.u_chB.count\[6\] _0319_ VGND VGND VPWR VPWR _0322_ sky130_fd_sc_hd__nand2_1
XFILLER_11_15 VGND VGND VPWR VPWR sky130_fd_sc_hd__decap_3
XFILLER_39_281 VGND VPWR VPWR VGND sky130_ef_sc_hd__decap_12
XFILLER_10_365 VGND VPWR VPWR VGND sky130_ef_sc_hd__decap_12
XFILLER_60_265 VGND VPWR VPWR VGND sky130_ef_sc_hd__decap_12
X_0932_ u_jt49.periodA\[3\] _0521_ _0567_ _0571_ _0542_ VGND VGND VPWR VPWR _0572_
+ sky130_fd_sc_hd__o221a_1
XFILLER_61_3 VGND VPWR VPWR VGND sky130_ef_sc_hd__decap_12
X_0863_ net22 addr\[1\] _0507_ VGND VGND VPWR VPWR _0511_ sky130_fd_sc_hd__mux2_1
X_0794_ u_jt49.u_env.last_step VGND VGND VPWR VPWR _0444_ sky130_fd_sc_hd__inv_2
X_1415_ u_jt49.eg_period\[9\] net70 _0408_ VGND VGND VPWR VPWR _0128_ sky130_fd_sc_hd__mux2_1
XFILLER_28_218 VGND VGND VPWR VPWR sky130_fd_sc_hd__decap_4
X_1346_ _0357_ _0362_ _0366_ VGND VGND VPWR VPWR _0367_ sky130_fd_sc_hd__or3_1
X_1277_ u_jt49.u_chB.count\[1\] u_jt49.u_chB.count\[0\] sample VGND VGND VPWR VPWR
+ _0310_ sky130_fd_sc_hd__nand3_1
XFILLER_11_107 VGND VGND VPWR VPWR sky130_fd_sc_hd__decap_4
XFILLER_11_129 VGND VGND VPWR VPWR sky130_fd_sc_hd__decap_8
XFILLER_47_77 VGND VGND VPWR VPWR sky130_fd_sc_hd__decap_6
Xclkbuf_leaf_22_clk clknet_2_2__leaf_clk VGND VGND VPWR VPWR clknet_leaf_22_clk sky130_fd_sc_hd__clkbuf_8
X_1200_ u_jt49.u_envdiv.count\[9\] net34 VGND VGND VPWR VPWR _0780_ sky130_fd_sc_hd__nand2_1
XFILLER_2_361 VGND VGND VPWR VPWR sky130_fd_sc_hd__decap_3
X_1131_ u_jt49.eg_period\[9\] _0477_ VGND VGND VPWR VPWR _0727_ sky130_fd_sc_hd__and2_1
XFILLER_33_254 VGND VGND VPWR VPWR sky130_fd_sc_hd__decap_4
X_1062_ u_jt49.u_chC.count\[5\] _0670_ _0673_ VGND VGND VPWR VPWR _0674_ sky130_fd_sc_hd__o21ba_1
Xclkbuf_leaf_13_clk clknet_2_3__leaf_clk VGND VGND VPWR VPWR clknet_leaf_13_clk sky130_fd_sc_hd__clkbuf_8
X_0915_ u_jt49.regarray\[6\]\[2\] _0526_ _0528_ u_jt49.periodC\[10\] VGND VGND VPWR
+ VPWR _0556_ sky130_fd_sc_hd__a22o_1
X_0846_ u_jt49.u_chA.count\[0\] VGND VGND VPWR VPWR _0496_ sky130_fd_sc_hd__inv_2
XFILLER_56_368 VGND VPWR VPWR VGND sky130_ef_sc_hd__decap_12
X_1329_ _0494_ u_jt49.periodA\[2\] _0495_ u_jt49.periodA\[1\] VGND VGND VPWR VPWR
+ _0350_ sky130_fd_sc_hd__a22o_1
XFILLER_33_57 VGND VGND VPWR VPWR sky130_fd_sc_hd__decap_8
XFILLER_59_151 VGND VPWR VPWR VGND sky130_ef_sc_hd__decap_12
XFILLER_58_65 VGND VPWR VPWR VGND sky130_ef_sc_hd__decap_12
Xhold9 u_jt49.logA\[3\] VGND VGND VPWR VPWR net115 sky130_fd_sc_hd__dlygate4sd3_1
XFILLER_3_169 VGND VPWR VPWR VGND sky130_ef_sc_hd__decap_12
XFILLER_15_265 VGND VPWR VPWR VGND sky130_ef_sc_hd__decap_12
X_1680_ clknet_leaf_5_clk _0095_ net86 VGND VGND VPWR VPWR u_jt49.u_chB.count\[7\]
+ sky130_fd_sc_hd__dfrtp_1
XFILLER_38_357 VGND VGND VPWR VPWR sky130_fd_sc_hd__decap_6
Xclkbuf_leaf_2_clk clknet_2_1__leaf_clk VGND VGND VPWR VPWR clknet_leaf_2_clk sky130_fd_sc_hd__clkbuf_8
X_1114_ _0630_ _0711_ VGND VGND VPWR VPWR _0712_ sky130_fd_sc_hd__nor2_1
XFILLER_53_349 VGND VPWR VPWR VGND sky130_ef_sc_hd__decap_12
X_1045_ net44 _0473_ _0661_ VGND VGND VPWR VPWR _0024_ sky130_fd_sc_hd__a21oi_1
X_0829_ u_jt49.u_envdiv.count\[7\] VGND VGND VPWR VPWR _0479_ sky130_fd_sc_hd__inv_2
XFILLER_28_46 VGND VGND VPWR VPWR sky130_fd_sc_hd__decap_4
XFILLER_8_206 VGND VGND VPWR VPWR sky130_fd_sc_hd__decap_4
XFILLER_12_246 VGND VGND VPWR VPWR sky130_fd_sc_hd__decap_6
XFILLER_60_77 VGND VGND VPWR VPWR sky130_fd_sc_hd__decap_6
XFILLER_47_154 VGND VPWR VPWR VGND sky130_ef_sc_hd__decap_12
XFILLER_35_305 VGND VGND VPWR VPWR sky130_fd_sc_hd__decap_8
X_1801_ clknet_leaf_6_clk _0214_ net86 VGND VGND VPWR VPWR IOB_out[7] sky130_fd_sc_hd__dfrtp_4
X_1663_ clknet_leaf_27_clk net184 net76 VGND VGND VPWR VPWR u_jt49.u_ng.poly17\[12\]
+ sky130_fd_sc_hd__dfrtp_1
X_1732_ clknet_leaf_24_clk _0145_ net94 VGND VGND VPWR VPWR u_jt49.regarray\[10\]\[2\]
+ sky130_fd_sc_hd__dfrtp_1
X_1594_ clknet_leaf_13_clk _0011_ VGND VGND VPWR VPWR din_latch\[7\] sky130_fd_sc_hd__dfxtp_1
XPHY_EDGE_ROW_7_Right_7 VGND VGND VPWR VPWR sky130_fd_sc_hd__decap_3
XFILLER_53_113 VGND VGND VPWR VPWR sky130_fd_sc_hd__decap_6
XFILLER_26_305 VGND VGND VPWR VPWR sky130_fd_sc_hd__decap_3
XFILLER_34_382 VGND VGND VPWR VPWR sky130_fd_sc_hd__decap_4
XFILLER_14_15 VGND VPWR VPWR VGND sky130_ef_sc_hd__decap_12
X_1028_ u_jt49.periodC\[1\] u_jt49.u_chC.count\[1\] VGND VGND VPWR VPWR _0645_ sky130_fd_sc_hd__nand2b_1
XFILLER_17_316 VGND VGND VPWR VPWR sky130_fd_sc_hd__decap_6
XFILLER_17_349 VGND VPWR VPWR VGND sky130_ef_sc_hd__decap_12
XFILLER_4_286 VGND VGND VPWR VPWR sky130_fd_sc_hd__decap_8
XFILLER_20_80 VGND VGND VPWR VPWR sky130_fd_sc_hd__decap_4
XFILLER_50_149 VGND VGND VPWR VPWR sky130_fd_sc_hd__decap_3
XFILLER_31_330 VGND VGND VPWR VPWR sky130_fd_sc_hd__decap_6
X_1646_ clknet_leaf_12_clk _0063_ net101 VGND VGND VPWR VPWR u_jt49.u_envdiv.count\[11\]
+ sky130_fd_sc_hd__dfrtp_1
X_1715_ clknet_leaf_11_clk _0128_ net101 VGND VGND VPWR VPWR u_jt49.eg_period\[9\]
+ sky130_fd_sc_hd__dfrtp_2
X_1577_ net74 net112 _0437_ _0438_ VGND VGND VPWR VPWR _0260_ sky130_fd_sc_hd__a22o_1
XFILLER_25_14 VGND VGND VPWR VPWR sky130_fd_sc_hd__decap_3
XFILLER_41_57 VGND VPWR VPWR VGND sky130_ef_sc_hd__decap_12
XFILLER_2_29 VGND VPWR VPWR VGND sky130_ef_sc_hd__decap_12
XFILLER_17_113 VGND VGND VPWR VPWR sky130_fd_sc_hd__decap_4
XFILLER_15_80 VGND VGND VPWR VPWR sky130_fd_sc_hd__decap_4
X_1500_ u_jt49.periodC\[5\] net61 _0417_ VGND VGND VPWR VPWR _0204_ sky130_fd_sc_hd__mux2_1
X_1293_ net31 _0320_ _0321_ VGND VGND VPWR VPWR _0093_ sky130_fd_sc_hd__and3_1
X_1362_ net46 u_jt49.u_chA.count\[4\] _0376_ VGND VGND VPWR VPWR _0379_ sky130_fd_sc_hd__and3_1
X_1431_ net41 _0523_ VGND VGND VPWR VPWR _0410_ sky130_fd_sc_hd__and2_2
XPHY_EDGE_ROW_43_Left_109 VGND VGND VPWR VPWR sky130_fd_sc_hd__decap_3
XPHY_EDGE_ROW_52_Left_118 VGND VGND VPWR VPWR sky130_fd_sc_hd__decap_3
X_1629_ clknet_leaf_21_clk _0046_ VGND VGND VPWR VPWR u_jt49.envelope\[0\] sky130_fd_sc_hd__dfxtp_1
XPHY_EDGE_ROW_61_Left_127 VGND VGND VPWR VPWR sky130_fd_sc_hd__decap_3
XFILLER_39_293 VGND VPWR VPWR VGND sky130_ef_sc_hd__decap_12
XFILLER_6_304 VGND VGND VPWR VPWR sky130_fd_sc_hd__decap_4
XFILLER_10_377 VGND VGND VPWR VPWR sky130_fd_sc_hd__decap_8
XFILLER_60_277 VGND VPWR VPWR VGND sky130_ef_sc_hd__decap_12
X_0862_ _0508_ _0020_ VGND VGND VPWR VPWR _0510_ sky130_fd_sc_hd__nand2b_1
XFILLER_9_175 VGND VGND VPWR VPWR sky130_fd_sc_hd__decap_4
X_0931_ _0568_ _0570_ VGND VGND VPWR VPWR _0571_ sky130_fd_sc_hd__or2_1
XFILLER_54_3 VGND VPWR VPWR VGND sky130_ef_sc_hd__decap_12
XFILLER_5_381 VGND VGND VPWR VPWR sky130_fd_sc_hd__decap_3
X_0793_ u_jt49.u_env.rst_clr VGND VGND VPWR VPWR _0443_ sky130_fd_sc_hd__inv_2
X_1414_ u_jt49.eg_period\[8\] net71 _0408_ VGND VGND VPWR VPWR _0127_ sky130_fd_sc_hd__mux2_1
X_1276_ u_jt49.u_chB.count\[0\] net46 u_jt49.u_chB.count\[1\] VGND VGND VPWR VPWR
+ _0309_ sky130_fd_sc_hd__a21o_1
X_1345_ _0339_ _0365_ VGND VGND VPWR VPWR _0366_ sky130_fd_sc_hd__nand2_1
XFILLER_22_15 VGND VPWR VPWR VGND sky130_ef_sc_hd__decap_12
XFILLER_59_300 VGND VPWR VPWR VGND sky130_ef_sc_hd__decap_12
X_1130_ u_jt49.u_envdiv.count\[11\] u_jt49.eg_period\[11\] VGND VGND VPWR VPWR _0726_
+ sky130_fd_sc_hd__and2b_1
XFILLER_33_200 VGND VPWR VPWR VGND sky130_ef_sc_hd__decap_12
X_1061_ u_jt49.u_chC.count\[5\] u_jt49.u_chC.count\[4\] _0668_ VGND VGND VPWR VPWR
+ _0673_ sky130_fd_sc_hd__and3_1
X_0914_ u_jt49.eg_period\[2\] _0524_ net35 u_jt49.periodA\[10\] VGND VGND VPWR VPWR
+ _0555_ sky130_fd_sc_hd__a22o_1
X_0845_ u_jt49.u_chA.count\[1\] VGND VGND VPWR VPWR _0495_ sky130_fd_sc_hd__inv_2
X_1259_ u_jt49.u_chB.count\[2\] u_jt49.periodB\[2\] VGND VGND VPWR VPWR _0293_ sky130_fd_sc_hd__and2b_1
X_1328_ _0495_ u_jt49.periodA\[1\] _0496_ u_jt49.periodA\[0\] VGND VGND VPWR VPWR
+ _0349_ sky130_fd_sc_hd__o211a_1
XFILLER_59_163 VGND VGND VPWR VPWR sky130_fd_sc_hd__decap_4
XFILLER_58_77 VGND VGND VPWR VPWR sky130_fd_sc_hd__decap_6
XFILLER_47_369 VGND VGND VPWR VPWR sky130_fd_sc_hd__decap_3
XFILLER_15_277 VGND VGND VPWR VPWR sky130_fd_sc_hd__decap_3
X_1113_ _0696_ _0698_ u_jt49.u_env.gain\[3\] VGND VGND VPWR VPWR _0711_ sky130_fd_sc_hd__a21boi_1
X_1044_ sample u_jt49.u_chC.count\[0\] _0660_ VGND VGND VPWR VPWR _0661_ sky130_fd_sc_hd__and3_1
XFILLER_61_361 VGND VPWR VPWR VGND sky130_ef_sc_hd__decap_12
X_0828_ u_jt49.u_envdiv.count\[8\] VGND VGND VPWR VPWR _0478_ sky130_fd_sc_hd__inv_2
XFILLER_52_361 VGND VGND VPWR VPWR sky130_fd_sc_hd__decap_3
XFILLER_5_18 VGND VGND VPWR VPWR sky130_fd_sc_hd__decap_4
XPHY_EDGE_ROW_8_Left_74 VGND VGND VPWR VPWR sky130_fd_sc_hd__decap_3
X_1800_ clknet_leaf_6_clk _0213_ net86 VGND VGND VPWR VPWR IOB_out[6] sky130_fd_sc_hd__dfrtp_4
X_1662_ clknet_leaf_28_clk _0079_ net76 VGND VGND VPWR VPWR u_jt49.u_ng.poly17\[11\]
+ sky130_fd_sc_hd__dfrtp_1
X_1731_ clknet_leaf_24_clk _0144_ net94 VGND VGND VPWR VPWR u_jt49.regarray\[10\]\[1\]
+ sky130_fd_sc_hd__dfrtp_1
X_1593_ clknet_leaf_13_clk _0010_ VGND VGND VPWR VPWR din_latch\[6\] sky130_fd_sc_hd__dfxtp_1
XFILLER_53_169 VGND VGND VPWR VPWR sky130_fd_sc_hd__decap_4
XFILLER_53_136 VGND VPWR VPWR VGND sky130_ef_sc_hd__decap_12
X_1027_ u_jt49.u_chC.count\[4\] u_jt49.periodC\[4\] VGND VGND VPWR VPWR _0644_ sky130_fd_sc_hd__and2b_1
XFILLER_30_15 VGND VPWR VPWR VGND sky130_ef_sc_hd__decap_12
XFILLER_39_57 VGND VPWR VPWR VGND sky130_ef_sc_hd__decap_12
XFILLER_32_309 VGND VPWR VPWR VGND sky130_ef_sc_hd__decap_12
XFILLER_4_221 VGND VGND VPWR VPWR sky130_fd_sc_hd__decap_4
XFILLER_35_169 VGND VPWR VPWR VGND sky130_ef_sc_hd__decap_12
Xhold90 u_jt49.regarray\[7\]\[4\] VGND VGND VPWR VPWR net196 sky130_fd_sc_hd__dlygate4sd3_1
XFILLER_31_320 VGND VGND VPWR VPWR sky130_fd_sc_hd__decap_4
X_1645_ clknet_leaf_13_clk _0062_ net101 VGND VGND VPWR VPWR u_jt49.u_envdiv.count\[10\]
+ sky130_fd_sc_hd__dfrtp_1
X_1714_ clknet_leaf_8_clk _0127_ net90 VGND VGND VPWR VPWR u_jt49.eg_period\[8\] sky130_fd_sc_hd__dfrtp_2
X_1576_ u_jt49.Cmix net20 VGND VGND VPWR VPWR _0438_ sky130_fd_sc_hd__and2_1
XFILLER_64_209 VGND VPWR VPWR VGND sky130_ef_sc_hd__decap_12
XFILLER_17_169 VGND VGND VPWR VPWR sky130_fd_sc_hd__decap_6
X_1430_ net58 u_jt49.eg_period\[7\] _0409_ VGND VGND VPWR VPWR _0142_ sky130_fd_sc_hd__mux2_1
X_1292_ u_jt49.u_chB.count\[5\] _0316_ VGND VGND VPWR VPWR _0321_ sky130_fd_sc_hd__or2_1
X_1361_ _0368_ _0377_ _0378_ net194 net43 VGND VGND VPWR VPWR _0104_ sky130_fd_sc_hd__a32o_1
XFILLER_48_283 VGND VGND VPWR VPWR sky130_fd_sc_hd__decap_3
X_1628_ clknet_leaf_17_clk _0045_ net103 VGND VGND VPWR VPWR u_jt49.eg_step sky130_fd_sc_hd__dfrtp_1
X_1559_ net227 net63 _0430_ VGND VGND VPWR VPWR _0250_ sky130_fd_sc_hd__mux2_1
XFILLER_45_275 VGND VGND VPWR VPWR sky130_fd_sc_hd__decap_4
XFILLER_60_289 VGND VPWR VPWR VGND sky130_ef_sc_hd__decap_12
X_0861_ net89 _0509_ VGND VGND VPWR VPWR _0020_ sky130_fd_sc_hd__and2_1
X_0930_ u_jt49.eg_period\[11\] _0529_ _0532_ u_jt49.periodB\[11\] _0569_ VGND VGND
+ VPWR VPWR _0570_ sky130_fd_sc_hd__a221o_1
XFILLER_9_121 VGND VGND VPWR VPWR sky130_fd_sc_hd__decap_6
XPHY_EDGE_ROW_21_Left_87 VGND VGND VPWR VPWR sky130_fd_sc_hd__decap_3
X_1413_ net41 _0529_ VGND VGND VPWR VPWR _0408_ sky130_fd_sc_hd__and2_2
XFILLER_47_3 VGND VGND VPWR VPWR sky130_fd_sc_hd__decap_6
X_1275_ _0305_ _0306_ net43 VGND VGND VPWR VPWR _0308_ sky130_fd_sc_hd__a21o_1
XFILLER_3_51 VGND VGND VPWR VPWR sky130_fd_sc_hd__decap_4
X_1344_ _0490_ u_jt49.periodA\[8\] _0354_ VGND VGND VPWR VPWR _0365_ sky130_fd_sc_hd__a21oi_1
Xfanout100 net105 VGND VGND VPWR VPWR net100 sky130_fd_sc_hd__clkbuf_4
XFILLER_59_312 VGND VGND VPWR VPWR sky130_fd_sc_hd__decap_3
XPHY_EDGE_ROW_29_Right_29 VGND VGND VPWR VPWR sky130_fd_sc_hd__decap_3
XPHY_EDGE_ROW_38_Right_38 VGND VGND VPWR VPWR sky130_fd_sc_hd__decap_3
XFILLER_6_113 VGND VPWR VPWR VGND sky130_ef_sc_hd__decap_12
XFILLER_2_341 VGND VPWR VPWR VGND sky130_ef_sc_hd__decap_12
XFILLER_10_197 VGND VGND VPWR VPWR sky130_fd_sc_hd__decap_6
XFILLER_12_93 VGND VPWR VPWR VGND sky130_ef_sc_hd__decap_12
XFILLER_65_337 VGND VGND VPWR VPWR sky130_fd_sc_hd__decap_8
XPHY_EDGE_ROW_47_Right_47 VGND VGND VPWR VPWR sky130_fd_sc_hd__decap_3
X_1060_ _0662_ _0671_ _0672_ VGND VGND VPWR VPWR _0028_ sky130_fd_sc_hd__and3_1
XFILLER_18_242 VGND VGND VPWR VPWR sky130_fd_sc_hd__decap_8
XPHY_EDGE_ROW_56_Right_56 VGND VGND VPWR VPWR sky130_fd_sc_hd__decap_3
XFILLER_33_212 VGND VGND VPWR VPWR sky130_fd_sc_hd__decap_4
XFILLER_18_253 VGND VGND VPWR VPWR sky130_fd_sc_hd__decap_6
XFILLER_18_297 VGND VGND VPWR VPWR sky130_fd_sc_hd__decap_8
X_0844_ u_jt49.u_chA.count\[2\] VGND VGND VPWR VPWR _0494_ sky130_fd_sc_hd__inv_2
X_0913_ net10 _0544_ _0545_ net2 _0554_ VGND VGND VPWR VPWR _0267_ sky130_fd_sc_hd__a221o_1
XPHY_EDGE_ROW_65_Right_65 VGND VGND VPWR VPWR sky130_fd_sc_hd__decap_3
XFILLER_56_326 VGND VPWR VPWR VGND sky130_ef_sc_hd__decap_12
X_1189_ net32 _0771_ _0772_ VGND VGND VPWR VPWR _0057_ sky130_fd_sc_hd__and3_1
X_1258_ u_jt49.periodB\[1\] u_jt49.u_chB.count\[1\] VGND VGND VPWR VPWR _0292_ sky130_fd_sc_hd__nand2b_1
X_1327_ _0346_ _0347_ VGND VGND VPWR VPWR _0348_ sky130_fd_sc_hd__nand2_1
XFILLER_47_337 VGND VPWR VPWR VGND sky130_ef_sc_hd__decap_12
XFILLER_30_237 VGND VGND VPWR VPWR sky130_fd_sc_hd__decap_8
XFILLER_53_318 VGND VPWR VPWR VGND sky130_ef_sc_hd__decap_12
X_1043_ _0633_ _0634_ _0656_ _0659_ VGND VGND VPWR VPWR _0660_ sky130_fd_sc_hd__o211a_1
XFILLER_0_52 VGND VGND VPWR VPWR sky130_fd_sc_hd__decap_4
XFILLER_0_85 VGND VPWR VPWR VGND sky130_ef_sc_hd__decap_12
X_1112_ u_jt49.u_env.gain\[2\] _0709_ _0710_ VGND VGND VPWR VPWR _0042_ sky130_fd_sc_hd__a21o_1
XFILLER_61_373 VGND VGND VPWR VPWR sky130_fd_sc_hd__decap_8
X_1876_ clknet_leaf_14_clk _0265_ VGND VGND VPWR VPWR u_jt49.wr_n sky130_fd_sc_hd__dfxtp_1
X_0827_ u_jt49.u_envdiv.count\[9\] VGND VGND VPWR VPWR _0477_ sky130_fd_sc_hd__inv_2
XPHY_EDGE_ROW_24_Left_90 VGND VGND VPWR VPWR sky130_fd_sc_hd__decap_3
XFILLER_29_337 VGND VGND VPWR VPWR sky130_fd_sc_hd__decap_6
XFILLER_29_304 VGND VGND VPWR VPWR sky130_fd_sc_hd__decap_4
XFILLER_44_329 VGND VGND VPWR VPWR sky130_fd_sc_hd__decap_6
X_1592_ clknet_leaf_13_clk _0009_ VGND VGND VPWR VPWR din_latch\[5\] sky130_fd_sc_hd__dfxtp_1
X_1661_ clknet_leaf_28_clk _0078_ net76 VGND VGND VPWR VPWR u_jt49.u_ng.poly17\[10\]
+ sky130_fd_sc_hd__dfrtp_1
XFILLER_11_281 VGND VGND VPWR VPWR sky130_fd_sc_hd__decap_8
X_1730_ clknet_leaf_24_clk _0143_ net94 VGND VGND VPWR VPWR u_jt49.regarray\[10\]\[0\]
+ sky130_fd_sc_hd__dfrtp_1
XFILLER_53_148 VGND VPWR VPWR VGND sky130_ef_sc_hd__decap_12
X_1026_ u_jt49.u_chC.count\[5\] _0470_ _0642_ VGND VGND VPWR VPWR _0643_ sky130_fd_sc_hd__a21oi_1
XFILLER_61_181 VGND VPWR VPWR VGND sky130_ef_sc_hd__decap_12
X_1859_ clknet_leaf_23_clk net114 VGND VGND VPWR VPWR B[1] sky130_fd_sc_hd__dfxtp_2
XFILLER_55_57 VGND VPWR VPWR VGND sky130_ef_sc_hd__decap_12
XFILLER_40_365 VGND VPWR VPWR VGND sky130_ef_sc_hd__decap_12
Xhold80 u_jt49.u_ng.poly17\[10\] VGND VGND VPWR VPWR net186 sky130_fd_sc_hd__dlygate4sd3_1
Xhold91 u_jt49.regarray\[7\]\[3\] VGND VGND VPWR VPWR net197 sky130_fd_sc_hd__dlygate4sd3_1
XFILLER_31_354 VGND VGND VPWR VPWR sky130_fd_sc_hd__decap_8
X_1713_ clknet_leaf_18_clk _0126_ net99 VGND VGND VPWR VPWR u_jt49.regarray\[13\]\[7\]
+ sky130_fd_sc_hd__dfrtp_1
X_1644_ clknet_leaf_13_clk _0061_ net101 VGND VGND VPWR VPWR u_jt49.u_envdiv.count\[9\]
+ sky130_fd_sc_hd__dfrtp_1
X_1575_ u_jt49.regarray\[10\]\[3\] u_jt49.envelope\[0\] u_jt49.regarray\[10\]\[4\]
+ VGND VGND VPWR VPWR _0437_ sky130_fd_sc_hd__mux2_1
XFILLER_26_137 VGND VGND VPWR VPWR sky130_fd_sc_hd__decap_3
X_1009_ _0507_ _0628_ net104 VGND VGND VPWR VPWR _0629_ sky130_fd_sc_hd__o21ai_1
XFILLER_25_49 VGND VGND VPWR VPWR sky130_fd_sc_hd__decap_6
XFILLER_41_15 VGND VPWR VPWR VGND sky130_ef_sc_hd__decap_12
XFILLER_9_6 VGND VPWR VPWR VGND sky130_ef_sc_hd__decap_12
XFILLER_57_284 VGND VGND VPWR VPWR sky130_fd_sc_hd__decap_4
XFILLER_9_325 VGND VGND VPWR VPWR sky130_fd_sc_hd__decap_6
X_1360_ net43 _0493_ _0375_ VGND VGND VPWR VPWR _0378_ sky130_fd_sc_hd__o21ai_1
X_1291_ _0319_ VGND VGND VPWR VPWR _0320_ sky130_fd_sc_hd__inv_2
X_1489_ u_jt49.periodC\[11\] net66 _0416_ VGND VGND VPWR VPWR _0194_ sky130_fd_sc_hd__mux2_1
X_1558_ u_jt49.periodA\[3\] net65 _0430_ VGND VGND VPWR VPWR _0249_ sky130_fd_sc_hd__mux2_1
X_1627_ clknet_leaf_22_clk _0044_ net94 VGND VGND VPWR VPWR u_jt49.u_env.gain\[4\]
+ sky130_fd_sc_hd__dfstp_1
XFILLER_54_265 VGND VPWR VPWR VGND sky130_ef_sc_hd__decap_12
XFILLER_7_3 VGND VPWR VPWR VGND sky130_ef_sc_hd__decap_12
XFILLER_26_70 VGND VGND VPWR VPWR sky130_fd_sc_hd__decap_4
Xclkbuf_leaf_25_clk clknet_2_0__leaf_clk VGND VGND VPWR VPWR clknet_leaf_25_clk sky130_fd_sc_hd__clkbuf_8
X_0860_ net24 net50 _0507_ VGND VGND VPWR VPWR _0509_ sky130_fd_sc_hd__mux2_1
XFILLER_42_80 VGND VGND VPWR VPWR sky130_fd_sc_hd__decap_4
X_1412_ net58 net168 _0407_ VGND VGND VPWR VPWR _0126_ sky130_fd_sc_hd__mux2_1
XFILLER_5_361 VGND VPWR VPWR VGND sky130_ef_sc_hd__decap_12
X_1343_ _0339_ _0354_ _0357_ _0363_ _0353_ VGND VGND VPWR VPWR _0364_ sky130_fd_sc_hd__o311a_1
XFILLER_36_210 VGND VGND VPWR VPWR sky130_fd_sc_hd__decap_4
X_1274_ _0465_ net43 _0307_ VGND VGND VPWR VPWR _0088_ sky130_fd_sc_hd__a21oi_1
XFILLER_51_246 VGND VPWR VPWR VGND sky130_ef_sc_hd__decap_12
Xclkbuf_leaf_16_clk clknet_2_3__leaf_clk VGND VGND VPWR VPWR clknet_leaf_16_clk sky130_fd_sc_hd__clkbuf_8
X_0989_ _0486_ u_jt49.u_ng.u_div.count\[2\] u_jt49.u_ng.u_div.count\[1\] _0483_ _0613_
+ VGND VGND VPWR VPWR _0614_ sky130_fd_sc_hd__o221a_1
Xfanout101 net105 VGND VGND VPWR VPWR net101 sky130_fd_sc_hd__clkbuf_2
XFILLER_63_57 VGND VPWR VPWR VGND sky130_ef_sc_hd__decap_12
XFILLER_27_276 VGND VGND VPWR VPWR sky130_fd_sc_hd__decap_4
XFILLER_6_125 VGND VPWR VPWR VGND sky130_ef_sc_hd__decap_12
XFILLER_2_353 VGND VGND VPWR VPWR sky130_fd_sc_hd__decap_8
XFILLER_53_90 VGND VGND VPWR VPWR sky130_fd_sc_hd__decap_4
X_0912_ u_jt49.periodA\[1\] _0521_ _0548_ _0553_ _0542_ VGND VGND VPWR VPWR _0554_
+ sky130_fd_sc_hd__o221a_1
X_0843_ u_jt49.u_chA.count\[3\] VGND VGND VPWR VPWR _0493_ sky130_fd_sc_hd__inv_2
XFILLER_56_338 VGND VPWR VPWR VGND sky130_ef_sc_hd__decap_12
Xclkbuf_leaf_5_clk clknet_2_1__leaf_clk VGND VGND VPWR VPWR clknet_leaf_5_clk sky130_fd_sc_hd__clkbuf_8
X_1326_ u_jt49.periodA\[5\] u_jt49.u_chA.count\[5\] VGND VGND VPWR VPWR _0347_ sky130_fd_sc_hd__nand2b_1
X_1188_ u_jt49.u_envdiv.count\[5\] _0768_ VGND VGND VPWR VPWR _0772_ sky130_fd_sc_hd__or2_1
X_1257_ _0457_ u_jt49.periodB\[9\] _0458_ u_jt49.periodB\[8\] VGND VGND VPWR VPWR
+ _0291_ sky130_fd_sc_hd__o22a_1
XFILLER_33_16 VGND VGND VPWR VPWR sky130_fd_sc_hd__decap_8
XPHY_EDGE_ROW_49_Left_115 VGND VGND VPWR VPWR sky130_fd_sc_hd__decap_3
XPHY_EDGE_ROW_58_Left_124 VGND VGND VPWR VPWR sky130_fd_sc_hd__decap_3
XFILLER_47_349 VGND VPWR VPWR VGND sky130_ef_sc_hd__decap_12
XFILLER_47_305 VGND VPWR VPWR VGND sky130_ef_sc_hd__decap_12
XFILLER_46_360 VGND VGND VPWR VPWR sky130_fd_sc_hd__decap_4
X_1042_ _0641_ _0652_ _0655_ _0658_ VGND VGND VPWR VPWR _0659_ sky130_fd_sc_hd__a31o_1
XFILLER_0_97 VGND VPWR VPWR VGND sky130_ef_sc_hd__decap_12
X_1111_ _0696_ _0698_ _0704_ _0630_ VGND VGND VPWR VPWR _0710_ sky130_fd_sc_hd__a31o_1
X_1875_ clknet_leaf_21_clk net119 VGND VGND VPWR VPWR C[4] sky130_fd_sc_hd__dfxtp_2
X_0826_ u_jt49.u_envdiv.count\[13\] VGND VGND VPWR VPWR _0476_ sky130_fd_sc_hd__inv_2
XFILLER_0_109 VGND VGND VPWR VPWR sky130_fd_sc_hd__decap_3
X_1309_ _0455_ _0330_ VGND VGND VPWR VPWR _0333_ sky130_fd_sc_hd__or2_1
XFILLER_52_341 VGND VPWR VPWR VGND sky130_ef_sc_hd__decap_12
XFILLER_60_25 VGND VGND VPWR VPWR sky130_fd_sc_hd__decap_3
XFILLER_20_271 VGND VGND VPWR VPWR sky130_fd_sc_hd__decap_6
XFILLER_43_352 VGND VPWR VPWR VGND sky130_ef_sc_hd__decap_12
XFILLER_34_70 VGND VPWR VPWR VGND sky130_ef_sc_hd__decap_12
X_1591_ clknet_leaf_13_clk _0008_ VGND VGND VPWR VPWR din_latch\[4\] sky130_fd_sc_hd__dfxtp_1
XFILLER_50_91 VGND VGND VPWR VPWR sky130_fd_sc_hd__decap_4
X_1660_ clknet_leaf_28_clk _0077_ net75 VGND VGND VPWR VPWR u_jt49.u_ng.poly17\[9\]
+ sky130_fd_sc_hd__dfrtp_1
XFILLER_22_3 VGND VPWR VPWR VGND sky130_ef_sc_hd__decap_12
XFILLER_61_193 VGND VPWR VPWR VGND sky130_ef_sc_hd__decap_12
X_1025_ u_jt49.periodC\[4\] u_jt49.u_chC.count\[4\] VGND VGND VPWR VPWR _0642_ sky130_fd_sc_hd__and2b_1
XFILLER_14_29 VGND VGND VPWR VPWR sky130_fd_sc_hd__decap_4
XFILLER_19_360 VGND VPWR VPWR VGND sky130_ef_sc_hd__decap_12
X_0809_ u_jt49.u_chB.count\[7\] VGND VGND VPWR VPWR _0459_ sky130_fd_sc_hd__inv_2
X_1858_ clknet_leaf_23_clk net107 VGND VGND VPWR VPWR B[0] sky130_fd_sc_hd__dfxtp_2
X_1789_ clknet_leaf_18_clk _0202_ net95 VGND VGND VPWR VPWR u_jt49.periodC\[3\] sky130_fd_sc_hd__dfrtp_2
XFILLER_55_69 VGND VPWR VPWR VGND sky130_ef_sc_hd__decap_12
XFILLER_44_127 VGND VPWR VPWR VGND sky130_ef_sc_hd__decap_12
XFILLER_40_377 VGND VGND VPWR VPWR sky130_fd_sc_hd__decap_8
XFILLER_40_344 VGND VGND VPWR VPWR sky130_fd_sc_hd__decap_4
Xhold70 u_jt49.u_ng.poly17\[16\] VGND VGND VPWR VPWR net176 sky130_fd_sc_hd__dlygate4sd3_1
Xhold81 u_jt49.u_ng.poly17\[0\] VGND VGND VPWR VPWR net187 sky130_fd_sc_hd__dlygate4sd3_1
Xhold92 u_jt49.u_ng.noise_en VGND VGND VPWR VPWR net198 sky130_fd_sc_hd__dlygate4sd3_1
X_1643_ clknet_leaf_13_clk _0060_ net104 VGND VGND VPWR VPWR u_jt49.u_envdiv.count\[8\]
+ sky130_fd_sc_hd__dfrtp_1
XANTENNA_1 net60 VGND VGND VPWR VPWR sky130_fd_sc_hd__diode_2
X_1712_ clknet_leaf_10_clk _0125_ net87 VGND VGND VPWR VPWR u_jt49.regarray\[13\]\[6\]
+ sky130_fd_sc_hd__dfrtp_1
X_1574_ net166 _0407_ net42 net126 VGND VGND VPWR VPWR _0259_ sky130_fd_sc_hd__a2bb2o_1
XFILLER_26_105 VGND VPWR VPWR VGND sky130_ef_sc_hd__decap_12
X_1008_ net26 net25 net28 net27 VGND VGND VPWR VPWR _0628_ sky130_fd_sc_hd__or4_1
XFILLER_41_27 VGND VGND VPWR VPWR sky130_fd_sc_hd__decap_8
XFILLER_25_39 VGND VGND VPWR VPWR sky130_fd_sc_hd__decap_6
XFILLER_15_50 VGND VGND VPWR VPWR sky130_fd_sc_hd__decap_6
XFILLER_40_141 VGND VGND VPWR VPWR sky130_fd_sc_hd__decap_6
XFILLER_9_337 VGND VPWR VPWR VGND sky130_ef_sc_hd__decap_12
X_1290_ u_jt49.u_chB.count\[5\] u_jt49.u_chB.count\[4\] u_jt49.u_chB.count\[3\] _0311_
+ VGND VGND VPWR VPWR _0319_ sky130_fd_sc_hd__and4_1
XFILLER_0_281 VGND VPWR VPWR VGND sky130_ef_sc_hd__decap_12
X_1626_ clknet_leaf_21_clk _0043_ net97 VGND VGND VPWR VPWR u_jt49.u_env.gain\[3\]
+ sky130_fd_sc_hd__dfstp_1
X_1488_ u_jt49.periodC\[10\] net68 _0416_ VGND VGND VPWR VPWR _0193_ sky130_fd_sc_hd__mux2_1
X_1557_ u_jt49.periodA\[2\] net67 _0430_ VGND VGND VPWR VPWR _0248_ sky130_fd_sc_hd__mux2_1
XFILLER_54_288 VGND VGND VPWR VPWR sky130_fd_sc_hd__decap_3
XFILLER_5_373 VGND VGND VPWR VPWR sky130_fd_sc_hd__decap_8
X_1273_ u_jt49.u_chB.count\[0\] net46 _0305_ _0306_ VGND VGND VPWR VPWR _0307_ sky130_fd_sc_hd__and4_1
X_1411_ net59 net167 _0407_ VGND VGND VPWR VPWR _0125_ sky130_fd_sc_hd__mux2_1
X_1342_ u_jt49.periodA\[10\] _0355_ u_jt49.u_chA.count\[10\] VGND VGND VPWR VPWR _0363_
+ sky130_fd_sc_hd__or3b_1
XFILLER_51_225 VGND VGND VPWR VPWR sky130_fd_sc_hd__decap_8
XFILLER_51_258 VGND VGND VPWR VPWR sky130_fd_sc_hd__decap_3
X_0988_ _0483_ u_jt49.u_ng.u_div.count\[1\] u_jt49.u_ng.u_div.count\[0\] _0484_ VGND
+ VGND VPWR VPWR _0613_ sky130_fd_sc_hd__a211o_1
XFILLER_22_29 VGND VPWR VPWR VGND sky130_ef_sc_hd__decap_12
Xfanout102 net103 VGND VGND VPWR VPWR net102 sky130_fd_sc_hd__clkbuf_4
X_1609_ clknet_leaf_20_clk _0026_ net95 VGND VGND VPWR VPWR u_jt49.u_chC.count\[2\]
+ sky130_fd_sc_hd__dfrtp_1
XFILLER_63_69 VGND VPWR VPWR VGND sky130_ef_sc_hd__decap_12
XFILLER_6_137 VGND VGND VPWR VPWR sky130_fd_sc_hd__decap_3
XFILLER_2_365 VGND VPWR VPWR VGND sky130_ef_sc_hd__decap_12
XFILLER_65_317 VGND VPWR VPWR VGND sky130_ef_sc_hd__decap_12
X_0842_ u_jt49.u_chA.count\[4\] VGND VGND VPWR VPWR _0492_ sky130_fd_sc_hd__inv_2
X_0911_ _0550_ _0552_ VGND VGND VPWR VPWR _0553_ sky130_fd_sc_hd__or2_1
X_1256_ _0457_ u_jt49.periodB\[9\] _0287_ _0289_ VGND VGND VPWR VPWR _0290_ sky130_fd_sc_hd__a211o_1
X_1325_ u_jt49.periodA\[4\] u_jt49.u_chA.count\[4\] VGND VGND VPWR VPWR _0346_ sky130_fd_sc_hd__nand2b_1
XFILLER_17_18 VGND VPWR VPWR VGND sky130_ef_sc_hd__decap_12
X_1187_ u_jt49.u_envdiv.count\[5\] u_jt49.u_envdiv.count\[4\] _0759_ _0766_ VGND VGND
+ VPWR VPWR _0771_ sky130_fd_sc_hd__nand4_2
XFILLER_59_133 VGND VGND VPWR VPWR sky130_fd_sc_hd__decap_3
XFILLER_62_309 VGND VPWR VPWR VGND sky130_ef_sc_hd__decap_12
XFILLER_55_361 VGND VPWR VPWR VGND sky130_ef_sc_hd__decap_12
XFILLER_47_317 VGND VPWR VPWR VGND sky130_ef_sc_hd__decap_12
XFILLER_23_72 VGND VPWR VPWR VGND sky130_ef_sc_hd__decap_12
XFILLER_23_94 VGND VGND VPWR VPWR sky130_fd_sc_hd__decap_6
XFILLER_65_147 VGND VPWR VPWR VGND sky130_ef_sc_hd__decap_12
X_1110_ _0630_ _0708_ _0709_ VGND VGND VPWR VPWR _0041_ sky130_fd_sc_hd__or3b_1
XFILLER_17_6 VGND VPWR VPWR VGND sky130_ef_sc_hd__decap_12
XFILLER_65_169 VGND VGND VPWR VPWR sky130_fd_sc_hd__decap_8
X_1041_ _0469_ u_jt49.periodC\[7\] _0637_ _0638_ _0657_ VGND VGND VPWR VPWR _0658_
+ sky130_fd_sc_hd__a2111o_1
X_0825_ u_jt49.u_envdiv.count\[14\] VGND VGND VPWR VPWR _0475_ sky130_fd_sc_hd__inv_2
X_1874_ clknet_leaf_21_clk net113 VGND VGND VPWR VPWR C[3] sky130_fd_sc_hd__dfxtp_2
X_1308_ _0455_ _0330_ VGND VGND VPWR VPWR _0332_ sky130_fd_sc_hd__nand2_1
X_1239_ u_jt49.u_ng.poly17\[7\] u_jt49.u_ng.poly17\[6\] u_jt49.u_ng.poly17\[9\] u_jt49.u_ng.poly17\[8\]
+ VGND VGND VPWR VPWR _0277_ sky130_fd_sc_hd__or4_1
XFILLER_52_353 VGND VGND VPWR VPWR sky130_fd_sc_hd__decap_8
XFILLER_47_169 VGND VGND VPWR VPWR sky130_fd_sc_hd__decap_6
X_1590_ clknet_leaf_8_clk _0007_ VGND VGND VPWR VPWR din_latch\[3\] sky130_fd_sc_hd__dfxtp_1
XFILLER_50_81 VGND VGND VPWR VPWR sky130_fd_sc_hd__decap_3
XFILLER_7_276 VGND VGND VPWR VPWR sky130_fd_sc_hd__decap_4
X_1024_ _0639_ _0640_ VGND VGND VPWR VPWR _0641_ sky130_fd_sc_hd__nor2_1
XFILLER_26_309 VGND VGND VPWR VPWR sky130_fd_sc_hd__decap_6
XFILLER_15_3 VGND VPWR VPWR VGND sky130_ef_sc_hd__decap_12
XFILLER_19_372 VGND VPWR VPWR VGND sky130_ef_sc_hd__decap_12
XFILLER_61_161 VGND VGND VPWR VPWR sky130_fd_sc_hd__decap_6
X_0808_ u_jt49.u_chB.count\[8\] VGND VGND VPWR VPWR _0458_ sky130_fd_sc_hd__inv_2
XFILLER_30_29 VGND VPWR VPWR VGND sky130_ef_sc_hd__decap_12
X_1857_ clknet_leaf_27_clk net111 VGND VGND VPWR VPWR A[4] sky130_fd_sc_hd__dfxtp_2
X_1788_ clknet_leaf_19_clk _0201_ net95 VGND VGND VPWR VPWR u_jt49.periodC\[2\] sky130_fd_sc_hd__dfrtp_1
Xhold82 u_jt49.u_ng.poly17\[14\] VGND VGND VPWR VPWR net188 sky130_fd_sc_hd__dlygate4sd3_1
Xhold71 _0083_ VGND VGND VPWR VPWR net177 sky130_fd_sc_hd__dlygate4sd3_1
Xhold60 u_jt49.last_write VGND VGND VPWR VPWR net166 sky130_fd_sc_hd__dlygate4sd3_1
Xhold93 u_jt49.regarray\[7\]\[2\] VGND VGND VPWR VPWR net199 sky130_fd_sc_hd__dlygate4sd3_1
XFILLER_50_109 VGND VGND VPWR VPWR sky130_fd_sc_hd__decap_3
X_1642_ clknet_leaf_13_clk _0059_ net104 VGND VGND VPWR VPWR u_jt49.u_envdiv.count\[7\]
+ sky130_fd_sc_hd__dfrtp_1
XANTENNA_2 net67 VGND VGND VPWR VPWR sky130_fd_sc_hd__diode_2
X_1711_ clknet_leaf_2_clk _0124_ net82 VGND VGND VPWR VPWR u_jt49.regarray\[13\]\[5\]
+ sky130_fd_sc_hd__dfrtp_1
XFILLER_58_209 VGND VGND VPWR VPWR sky130_fd_sc_hd__decap_6
X_1573_ net74 net118 _0432_ _0436_ VGND VGND VPWR VPWR _0258_ sky130_fd_sc_hd__a22o_1
XFILLER_26_117 VGND VPWR VPWR VGND sky130_ef_sc_hd__decap_12
X_1007_ _0619_ _0627_ VGND VGND VPWR VPWR _0016_ sky130_fd_sc_hd__and2_1
XFILLER_34_183 VGND VGND VPWR VPWR sky130_fd_sc_hd__decap_3
XFILLER_32_109 VGND VGND VPWR VPWR sky130_fd_sc_hd__decap_3
XFILLER_13_312 VGND VPWR VPWR VGND sky130_ef_sc_hd__decap_12
XFILLER_9_349 VGND VPWR VPWR VGND sky130_ef_sc_hd__decap_12
XFILLER_48_253 VGND VGND VPWR VPWR sky130_fd_sc_hd__decap_4
XFILLER_0_293 VGND VPWR VPWR VGND sky130_ef_sc_hd__decap_12
XFILLER_16_150 VGND VGND VPWR VPWR sky130_fd_sc_hd__decap_4
X_1625_ clknet_leaf_21_clk _0042_ net97 VGND VGND VPWR VPWR u_jt49.u_env.gain\[2\]
+ sky130_fd_sc_hd__dfstp_1
X_1556_ u_jt49.periodA\[1\] net69 _0430_ VGND VGND VPWR VPWR _0247_ sky130_fd_sc_hd__mux2_1
X_1487_ u_jt49.periodC\[9\] net70 _0416_ VGND VGND VPWR VPWR _0192_ sky130_fd_sc_hd__mux2_1
XFILLER_10_304 VGND VGND VPWR VPWR sky130_fd_sc_hd__decap_4
XFILLER_9_113 VGND VGND VPWR VPWR sky130_fd_sc_hd__decap_3
X_1410_ net61 net164 _0407_ VGND VGND VPWR VPWR _0124_ sky130_fd_sc_hd__mux2_1
X_1272_ _0287_ _0288_ _0290_ _0291_ VGND VGND VPWR VPWR _0306_ sky130_fd_sc_hd__o2bb2a_1
X_1341_ _0345_ _0352_ _0359_ _0361_ VGND VGND VPWR VPWR _0362_ sky130_fd_sc_hd__o31a_1
Xwire38 _0694_ VGND VGND VPWR VPWR net38 sky130_fd_sc_hd__clkbuf_1
XFILLER_36_223 VGND VGND VPWR VPWR sky130_fd_sc_hd__decap_4
X_0987_ net47 u_jt49.u_ng.u_div.count\[0\] VGND VGND VPWR VPWR _0612_ sky130_fd_sc_hd__or2_1
XFILLER_59_337 VGND VPWR VPWR VGND sky130_ef_sc_hd__decap_12
Xfanout103 net104 VGND VGND VPWR VPWR net103 sky130_fd_sc_hd__clkbuf_4
X_1539_ net149 net63 _0423_ VGND VGND VPWR VPWR _0237_ sky130_fd_sc_hd__mux2_1
X_1608_ clknet_leaf_20_clk _0025_ net95 VGND VGND VPWR VPWR u_jt49.u_chC.count\[1\]
+ sky130_fd_sc_hd__dfrtp_1
XFILLER_63_15 VGND VPWR VPWR VGND sky130_ef_sc_hd__decap_12
XFILLER_27_245 VGND VGND VPWR VPWR sky130_fd_sc_hd__decap_8
XFILLER_10_189 VGND VGND VPWR VPWR sky130_fd_sc_hd__decap_6
XFILLER_65_329 VGND VGND VPWR VPWR sky130_fd_sc_hd__decap_6
XFILLER_2_377 VGND VGND VPWR VPWR sky130_fd_sc_hd__decap_8
XPHY_EDGE_ROW_16_Right_16 VGND VGND VPWR VPWR sky130_fd_sc_hd__decap_3
X_0841_ u_jt49.u_chA.count\[7\] VGND VGND VPWR VPWR _0491_ sky130_fd_sc_hd__inv_2
X_0910_ u_jt49.regarray\[8\]\[1\] _0525_ _0531_ u_jt49.periodB\[1\] _0551_ VGND VGND
+ VPWR VPWR _0552_ sky130_fd_sc_hd__a221o_1
XPHY_EDGE_ROW_25_Right_25 VGND VGND VPWR VPWR sky130_fd_sc_hd__decap_3
XFILLER_45_3 VGND VGND VPWR VPWR sky130_fd_sc_hd__decap_8
X_1186_ net32 _0769_ _0770_ VGND VGND VPWR VPWR _0056_ sky130_fd_sc_hd__and3_1
X_1255_ u_jt49.u_chB.count\[10\] _0456_ _0288_ VGND VGND VPWR VPWR _0289_ sky130_fd_sc_hd__o21ai_1
XPHY_EDGE_ROW_34_Right_34 VGND VGND VPWR VPWR sky130_fd_sc_hd__decap_3
X_1324_ _0341_ _0343_ _0344_ VGND VGND VPWR VPWR _0345_ sky130_fd_sc_hd__or3_1
XFILLER_32_281 VGND VGND VPWR VPWR sky130_fd_sc_hd__decap_4
XPHY_EDGE_ROW_43_Right_43 VGND VGND VPWR VPWR sky130_fd_sc_hd__decap_3
XFILLER_3_108 VGND VGND VPWR VPWR sky130_fd_sc_hd__decap_4
XPHY_EDGE_ROW_52_Right_52 VGND VGND VPWR VPWR sky130_fd_sc_hd__decap_3
XFILLER_47_329 VGND VGND VPWR VPWR sky130_fd_sc_hd__decap_6
XFILLER_55_373 VGND VPWR VPWR VGND sky130_ef_sc_hd__decap_12
XPHY_EDGE_ROW_61_Right_61 VGND VGND VPWR VPWR sky130_fd_sc_hd__decap_3
XFILLER_23_40 VGND VPWR VPWR VGND sky130_ef_sc_hd__decap_12
XFILLER_23_281 VGND VGND VPWR VPWR sky130_fd_sc_hd__decap_4
XFILLER_2_152 VGND VGND VPWR VPWR sky130_fd_sc_hd__decap_8
XFILLER_2_130 VGND VGND VPWR VPWR sky130_fd_sc_hd__decap_8
XFILLER_2_141 VGND VGND VPWR VPWR sky130_fd_sc_hd__decap_4
XFILLER_65_159 VGND VGND VPWR VPWR sky130_fd_sc_hd__decap_8
XFILLER_48_70 VGND VPWR VPWR VGND sky130_ef_sc_hd__decap_12
X_1040_ u_jt49.u_chC.count\[8\] _0468_ _0636_ VGND VGND VPWR VPWR _0657_ sky130_fd_sc_hd__o21ai_1
X_0824_ net207 VGND VGND VPWR VPWR _0474_ sky130_fd_sc_hd__inv_2
X_1873_ clknet_leaf_21_clk net108 VGND VGND VPWR VPWR C[2] sky130_fd_sc_hd__dfxtp_2
X_1169_ u_jt49.u_env.cen u_jt49.u_envdiv.count\[0\] _0720_ _0749_ VGND VGND VPWR VPWR
+ _0758_ sky130_fd_sc_hd__and4_1
X_1307_ _0308_ _0330_ _0331_ VGND VGND VPWR VPWR _0097_ sky130_fd_sc_hd__and3_1
X_1238_ u_jt49.u_ng.poly17\[15\] u_jt49.u_ng.poly17\[14\] u_jt49.u_ng.poly17\[16\]
+ _0275_ VGND VGND VPWR VPWR _0276_ sky130_fd_sc_hd__or4_1
XFILLER_52_365 VGND VPWR VPWR VGND sky130_ef_sc_hd__decap_12
XFILLER_7_244 VGND VGND VPWR VPWR sky130_fd_sc_hd__decap_6
X_1023_ u_jt49.periodC\[6\] u_jt49.u_chC.count\[6\] VGND VGND VPWR VPWR _0640_ sky130_fd_sc_hd__and2b_1
XPHY_EDGE_ROW_28_Left_94 VGND VGND VPWR VPWR sky130_fd_sc_hd__decap_3
X_0807_ u_jt49.u_chB.count\[9\] VGND VGND VPWR VPWR _0457_ sky130_fd_sc_hd__inv_2
X_1856_ clknet_leaf_27_clk net115 VGND VGND VPWR VPWR A[3] sky130_fd_sc_hd__dfxtp_2
XPHY_EDGE_ROW_12_Left_78 VGND VGND VPWR VPWR sky130_fd_sc_hd__decap_3
X_1787_ clknet_leaf_18_clk _0200_ net95 VGND VGND VPWR VPWR u_jt49.periodC\[1\] sky130_fd_sc_hd__dfrtp_1
XPHY_EDGE_ROW_2_Right_2 VGND VGND VPWR VPWR sky130_fd_sc_hd__decap_3
XFILLER_25_321 VGND VPWR VPWR VGND sky130_ef_sc_hd__decap_12
XFILLER_20_85 VGND VGND VPWR VPWR sky130_fd_sc_hd__decap_4
Xhold94 u_jt49.u_chB.count\[11\] VGND VGND VPWR VPWR net200 sky130_fd_sc_hd__dlygate4sd3_1
Xhold50 u_jt49.regarray\[3\]\[7\] VGND VGND VPWR VPWR net156 sky130_fd_sc_hd__dlygate4sd3_1
Xhold61 u_jt49.regarray\[13\]\[6\] VGND VGND VPWR VPWR net167 sky130_fd_sc_hd__dlygate4sd3_1
XFILLER_28_170 VGND VGND VPWR VPWR sky130_fd_sc_hd__decap_4
Xhold72 u_jt49.u_ng.poly17\[8\] VGND VGND VPWR VPWR net178 sky130_fd_sc_hd__dlygate4sd3_1
Xhold83 _0082_ VGND VGND VPWR VPWR net189 sky130_fd_sc_hd__dlygate4sd3_1
XFILLER_45_60 VGND VGND VPWR VPWR sky130_fd_sc_hd__decap_6
XFILLER_16_343 VGND VPWR VPWR VGND sky130_ef_sc_hd__decap_12
XFILLER_16_365 VGND VPWR VPWR VGND sky130_ef_sc_hd__decap_12
XFILLER_61_81 VGND VPWR VPWR VGND sky130_ef_sc_hd__decap_12
X_1641_ clknet_leaf_13_clk _0058_ net104 VGND VGND VPWR VPWR u_jt49.u_envdiv.count\[6\]
+ sky130_fd_sc_hd__dfrtp_1
XFILLER_6_65 VGND VGND VPWR VPWR sky130_fd_sc_hd__decap_6
X_1572_ u_jt49.regarray\[9\]\[3\] u_jt49.envelope\[4\] u_jt49.regarray\[9\]\[4\] VGND
+ VGND VPWR VPWR _0436_ sky130_fd_sc_hd__mux2_1
X_1710_ clknet_leaf_25_clk _0123_ net81 VGND VGND VPWR VPWR u_jt49.regarray\[13\]\[4\]
+ sky130_fd_sc_hd__dfrtp_1
XFILLER_34_151 VGND VGND VPWR VPWR sky130_fd_sc_hd__decap_4
XFILLER_26_129 VGND VGND VPWR VPWR sky130_fd_sc_hd__decap_8
X_1006_ u_jt49.u_ng.u_div.count\[4\] _0625_ VGND VGND VPWR VPWR _0627_ sky130_fd_sc_hd__xnor2_1
X_1839_ clknet_leaf_3_clk _0252_ net85 VGND VGND VPWR VPWR u_jt49.periodA\[6\] sky130_fd_sc_hd__dfrtp_1
XFILLER_22_368 VGND VGND VPWR VPWR sky130_fd_sc_hd__decap_8
XFILLER_31_73 VGND VPWR VPWR VGND sky130_ef_sc_hd__decap_12
Xclkbuf_leaf_28_clk clknet_2_0__leaf_clk VGND VGND VPWR VPWR clknet_leaf_28_clk sky130_fd_sc_hd__clkbuf_8
X_1624_ clknet_leaf_21_clk _0041_ net97 VGND VGND VPWR VPWR u_jt49.u_env.gain\[1\]
+ sky130_fd_sc_hd__dfstp_1
X_1555_ net221 net71 _0430_ VGND VGND VPWR VPWR _0246_ sky130_fd_sc_hd__mux2_1
XFILLER_54_235 VGND VPWR VPWR VGND sky130_ef_sc_hd__decap_12
XFILLER_39_221 VGND VGND VPWR VPWR sky130_fd_sc_hd__decap_3
XFILLER_36_29 VGND VPWR VPWR VGND sky130_ef_sc_hd__decap_12
X_1486_ u_jt49.periodC\[8\] net72 _0416_ VGND VGND VPWR VPWR _0191_ sky130_fd_sc_hd__mux2_1
Xclkbuf_leaf_19_clk clknet_2_2__leaf_clk VGND VGND VPWR VPWR clknet_leaf_19_clk sky130_fd_sc_hd__clkbuf_8
XFILLER_6_309 VGND VGND VPWR VPWR sky130_fd_sc_hd__decap_3
XPHY_EDGE_ROW_15_Left_81 VGND VGND VPWR VPWR sky130_fd_sc_hd__decap_3
XFILLER_13_121 VGND VGND VPWR VPWR sky130_fd_sc_hd__decap_6
X_1340_ _0491_ u_jt49.periodA\[7\] _0342_ _0360_ VGND VGND VPWR VPWR _0361_ sky130_fd_sc_hd__a22o_1
X_1271_ _0459_ u_jt49.periodB\[7\] _0301_ _0302_ _0304_ VGND VGND VPWR VPWR _0305_
+ sky130_fd_sc_hd__a221o_1
XFILLER_51_205 VGND VPWR VPWR VGND sky130_ef_sc_hd__decap_12
Xwire39 _0693_ VGND VGND VPWR VPWR net39 sky130_fd_sc_hd__clkbuf_1
XFILLER_36_246 VGND VGND VPWR VPWR sky130_fd_sc_hd__decap_6
X_0986_ net57 net28 _0611_ VGND VGND VPWR VPWR _0011_ sky130_fd_sc_hd__mux2_1
Xclkbuf_leaf_8_clk clknet_2_1__leaf_clk VGND VGND VPWR VPWR clknet_leaf_8_clk sky130_fd_sc_hd__clkbuf_8
XFILLER_59_349 VGND VGND VPWR VPWR sky130_fd_sc_hd__decap_8
Xfanout104 net105 VGND VGND VPWR VPWR net104 sky130_fd_sc_hd__clkbuf_4
X_1538_ u_jt49.periodA\[11\] net65 _0423_ VGND VGND VPWR VPWR _0236_ sky130_fd_sc_hd__mux2_1
X_1469_ net69 net201 _0414_ VGND VGND VPWR VPWR _0176_ sky130_fd_sc_hd__mux2_1
X_1607_ clknet_leaf_19_clk _0024_ net95 VGND VGND VPWR VPWR u_jt49.u_chC.count\[0\]
+ sky130_fd_sc_hd__dfstp_1
XFILLER_63_27 VGND VPWR VPWR VGND sky130_ef_sc_hd__decap_12
XFILLER_42_249 VGND VGND VPWR VPWR sky130_fd_sc_hd__decap_3
XPHY_EDGE_ROW_0_Left_66 VGND VGND VPWR VPWR sky130_fd_sc_hd__decap_3
XFILLER_58_360 VGND VGND VPWR VPWR sky130_fd_sc_hd__decap_4
X_0840_ u_jt49.u_chA.count\[8\] VGND VGND VPWR VPWR _0490_ sky130_fd_sc_hd__inv_2
XFILLER_38_3 VGND VPWR VPWR VGND sky130_ef_sc_hd__decap_12
X_1323_ u_jt49.u_chA.count\[6\] u_jt49.periodA\[6\] VGND VGND VPWR VPWR _0344_ sky130_fd_sc_hd__and2b_1
X_1185_ _0482_ _0767_ VGND VGND VPWR VPWR _0770_ sky130_fd_sc_hd__nand2_1
X_1254_ u_jt49.u_chB.count\[11\] u_jt49.periodB\[11\] VGND VGND VPWR VPWR _0288_ sky130_fd_sc_hd__nand2b_1
X_0969_ u_jt49.regarray\[6\]\[7\] _0526_ net35 u_jt49.regarray\[1\]\[7\] VGND VGND
+ VPWR VPWR _0605_ sky130_fd_sc_hd__a22o_1
XFILLER_59_113 VGND VPWR VPWR VGND sky130_ef_sc_hd__decap_12
XFILLER_15_216 VGND VGND VPWR VPWR sky130_fd_sc_hd__decap_8
XPHY_EDGE_ROW_36_Left_102 VGND VGND VPWR VPWR sky130_fd_sc_hd__decap_3
XFILLER_23_52 VGND VGND VPWR VPWR sky130_fd_sc_hd__decap_4
XFILLER_2_197 VGND VGND VPWR VPWR sky130_fd_sc_hd__decap_4
XFILLER_65_116 VGND VPWR VPWR VGND sky130_ef_sc_hd__decap_12
XPHY_EDGE_ROW_45_Left_111 VGND VGND VPWR VPWR sky130_fd_sc_hd__decap_3
XPHY_EDGE_ROW_54_Left_120 VGND VGND VPWR VPWR sky130_fd_sc_hd__decap_3
X_1872_ clknet_leaf_21_clk net110 VGND VGND VPWR VPWR C[1] sky130_fd_sc_hd__dfxtp_2
X_0823_ net204 VGND VGND VPWR VPWR _0473_ sky130_fd_sc_hd__inv_2
X_1306_ u_jt49.u_chB.count\[9\] _0327_ VGND VGND VPWR VPWR _0331_ sky130_fd_sc_hd__or2_1
XFILLER_52_377 VGND VGND VPWR VPWR sky130_fd_sc_hd__decap_8
X_1237_ u_jt49.u_ng.poly17\[11\] u_jt49.u_ng.poly17\[10\] u_jt49.u_ng.poly17\[13\]
+ u_jt49.u_ng.poly17\[12\] VGND VGND VPWR VPWR _0275_ sky130_fd_sc_hd__or4_1
X_1168_ u_jt49.u_ng.noise_en net128 _0757_ VGND VGND VPWR VPWR _0051_ sky130_fd_sc_hd__mux2_1
X_1099_ u_jt49.u_env.inv _0702_ _0701_ VGND VGND VPWR VPWR _0037_ sky130_fd_sc_hd__mux2_1
XFILLER_59_81 VGND VPWR VPWR VGND sky130_ef_sc_hd__decap_12
XFILLER_38_105 VGND VPWR VPWR VGND sky130_ef_sc_hd__decap_12
X_1022_ u_jt49.periodC\[7\] u_jt49.u_chC.count\[7\] VGND VGND VPWR VPWR _0639_ sky130_fd_sc_hd__and2b_1
X_1855_ clknet_leaf_27_clk net116 VGND VGND VPWR VPWR A[2] sky130_fd_sc_hd__dfxtp_2
X_0806_ u_jt49.periodB\[10\] VGND VGND VPWR VPWR _0456_ sky130_fd_sc_hd__inv_2
XFILLER_39_18 VGND VPWR VPWR VGND sky130_ef_sc_hd__decap_12
X_1786_ clknet_leaf_19_clk _0199_ net93 VGND VGND VPWR VPWR u_jt49.periodC\[0\] sky130_fd_sc_hd__dfrtp_1
XFILLER_25_333 VGND VGND VPWR VPWR sky130_fd_sc_hd__decap_3
Xhold40 u_jt49.regarray\[8\]\[7\] VGND VGND VPWR VPWR net146 sky130_fd_sc_hd__dlygate4sd3_1
Xhold51 u_jt49.regarray\[10\]\[6\] VGND VGND VPWR VPWR net157 sky130_fd_sc_hd__dlygate4sd3_1
Xhold62 u_jt49.regarray\[13\]\[7\] VGND VGND VPWR VPWR net168 sky130_fd_sc_hd__dlygate4sd3_1
Xhold84 u_jt49.u_ng.poly17\[11\] VGND VGND VPWR VPWR net190 sky130_fd_sc_hd__dlygate4sd3_1
Xhold73 u_jt49.u_ng.poly17\[1\] VGND VGND VPWR VPWR net179 sky130_fd_sc_hd__dlygate4sd3_1
XFILLER_16_355 VGND VGND VPWR VPWR sky130_fd_sc_hd__decap_8
Xhold95 u_jt49.regarray\[7\]\[1\] VGND VGND VPWR VPWR net201 sky130_fd_sc_hd__dlygate4sd3_1
XFILLER_61_93 VGND VPWR VPWR VGND sky130_ef_sc_hd__decap_12
XFILLER_31_303 VGND VGND VPWR VPWR sky130_fd_sc_hd__decap_8
XFILLER_16_377 VGND VGND VPWR VPWR sky130_fd_sc_hd__decap_8
X_1640_ clknet_leaf_15_clk _0057_ net104 VGND VGND VPWR VPWR u_jt49.u_envdiv.count\[5\]
+ sky130_fd_sc_hd__dfrtp_1
X_1571_ net74 net117 _0432_ _0435_ VGND VGND VPWR VPWR _0257_ sky130_fd_sc_hd__a22o_1
XFILLER_20_3 VGND VPWR VPWR VGND sky130_ef_sc_hd__decap_12
X_1005_ _0619_ _0625_ _0626_ VGND VGND VPWR VPWR _0015_ sky130_fd_sc_hd__and3_1
X_1838_ clknet_leaf_1_clk _0251_ net79 VGND VGND VPWR VPWR u_jt49.periodA\[5\] sky130_fd_sc_hd__dfrtp_1
X_1769_ clknet_leaf_9_clk _0182_ net87 VGND VGND VPWR VPWR IOB_oe sky130_fd_sc_hd__dfrtp_4
XFILLER_31_85 VGND VPWR VPWR VGND sky130_ef_sc_hd__decap_12
XFILLER_63_225 VGND VPWR VPWR VGND sky130_ef_sc_hd__decap_12
X_1485_ net42 _0528_ VGND VGND VPWR VPWR _0416_ sky130_fd_sc_hd__and2_2
X_1554_ net41 _0520_ VGND VGND VPWR VPWR _0430_ sky130_fd_sc_hd__and2_2
X_1623_ clknet_leaf_21_clk _0040_ net97 VGND VGND VPWR VPWR u_jt49.u_env.gain\[0\]
+ sky130_fd_sc_hd__dfstp_1
C0 net44 VPWR 6.25962f
C1 _0527_ VPWR 4.18936f
C2 VPWR clknet_leaf_7_clk 2.53534f
C3 clknet_leaf_29_clk VPWR 2.79884f
C4 clknet_leaf_3_clk VPWR 2.14675f
C5 net105 clknet_2_3__leaf_clk 2.46047f
C6 clknet_leaf_11_clk clknet_2_3__leaf_clk 2.11045f
C7 VPWR net6 11.76971f
C8 _0527_ u_jt49.periodC\[6\] 2.06222f
C9 din_latch\[5\] VPWR 2.34815f
C10 VPWR clknet_leaf_17_clk 2.24698f
C11 net36 VPWR 2.12698f
C12 VPWR u_jt49.regarray\[10\]\[4\] 2.67038f
C13 VPWR u_jt49.periodA\[3\] 4.02186f
C14 VPWR _0608_ 2.04355f
C15 net41 clknet_2_1__leaf_clk 2.04902f
C16 _0544_ VPWR 2.61342f
C17 u_jt49.eg_period\[8\] VPWR 5.19689f
C18 VPWR _0418_ 4.9527f
C19 VPWR _0413_ 4.03261f
C20 net44 _0553_ 2.1121f
C21 u_jt49.regarray\[13\]\[2\] _0522_ 2.14914f
C22 VPWR u_jt49.periodB\[3\] 2.27691f
C23 u_jt49.eg_period\[13\] net61 2.58943f
C24 VPWR u_jt49.regarray\[10\]\[1\] 2.08253f
C25 _0266_ VPWR 4.97946f
C26 net63 VPWR 7.32991f
C27 VPWR u_jt49.envelope\[0\] 4.06809f
C28 _0504_ _0662_ 2.21114f
C29 _0272_ _0543_ 2.77359f
C30 net66 net68 2.10499f
C31 clknet_leaf_4_clk VPWR 6.68826f
C32 u_jt49.u_chC.count\[8\] VPWR 2.24034f
C33 _0269_ VPWR 3.19943f
C34 VPWR u_jt49.periodC\[4\] 3.08633f
C35 VPWR u_jt49.eg_period\[11\] 5.11612f
C36 _0530_ VPWR 4.31634f
C37 u_jt49.regarray\[10\]\[2\] VPWR 4.33464f
C38 VPWR net21 2.33289f
C39 din_latch\[7\] VPWR 3.29638f
C40 u_jt49.eg_period\[15\] VPWR 3.69727f
C41 VPWR net16 3.67944f
C42 VPWR u_jt49.u_chC.count\[6\] 2.41137f
C43 net42 VPWR 8.67414f
C44 net58 VPWR 4.813f
C45 u_jt49.regarray\[13\]\[2\] VPWR 6.576f
C46 u_jt49.periodC\[8\] VPWR 2.49757f
C47 addr\[0\] VPWR 2.25103f
C48 _0522_ VPWR 4.29048f
C49 VPWR net43 3.83356f
C50 net85 VPWR 2.81733f
C51 VPWR net7 6.08507f
C52 VPWR _0551_ 2.68628f
C53 u_jt49.write VPWR 2.40836f
C54 u_jt49.eg_period\[3\] _0570_ 2.62725f
C55 VPWR net81 2.40754f
C56 VPWR net14 2.32877f
C57 VPWR _0531_ 2.6749f
C58 VPWR _0591_ 5.09219f
C59 VPWR _0421_ 2.00473f
C60 u_jt49.periodC\[3\] VPWR 3.78182f
C61 VPWR u_jt49.periodB\[5\] 3.00049f
C62 _0536_ VPWR 3.01148f
C63 net73 VPWR 3.68772f
C64 net26 VPWR 2.73989f
C65 u_jt49.eg_period\[5\] VPWR 3.24253f
C66 VPWR net71 7.16953f
C67 net91 VPWR 3.65716f
C68 net67 VPWR 11.70136f
C69 _0528_ VPWR 2.28185f
C70 _0417_ VPWR 2.26422f
C71 VPWR u_jt49.periodB\[1\] 3.01746f
C72 _0308_ VPWR 2.0303f
C73 net13 VPWR 4.78629f
C74 u_jt49.periodC\[6\] VPWR 5.20912f
C75 u_jt49.eg_period\[5\] clknet_2_3__leaf_clk 2.3388f
C76 VPWR _0589_ 5.50357f
C77 VPWR net9 4.43838f
C78 din_latch\[0\] VPWR 4.94297f
C79 _0695_ net64 2.48841f
C80 clk VPWR 4.55445f
C81 VPWR net12 4.41073f
C82 VPWR net62 4.15637f
C83 VPWR clknet_2_3__leaf_clk 5.06329f
C84 _0520_ _0522_ 2.01094f
C85 u_jt49.eg_period\[7\] VPWR 2.60193f
C86 clknet_leaf_6_clk VPWR 3.18327f
C87 net3 VPWR 16.5602f
C88 u_jt49.periodC\[1\] VPWR 2.98176f
C89 net4 VPWR 8.3413f
C90 net80 VPWR 2.45121f
C91 _0419_ VPWR 3.55505f
C92 VPWR u_jt49.eg_period\[6\] 2.29712f
C93 _0520_ VPWR 3.06524f
C94 u_jt49.periodA\[8\] VPWR 2.1922f
C95 _0521_ _0542_ 2.41148f
C96 u_jt49.periodC\[5\] VPWR 2.24122f
C97 net5 VPWR 5.21018f
C98 net82 clknet_leaf_25_clk 2.26005f
C99 VPWR clknet_leaf_26_clk 5.10441f
C100 VPWR u_jt49.periodB\[6\] 4.17978f
C101 net42 net97 2.66778f
C102 clknet_leaf_20_clk VPWR 3.28083f
C103 _0408_ VPWR 2.17541f
C104 net106 _0545_ 2.40976f
C105 _0415_ VPWR 3.30219f
C106 u_jt49.periodC\[11\] VPWR 2.69639f
C107 VPWR clknet_2_2__leaf_clk 4.23256f
C108 net11 VPWR 5.26504f
C109 VPWR net59 7.79151f
C110 net35 VPWR 4.49621f
C111 VPWR net2 13.59797f
C112 _0662_ VPWR 3.71431f
C113 u_jt49.periodA\[11\] VPWR 4.27505f
C114 VPWR net57 19.06858f
C115 _0547_ u_jt49.periodB\[2\] 2.66779f
C116 clknet_0_clk VPWR 6.06579f
C117 VPWR u_jt49.periodC\[10\] 3.55625f
C118 VPWR net64 10.42416f
C119 u_jt49.periodC\[7\] VPWR 2.22425f
C120 net66 VPWR 3.27108f
C121 VPWR u_jt49.eg_period\[10\] 4.01428f
C122 _0407_ VPWR 4.1686f
C123 u_jt49.regarray\[8\]\[4\] VPWR 2.67566f
C124 _0580_ _0545_ 2.06889f
C125 u_jt49.periodB\[11\] VPWR 2.4278f
C126 net25 VPWR 3.53559f
C127 u_jt49.regarray\[13\]\[2\] u_jt49.periodC\[9\] 3.22688f
C128 VPWR net97 3.29594f
C129 net41 VPWR 4.64173f
C130 VPWR clknet_leaf_21_clk 4.00072f
C131 _0441_ VPWR 2.32286f
C132 VPWR net8 6.36946f
C133 VPWR _0414_ 5.22117f
C134 VPWR net70 7.17117f
C135 VPWR clknet_leaf_1_clk 2.50218f
C136 VPWR clknet_leaf_24_clk 3.20044f
C137 u_jt49.write net30 2.18298f
C138 _0540_ _0528_ 2.67646f
C139 din_latch\[1\] VPWR 2.62546f
C140 din_latch\[6\] VPWR 2.86646f
C141 VPWR _0410_ 3.04687f
C142 clknet_leaf_0_clk VPWR 2.56109f
C143 clknet_leaf_28_clk VPWR 3.69281f
C144 _0545_ _0544_ 2.37899f
C145 u_jt49.eg_period\[13\] VPWR 2.09143f
C146 VPWR u_jt49.periodB\[10\] 4.54327f
C147 net15 VPWR 4.04711f
C148 _0409_ VPWR 2.02552f
C149 u_jt49.bitB VPWR 4.06888f
C150 clknet_leaf_10_clk VPWR 2.68593f
C151 VPWR clknet_leaf_23_clk 4.41896f
C152 VPWR _0529_ 3.39765f
C153 u_jt49.eg_period\[1\] u_jt49.eg_period\[2\] 2.05941f
C154 net81 _0423_ 2.29165f
C155 VPWR u_jt49.eg_period\[4\] 2.34706f
C156 net95 VPWR 4.77605f
C157 VPWR net45 6.97227f
C158 VPWR clknet_2_0__leaf_clk 5.34307f
C159 VPWR net61 16.6623f
C160 net83 VPWR 4.60334f
C161 u_jt49.regarray\[13\]\[3\] VPWR 5.53621f
C162 u_jt49.periodC\[9\] VPWR 2.74217f
C163 VPWR _0412_ 2.04778f
C164 VPWR clknet_2_1__leaf_clk 6.63559f
C165 net79 VPWR 2.41176f
C166 net65 net71 2.08254f
C167 VPWR net10 2.89176f
C168 VPWR net104 4.21885f
C169 _0525_ _0588_ 2.35783f
C170 VPWR net20 12.9753f
C171 net65 VPWR 11.44871f
C172 VPWR _0423_ 2.75852f
C173 VPWR net84 2.43712f
C174 VPWR net60 10.62691f
C175 VPWR net24 4.02589f
C176 _0521_ VPWR 3.57954f
C177 clknet_leaf_27_clk VPWR 3.93784f
C178 net100 VPWR 2.48454f
C179 VPWR _0416_ 5.57573f
C180 net20 clknet_2_3__leaf_clk 3.38454f
C181 _0479_ VPWR 2.77486f
C182 VPWR _0370_ 4.79121f
C183 u_jt49.eg_period\[3\] VPWR 3.19717f
C184 net1 VPWR 18.32593f
C185 u_jt49.periodC\[11\] u_jt49.periodC\[10\] 3.03176f
C186 din_latch\[2\] VPWR 4.79981f
C187 net94 VPWR 3.24668f
C188 VPWR net68 9.24965f
C189 _0611_ VPWR 6.53047f
C190 net86 VPWR 3.03974f
C191 u_jt49.periodB\[8\] VPWR 4.46999f
C192 VPWR clknet_leaf_15_clk 6.06727f
C193 net4 net20 2.4353f
C194 _0504_ VPWR 3.75747f
C195 VPWR u_jt49.u_env.gain\[1\] 2.46923f
C196 _0523_ VPWR 3.51326f
C197 _0545_ VPWR 10.91024f
C198 VPWR net32 6.64571f
C199 u_jt49.periodB\[9\] VPWR 3.92838f
C200 VPWR clknet_leaf_8_clk 2.65142f
C201 VPWR u_jt49.eg_period\[2\] 4.80869f
C202 VPWR sample 17.17968f
C203 net106 net91 5.1143f
C204 net72 VPWR 4.22498f
C205 VPWR net47 4.56246f
C206 net92 net7 2.37473f
C207 VPWR _0507_ 4.34878f
C208 net106 VPWR 6.52039f
C209 clknet_leaf_9_clk VPWR 2.10406f
C210 u_jt49.periodC\[8\] u_jt49.regarray\[10\]\[4\] 2.8166f
C211 VPWR net31 4.41034f
C212 net105 VPWR 7.53286f
C213 net69 VPWR 9.50256f
C214 _0482_ VPWR 2.20769f
C215 _0786_ u_jt49.u_envdiv.count\[13\] 2.31122f
C216 _0542_ VPWR 2.53439f
C217 VPWR _0430_ 3.45273f
C218 VPWR net87 5.68897f
C219 u_jt49.regarray\[8\]\[4\] clknet_leaf_25_clk 2.06091f
C220 VPWR IOA_oe 7.92583f
C221 VPWR _0524_ 9.64727f
C222 net78 VPWR 2.02859f
C223 net49 VPWR 2.19734f
C224 VPWR IOB_oe 5.13052f
C225 net102 VPWR 2.47248f
C226 IOB_oe VGND 5.33575f
C227 _0423_ VGND 6.26422f
C228 _0430_ VGND 3.32322f
C229 clknet_2_0__leaf_clk VGND 8.97357f
C230 u_jt49.envelope\[4\] VGND 3.8555f
C231 clknet_leaf_18_clk VGND 4.36092f
C232 clknet_leaf_21_clk VGND 8.25552f
C233 u_jt49.periodB\[1\] VGND 3.10118f
C234 u_jt49.u_chC.count\[1\] VGND 2.30965f
C235 u_jt49.periodC\[2\] VGND 2.74254f
C236 net97 VGND 4.2977f
C237 net28 VGND 2.33328f
C238 u_jt49.periodA\[1\] VGND 2.97673f
C239 clknet_2_3__leaf_clk VGND 8.30631f
C240 u_jt49.regarray\[10\]\[3\] VGND 4.63652f
C241 u_jt49.regarray\[10\]\[4\] VGND 3.58558f
C242 net99 VGND 5.46859f
C243 net10 VGND 6.49755f
C244 net2 VGND 2.28907f
C245 u_jt49.eg_period\[11\] VGND 2.97561f
C246 u_jt49.regarray\[10\]\[1\] VGND 4.10909f
C247 clknet_leaf_24_clk VGND 4.7387f
C248 _0660_ VGND 2.49253f
C249 sample VGND 14.23115f
C250 _0524_ VGND 5.06156f
C251 u_jt49.eg_period\[2\] VGND 2.9135f
C252 net74 VGND 5.45983f
C253 _0438_ VGND 2.67933f
C254 clknet_2_1__leaf_clk VGND 6.7868f
C255 u_jt49.periodC\[10\] VGND 3.26816f
C256 u_jt49.u_chB.count\[0\] VGND 2.02315f
C257 net22 VGND 2.26425f
C258 _0507_ VGND 6.57922f
C259 net60 VGND 9.66369f
C260 net51 VGND 3.48942f
C261 _0370_ VGND 3.82769f
C262 u_jt49.u_chC.count\[2\] VGND 2.13562f
C263 clknet_leaf_15_clk VGND 3.82387f
C264 _0531_ VGND 3.25961f
C265 u_jt49.periodB\[2\] VGND 4.80075f
C266 net31 VGND 7.46015f
C267 _0572_ VGND 3.18611f
C268 net70 VGND 8.11153f
C269 _0412_ VGND 5.60666f
C270 net93 VGND 2.90784f
C271 net104 VGND 10.96031f
C272 _0532_ VGND 2.95285f
C273 net68 VGND 4.41117f
C274 _0410_ VGND 3.62184f
C275 net89 VGND 3.80968f
C276 clknet_leaf_8_clk VGND 6.76331f
C277 clknet_leaf_14_clk VGND 3.46608f
C278 _0529_ VGND 3.65364f
C279 u_jt49.eg_period\[10\] VGND 2.51582f
C280 _0418_ VGND 6.69641f
C281 clknet_leaf_26_clk VGND 4.66797f
C282 clknet_leaf_7_clk VGND 7.3296f
C283 net64 VGND 8.82969f
C284 IOB_out[1] VGND 2.34991f
C285 net14 VGND 3.3064f
C286 net6 VGND 5.40743f
C287 clknet_leaf_1_clk VGND 3.71934f
C288 net90 VGND 3.37028f
C289 _0677_ VGND 2.48981f
C290 net81 VGND 3.62621f
C291 u_jt49.eg_period\[12\] VGND 6.22221f
C292 IOB_out[2] VGND 2.68767f
C293 _0591_ VGND 3.85167f
C294 _0396_ VGND 2.25444f
C295 _0414_ VGND 4.96153f
C296 net62 VGND 8.74115f
C297 _0480_ VGND 2.41026f
C298 u_jt49.eg_period\[4\] VGND 3.45555f
C299 IOA_oe VGND 5.48987f
C300 net96 VGND 2.35446f
C301 u_jt49.periodB\[4\] VGND 4.90301f
C302 _0421_ VGND 2.79128f
C303 clknet_leaf_25_clk VGND 2.57756f
C304 _0416_ VGND 3.43569f
C305 net82 VGND 4.68236f
C306 net32 VGND 5.45023f
C307 clknet_leaf_23_clk VGND 6.01056f
C308 net56 VGND 2.97056f
C309 u_jt49.periodB\[6\] VGND 2.42032f
C310 u_jt49.u_env.cen VGND 6.08412f
C311 net61 VGND 8.64766f
C312 net8 VGND 4.65798f
C313 net20 VGND 12.88029f
C314 net59 VGND 9.52172f
C315 net130 VGND 2.09267f
C316 net45 VGND 8.39526f
C317 clknet_leaf_22_clk VGND 4.74768f
C318 net103 VGND 4.41409f
C319 clknet_leaf_17_clk VGND 3.04231f
C320 u_jt49.eg_period\[6\] VGND 4.18117f
C321 u_jt49.noise VGND 5.11194f
C322 net43 VGND 4.31994f
C323 u_jt49.periodB\[7\] VGND 2.04755f
C324 u_jt49.periodB\[5\] VGND 2.27384f
C325 net71 VGND 12.1821f
C326 _0413_ VGND 3.8324f
C327 net7 VGND 5.67897f
C328 net33 VGND 3.59997f
C329 net47 VGND 6.76805f
C330 net57 VGND 11.25748f
C331 net87 VGND 2.6578f
C332 clknet_2_2__leaf_clk VGND 8.64215f
C333 u_jt49.u_env.inv VGND 2.51748f
C334 net84 VGND 5.54642f
C335 VPWR VGND 2.89667p
C336 net75 VGND 5.15391f
C337 clknet_leaf_29_clk VGND 4.49508f
C338 u_jt49.regarray\[6\]\[4\] VGND 2.74473f
C339 u_jt49.periodB\[11\] VGND 3.24282f
C340 _0542_ VGND 4.52566f
C341 _0521_ VGND 3.40596f
C342 u_jt49.periodA\[2\] VGND 2.82928f
C343 _0415_ VGND 3.74738f
C344 u_jt49.regarray\[8\]\[0\] VGND 5.17291f
C345 u_jt49.regarray\[8\]\[4\] VGND 2.84055f
C346 net50 VGND 2.75669f
C347 u_jt49.regarray\[9\]\[3\] VGND 3.34506f
C348 u_jt49.regarray\[9\]\[4\] VGND 2.95308f
C349 net36 VGND 2.96886f
C350 _0267_ VGND 5.82718f
C351 u_jt49.regarray\[6\]\[1\] VGND 2.17868f
C352 net55 VGND 2.7679f
C353 net53 VGND 2.59669f
C354 net49 VGND 2.76897f
C355 net5 VGND 8.80778f
C356 _0462_ VGND 2.6398f
C357 _0425_ VGND 2.21608f
C358 net48 VGND 2.13884f
C359 _0268_ VGND 3.53558f
C360 clknet_leaf_28_clk VGND 5.02176f
C361 net4 VGND 8.60641f
C362 net67 VGND 14.43398f
C363 u_jt49.envelope\[2\] VGND 2.52988f
C364 _0417_ VGND 3.52526f
C365 net73 VGND 3.81276f
C366 _0432_ VGND 3.4707f
C367 clknet_leaf_30_clk VGND 2.26106f
C368 u_jt49.regarray\[10\]\[2\] VGND 2.90893f
C369 clknet_leaf_12_clk VGND 2.36775f
C370 u_jt49.u_chC.count\[5\] VGND 3.08059f
C371 u_jt49.periodC\[3\] VGND 6.54517f
C372 u_jt49.regarray\[6\]\[0\] VGND 2.26662f
C373 _0544_ VGND 3.27825f
C374 _0545_ VGND 8.12577f
C375 _0662_ VGND 6.88369f
C376 u_jt49.periodA\[11\] VGND 2.49481f
C377 _0408_ VGND 2.71403f
C378 din_latch\[2\] VGND 2.76296f
C379 clknet_leaf_13_clk VGND 5.24557f
C380 u_jt49.periodC\[7\] VGND 5.48509f
C381 u_jt49.periodC\[6\] VGND 2.17161f
C382 u_jt49.periodA\[9\] VGND 4.63487f
C383 _0526_ VGND 2.41583f
C384 _0663_ VGND 2.19049f
C385 u_jt49.periodA\[10\] VGND 2.29266f
C386 _0561_ VGND 2.10667f
C387 u_jt49.periodB\[0\] VGND 3.71056f
C388 clknet_leaf_11_clk VGND 2.18919f
C389 net76 VGND 4.38332f
C390 _0271_ VGND 2.44711f
C391 clknet_leaf_6_clk VGND 3.80715f
C392 u_jt49.eg_period\[1\] VGND 2.26668f
C393 net1 VGND 4.25259f
C394 _0409_ VGND 3.40164f
C395 net79 VGND 4.03141f
C396 net94 VGND 4.98346f
C397 u_jt49.periodA\[7\] VGND 3.72497f
C398 net11 VGND 2.3277f
C399 net3 VGND 2.49473f
C400 net44 VGND 7.47891f
C401 net91 VGND 5.59194f
C402 net105 VGND 7.67758f
C403 _0533_ VGND 5.7613f
C404 net41 VGND 5.01833f
C405 net77 VGND 3.1396f
C406 net92 VGND 4.64883f
C407 u_jt49.periodC\[9\] VGND 2.47168f
C408 u_jt49.periodC\[11\] VGND 3.60683f
C409 u_jt49.u_envdiv.count\[0\] VGND 2.10898f
C410 u_jt49.write VGND 3.02594f
C411 _0308_ VGND 3.91145f
C412 net72 VGND 8.54657f
C413 _0720_ VGND 2.36602f
C414 clknet_leaf_4_clk VGND 6.27101f
C415 _0407_ VGND 4.84158f
C416 _0522_ VGND 3.23725f
C417 _0527_ VGND 5.26684f
C418 _0681_ VGND 2.86935f
C419 _0504_ VGND 3.93031f
C420 clknet_0_clk VGND 4.74699f
C421 u_jt49.eg_period\[9\] VGND 4.15788f
C422 net18 VGND 2.17218f
C423 u_jt49.eg_period\[13\] VGND 2.08508f
C424 net86 VGND 6.15727f
C425 net52 VGND 2.63974f
C426 _0411_ VGND 2.94999f
C427 u_jt49.eg_period\[14\] VGND 2.54142f
C428 net100 VGND 6.75771f
C429 net69 VGND 11.38316f
C430 clk VGND 2.55802f
C431 net85 VGND 4.12001f
C432 clknet_leaf_3_clk VGND 4.28238f
C433 u_jt49.eg_period\[3\] VGND 4.40642f
C434 _0479_ VGND 2.00156f
C435 net106 VGND 23.6086f
C436 din_latch\[0\] VGND 2.67584f
C437 din_latch\[5\] VGND 2.36012f
C438 net66 VGND 13.70661f
C439 u_jt49.u_ng.poly17\[8\] VGND 2.01008f
C440 _0525_ VGND 4.179f
C441 _0520_ VGND 4.07031f
C442 _0695_ VGND 2.58374f
C443 _0523_ VGND 8.95479f
C444 net78 VGND 5.62665f
C445 u_jt49.eg_period\[5\] VGND 5.18204f
C446 _0530_ VGND 2.66112f
C447 u_jt49.regarray\[13\]\[1\] VGND 3.67074f
C448 din_latch\[1\] VGND 4.32038f
C449 net46 VGND 3.57254f
C450 _0528_ VGND 5.7228f
C451 u_jt49.periodC\[8\] VGND 4.30923f
C452 _0599_ VGND 3.13267f
C453 u_jt49.bitA VGND 2.55418f
C454 u_jt49.bitB VGND 2.27221f
C455 clknet_leaf_5_clk VGND 2.25929f
C456 net65 VGND 6.63561f
C457 clknet_leaf_0_clk VGND 3.57766f
C458 u_jt49.u_envdiv.count\[2\] VGND 2.48841f
C459 net83 VGND 4.94116f
C460 net35 VGND 2.89344f
C461 _0611_ VGND 11.05892f
C462 net102 VGND 5.66181f
C463 clknet_leaf_16_clk VGND 2.66266f
C464 net63 VGND 15.72092f
C465 u_jt49.regarray\[8\]\[2\] VGND 2.4978f
C466 net58 VGND 11.11032f
C467 u_jt49.periodB\[8\] VGND 4.72972f
C468 clknet_leaf_19_clk VGND 4.03978f
C469 net98 VGND 3.93733f
C470 clknet_leaf_10_clk VGND 3.71162f
C471 net42 VGND 8.75996f
C472 u_jt49.u_env.rst_latch VGND 5.72314f
C473 net37 VGND 2.00468f
C474 _0419_ VGND 2.5027f
C475 u_jt49.eg_period\[8\] VGND 2.57544f
C476 net25 VGND 3.16445f
C477 net121 VGND 4.26728f
C478 clknet_leaf_27_clk VGND 6.30582f
C479 net80 VGND 5.61479f
C480 _0273_ VGND 2.8676f
C481 _0603_ VGND 3.18078f
C482 u_jt49.eg_period\[7\] VGND 2.27745f
C483 clknet_leaf_2_clk VGND 4.87571f
C484 clknet_leaf_9_clk VGND 2.50533f
C485 u_jt49.u_chC.count\[9\] VGND 2.39505f
C486 u_jt49.eg_period\[15\] VGND 2.58661f
C487 net95 VGND 3.75614f
C488 clknet_leaf_20_clk VGND 4.86182f
.ends
