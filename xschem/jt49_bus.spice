* NGSPICE file created from jt49_bus.ext - technology: sky130A

.subckt sky130_fd_sc_hd__decap_4 VGND VNB VPB VPWR
X0 VPWR VGND VPWR VPB sky130_fd_pr__pfet_01v8_hvt ad=0.2262 pd=2.26 as=0.4524 ps=4.52 w=0.87 l=1.05
X1 VGND VPWR VGND VNB sky130_fd_pr__nfet_01v8 ad=0.143 pd=1.62 as=0.286 ps=3.24 w=0.55 l=1.05
.ends

.subckt sky130_fd_sc_hd__decap_8 VGND VNB VPB VPWR
X0 VPWR VGND VPWR VPB sky130_fd_pr__pfet_01v8_hvt ad=0.2262 pd=2.26 as=0.4524 ps=4.52 w=0.87 l=2.89
X1 VGND VPWR VGND VNB sky130_fd_pr__nfet_01v8 ad=0.143 pd=1.62 as=0.286 ps=3.24 w=0.55 l=2.89
.ends

.subckt sky130_ef_sc_hd__decap_12 VGND VPWR VPB VNB
X0 VPWR VGND VPWR VPB sky130_fd_pr__pfet_01v8_hvt ad=0.2262 pd=2.26 as=0.4524 ps=4.52 w=0.87 l=4.73
X1 VGND VPWR VGND VNB sky130_fd_pr__nfet_01v8 ad=0.143 pd=1.62 as=0.286 ps=3.24 w=0.55 l=4.73
.ends

.subckt sky130_fd_sc_hd__decap_3 VGND VNB VPB VPWR
X0 VPWR VGND VPWR VPB sky130_fd_pr__pfet_01v8_hvt ad=0.2262 pd=2.26 as=0.4524 ps=4.52 w=0.87 l=0.59
X1 VGND VPWR VGND VNB sky130_fd_pr__nfet_01v8 ad=0.143 pd=1.62 as=0.286 ps=3.24 w=0.55 l=0.59
.ends

.subckt sky130_fd_sc_hd__a21o_1 A1 A2 B1 VGND VNB VPB VPWR X
X0 a_81_21# B1 VGND VNB sky130_fd_pr__nfet_01v8 ad=0.08937 pd=0.925 as=0.25675 ps=1.44 w=0.65 l=0.15
X1 a_299_297# B1 a_81_21# VPB sky130_fd_pr__pfet_01v8_hvt ad=0.1375 pd=1.275 as=0.26 ps=2.52 w=1 l=0.15
X2 VPWR a_81_21# X VPB sky130_fd_pr__pfet_01v8_hvt ad=0.26 pd=2.52 as=0.26 ps=2.52 w=1 l=0.15
X3 VPWR A1 a_299_297# VPB sky130_fd_pr__pfet_01v8_hvt ad=0.14 pd=1.28 as=0.1375 ps=1.275 w=1 l=0.15
X4 VGND a_81_21# X VNB sky130_fd_pr__nfet_01v8 ad=0.25675 pd=1.44 as=0.169 ps=1.82 w=0.65 l=0.15
X5 VGND A2 a_384_47# VNB sky130_fd_pr__nfet_01v8 ad=0.17225 pd=1.83 as=0.091 ps=0.93 w=0.65 l=0.15
X6 a_299_297# A2 VPWR VPB sky130_fd_pr__pfet_01v8_hvt ad=0.265 pd=2.53 as=0.14 ps=1.28 w=1 l=0.15
X7 a_384_47# A1 a_81_21# VNB sky130_fd_pr__nfet_01v8 ad=0.091 pd=0.93 as=0.08937 ps=0.925 w=0.65 l=0.15
.ends

.subckt sky130_fd_sc_hd__dfrtp_2 CLK D RESET_B VGND VNB VPB VPWR Q
X0 a_805_47# a_761_289# a_639_47# VNB sky130_fd_pr__nfet_01v8 ad=0.0441 pd=0.63 as=0.1401 ps=1.1 w=0.42 l=0.15
X1 a_1217_47# a_27_47# a_1108_47# VNB sky130_fd_pr__special_nfet_01v8 ad=0.0669 pd=0.75 as=0.0711 ps=0.755 w=0.36 l=0.15
X2 VGND a_1283_21# Q VNB sky130_fd_pr__nfet_01v8 ad=0.169 pd=1.82 as=0.08775 ps=0.92 w=0.65 l=0.15
X3 a_1283_21# a_1108_47# a_1462_47# VNB sky130_fd_pr__nfet_01v8 ad=0.1092 pd=1.36 as=0.06405 ps=0.725 w=0.42 l=0.15
X4 a_651_413# a_27_47# a_543_47# VPB sky130_fd_pr__pfet_01v8_hvt ad=0.1155 pd=0.97 as=0.07245 ps=0.765 w=0.42 l=0.15
X5 VPWR a_1283_21# Q VPB sky130_fd_pr__pfet_01v8_hvt ad=0.26 pd=2.52 as=0.135 ps=1.27 w=1 l=0.15
X6 a_1108_47# a_193_47# a_761_289# VNB sky130_fd_pr__special_nfet_01v8 ad=0.0711 pd=0.755 as=0.0999 ps=0.985 w=0.36 l=0.15
X7 VGND RESET_B a_805_47# VNB sky130_fd_pr__nfet_01v8 ad=0.1346 pd=1.15 as=0.0441 ps=0.63 w=0.42 l=0.15
X8 Q a_1283_21# VPWR VPB sky130_fd_pr__pfet_01v8_hvt ad=0.135 pd=1.27 as=0.3012 ps=2.66 w=1 l=0.15
X9 VPWR CLK a_27_47# VPB sky130_fd_pr__pfet_01v8_hvt ad=0.0864 pd=0.91 as=0.1664 ps=1.8 w=0.64 l=0.15
X10 a_448_47# D VPWR VPB sky130_fd_pr__pfet_01v8_hvt ad=0.0651 pd=0.73 as=0.1092 ps=1.36 w=0.42 l=0.15
X11 a_761_289# a_543_47# VGND VNB sky130_fd_pr__nfet_01v8 ad=0.0999 pd=0.985 as=0.1346 ps=1.15 w=0.64 l=0.15
X12 a_193_47# a_27_47# VGND VNB sky130_fd_pr__nfet_01v8 ad=0.1092 pd=1.36 as=0.0567 ps=0.69 w=0.42 l=0.15
X13 a_1108_47# a_27_47# a_761_289# VPB sky130_fd_pr__pfet_01v8_hvt ad=0.0588 pd=0.7 as=0.12915 ps=1.185 w=0.42 l=0.15
X14 a_1462_47# RESET_B VGND VNB sky130_fd_pr__nfet_01v8 ad=0.06405 pd=0.725 as=0.12495 ps=1.015 w=0.42 l=0.15
X15 a_543_47# a_27_47# a_448_47# VNB sky130_fd_pr__special_nfet_01v8 ad=0.0594 pd=0.69 as=0.066 ps=0.745 w=0.36 l=0.15
X16 a_543_47# a_193_47# a_448_47# VPB sky130_fd_pr__pfet_01v8_hvt ad=0.07245 pd=0.765 as=0.0651 ps=0.73 w=0.42 l=0.15
X17 a_448_47# D VGND VNB sky130_fd_pr__nfet_01v8 ad=0.066 pd=0.745 as=0.2205 ps=1.89 w=0.42 l=0.15
X18 VPWR a_1283_21# a_1270_413# VPB sky130_fd_pr__pfet_01v8_hvt ad=0.0819 pd=0.81 as=0.0567 ps=0.69 w=0.42 l=0.15
X19 VPWR a_1108_47# a_1283_21# VPB sky130_fd_pr__pfet_01v8_hvt ad=0.1134 pd=1.38 as=0.0567 ps=0.69 w=0.42 l=0.15
X20 a_1270_413# a_193_47# a_1108_47# VPB sky130_fd_pr__pfet_01v8_hvt ad=0.0567 pd=0.69 as=0.0588 ps=0.7 w=0.42 l=0.15
X21 a_193_47# a_27_47# VPWR VPB sky130_fd_pr__pfet_01v8_hvt ad=0.1664 pd=1.8 as=0.0864 ps=0.91 w=0.64 l=0.15
X22 a_1283_21# RESET_B VPWR VPB sky130_fd_pr__pfet_01v8_hvt ad=0.0567 pd=0.69 as=0.0819 ps=0.81 w=0.42 l=0.15
X23 VPWR a_761_289# a_651_413# VPB sky130_fd_pr__pfet_01v8_hvt ad=0.07035 pd=0.755 as=0.1155 ps=0.97 w=0.42 l=0.15
X24 Q a_1283_21# VGND VNB sky130_fd_pr__nfet_01v8 ad=0.08775 pd=0.92 as=0.2087 ps=2.02 w=0.65 l=0.15
X25 a_639_47# a_193_47# a_543_47# VNB sky130_fd_pr__special_nfet_01v8 ad=0.1401 pd=1.1 as=0.0594 ps=0.69 w=0.36 l=0.15
X26 VGND a_1283_21# a_1217_47# VNB sky130_fd_pr__nfet_01v8 ad=0.12495 pd=1.015 as=0.0669 ps=0.75 w=0.42 l=0.15
X27 a_651_413# RESET_B VPWR VPB sky130_fd_pr__pfet_01v8_hvt ad=0.1092 pd=1.36 as=0.07035 ps=0.755 w=0.42 l=0.15
X28 VGND CLK a_27_47# VNB sky130_fd_pr__nfet_01v8 ad=0.0567 pd=0.69 as=0.1092 ps=1.36 w=0.42 l=0.15
X29 a_761_289# a_543_47# VPWR VPB sky130_fd_pr__pfet_01v8_hvt ad=0.12915 pd=1.185 as=0.2184 ps=2.2 w=0.84 l=0.15
.ends

.subckt sky130_fd_sc_hd__o221a_1 A1 A2 B1 B2 C1 VGND VNB VPB VPWR X
X0 a_240_47# A2 VGND VNB sky130_fd_pr__nfet_01v8 ad=0.08775 pd=0.92 as=0.169 ps=1.82 w=0.65 l=0.15
X1 X a_51_297# VGND VNB sky130_fd_pr__nfet_01v8 ad=0.182 pd=1.86 as=0.08775 ps=0.92 w=0.65 l=0.15
X2 VGND A1 a_240_47# VNB sky130_fd_pr__nfet_01v8 ad=0.08775 pd=0.92 as=0.08775 ps=0.92 w=0.65 l=0.15
X3 a_51_297# B2 a_245_297# VPB sky130_fd_pr__pfet_01v8_hvt ad=0.4125 pd=1.825 as=0.105 ps=1.21 w=1 l=0.15
X4 a_149_47# C1 a_51_297# VNB sky130_fd_pr__nfet_01v8 ad=0.09912 pd=0.955 as=0.2015 ps=1.92 w=0.65 l=0.15
X5 a_240_47# B1 a_149_47# VNB sky130_fd_pr__nfet_01v8 ad=0.08775 pd=0.92 as=0.09912 ps=0.955 w=0.65 l=0.15
X6 VPWR A1 a_512_297# VPB sky130_fd_pr__pfet_01v8_hvt ad=0.165 pd=1.33 as=0.105 ps=1.21 w=1 l=0.15
X7 X a_51_297# VPWR VPB sky130_fd_pr__pfet_01v8_hvt ad=0.28 pd=2.56 as=0.165 ps=1.33 w=1 l=0.15
X8 a_149_47# B2 a_240_47# VNB sky130_fd_pr__nfet_01v8 ad=0.169 pd=1.82 as=0.08775 ps=0.92 w=0.65 l=0.15
X9 a_245_297# B1 VPWR VPB sky130_fd_pr__pfet_01v8_hvt ad=0.105 pd=1.21 as=0.165 ps=1.33 w=1 l=0.15
X10 VPWR C1 a_51_297# VPB sky130_fd_pr__pfet_01v8_hvt ad=0.165 pd=1.33 as=0.34 ps=2.68 w=1 l=0.15
X11 a_512_297# A2 a_51_297# VPB sky130_fd_pr__pfet_01v8_hvt ad=0.105 pd=1.21 as=0.4125 ps=1.825 w=1 l=0.15
.ends

.subckt sky130_fd_sc_hd__clkbuf_4 A VGND VNB VPB VPWR X
X0 VPWR A a_27_47# VPB sky130_fd_pr__pfet_01v8_hvt ad=0.165 pd=1.33 as=0.265 ps=2.53 w=1 l=0.15
X1 VGND a_27_47# X VNB sky130_fd_pr__nfet_01v8 ad=0.1218 pd=1.42 as=0.0588 ps=0.7 w=0.42 l=0.15
X2 VGND a_27_47# X VNB sky130_fd_pr__nfet_01v8 ad=0.0588 pd=0.7 as=0.0588 ps=0.7 w=0.42 l=0.15
X3 X a_27_47# VPWR VPB sky130_fd_pr__pfet_01v8_hvt ad=0.14 pd=1.28 as=0.14 ps=1.28 w=1 l=0.15
X4 X a_27_47# VGND VNB sky130_fd_pr__nfet_01v8 ad=0.0588 pd=0.7 as=0.0588 ps=0.7 w=0.42 l=0.15
X5 VGND A a_27_47# VNB sky130_fd_pr__nfet_01v8 ad=0.07035 pd=0.755 as=0.1113 ps=1.37 w=0.42 l=0.15
X6 VPWR a_27_47# X VPB sky130_fd_pr__pfet_01v8_hvt ad=0.3 pd=2.6 as=0.14 ps=1.28 w=1 l=0.15
X7 X a_27_47# VGND VNB sky130_fd_pr__nfet_01v8 ad=0.0588 pd=0.7 as=0.07035 ps=0.755 w=0.42 l=0.15
X8 X a_27_47# VPWR VPB sky130_fd_pr__pfet_01v8_hvt ad=0.14 pd=1.28 as=0.165 ps=1.33 w=1 l=0.15
X9 VPWR a_27_47# X VPB sky130_fd_pr__pfet_01v8_hvt ad=0.14 pd=1.28 as=0.14 ps=1.28 w=1 l=0.15
.ends

.subckt sky130_fd_sc_hd__mux2_1 A0 A1 S VGND VNB VPB VPWR X
X0 VPWR a_505_21# a_535_374# VPB sky130_fd_pr__pfet_01v8_hvt ad=0.0693 pd=0.75 as=0.0441 ps=0.63 w=0.42 l=0.15
X1 a_505_21# S VPWR VPB sky130_fd_pr__pfet_01v8_hvt ad=0.1176 pd=1.4 as=0.0693 ps=0.75 w=0.42 l=0.15
X2 a_218_374# S VPWR VPB sky130_fd_pr__pfet_01v8_hvt ad=0.07665 pd=0.785 as=0.15835 ps=1.395 w=0.42 l=0.15
X3 VGND a_505_21# a_439_47# VNB sky130_fd_pr__nfet_01v8 ad=0.1449 pd=1.11 as=0.0693 ps=0.75 w=0.42 l=0.15
X4 a_76_199# A0 a_218_374# VPB sky130_fd_pr__pfet_01v8_hvt ad=0.1932 pd=1.34 as=0.07665 ps=0.785 w=0.42 l=0.15
X5 a_505_21# S VGND VNB sky130_fd_pr__nfet_01v8 ad=0.1092 pd=1.36 as=0.1449 ps=1.11 w=0.42 l=0.15
X6 a_439_47# A0 a_76_199# VNB sky130_fd_pr__nfet_01v8 ad=0.0693 pd=0.75 as=0.09975 ps=0.895 w=0.42 l=0.15
X7 a_535_374# A1 a_76_199# VPB sky130_fd_pr__pfet_01v8_hvt ad=0.0441 pd=0.63 as=0.1932 ps=1.34 w=0.42 l=0.15
X8 a_76_199# A1 a_218_47# VNB sky130_fd_pr__nfet_01v8 ad=0.09975 pd=0.895 as=0.0693 ps=0.75 w=0.42 l=0.15
X9 a_218_47# S VGND VNB sky130_fd_pr__nfet_01v8 ad=0.0693 pd=0.75 as=0.11285 ps=1.045 w=0.42 l=0.15
X10 VPWR a_76_199# X VPB sky130_fd_pr__pfet_01v8_hvt ad=0.15835 pd=1.395 as=0.26 ps=2.52 w=1 l=0.15
X11 VGND a_76_199# X VNB sky130_fd_pr__nfet_01v8 ad=0.11285 pd=1.045 as=0.169 ps=1.82 w=0.65 l=0.15
.ends

.subckt sky130_fd_sc_hd__clkbuf_2 A VGND VNB VPB VPWR X
X0 VPWR A a_27_47# VPB sky130_fd_pr__pfet_01v8_hvt ad=0.1625 pd=1.325 as=0.265 ps=2.53 w=1 l=0.15
X1 VPWR a_27_47# X VPB sky130_fd_pr__pfet_01v8_hvt ad=0.26 pd=2.52 as=0.135 ps=1.27 w=1 l=0.15
X2 VGND A a_27_47# VNB sky130_fd_pr__nfet_01v8 ad=0.06825 pd=0.745 as=0.1113 ps=1.37 w=0.42 l=0.15
X3 X a_27_47# VPWR VPB sky130_fd_pr__pfet_01v8_hvt ad=0.135 pd=1.27 as=0.1625 ps=1.325 w=1 l=0.15
X4 X a_27_47# VGND VNB sky130_fd_pr__nfet_01v8 ad=0.0567 pd=0.69 as=0.06825 ps=0.745 w=0.42 l=0.15
X5 VGND a_27_47# X VNB sky130_fd_pr__nfet_01v8 ad=0.1092 pd=1.36 as=0.0567 ps=0.69 w=0.42 l=0.15
.ends

.subckt sky130_fd_sc_hd__decap_6 VGND VNB VPB VPWR
X0 VPWR VGND VPWR VPB sky130_fd_pr__pfet_01v8_hvt ad=0.2262 pd=2.26 as=0.4524 ps=4.52 w=0.87 l=1.97
X1 VGND VPWR VGND VNB sky130_fd_pr__nfet_01v8 ad=0.143 pd=1.62 as=0.286 ps=3.24 w=0.55 l=1.97
.ends

.subckt sky130_fd_sc_hd__nand2b_1 A_N B VGND VNB VPB VPWR Y
X0 VGND A_N a_27_93# VNB sky130_fd_pr__nfet_01v8 ad=0.10025 pd=0.985 as=0.1092 ps=1.36 w=0.42 l=0.15
X1 Y a_27_93# a_206_47# VNB sky130_fd_pr__nfet_01v8 ad=0.169 pd=1.82 as=0.08775 ps=0.92 w=0.65 l=0.15
X2 a_206_47# B VGND VNB sky130_fd_pr__nfet_01v8 ad=0.08775 pd=0.92 as=0.10025 ps=0.985 w=0.65 l=0.15
X3 VPWR a_27_93# Y VPB sky130_fd_pr__pfet_01v8_hvt ad=0.265 pd=2.53 as=0.135 ps=1.27 w=1 l=0.15
X4 Y B VPWR VPB sky130_fd_pr__pfet_01v8_hvt ad=0.135 pd=1.27 as=0.14575 ps=1.335 w=1 l=0.15
X5 VPWR A_N a_27_93# VPB sky130_fd_pr__pfet_01v8_hvt ad=0.14575 pd=1.335 as=0.1092 ps=1.36 w=0.42 l=0.15
.ends

.subckt sky130_fd_sc_hd__nand2_1 A B VGND VNB VPB VPWR Y
X0 VPWR A Y VPB sky130_fd_pr__pfet_01v8_hvt ad=0.26 pd=2.52 as=0.135 ps=1.27 w=1 l=0.15
X1 Y A a_113_47# VNB sky130_fd_pr__nfet_01v8 ad=0.169 pd=1.82 as=0.08775 ps=0.92 w=0.65 l=0.15
X2 a_113_47# B VGND VNB sky130_fd_pr__nfet_01v8 ad=0.08775 pd=0.92 as=0.169 ps=1.82 w=0.65 l=0.15
X3 Y B VPWR VPB sky130_fd_pr__pfet_01v8_hvt ad=0.135 pd=1.27 as=0.26 ps=2.52 w=1 l=0.15
.ends

.subckt sky130_fd_sc_hd__and3_1 A B C VGND VNB VPB VPWR X
X0 VPWR A a_27_47# VPB sky130_fd_pr__pfet_01v8_hvt ad=0.0567 pd=0.69 as=0.1092 ps=1.36 w=0.42 l=0.15
X1 VPWR C a_27_47# VPB sky130_fd_pr__pfet_01v8_hvt ad=0.14222 pd=1.335 as=0.06615 ps=0.735 w=0.42 l=0.15
X2 a_181_47# B a_109_47# VNB sky130_fd_pr__nfet_01v8 ad=0.0441 pd=0.63 as=0.0441 ps=0.63 w=0.42 l=0.15
X3 VGND C a_181_47# VNB sky130_fd_pr__nfet_01v8 ad=0.13165 pd=1.14 as=0.0441 ps=0.63 w=0.42 l=0.15
X4 a_27_47# B VPWR VPB sky130_fd_pr__pfet_01v8_hvt ad=0.06615 pd=0.735 as=0.0567 ps=0.69 w=0.42 l=0.15
X5 X a_27_47# VPWR VPB sky130_fd_pr__pfet_01v8_hvt ad=0.26 pd=2.52 as=0.14222 ps=1.335 w=1 l=0.15
X6 X a_27_47# VGND VNB sky130_fd_pr__nfet_01v8 ad=0.169 pd=1.82 as=0.13165 ps=1.14 w=0.65 l=0.15
X7 a_109_47# A a_27_47# VNB sky130_fd_pr__nfet_01v8 ad=0.0441 pd=0.63 as=0.1092 ps=1.36 w=0.42 l=0.15
.ends

.subckt sky130_fd_sc_hd__or3_1 A B C VGND VNB VPB VPWR X
X0 X a_29_53# VPWR VPB sky130_fd_pr__pfet_01v8_hvt ad=0.28 pd=2.56 as=0.14825 ps=1.34 w=1 l=0.15
X1 a_111_297# C a_29_53# VPB sky130_fd_pr__pfet_01v8_hvt ad=0.0441 pd=0.63 as=0.1092 ps=1.36 w=0.42 l=0.15
X2 X a_29_53# VGND VNB sky130_fd_pr__nfet_01v8 ad=0.182 pd=1.86 as=0.10187 ps=0.99 w=0.65 l=0.15
X3 a_183_297# B a_111_297# VPB sky130_fd_pr__pfet_01v8_hvt ad=0.0693 pd=0.75 as=0.0441 ps=0.63 w=0.42 l=0.15
X4 VPWR A a_183_297# VPB sky130_fd_pr__pfet_01v8_hvt ad=0.14825 pd=1.34 as=0.0693 ps=0.75 w=0.42 l=0.15
X5 a_29_53# B VGND VNB sky130_fd_pr__nfet_01v8 ad=0.0567 pd=0.69 as=0.0567 ps=0.69 w=0.42 l=0.15
X6 VGND C a_29_53# VNB sky130_fd_pr__nfet_01v8 ad=0.0567 pd=0.69 as=0.1092 ps=1.36 w=0.42 l=0.15
X7 VGND A a_29_53# VNB sky130_fd_pr__nfet_01v8 ad=0.10187 pd=0.99 as=0.0567 ps=0.69 w=0.42 l=0.15
.ends

.subckt sky130_fd_sc_hd__a221o_1 A1 A2 B1 B2 C1 VGND VNB VPB VPWR X
X0 a_465_47# A1 a_27_47# VNB sky130_fd_pr__nfet_01v8 ad=0.10725 pd=0.98 as=0.169 ps=1.82 w=0.65 l=0.15
X1 X a_27_47# VPWR VPB sky130_fd_pr__pfet_01v8_hvt ad=0.26 pd=2.52 as=0.1575 ps=1.315 w=1 l=0.15
X2 a_109_297# B1 a_193_297# VPB sky130_fd_pr__pfet_01v8_hvt ad=0.26 pd=2.52 as=0.135 ps=1.27 w=1 l=0.15
X3 a_193_297# B2 a_109_297# VPB sky130_fd_pr__pfet_01v8_hvt ad=0.135 pd=1.27 as=0.135 ps=1.27 w=1 l=0.15
X4 X a_27_47# VGND VNB sky130_fd_pr__nfet_01v8 ad=0.169 pd=1.82 as=0.10238 ps=0.965 w=0.65 l=0.15
X5 a_205_47# B2 VGND VNB sky130_fd_pr__nfet_01v8 ad=0.06825 pd=0.86 as=0.10725 ps=0.98 w=0.65 l=0.15
X6 VPWR A2 a_193_297# VPB sky130_fd_pr__pfet_01v8_hvt ad=0.1575 pd=1.315 as=0.165 ps=1.33 w=1 l=0.15
X7 a_193_297# A1 VPWR VPB sky130_fd_pr__pfet_01v8_hvt ad=0.165 pd=1.33 as=0.26 ps=2.52 w=1 l=0.15
X8 a_27_47# B1 a_205_47# VNB sky130_fd_pr__nfet_01v8 ad=0.169 pd=1.82 as=0.06825 ps=0.86 w=0.65 l=0.15
X9 a_109_297# C1 a_27_47# VPB sky130_fd_pr__pfet_01v8_hvt ad=0.135 pd=1.27 as=0.26 ps=2.52 w=1 l=0.15
X10 VGND C1 a_27_47# VNB sky130_fd_pr__nfet_01v8 ad=0.10725 pd=0.98 as=0.169 ps=1.82 w=0.65 l=0.15
X11 VGND A2 a_465_47# VNB sky130_fd_pr__nfet_01v8 ad=0.10238 pd=0.965 as=0.10725 ps=0.98 w=0.65 l=0.15
.ends

.subckt sky130_fd_sc_hd__inv_2 A VGND VNB VPB VPWR Y
X0 Y A VPWR VPB sky130_fd_pr__pfet_01v8_hvt ad=0.135 pd=1.27 as=0.26 ps=2.52 w=1 l=0.15
X1 VGND A Y VNB sky130_fd_pr__nfet_01v8 ad=0.169 pd=1.82 as=0.08775 ps=0.92 w=0.65 l=0.15
X2 Y A VGND VNB sky130_fd_pr__nfet_01v8 ad=0.08775 pd=0.92 as=0.169 ps=1.82 w=0.65 l=0.15
X3 VPWR A Y VPB sky130_fd_pr__pfet_01v8_hvt ad=0.26 pd=2.52 as=0.135 ps=1.27 w=1 l=0.15
.ends

.subckt sky130_fd_sc_hd__o311a_1 A1 A2 A3 B1 C1 VGND VNB VPB VPWR X
X0 a_585_47# B1 a_266_47# VNB sky130_fd_pr__nfet_01v8 ad=0.06825 pd=0.86 as=0.11863 ps=1.015 w=0.65 l=0.15
X1 VGND A2 a_266_47# VNB sky130_fd_pr__nfet_01v8 ad=0.1365 pd=1.07 as=0.117 ps=1.01 w=0.65 l=0.15
X2 VPWR a_81_21# X VPB sky130_fd_pr__pfet_01v8_hvt ad=0.3125 pd=1.625 as=0.26 ps=2.52 w=1 l=0.15
X3 a_81_21# C1 a_585_47# VNB sky130_fd_pr__nfet_01v8 ad=0.169 pd=1.82 as=0.06825 ps=0.86 w=0.65 l=0.15
X4 VGND a_81_21# X VNB sky130_fd_pr__nfet_01v8 ad=0.20312 pd=1.275 as=0.169 ps=1.82 w=0.65 l=0.15
X5 a_266_297# A1 VPWR VPB sky130_fd_pr__pfet_01v8_hvt ad=0.18 pd=1.36 as=0.3125 ps=1.625 w=1 l=0.15
X6 a_368_297# A2 a_266_297# VPB sky130_fd_pr__pfet_01v8_hvt ad=0.21 pd=1.42 as=0.18 ps=1.36 w=1 l=0.15
X7 a_266_47# A3 VGND VNB sky130_fd_pr__nfet_01v8 ad=0.11863 pd=1.015 as=0.1365 ps=1.07 w=0.65 l=0.15
X8 a_266_47# A1 VGND VNB sky130_fd_pr__nfet_01v8 ad=0.117 pd=1.01 as=0.20312 ps=1.275 w=0.65 l=0.15
X9 a_81_21# A3 a_368_297# VPB sky130_fd_pr__pfet_01v8_hvt ad=0.1375 pd=1.275 as=0.21 ps=1.42 w=1 l=0.15
X10 a_81_21# C1 VPWR VPB sky130_fd_pr__pfet_01v8_hvt ad=0.26 pd=2.52 as=0.15 ps=1.3 w=1 l=0.15
X11 VPWR B1 a_81_21# VPB sky130_fd_pr__pfet_01v8_hvt ad=0.15 pd=1.3 as=0.1375 ps=1.275 w=1 l=0.15
.ends

.subckt sky130_fd_sc_hd__a2111o_1 A1 A2 B1 C1 D1 VGND VNB VPB VPWR X
X0 VGND A2 a_660_47# VNB sky130_fd_pr__nfet_01v8 ad=0.1885 pd=1.88 as=0.08287 ps=0.905 w=0.65 l=0.15
X1 VGND C1 a_85_193# VNB sky130_fd_pr__nfet_01v8 ad=0.117 pd=1.01 as=0.10075 ps=0.96 w=0.65 l=0.15
X2 a_414_297# C1 a_334_297# VPB sky130_fd_pr__pfet_01v8_hvt ad=0.18 pd=1.36 as=0.125 ps=1.25 w=1 l=0.15
X3 VGND a_85_193# X VNB sky130_fd_pr__nfet_01v8 ad=0.27463 pd=1.495 as=0.2145 ps=1.96 w=0.65 l=0.15
X4 a_334_297# D1 a_85_193# VPB sky130_fd_pr__pfet_01v8_hvt ad=0.125 pd=1.25 as=0.385 ps=2.77 w=1 l=0.15
X5 a_516_297# B1 a_414_297# VPB sky130_fd_pr__pfet_01v8_hvt ad=0.28 pd=1.56 as=0.18 ps=1.36 w=1 l=0.15
X6 a_516_297# A2 VPWR VPB sky130_fd_pr__pfet_01v8_hvt ad=0.29 pd=2.58 as=0.135 ps=1.27 w=1 l=0.15
X7 a_660_47# A1 a_85_193# VNB sky130_fd_pr__nfet_01v8 ad=0.08287 pd=0.905 as=0.18525 ps=1.22 w=0.65 l=0.15
X8 a_85_193# D1 VGND VNB sky130_fd_pr__nfet_01v8 ad=0.10075 pd=0.96 as=0.27463 ps=1.495 w=0.65 l=0.15
X9 VPWR A1 a_516_297# VPB sky130_fd_pr__pfet_01v8_hvt ad=0.135 pd=1.27 as=0.28 ps=1.56 w=1 l=0.15
X10 a_85_193# B1 VGND VNB sky130_fd_pr__nfet_01v8 ad=0.18525 pd=1.22 as=0.117 ps=1.01 w=0.65 l=0.15
X11 VPWR a_85_193# X VPB sky130_fd_pr__pfet_01v8_hvt ad=0.265 pd=2.53 as=0.29 ps=2.58 w=1 l=0.15
.ends

.subckt sky130_fd_sc_hd__and2b_1 A_N B VGND VNB VPB VPWR X
X0 VPWR B a_207_413# VPB sky130_fd_pr__pfet_01v8_hvt ad=0.2279 pd=1.74 as=0.0609 ps=0.71 w=0.42 l=0.15
X1 X a_207_413# VPWR VPB sky130_fd_pr__pfet_01v8_hvt ad=0.26 pd=2.52 as=0.2279 ps=1.74 w=1 l=0.15
X2 a_297_47# a_27_413# a_207_413# VNB sky130_fd_pr__nfet_01v8 ad=0.0504 pd=0.66 as=0.1092 ps=1.36 w=0.42 l=0.15
X3 X a_207_413# VGND VNB sky130_fd_pr__nfet_01v8 ad=0.169 pd=1.82 as=0.1013 ps=0.99 w=0.65 l=0.15
X4 a_207_413# a_27_413# VPWR VPB sky130_fd_pr__pfet_01v8_hvt ad=0.0609 pd=0.71 as=0.0714 ps=0.76 w=0.42 l=0.15
X5 VPWR A_N a_27_413# VPB sky130_fd_pr__pfet_01v8_hvt ad=0.0714 pd=0.76 as=0.1092 ps=1.36 w=0.42 l=0.15
X6 VGND B a_297_47# VNB sky130_fd_pr__nfet_01v8 ad=0.1013 pd=0.99 as=0.0504 ps=0.66 w=0.42 l=0.15
X7 a_27_413# A_N VGND VNB sky130_fd_pr__nfet_01v8 ad=0.1092 pd=1.36 as=0.1092 ps=1.36 w=0.42 l=0.15
.ends

.subckt sky130_fd_sc_hd__dfxtp_1 CLK D VGND VNB VPB VPWR Q
X0 Q a_1059_315# VGND VNB sky130_fd_pr__nfet_01v8 ad=0.169 pd=1.82 as=0.08775 ps=0.92 w=0.65 l=0.15
X1 a_891_413# a_193_47# a_634_159# VNB sky130_fd_pr__special_nfet_01v8 ad=0.0684 pd=0.74 as=0.0989 ps=0.995 w=0.36 l=0.15
X2 a_561_413# a_27_47# a_466_413# VPB sky130_fd_pr__pfet_01v8_hvt ad=0.07665 pd=0.785 as=0.06825 ps=0.745 w=0.42 l=0.15
X3 VPWR CLK a_27_47# VPB sky130_fd_pr__pfet_01v8_hvt ad=0.0864 pd=0.91 as=0.1664 ps=1.8 w=0.64 l=0.15
X4 Q a_1059_315# VPWR VPB sky130_fd_pr__pfet_01v8_hvt ad=0.26 pd=2.52 as=0.135 ps=1.27 w=1 l=0.15
X5 a_381_47# D VPWR VPB sky130_fd_pr__pfet_01v8_hvt ad=0.05775 pd=0.695 as=0.1092 ps=1.36 w=0.42 l=0.15
X6 VGND a_634_159# a_592_47# VNB sky130_fd_pr__nfet_01v8 ad=0.12095 pd=1.085 as=0.0696 ps=0.765 w=0.42 l=0.15
X7 VPWR a_891_413# a_1059_315# VPB sky130_fd_pr__pfet_01v8_hvt ad=0.135 pd=1.27 as=0.27 ps=2.54 w=1 l=0.15
X8 a_466_413# a_193_47# a_381_47# VPB sky130_fd_pr__pfet_01v8_hvt ad=0.06825 pd=0.745 as=0.05775 ps=0.695 w=0.42 l=0.15
X9 VPWR a_634_159# a_561_413# VPB sky130_fd_pr__pfet_01v8_hvt ad=0.17887 pd=1.26 as=0.07665 ps=0.785 w=0.42 l=0.15
X10 a_634_159# a_466_413# VGND VNB sky130_fd_pr__nfet_01v8 ad=0.0989 pd=0.995 as=0.12095 ps=1.085 w=0.64 l=0.15
X11 a_634_159# a_466_413# VPWR VPB sky130_fd_pr__pfet_01v8_hvt ad=0.1095 pd=1.075 as=0.17887 ps=1.26 w=0.75 l=0.15
X12 a_975_413# a_193_47# a_891_413# VPB sky130_fd_pr__pfet_01v8_hvt ad=0.0882 pd=0.84 as=0.0567 ps=0.69 w=0.42 l=0.15
X13 VGND a_1059_315# a_1017_47# VNB sky130_fd_pr__nfet_01v8 ad=0.1092 pd=1.36 as=0.066 ps=0.745 w=0.42 l=0.15
X14 a_193_47# a_27_47# VGND VNB sky130_fd_pr__nfet_01v8 ad=0.1092 pd=1.36 as=0.0567 ps=0.69 w=0.42 l=0.15
X15 a_891_413# a_27_47# a_634_159# VPB sky130_fd_pr__pfet_01v8_hvt ad=0.0567 pd=0.69 as=0.1095 ps=1.075 w=0.42 l=0.15
X16 a_592_47# a_193_47# a_466_413# VNB sky130_fd_pr__special_nfet_01v8 ad=0.0696 pd=0.765 as=0.0621 ps=0.705 w=0.36 l=0.15
X17 VPWR a_1059_315# a_975_413# VPB sky130_fd_pr__pfet_01v8_hvt ad=0.1113 pd=1.37 as=0.0882 ps=0.84 w=0.42 l=0.15
X18 a_1017_47# a_27_47# a_891_413# VNB sky130_fd_pr__special_nfet_01v8 ad=0.066 pd=0.745 as=0.0684 ps=0.74 w=0.36 l=0.15
X19 a_193_47# a_27_47# VPWR VPB sky130_fd_pr__pfet_01v8_hvt ad=0.1664 pd=1.8 as=0.0864 ps=0.91 w=0.64 l=0.15
X20 a_466_413# a_27_47# a_381_47# VNB sky130_fd_pr__special_nfet_01v8 ad=0.0621 pd=0.705 as=0.0813 ps=0.83 w=0.36 l=0.15
X21 VGND a_891_413# a_1059_315# VNB sky130_fd_pr__nfet_01v8 ad=0.08775 pd=0.92 as=0.169 ps=1.82 w=0.65 l=0.15
X22 a_381_47# D VGND VNB sky130_fd_pr__nfet_01v8 ad=0.0813 pd=0.83 as=0.1092 ps=1.36 w=0.42 l=0.15
X23 VGND CLK a_27_47# VNB sky130_fd_pr__nfet_01v8 ad=0.0567 pd=0.69 as=0.1092 ps=1.36 w=0.42 l=0.15
.ends

.subckt sky130_fd_sc_hd__dfrtp_1 CLK D RESET_B VGND VNB VPB VPWR Q
X0 a_805_47# a_761_289# a_639_47# VNB sky130_fd_pr__nfet_01v8 ad=0.0441 pd=0.63 as=0.1401 ps=1.1 w=0.42 l=0.15
X1 a_1217_47# a_27_47# a_1108_47# VNB sky130_fd_pr__special_nfet_01v8 ad=0.0669 pd=0.75 as=0.0711 ps=0.755 w=0.36 l=0.15
X2 a_1283_21# a_1108_47# a_1462_47# VNB sky130_fd_pr__nfet_01v8 ad=0.1092 pd=1.36 as=0.06405 ps=0.725 w=0.42 l=0.15
X3 a_651_413# a_27_47# a_543_47# VPB sky130_fd_pr__pfet_01v8_hvt ad=0.1155 pd=0.97 as=0.07245 ps=0.765 w=0.42 l=0.15
X4 a_1108_47# a_193_47# a_761_289# VNB sky130_fd_pr__special_nfet_01v8 ad=0.0711 pd=0.755 as=0.0999 ps=0.985 w=0.36 l=0.15
X5 VGND RESET_B a_805_47# VNB sky130_fd_pr__nfet_01v8 ad=0.1346 pd=1.15 as=0.0441 ps=0.63 w=0.42 l=0.15
X6 Q a_1283_21# VPWR VPB sky130_fd_pr__pfet_01v8_hvt ad=0.26 pd=2.52 as=0.3012 ps=2.66 w=1 l=0.15
X7 VPWR CLK a_27_47# VPB sky130_fd_pr__pfet_01v8_hvt ad=0.0864 pd=0.91 as=0.1664 ps=1.8 w=0.64 l=0.15
X8 a_448_47# D VPWR VPB sky130_fd_pr__pfet_01v8_hvt ad=0.0651 pd=0.73 as=0.1092 ps=1.36 w=0.42 l=0.15
X9 a_761_289# a_543_47# VGND VNB sky130_fd_pr__nfet_01v8 ad=0.0999 pd=0.985 as=0.1346 ps=1.15 w=0.64 l=0.15
X10 a_193_47# a_27_47# VGND VNB sky130_fd_pr__nfet_01v8 ad=0.1092 pd=1.36 as=0.0567 ps=0.69 w=0.42 l=0.15
X11 a_1108_47# a_27_47# a_761_289# VPB sky130_fd_pr__pfet_01v8_hvt ad=0.0588 pd=0.7 as=0.12915 ps=1.185 w=0.42 l=0.15
X12 a_1462_47# RESET_B VGND VNB sky130_fd_pr__nfet_01v8 ad=0.06405 pd=0.725 as=0.12495 ps=1.015 w=0.42 l=0.15
X13 a_543_47# a_27_47# a_448_47# VNB sky130_fd_pr__special_nfet_01v8 ad=0.0594 pd=0.69 as=0.066 ps=0.745 w=0.36 l=0.15
X14 a_543_47# a_193_47# a_448_47# VPB sky130_fd_pr__pfet_01v8_hvt ad=0.07245 pd=0.765 as=0.0651 ps=0.73 w=0.42 l=0.15
X15 a_448_47# D VGND VNB sky130_fd_pr__nfet_01v8 ad=0.066 pd=0.745 as=0.2205 ps=1.89 w=0.42 l=0.15
X16 VPWR a_1283_21# a_1270_413# VPB sky130_fd_pr__pfet_01v8_hvt ad=0.0819 pd=0.81 as=0.0567 ps=0.69 w=0.42 l=0.15
X17 VPWR a_1108_47# a_1283_21# VPB sky130_fd_pr__pfet_01v8_hvt ad=0.1134 pd=1.38 as=0.0567 ps=0.69 w=0.42 l=0.15
X18 a_1270_413# a_193_47# a_1108_47# VPB sky130_fd_pr__pfet_01v8_hvt ad=0.0567 pd=0.69 as=0.0588 ps=0.7 w=0.42 l=0.15
X19 a_193_47# a_27_47# VPWR VPB sky130_fd_pr__pfet_01v8_hvt ad=0.1664 pd=1.8 as=0.0864 ps=0.91 w=0.64 l=0.15
X20 a_1283_21# RESET_B VPWR VPB sky130_fd_pr__pfet_01v8_hvt ad=0.0567 pd=0.69 as=0.0819 ps=0.81 w=0.42 l=0.15
X21 VPWR a_761_289# a_651_413# VPB sky130_fd_pr__pfet_01v8_hvt ad=0.07035 pd=0.755 as=0.1155 ps=0.97 w=0.42 l=0.15
X22 Q a_1283_21# VGND VNB sky130_fd_pr__nfet_01v8 ad=0.169 pd=1.82 as=0.2087 ps=2.02 w=0.65 l=0.15
X23 a_639_47# a_193_47# a_543_47# VNB sky130_fd_pr__special_nfet_01v8 ad=0.1401 pd=1.1 as=0.0594 ps=0.69 w=0.36 l=0.15
X24 VGND a_1283_21# a_1217_47# VNB sky130_fd_pr__nfet_01v8 ad=0.12495 pd=1.015 as=0.0669 ps=0.75 w=0.42 l=0.15
X25 a_651_413# RESET_B VPWR VPB sky130_fd_pr__pfet_01v8_hvt ad=0.1092 pd=1.36 as=0.07035 ps=0.755 w=0.42 l=0.15
X26 VGND CLK a_27_47# VNB sky130_fd_pr__nfet_01v8 ad=0.0567 pd=0.69 as=0.1092 ps=1.36 w=0.42 l=0.15
X27 a_761_289# a_543_47# VPWR VPB sky130_fd_pr__pfet_01v8_hvt ad=0.12915 pd=1.185 as=0.2184 ps=2.2 w=0.84 l=0.15
.ends

.subckt sky130_fd_sc_hd__dlygate4sd3_1 A VGND VNB VPB VPWR X
X0 VPWR A a_49_47# VPB sky130_fd_pr__pfet_01v8_hvt ad=0.0567 pd=0.69 as=0.1092 ps=1.36 w=0.42 l=0.15
X1 VGND a_285_47# a_391_47# VNB sky130_fd_pr__nfet_01v8 ad=0.097 pd=0.975 as=0.1092 ps=1.36 w=0.42 l=0.5
X2 X a_391_47# VPWR VPB sky130_fd_pr__pfet_01v8_hvt ad=0.26 pd=2.52 as=0.14075 ps=1.325 w=1 l=0.15
X3 VGND A a_49_47# VNB sky130_fd_pr__nfet_01v8 ad=0.0567 pd=0.69 as=0.1092 ps=1.36 w=0.42 l=0.15
X4 VPWR a_285_47# a_391_47# VPB sky130_fd_pr__pfet_01v8_hvt ad=0.14075 pd=1.325 as=0.1092 ps=1.36 w=0.42 l=0.5
X5 a_285_47# a_49_47# VGND VNB sky130_fd_pr__nfet_01v8 ad=0.1092 pd=1.36 as=0.0567 ps=0.69 w=0.42 l=0.5
X6 a_285_47# a_49_47# VPWR VPB sky130_fd_pr__pfet_01v8_hvt ad=0.1092 pd=1.36 as=0.0567 ps=0.69 w=0.42 l=0.5
X7 X a_391_47# VGND VNB sky130_fd_pr__nfet_01v8 ad=0.169 pd=1.82 as=0.097 ps=0.975 w=0.65 l=0.15
.ends

.subckt sky130_fd_sc_hd__diode_2 DIODE VGND VNB VPB VPWR
X0 VNB DIODE sky130_fd_pr__diode_pw2nd_05v5 perim=2.64e+06 area=4.347e+11
.ends

.subckt sky130_fd_sc_hd__and2_1 A B VGND VNB VPB VPWR X
X0 VPWR B a_59_75# VPB sky130_fd_pr__pfet_01v8_hvt ad=0.16655 pd=1.39 as=0.0567 ps=0.69 w=0.42 l=0.15
X1 X a_59_75# VPWR VPB sky130_fd_pr__pfet_01v8_hvt ad=0.475 pd=2.95 as=0.16655 ps=1.39 w=1 l=0.15
X2 VGND B a_145_75# VNB sky130_fd_pr__nfet_01v8 ad=0.1118 pd=1.04 as=0.0567 ps=0.69 w=0.42 l=0.15
X3 a_59_75# A VPWR VPB sky130_fd_pr__pfet_01v8_hvt ad=0.0567 pd=0.69 as=0.1176 ps=1.4 w=0.42 l=0.15
X4 X a_59_75# VGND VNB sky130_fd_pr__nfet_01v8 ad=0.182 pd=1.86 as=0.1118 ps=1.04 w=0.65 l=0.15
X5 a_145_75# A a_59_75# VNB sky130_fd_pr__nfet_01v8 ad=0.0567 pd=0.69 as=0.1176 ps=1.4 w=0.42 l=0.15
.ends

.subckt sky130_fd_sc_hd__or4_1 A B C D VGND VNB VPB VPWR X
X0 a_27_297# B VGND VNB sky130_fd_pr__nfet_01v8 ad=0.0567 pd=0.69 as=0.0567 ps=0.69 w=0.42 l=0.15
X1 a_27_297# D VGND VNB sky130_fd_pr__nfet_01v8 ad=0.0693 pd=0.75 as=0.1092 ps=1.36 w=0.42 l=0.15
X2 a_277_297# B a_205_297# VPB sky130_fd_pr__pfet_01v8_hvt ad=0.0693 pd=0.75 as=0.0441 ps=0.63 w=0.42 l=0.15
X3 VPWR A a_277_297# VPB sky130_fd_pr__pfet_01v8_hvt ad=0.14825 pd=1.34 as=0.0693 ps=0.75 w=0.42 l=0.15
X4 X a_27_297# VGND VNB sky130_fd_pr__nfet_01v8 ad=0.1755 pd=1.84 as=0.10187 ps=0.99 w=0.65 l=0.15
X5 a_205_297# C a_109_297# VPB sky130_fd_pr__pfet_01v8_hvt ad=0.0441 pd=0.63 as=0.0693 ps=0.75 w=0.42 l=0.15
X6 X a_27_297# VPWR VPB sky130_fd_pr__pfet_01v8_hvt ad=0.27 pd=2.54 as=0.14825 ps=1.34 w=1 l=0.15
X7 VGND C a_27_297# VNB sky130_fd_pr__nfet_01v8 ad=0.0567 pd=0.69 as=0.0693 ps=0.75 w=0.42 l=0.15
X8 a_109_297# D a_27_297# VPB sky130_fd_pr__pfet_01v8_hvt ad=0.0693 pd=0.75 as=0.1092 ps=1.36 w=0.42 l=0.15
X9 VGND A a_27_297# VNB sky130_fd_pr__nfet_01v8 ad=0.10187 pd=0.99 as=0.0567 ps=0.69 w=0.42 l=0.15
.ends

.subckt sky130_fd_sc_hd__buf_2 A VGND VNB VPB VPWR X
X0 VPWR a_27_47# X VPB sky130_fd_pr__pfet_01v8_hvt ad=0.265 pd=2.53 as=0.135 ps=1.27 w=1 l=0.15
X1 X a_27_47# VPWR VPB sky130_fd_pr__pfet_01v8_hvt ad=0.135 pd=1.27 as=0.149 ps=1.325 w=1 l=0.15
X2 VPWR A a_27_47# VPB sky130_fd_pr__pfet_01v8_hvt ad=0.149 pd=1.325 as=0.1664 ps=1.8 w=0.64 l=0.15
X3 X a_27_47# VGND VNB sky130_fd_pr__nfet_01v8 ad=0.08775 pd=0.92 as=0.097 ps=0.975 w=0.65 l=0.15
X4 VGND a_27_47# X VNB sky130_fd_pr__nfet_01v8 ad=0.17225 pd=1.83 as=0.08775 ps=0.92 w=0.65 l=0.15
X5 VGND A a_27_47# VNB sky130_fd_pr__nfet_01v8 ad=0.097 pd=0.975 as=0.1092 ps=1.36 w=0.42 l=0.15
.ends

.subckt sky130_fd_sc_hd__a22o_1 A1 A2 B1 B2 VGND VNB VPB VPWR X
X0 VPWR A2 a_109_297# VPB sky130_fd_pr__pfet_01v8_hvt ad=0.155 pd=1.31 as=0.16 ps=1.32 w=1 l=0.15
X1 a_27_297# B1 a_109_47# VNB sky130_fd_pr__nfet_01v8 ad=0.169 pd=1.82 as=0.07475 ps=0.88 w=0.65 l=0.15
X2 VGND A2 a_373_47# VNB sky130_fd_pr__nfet_01v8 ad=0.10075 pd=0.96 as=0.11375 ps=1 w=0.65 l=0.15
X3 X a_27_297# VPWR VPB sky130_fd_pr__pfet_01v8_hvt ad=0.26 pd=2.52 as=0.155 ps=1.31 w=1 l=0.15
X4 a_27_297# B1 a_109_297# VPB sky130_fd_pr__pfet_01v8_hvt ad=0.25285 pd=2.52 as=0.135 ps=1.27 w=1 l=0.15
X5 a_109_297# A1 VPWR VPB sky130_fd_pr__pfet_01v8_hvt ad=0.16 pd=1.32 as=0.2529 ps=2.52 w=1 l=0.15
X6 a_373_47# A1 a_27_297# VNB sky130_fd_pr__nfet_01v8 ad=0.11375 pd=1 as=0.169 ps=1.82 w=0.65 l=0.15
X7 X a_27_297# VGND VNB sky130_fd_pr__nfet_01v8 ad=0.169 pd=1.82 as=0.10075 ps=0.96 w=0.65 l=0.15
X8 a_109_297# B2 a_27_297# VPB sky130_fd_pr__pfet_01v8_hvt ad=0.135 pd=1.27 as=0.26 ps=2.52 w=1 l=0.15
X9 a_109_47# B2 VGND VNB sky130_fd_pr__nfet_01v8 ad=0.07475 pd=0.88 as=0.169 ps=1.82 w=0.65 l=0.15
.ends

.subckt sky130_fd_sc_hd__a211o_1 A1 A2 B1 C1 VGND VNB VPB VPWR X
X0 VPWR a_80_21# X VPB sky130_fd_pr__pfet_01v8_hvt ad=0.265 pd=2.53 as=0.265 ps=2.53 w=1 l=0.15
X1 a_80_21# C1 a_472_297# VPB sky130_fd_pr__pfet_01v8_hvt ad=0.265 pd=2.53 as=0.155 ps=1.31 w=1 l=0.15
X2 VPWR A2 a_217_297# VPB sky130_fd_pr__pfet_01v8_hvt ad=0.14 pd=1.28 as=0.265 ps=2.53 w=1 l=0.15
X3 VGND B1 a_80_21# VNB sky130_fd_pr__nfet_01v8 ad=0.10075 pd=0.96 as=0.091 ps=0.93 w=0.65 l=0.15
X4 VGND a_80_21# X VNB sky130_fd_pr__nfet_01v8 ad=0.26 pd=1.45 as=0.17225 ps=1.83 w=0.65 l=0.15
X5 a_300_47# A2 VGND VNB sky130_fd_pr__nfet_01v8 ad=0.091 pd=0.93 as=0.26 ps=1.45 w=0.65 l=0.15
X6 a_217_297# A1 VPWR VPB sky130_fd_pr__pfet_01v8_hvt ad=0.14 pd=1.28 as=0.14 ps=1.28 w=1 l=0.15
X7 a_80_21# A1 a_300_47# VNB sky130_fd_pr__nfet_01v8 ad=0.091 pd=0.93 as=0.091 ps=0.93 w=0.65 l=0.15
X8 a_472_297# B1 a_217_297# VPB sky130_fd_pr__pfet_01v8_hvt ad=0.155 pd=1.31 as=0.14 ps=1.28 w=1 l=0.15
X9 a_80_21# C1 VGND VNB sky130_fd_pr__nfet_01v8 ad=0.17225 pd=1.83 as=0.10075 ps=0.96 w=0.65 l=0.15
.ends

.subckt sky130_fd_sc_hd__and2_2 A B VGND VNB VPB VPWR X
X0 X a_61_75# VPWR VPB sky130_fd_pr__pfet_01v8_hvt ad=0.195 pd=1.39 as=0.16655 ps=1.39 w=1 l=0.15
X1 VPWR a_61_75# X VPB sky130_fd_pr__pfet_01v8_hvt ad=0.38 pd=2.76 as=0.195 ps=1.39 w=1 l=0.15
X2 VPWR B a_61_75# VPB sky130_fd_pr__pfet_01v8_hvt ad=0.16655 pd=1.39 as=0.0567 ps=0.69 w=0.42 l=0.15
X3 VGND B a_147_75# VNB sky130_fd_pr__nfet_01v8 ad=0.1118 pd=1.04 as=0.0567 ps=0.69 w=0.42 l=0.15
X4 X a_61_75# VGND VNB sky130_fd_pr__nfet_01v8 ad=0.12675 pd=1.04 as=0.1118 ps=1.04 w=0.65 l=0.15
X5 VGND a_61_75# X VNB sky130_fd_pr__nfet_01v8 ad=0.247 pd=2.06 as=0.12675 ps=1.04 w=0.65 l=0.15
X6 a_61_75# A VPWR VPB sky130_fd_pr__pfet_01v8_hvt ad=0.0567 pd=0.69 as=0.1176 ps=1.4 w=0.42 l=0.15
X7 a_147_75# A a_61_75# VNB sky130_fd_pr__nfet_01v8 ad=0.0567 pd=0.69 as=0.1176 ps=1.4 w=0.42 l=0.15
.ends

.subckt sky130_fd_sc_hd__o22a_1 A1 A2 B1 B2 VGND VNB VPB VPWR X
X0 a_78_199# B1 a_215_47# VNB sky130_fd_pr__nfet_01v8 ad=0.08775 pd=0.92 as=0.169 ps=1.82 w=0.65 l=0.15
X1 VPWR A1 a_493_297# VPB sky130_fd_pr__pfet_01v8_hvt ad=0.26 pd=2.52 as=0.105 ps=1.21 w=1 l=0.15
X2 a_493_297# A2 a_78_199# VPB sky130_fd_pr__pfet_01v8_hvt ad=0.105 pd=1.21 as=0.235 ps=1.47 w=1 l=0.15
X3 VPWR a_78_199# X VPB sky130_fd_pr__pfet_01v8_hvt ad=0.3725 pd=1.745 as=0.28 ps=2.56 w=1 l=0.15
X4 VGND A2 a_215_47# VNB sky130_fd_pr__nfet_01v8 ad=0.08775 pd=0.92 as=0.11375 ps=1 w=0.65 l=0.15
X5 a_78_199# B2 a_292_297# VPB sky130_fd_pr__pfet_01v8_hvt ad=0.235 pd=1.47 as=0.1175 ps=1.235 w=1 l=0.15
X6 a_215_47# A1 VGND VNB sky130_fd_pr__nfet_01v8 ad=0.169 pd=1.82 as=0.08775 ps=0.92 w=0.65 l=0.15
X7 a_215_47# B2 a_78_199# VNB sky130_fd_pr__nfet_01v8 ad=0.11375 pd=1 as=0.08775 ps=0.92 w=0.65 l=0.15
X8 a_292_297# B1 VPWR VPB sky130_fd_pr__pfet_01v8_hvt ad=0.1175 pd=1.235 as=0.3725 ps=1.745 w=1 l=0.15
X9 VGND a_78_199# X VNB sky130_fd_pr__nfet_01v8 ad=0.169 pd=1.82 as=0.169 ps=1.82 w=0.65 l=0.15
.ends

.subckt sky130_fd_sc_hd__or2_1 A B VGND VNB VPB VPWR X
X0 VGND A a_68_297# VNB sky130_fd_pr__nfet_01v8 ad=0.10025 pd=0.985 as=0.0567 ps=0.69 w=0.42 l=0.15
X1 a_68_297# B VGND VNB sky130_fd_pr__nfet_01v8 ad=0.0567 pd=0.69 as=0.1092 ps=1.36 w=0.42 l=0.15
X2 X a_68_297# VGND VNB sky130_fd_pr__nfet_01v8 ad=0.169 pd=1.82 as=0.10025 ps=0.985 w=0.65 l=0.15
X3 VPWR A a_150_297# VPB sky130_fd_pr__pfet_01v8_hvt ad=0.14575 pd=1.335 as=0.0441 ps=0.63 w=0.42 l=0.15
X4 X a_68_297# VPWR VPB sky130_fd_pr__pfet_01v8_hvt ad=0.34 pd=2.68 as=0.14575 ps=1.335 w=1 l=0.15
X5 a_150_297# B a_68_297# VPB sky130_fd_pr__pfet_01v8_hvt ad=0.0441 pd=0.63 as=0.1092 ps=1.36 w=0.42 l=0.15
.ends

.subckt sky130_fd_sc_hd__nor2_4 A B VGND VNB VPB VPWR Y
X0 VPWR A a_27_297# VPB sky130_fd_pr__pfet_01v8_hvt ad=0.135 pd=1.27 as=0.135 ps=1.27 w=1 l=0.15
X1 Y A VGND VNB sky130_fd_pr__nfet_01v8 ad=0.08775 pd=0.92 as=0.08775 ps=0.92 w=0.65 l=0.15
X2 a_27_297# A VPWR VPB sky130_fd_pr__pfet_01v8_hvt ad=0.135 pd=1.27 as=0.135 ps=1.27 w=1 l=0.15
X3 VGND A Y VNB sky130_fd_pr__nfet_01v8 ad=0.08775 pd=0.92 as=0.08775 ps=0.92 w=0.65 l=0.15
X4 a_27_297# B Y VPB sky130_fd_pr__pfet_01v8_hvt ad=0.27 pd=2.54 as=0.135 ps=1.27 w=1 l=0.15
X5 Y A VGND VNB sky130_fd_pr__nfet_01v8 ad=0.08775 pd=0.92 as=0.182 ps=1.86 w=0.65 l=0.15
X6 VGND A Y VNB sky130_fd_pr__nfet_01v8 ad=0.08775 pd=0.92 as=0.08775 ps=0.92 w=0.65 l=0.15
X7 VGND B Y VNB sky130_fd_pr__nfet_01v8 ad=0.08775 pd=0.92 as=0.08775 ps=0.92 w=0.65 l=0.15
X8 VGND B Y VNB sky130_fd_pr__nfet_01v8 ad=0.169 pd=1.82 as=0.08775 ps=0.92 w=0.65 l=0.15
X9 Y B a_27_297# VPB sky130_fd_pr__pfet_01v8_hvt ad=0.135 pd=1.27 as=0.135 ps=1.27 w=1 l=0.15
X10 VPWR A a_27_297# VPB sky130_fd_pr__pfet_01v8_hvt ad=0.135 pd=1.27 as=0.28 ps=2.56 w=1 l=0.15
X11 Y B VGND VNB sky130_fd_pr__nfet_01v8 ad=0.08775 pd=0.92 as=0.08775 ps=0.92 w=0.65 l=0.15
X12 Y B VGND VNB sky130_fd_pr__nfet_01v8 ad=0.08775 pd=0.92 as=0.08775 ps=0.92 w=0.65 l=0.15
X13 a_27_297# B Y VPB sky130_fd_pr__pfet_01v8_hvt ad=0.135 pd=1.27 as=0.135 ps=1.27 w=1 l=0.15
X14 Y B a_27_297# VPB sky130_fd_pr__pfet_01v8_hvt ad=0.135 pd=1.27 as=0.135 ps=1.27 w=1 l=0.15
X15 a_27_297# A VPWR VPB sky130_fd_pr__pfet_01v8_hvt ad=0.135 pd=1.27 as=0.135 ps=1.27 w=1 l=0.15
.ends

.subckt sky130_fd_sc_hd__nor2_1 A B VGND VNB VPB VPWR Y
X0 VPWR A a_109_297# VPB sky130_fd_pr__pfet_01v8_hvt ad=0.26 pd=2.52 as=0.105 ps=1.21 w=1 l=0.15
X1 VGND A Y VNB sky130_fd_pr__nfet_01v8 ad=0.169 pd=1.82 as=0.08775 ps=0.92 w=0.65 l=0.15
X2 a_109_297# B Y VPB sky130_fd_pr__pfet_01v8_hvt ad=0.105 pd=1.21 as=0.26 ps=2.52 w=1 l=0.15
X3 Y B VGND VNB sky130_fd_pr__nfet_01v8 ad=0.08775 pd=0.92 as=0.169 ps=1.82 w=0.65 l=0.15
.ends

.subckt sky130_fd_sc_hd__a21bo_1 A1 A2 B1_N VGND VNB VPB VPWR X
X0 a_298_297# a_27_413# a_215_297# VPB sky130_fd_pr__pfet_01v8_hvt ad=0.135 pd=1.27 as=0.265 ps=2.53 w=1 l=0.15
X1 a_215_297# a_27_413# VGND VNB sky130_fd_pr__nfet_01v8 ad=0.08775 pd=0.92 as=0.1359 ps=1.1 w=0.65 l=0.15
X2 a_298_297# A2 VPWR VPB sky130_fd_pr__pfet_01v8_hvt ad=0.265 pd=2.53 as=0.14 ps=1.28 w=1 l=0.15
X3 X a_215_297# VGND VNB sky130_fd_pr__nfet_01v8 ad=0.169 pd=1.82 as=0.25837 ps=1.445 w=0.65 l=0.15
X4 VPWR B1_N a_27_413# VPB sky130_fd_pr__pfet_01v8_hvt ad=0.1092 pd=1.36 as=0.1092 ps=1.36 w=0.42 l=0.15
X5 X a_215_297# VPWR VPB sky130_fd_pr__pfet_01v8_hvt ad=0.26 pd=2.52 as=0.26 ps=2.52 w=1 l=0.15
X6 a_382_47# A1 a_215_297# VNB sky130_fd_pr__nfet_01v8 ad=0.091 pd=0.93 as=0.08775 ps=0.92 w=0.65 l=0.15
X7 VGND B1_N a_27_413# VNB sky130_fd_pr__nfet_01v8 ad=0.1359 pd=1.1 as=0.1113 ps=1.37 w=0.42 l=0.15
X8 VPWR A1 a_298_297# VPB sky130_fd_pr__pfet_01v8_hvt ad=0.14 pd=1.28 as=0.135 ps=1.27 w=1 l=0.15
X9 VGND A2 a_382_47# VNB sky130_fd_pr__nfet_01v8 ad=0.25837 pd=1.445 as=0.091 ps=0.93 w=0.65 l=0.15
.ends

.subckt sky130_fd_sc_hd__dfstp_1 CLK D SET_B VGND VNB VPB VPWR Q
X0 VGND a_652_21# a_586_47# VNB sky130_fd_pr__nfet_01v8 ad=0.0882 pd=0.84 as=0.06705 ps=0.75 w=0.42 l=0.15
X1 a_956_413# a_476_47# VPWR VPB sky130_fd_pr__pfet_01v8_hvt ad=0.0483 pd=0.65 as=0.0567 ps=0.69 w=0.42 l=0.15
X2 VPWR a_476_47# a_652_21# VPB sky130_fd_pr__pfet_01v8_hvt ad=0.0567 pd=0.69 as=0.0567 ps=0.69 w=0.42 l=0.15
X3 VPWR CLK a_27_47# VPB sky130_fd_pr__pfet_01v8_hvt ad=0.0864 pd=0.91 as=0.1664 ps=1.8 w=0.64 l=0.15
X4 a_586_47# a_193_47# a_476_47# VNB sky130_fd_pr__special_nfet_01v8 ad=0.06705 pd=0.75 as=0.072 ps=0.76 w=0.36 l=0.15
X5 a_1056_47# a_476_47# VGND VNB sky130_fd_pr__nfet_01v8 ad=0.0441 pd=0.63 as=0.1092 ps=1.36 w=0.42 l=0.15
X6 a_476_47# a_27_47# a_381_47# VNB sky130_fd_pr__special_nfet_01v8 ad=0.072 pd=0.76 as=0.0935 ps=0.965 w=0.36 l=0.15
X7 a_381_47# D VPWR VPB sky130_fd_pr__pfet_01v8_hvt ad=0.12495 pd=1.175 as=0.2184 ps=2.2 w=0.84 l=0.15
X8 a_652_21# SET_B VPWR VPB sky130_fd_pr__pfet_01v8_hvt ad=0.0567 pd=0.69 as=0.0798 ps=0.8 w=0.42 l=0.15
X9 a_1224_47# a_27_47# a_1032_413# VNB sky130_fd_pr__nfet_01v8 ad=0.0441 pd=0.63 as=0.0693 ps=0.75 w=0.42 l=0.15
X10 a_562_413# a_27_47# a_476_47# VPB sky130_fd_pr__pfet_01v8_hvt ad=0.0945 pd=0.87 as=0.0567 ps=0.69 w=0.42 l=0.15
X11 VGND a_1032_413# a_1602_47# VNB sky130_fd_pr__nfet_01v8 ad=0.097 pd=0.975 as=0.1092 ps=1.36 w=0.42 l=0.15
X12 VPWR a_1182_261# a_1140_413# VPB sky130_fd_pr__pfet_01v8_hvt ad=0.1092 pd=1.36 as=0.0441 ps=0.63 w=0.42 l=0.15
X13 Q a_1602_47# VPWR VPB sky130_fd_pr__pfet_01v8_hvt ad=0.26 pd=2.52 as=0.149 ps=1.325 w=1 l=0.15
X14 a_1032_413# a_193_47# a_1056_47# VNB sky130_fd_pr__nfet_01v8 ad=0.0693 pd=0.75 as=0.0441 ps=0.63 w=0.42 l=0.15
X15 a_476_47# a_193_47# a_381_47# VPB sky130_fd_pr__pfet_01v8_hvt ad=0.0567 pd=0.69 as=0.12495 ps=1.175 w=0.42 l=0.15
X16 a_1296_47# a_1182_261# a_1224_47# VNB sky130_fd_pr__nfet_01v8 ad=0.0483 pd=0.65 as=0.0441 ps=0.63 w=0.42 l=0.15
X17 a_193_47# a_27_47# VGND VNB sky130_fd_pr__nfet_01v8 ad=0.1092 pd=1.36 as=0.0567 ps=0.69 w=0.42 l=0.15
X18 VPWR a_652_21# a_562_413# VPB sky130_fd_pr__pfet_01v8_hvt ad=0.0798 pd=0.8 as=0.0945 ps=0.87 w=0.42 l=0.15
X19 VPWR SET_B a_1032_413# VPB sky130_fd_pr__pfet_01v8_hvt ad=0.12285 pd=1.17 as=0.1092 ps=1.36 w=0.42 l=0.15
X20 a_1032_413# a_27_47# a_956_413# VPB sky130_fd_pr__pfet_01v8_hvt ad=0.0819 pd=0.81 as=0.0483 ps=0.65 w=0.42 l=0.15
X21 a_1182_261# a_1032_413# VPWR VPB sky130_fd_pr__pfet_01v8_hvt ad=0.2184 pd=2.2 as=0.12285 ps=1.17 w=0.84 l=0.15
X22 Q a_1602_47# VGND VNB sky130_fd_pr__nfet_01v8 ad=0.169 pd=1.82 as=0.097 ps=0.975 w=0.65 l=0.15
X23 a_193_47# a_27_47# VPWR VPB sky130_fd_pr__pfet_01v8_hvt ad=0.1664 pd=1.8 as=0.0864 ps=0.91 w=0.64 l=0.15
X24 a_1140_413# a_193_47# a_1032_413# VPB sky130_fd_pr__pfet_01v8_hvt ad=0.0441 pd=0.63 as=0.0819 ps=0.81 w=0.42 l=0.15
X25 VPWR a_1032_413# a_1602_47# VPB sky130_fd_pr__pfet_01v8_hvt ad=0.149 pd=1.325 as=0.1664 ps=1.8 w=0.64 l=0.15
X26 a_796_47# SET_B VGND VNB sky130_fd_pr__nfet_01v8 ad=0.0441 pd=0.63 as=0.0882 ps=0.84 w=0.42 l=0.15
X27 a_381_47# D VGND VNB sky130_fd_pr__nfet_01v8 ad=0.0935 pd=0.965 as=0.1664 ps=1.8 w=0.64 l=0.15
X28 a_1182_261# a_1032_413# VGND VNB sky130_fd_pr__nfet_01v8 ad=0.1404 pd=1.6 as=0.1137 ps=1.01 w=0.54 l=0.15
X29 a_652_21# a_476_47# a_796_47# VNB sky130_fd_pr__nfet_01v8 ad=0.1092 pd=1.36 as=0.0441 ps=0.63 w=0.42 l=0.15
X30 VGND CLK a_27_47# VNB sky130_fd_pr__nfet_01v8 ad=0.0567 pd=0.69 as=0.1092 ps=1.36 w=0.42 l=0.15
X31 VGND SET_B a_1296_47# VNB sky130_fd_pr__nfet_01v8 ad=0.1137 pd=1.01 as=0.0483 ps=0.65 w=0.42 l=0.15
.ends

.subckt sky130_fd_sc_hd__nand4_2 A B C D VGND VNB VPB VPWR Y
X0 VPWR C Y VPB sky130_fd_pr__pfet_01v8_hvt ad=0.215 pd=1.43 as=0.135 ps=1.27 w=1 l=0.15
X1 a_471_47# B a_277_47# VNB sky130_fd_pr__nfet_01v8 ad=0.08775 pd=0.92 as=0.08775 ps=0.92 w=0.65 l=0.15
X2 Y C VPWR VPB sky130_fd_pr__pfet_01v8_hvt ad=0.135 pd=1.27 as=0.135 ps=1.27 w=1 l=0.15
X3 VPWR D Y VPB sky130_fd_pr__pfet_01v8_hvt ad=0.135 pd=1.27 as=0.135 ps=1.27 w=1 l=0.15
X4 VPWR A Y VPB sky130_fd_pr__pfet_01v8_hvt ad=0.42 pd=2.84 as=0.135 ps=1.27 w=1 l=0.15
X5 a_27_47# D VGND VNB sky130_fd_pr__nfet_01v8 ad=0.08775 pd=0.92 as=0.08775 ps=0.92 w=0.65 l=0.15
X6 a_27_47# C a_277_47# VNB sky130_fd_pr__nfet_01v8 ad=0.182 pd=1.86 as=0.08775 ps=0.92 w=0.65 l=0.15
X7 Y A VPWR VPB sky130_fd_pr__pfet_01v8_hvt ad=0.135 pd=1.27 as=0.335 ps=1.67 w=1 l=0.15
X8 a_277_47# B a_471_47# VNB sky130_fd_pr__nfet_01v8 ad=0.08775 pd=0.92 as=0.182 ps=1.86 w=0.65 l=0.15
X9 VPWR B Y VPB sky130_fd_pr__pfet_01v8_hvt ad=0.335 pd=1.67 as=0.135 ps=1.27 w=1 l=0.15
X10 Y A a_471_47# VNB sky130_fd_pr__nfet_01v8 ad=0.08775 pd=0.92 as=0.08775 ps=0.92 w=0.65 l=0.15
X11 a_277_47# C a_27_47# VNB sky130_fd_pr__nfet_01v8 ad=0.08775 pd=0.92 as=0.08775 ps=0.92 w=0.65 l=0.15
X12 Y B VPWR VPB sky130_fd_pr__pfet_01v8_hvt ad=0.135 pd=1.27 as=0.215 ps=1.43 w=1 l=0.15
X13 a_471_47# A Y VNB sky130_fd_pr__nfet_01v8 ad=0.234 pd=2.02 as=0.08775 ps=0.92 w=0.65 l=0.15
X14 Y D VPWR VPB sky130_fd_pr__pfet_01v8_hvt ad=0.135 pd=1.27 as=0.26 ps=2.52 w=1 l=0.15
X15 VGND D a_27_47# VNB sky130_fd_pr__nfet_01v8 ad=0.08775 pd=0.92 as=0.169 ps=1.82 w=0.65 l=0.15
.ends

.subckt sky130_fd_sc_hd__and4_4 A B C D VGND VNB VPB VPWR X
X0 VPWR a_27_47# X VPB sky130_fd_pr__pfet_01v8_hvt ad=0.26 pd=2.52 as=0.135 ps=1.27 w=1 l=0.15
X1 X a_27_47# VPWR VPB sky130_fd_pr__pfet_01v8_hvt ad=0.135 pd=1.27 as=0.135 ps=1.27 w=1 l=0.15
X2 a_188_47# B a_109_47# VNB sky130_fd_pr__nfet_01v8 ad=0.10887 pd=0.985 as=0.07963 ps=0.895 w=0.65 l=0.15
X3 VPWR a_27_47# X VPB sky130_fd_pr__pfet_01v8_hvt ad=0.135 pd=1.27 as=0.135 ps=1.27 w=1 l=0.15
X4 VGND D a_285_47# VNB sky130_fd_pr__nfet_01v8 ad=0.10563 pd=0.975 as=0.14138 ps=1.085 w=0.65 l=0.15
X5 VPWR D a_27_47# VPB sky130_fd_pr__pfet_01v8_hvt ad=0.165 pd=1.33 as=0.215 ps=1.43 w=1 l=0.15
X6 X a_27_47# VPWR VPB sky130_fd_pr__pfet_01v8_hvt ad=0.135 pd=1.27 as=0.165 ps=1.33 w=1 l=0.15
X7 VGND a_27_47# X VNB sky130_fd_pr__nfet_01v8 ad=0.08775 pd=0.92 as=0.08775 ps=0.92 w=0.65 l=0.15
X8 VPWR B a_27_47# VPB sky130_fd_pr__pfet_01v8_hvt ad=0.155 pd=1.31 as=0.135 ps=1.27 w=1 l=0.15
X9 X a_27_47# VGND VNB sky130_fd_pr__nfet_01v8 ad=0.08775 pd=0.92 as=0.10563 ps=0.975 w=0.65 l=0.15
X10 X a_27_47# VGND VNB sky130_fd_pr__nfet_01v8 ad=0.08775 pd=0.92 as=0.08775 ps=0.92 w=0.65 l=0.15
X11 a_27_47# C VPWR VPB sky130_fd_pr__pfet_01v8_hvt ad=0.215 pd=1.43 as=0.155 ps=1.31 w=1 l=0.15
X12 VGND a_27_47# X VNB sky130_fd_pr__nfet_01v8 ad=0.169 pd=1.82 as=0.08775 ps=0.92 w=0.65 l=0.15
X13 a_27_47# A VPWR VPB sky130_fd_pr__pfet_01v8_hvt ad=0.135 pd=1.27 as=0.26 ps=2.52 w=1 l=0.15
X14 a_285_47# C a_188_47# VNB sky130_fd_pr__nfet_01v8 ad=0.14138 pd=1.085 as=0.10887 ps=0.985 w=0.65 l=0.15
X15 a_109_47# A a_27_47# VNB sky130_fd_pr__nfet_01v8 ad=0.07963 pd=0.895 as=0.169 ps=1.82 w=0.65 l=0.15
.ends

.subckt sky130_fd_sc_hd__o21ba_1 A1 A2 B1_N VGND VNB VPB VPWR X
X0 a_222_93# B1_N VGND VNB sky130_fd_pr__nfet_01v8 ad=0.1092 pd=1.36 as=0.10025 ps=0.985 w=0.42 l=0.15
X1 VPWR A1 a_544_297# VPB sky130_fd_pr__pfet_01v8_hvt ad=0.28 pd=2.56 as=0.105 ps=1.21 w=1 l=0.15
X2 VGND a_79_199# X VNB sky130_fd_pr__nfet_01v8 ad=0.10025 pd=0.985 as=0.169 ps=1.82 w=0.65 l=0.15
X3 a_222_93# B1_N VPWR VPB sky130_fd_pr__pfet_01v8_hvt ad=0.1176 pd=1.4 as=0.18575 ps=1.415 w=0.42 l=0.15
X4 VGND A2 a_448_47# VNB sky130_fd_pr__nfet_01v8 ad=0.08775 pd=0.92 as=0.10725 ps=0.98 w=0.65 l=0.15
X5 a_448_47# a_222_93# a_79_199# VNB sky130_fd_pr__nfet_01v8 ad=0.10725 pd=0.98 as=0.169 ps=1.82 w=0.65 l=0.15
X6 a_79_199# a_222_93# VPWR VPB sky130_fd_pr__pfet_01v8_hvt ad=0.165 pd=1.33 as=0.3 ps=2.6 w=1 l=0.15
X7 a_544_297# A2 a_79_199# VPB sky130_fd_pr__pfet_01v8_hvt ad=0.105 pd=1.21 as=0.165 ps=1.33 w=1 l=0.15
X8 a_448_47# A1 VGND VNB sky130_fd_pr__nfet_01v8 ad=0.17225 pd=1.83 as=0.08775 ps=0.92 w=0.65 l=0.15
X9 VPWR a_79_199# X VPB sky130_fd_pr__pfet_01v8_hvt ad=0.18575 pd=1.415 as=0.26 ps=2.52 w=1 l=0.15
.ends

.subckt sky130_fd_sc_hd__a21oi_1 A1 A2 B1 VGND VNB VPB VPWR Y
X0 a_199_47# A1 Y VNB sky130_fd_pr__nfet_01v8 ad=0.09588 pd=0.945 as=0.091 ps=0.93 w=0.65 l=0.15
X1 a_113_297# A2 VPWR VPB sky130_fd_pr__pfet_01v8_hvt ad=0.265 pd=2.53 as=0.1475 ps=1.295 w=1 l=0.15
X2 Y B1 VGND VNB sky130_fd_pr__nfet_01v8 ad=0.091 pd=0.93 as=0.17225 ps=1.83 w=0.65 l=0.15
X3 VPWR A1 a_113_297# VPB sky130_fd_pr__pfet_01v8_hvt ad=0.1475 pd=1.295 as=0.14 ps=1.28 w=1 l=0.15
X4 a_113_297# B1 Y VPB sky130_fd_pr__pfet_01v8_hvt ad=0.14 pd=1.28 as=0.265 ps=2.53 w=1 l=0.15
X5 VGND A2 a_199_47# VNB sky130_fd_pr__nfet_01v8 ad=0.17225 pd=1.83 as=0.09588 ps=0.945 w=0.65 l=0.15
.ends

.subckt sky130_fd_sc_hd__xnor2_1 A B VGND VNB VPB VPWR Y
X0 a_377_297# A VPWR VPB sky130_fd_pr__pfet_01v8_hvt ad=0.105 pd=1.21 as=0.365 ps=1.73 w=1 l=0.15
X1 a_47_47# B VPWR VPB sky130_fd_pr__pfet_01v8_hvt ad=0.135 pd=1.27 as=0.3 ps=2.6 w=1 l=0.15
X2 a_129_47# B a_47_47# VNB sky130_fd_pr__nfet_01v8 ad=0.06825 pd=0.86 as=0.169 ps=1.82 w=0.65 l=0.15
X3 a_285_47# B VGND VNB sky130_fd_pr__nfet_01v8 ad=0.08775 pd=0.92 as=0.169 ps=1.82 w=0.65 l=0.15
X4 Y a_47_47# a_285_47# VNB sky130_fd_pr__nfet_01v8 ad=0.195 pd=1.9 as=0.08775 ps=0.92 w=0.65 l=0.15
X5 VGND A a_129_47# VNB sky130_fd_pr__nfet_01v8 ad=0.08775 pd=0.92 as=0.06825 ps=0.86 w=0.65 l=0.15
X6 VPWR A a_47_47# VPB sky130_fd_pr__pfet_01v8_hvt ad=0.365 pd=1.73 as=0.135 ps=1.27 w=1 l=0.15
X7 VPWR a_47_47# Y VPB sky130_fd_pr__pfet_01v8_hvt ad=0.36 pd=2.72 as=0.165 ps=1.33 w=1 l=0.15
X8 Y B a_377_297# VPB sky130_fd_pr__pfet_01v8_hvt ad=0.165 pd=1.33 as=0.105 ps=1.21 w=1 l=0.15
X9 a_285_47# A VGND VNB sky130_fd_pr__nfet_01v8 ad=0.169 pd=1.82 as=0.08775 ps=0.92 w=0.65 l=0.15
.ends

.subckt sky130_fd_sc_hd__o21ai_1 A1 A2 B1 VGND VNB VPB VPWR Y
X0 Y A2 a_109_297# VPB sky130_fd_pr__pfet_01v8_hvt ad=0.174 pd=1.39 as=0.105 ps=1.21 w=1 l=0.15
X1 VPWR B1 Y VPB sky130_fd_pr__pfet_01v8_hvt ad=0.182 pd=1.92 as=0.174 ps=1.39 w=0.7 l=0.15
X2 a_27_47# A2 VGND VNB sky130_fd_pr__nfet_01v8 ad=0.08775 pd=0.92 as=0.10725 ps=0.98 w=0.65 l=0.15
X3 Y B1 a_27_47# VNB sky130_fd_pr__nfet_01v8 ad=0.169 pd=1.82 as=0.08775 ps=0.92 w=0.65 l=0.15
X4 a_109_297# A1 VPWR VPB sky130_fd_pr__pfet_01v8_hvt ad=0.105 pd=1.21 as=0.26 ps=2.52 w=1 l=0.15
X5 VGND A1 a_27_47# VNB sky130_fd_pr__nfet_01v8 ad=0.10725 pd=0.98 as=0.169 ps=1.82 w=0.65 l=0.15
.ends

.subckt sky130_fd_sc_hd__o211a_1 A1 A2 B1 C1 VGND VNB VPB VPWR X
X0 VGND A1 a_215_47# VNB sky130_fd_pr__nfet_01v8 ad=0.10563 pd=0.975 as=0.169 ps=1.82 w=0.65 l=0.15
X1 a_510_47# B1 a_215_47# VNB sky130_fd_pr__nfet_01v8 ad=0.11375 pd=1 as=0.143 ps=1.09 w=0.65 l=0.15
X2 a_79_21# C1 VPWR VPB sky130_fd_pr__pfet_01v8_hvt ad=0.3 pd=2.6 as=0.175 ps=1.35 w=1 l=0.15
X3 VPWR B1 a_79_21# VPB sky130_fd_pr__pfet_01v8_hvt ad=0.175 pd=1.35 as=0.22 ps=1.44 w=1 l=0.15
X4 a_79_21# A2 a_297_297# VPB sky130_fd_pr__pfet_01v8_hvt ad=0.22 pd=1.44 as=0.1625 ps=1.325 w=1 l=0.15
X5 a_297_297# A1 VPWR VPB sky130_fd_pr__pfet_01v8_hvt ad=0.1625 pd=1.325 as=0.26 ps=2.52 w=1 l=0.15
X6 a_79_21# C1 a_510_47# VNB sky130_fd_pr__nfet_01v8 ad=0.195 pd=1.9 as=0.11375 ps=1 w=0.65 l=0.15
X7 VPWR a_79_21# X VPB sky130_fd_pr__pfet_01v8_hvt ad=0.26 pd=2.52 as=0.26 ps=2.52 w=1 l=0.15
X8 VGND a_79_21# X VNB sky130_fd_pr__nfet_01v8 ad=0.169 pd=1.82 as=0.169 ps=1.82 w=0.65 l=0.15
X9 a_215_47# A2 VGND VNB sky130_fd_pr__nfet_01v8 ad=0.143 pd=1.09 as=0.10563 ps=0.975 w=0.65 l=0.15
.ends

.subckt sky130_fd_sc_hd__dlymetal6s2s_1 A VGND VNB VPB VPWR X
X0 a_558_47# a_381_47# VPWR VPB sky130_fd_pr__pfet_01v8_hvt ad=0.26 pd=2.52 as=0.14075 ps=1.325 w=1 l=0.15
X1 VGND X a_381_47# VNB sky130_fd_pr__nfet_01v8 ad=0.097 pd=0.975 as=0.1092 ps=1.36 w=0.42 l=0.15
X2 a_841_47# a_664_47# VPWR VPB sky130_fd_pr__pfet_01v8_hvt ad=0.26 pd=2.52 as=0.14075 ps=1.325 w=1 l=0.15
X3 VPWR A a_62_47# VPB sky130_fd_pr__pfet_01v8_hvt ad=0.14075 pd=1.325 as=0.1092 ps=1.36 w=0.42 l=0.15
X4 VGND A a_62_47# VNB sky130_fd_pr__nfet_01v8 ad=0.097 pd=0.975 as=0.1092 ps=1.36 w=0.42 l=0.15
X5 a_558_47# a_381_47# VGND VNB sky130_fd_pr__nfet_01v8 ad=0.169 pd=1.82 as=0.097 ps=0.975 w=0.65 l=0.15
X6 X a_62_47# VPWR VPB sky130_fd_pr__pfet_01v8_hvt ad=0.26 pd=2.52 as=0.14075 ps=1.325 w=1 l=0.15
X7 VPWR X a_381_47# VPB sky130_fd_pr__pfet_01v8_hvt ad=0.14075 pd=1.325 as=0.1092 ps=1.36 w=0.42 l=0.15
X8 a_841_47# a_664_47# VGND VNB sky130_fd_pr__nfet_01v8 ad=0.169 pd=1.82 as=0.097 ps=0.975 w=0.65 l=0.15
X9 X a_62_47# VGND VNB sky130_fd_pr__nfet_01v8 ad=0.169 pd=1.82 as=0.097 ps=0.975 w=0.65 l=0.15
X10 VPWR a_558_47# a_664_47# VPB sky130_fd_pr__pfet_01v8_hvt ad=0.14075 pd=1.325 as=0.1092 ps=1.36 w=0.42 l=0.15
X11 VGND a_558_47# a_664_47# VNB sky130_fd_pr__nfet_01v8 ad=0.097 pd=0.975 as=0.1092 ps=1.36 w=0.42 l=0.15
.ends

.subckt sky130_fd_sc_hd__and4_1 A B C D VGND VNB VPB VPWR X
X0 a_27_47# C VPWR VPB sky130_fd_pr__pfet_01v8_hvt ad=0.0588 pd=0.7 as=0.0777 ps=0.79 w=0.42 l=0.15
X1 a_197_47# B a_109_47# VNB sky130_fd_pr__nfet_01v8 ad=0.0798 pd=0.8 as=0.0609 ps=0.71 w=0.42 l=0.15
X2 X a_27_47# VPWR VPB sky130_fd_pr__pfet_01v8_hvt ad=0.26 pd=2.52 as=0.31245 ps=1.68 w=1 l=0.15
X3 a_303_47# C a_197_47# VNB sky130_fd_pr__nfet_01v8 ad=0.0693 pd=0.75 as=0.0798 ps=0.8 w=0.42 l=0.15
X4 a_27_47# A VPWR VPB sky130_fd_pr__pfet_01v8_hvt ad=0.0735 pd=0.77 as=0.1092 ps=1.36 w=0.42 l=0.15
X5 VPWR D a_27_47# VPB sky130_fd_pr__pfet_01v8_hvt ad=0.31245 pd=1.68 as=0.0588 ps=0.7 w=0.42 l=0.15
X6 VGND D a_303_47# VNB sky130_fd_pr__nfet_01v8 ad=0.19627 pd=1.33 as=0.0693 ps=0.75 w=0.42 l=0.15
X7 VPWR B a_27_47# VPB sky130_fd_pr__pfet_01v8_hvt ad=0.0777 pd=0.79 as=0.0735 ps=0.77 w=0.42 l=0.15
X8 X a_27_47# VGND VNB sky130_fd_pr__nfet_01v8 ad=0.169 pd=1.82 as=0.19627 ps=1.33 w=0.65 l=0.15
X9 a_109_47# A a_27_47# VNB sky130_fd_pr__nfet_01v8 ad=0.0609 pd=0.71 as=0.1092 ps=1.36 w=0.42 l=0.15
.ends

.subckt sky130_fd_sc_hd__o2111a_1 A1 A2 B1 C1 D1 VGND VNB VPB VPWR X
X0 a_676_297# A2 a_79_21# VPB sky130_fd_pr__pfet_01v8_hvt ad=0.105 pd=1.21 as=0.2125 ps=1.425 w=1 l=0.15
X1 a_512_47# B1 a_409_47# VNB sky130_fd_pr__nfet_01v8 ad=0.19825 pd=1.26 as=0.11863 ps=1.015 w=0.65 l=0.15
X2 a_306_47# D1 a_79_21# VNB sky130_fd_pr__nfet_01v8 ad=0.11863 pd=1.015 as=0.19825 ps=1.91 w=0.65 l=0.15
X3 VGND A2 a_512_47# VNB sky130_fd_pr__nfet_01v8 ad=0.08775 pd=0.92 as=0.19825 ps=1.26 w=0.65 l=0.15
X4 VPWR C1 a_79_21# VPB sky130_fd_pr__pfet_01v8_hvt ad=0.305 pd=1.61 as=0.2175 ps=1.435 w=1 l=0.15
X5 a_79_21# B1 VPWR VPB sky130_fd_pr__pfet_01v8_hvt ad=0.2125 pd=1.425 as=0.305 ps=1.61 w=1 l=0.15
X6 VPWR A1 a_676_297# VPB sky130_fd_pr__pfet_01v8_hvt ad=0.265 pd=2.53 as=0.105 ps=1.21 w=1 l=0.15
X7 a_512_47# A1 VGND VNB sky130_fd_pr__nfet_01v8 ad=0.17225 pd=1.83 as=0.08775 ps=0.92 w=0.65 l=0.15
X8 a_409_47# C1 a_306_47# VNB sky130_fd_pr__nfet_01v8 ad=0.11863 pd=1.015 as=0.11863 ps=1.015 w=0.65 l=0.15
X9 VPWR a_79_21# X VPB sky130_fd_pr__pfet_01v8_hvt ad=0.3825 pd=1.765 as=0.26 ps=2.52 w=1 l=0.15
X10 a_79_21# D1 VPWR VPB sky130_fd_pr__pfet_01v8_hvt ad=0.2175 pd=1.435 as=0.3825 ps=1.765 w=1 l=0.15
X11 VGND a_79_21# X VNB sky130_fd_pr__nfet_01v8 ad=0.169 pd=1.82 as=0.169 ps=1.82 w=0.65 l=0.15
.ends

.subckt sky130_fd_sc_hd__and4bb_4 A_N B_N C D VGND VNB VPB VPWR X
X0 VPWR a_174_21# X VPB sky130_fd_pr__pfet_01v8_hvt ad=0.175 pd=1.35 as=0.135 ps=1.27 w=1 l=0.15
X1 a_174_21# a_832_21# a_766_47# VNB sky130_fd_pr__nfet_01v8 ad=0.169 pd=1.82 as=0.10725 ps=0.98 w=0.65 l=0.15
X2 X a_174_21# VPWR VPB sky130_fd_pr__pfet_01v8_hvt ad=0.135 pd=1.27 as=0.135 ps=1.27 w=1 l=0.15
X3 a_832_21# A_N VGND VNB sky130_fd_pr__nfet_01v8 ad=0.1092 pd=1.36 as=0.1764 ps=1.68 w=0.42 l=0.15
X4 a_766_47# a_27_47# a_652_47# VNB sky130_fd_pr__nfet_01v8 ad=0.10725 pd=0.98 as=0.1365 ps=1.07 w=0.65 l=0.15
X5 VPWR a_174_21# X VPB sky130_fd_pr__pfet_01v8_hvt ad=0.135 pd=1.27 as=0.135 ps=1.27 w=1 l=0.15
X6 X a_174_21# VPWR VPB sky130_fd_pr__pfet_01v8_hvt ad=0.135 pd=1.27 as=0.14075 ps=1.325 w=1 l=0.15
X7 VPWR B_N a_27_47# VPB sky130_fd_pr__pfet_01v8_hvt ad=0.14075 pd=1.325 as=0.1092 ps=1.36 w=0.42 l=0.15
X8 a_652_47# C a_556_47# VNB sky130_fd_pr__nfet_01v8 ad=0.1365 pd=1.07 as=0.10725 ps=0.98 w=0.65 l=0.15
X9 a_832_21# A_N VPWR VPB sky130_fd_pr__pfet_01v8_hvt ad=0.1092 pd=1.36 as=0.31165 ps=2.125 w=0.42 l=0.15
X10 X a_174_21# VGND VNB sky130_fd_pr__nfet_01v8 ad=0.08775 pd=0.92 as=0.097 ps=0.975 w=0.65 l=0.15
X11 X a_174_21# VGND VNB sky130_fd_pr__nfet_01v8 ad=0.08775 pd=0.92 as=0.08775 ps=0.92 w=0.65 l=0.15
X12 a_556_47# D VGND VNB sky130_fd_pr__nfet_01v8 ad=0.10725 pd=0.98 as=0.11375 ps=1 w=0.65 l=0.15
X13 a_174_21# D VPWR VPB sky130_fd_pr__pfet_01v8_hvt ad=0.165 pd=1.33 as=0.175 ps=1.35 w=1 l=0.15
X14 VPWR C a_174_21# VPB sky130_fd_pr__pfet_01v8_hvt ad=0.21 pd=1.42 as=0.165 ps=1.33 w=1 l=0.15
X15 VGND a_174_21# X VNB sky130_fd_pr__nfet_01v8 ad=0.08775 pd=0.92 as=0.08775 ps=0.92 w=0.65 l=0.15
X16 VGND a_174_21# X VNB sky130_fd_pr__nfet_01v8 ad=0.11375 pd=1 as=0.08775 ps=0.92 w=0.65 l=0.15
X17 VPWR a_832_21# a_174_21# VPB sky130_fd_pr__pfet_01v8_hvt ad=0.31165 pd=2.125 as=0.165 ps=1.33 w=1 l=0.15
X18 a_174_21# a_27_47# VPWR VPB sky130_fd_pr__pfet_01v8_hvt ad=0.165 pd=1.33 as=0.21 ps=1.42 w=1 l=0.15
X19 VGND B_N a_27_47# VNB sky130_fd_pr__nfet_01v8 ad=0.097 pd=0.975 as=0.1092 ps=1.36 w=0.42 l=0.15
.ends

.subckt sky130_fd_sc_hd__and4bb_1 A_N B_N C D VGND VNB VPB VPWR X
X0 VPWR D a_343_93# VPB sky130_fd_pr__pfet_01v8_hvt ad=0.172 pd=1.46 as=0.0777 ps=0.79 w=0.42 l=0.15
X1 a_223_47# B_N VGND VNB sky130_fd_pr__nfet_01v8 ad=0.1386 pd=1.5 as=0.0588 ps=0.7 w=0.42 l=0.15
X2 a_515_93# a_223_47# a_429_93# VNB sky130_fd_pr__nfet_01v8 ad=0.0735 pd=0.77 as=0.0588 ps=0.7 w=0.42 l=0.15
X3 a_223_47# B_N VPWR VPB sky130_fd_pr__pfet_01v8_hvt ad=0.1344 pd=1.48 as=0.0588 ps=0.7 w=0.42 l=0.15
X4 VPWR A_N a_27_47# VPB sky130_fd_pr__pfet_01v8_hvt ad=0.0588 pd=0.7 as=0.168 ps=1.64 w=0.42 l=0.15
X5 VGND A_N a_27_47# VNB sky130_fd_pr__nfet_01v8 ad=0.0588 pd=0.7 as=0.168 ps=1.64 w=0.42 l=0.15
X6 X a_343_93# VPWR VPB sky130_fd_pr__pfet_01v8_hvt ad=0.26 pd=2.52 as=0.172 ps=1.46 w=1 l=0.15
X7 a_429_93# a_27_47# a_343_93# VNB sky130_fd_pr__nfet_01v8 ad=0.0588 pd=0.7 as=0.1176 ps=1.4 w=0.42 l=0.15
X8 VGND D a_615_93# VNB sky130_fd_pr__nfet_01v8 ad=0.1265 pd=1.11 as=0.0777 ps=0.79 w=0.42 l=0.15
X9 a_343_93# C VPWR VPB sky130_fd_pr__pfet_01v8_hvt ad=0.0777 pd=0.79 as=0.0735 ps=0.77 w=0.42 l=0.15
X10 a_343_93# a_27_47# VPWR VPB sky130_fd_pr__pfet_01v8_hvt ad=0.0588 pd=0.7 as=0.1218 ps=1.42 w=0.42 l=0.15
X11 a_615_93# C a_515_93# VNB sky130_fd_pr__nfet_01v8 ad=0.0777 pd=0.79 as=0.0735 ps=0.77 w=0.42 l=0.15
X12 X a_343_93# VGND VNB sky130_fd_pr__nfet_01v8 ad=0.1654 pd=1.82 as=0.1265 ps=1.11 w=0.65 l=0.15
X13 VPWR a_223_47# a_343_93# VPB sky130_fd_pr__pfet_01v8_hvt ad=0.0735 pd=0.77 as=0.0588 ps=0.7 w=0.42 l=0.15
.ends

.subckt sky130_fd_sc_hd__clkbuf_8 A VGND VNB VPB VPWR X
X0 VPWR A a_110_47# VPB sky130_fd_pr__pfet_01v8_hvt ad=0.14 pd=1.28 as=0.14 ps=1.28 w=1 l=0.15
X1 VPWR a_110_47# X VPB sky130_fd_pr__pfet_01v8_hvt ad=0.14 pd=1.28 as=0.14 ps=1.28 w=1 l=0.15
X2 X a_110_47# VPWR VPB sky130_fd_pr__pfet_01v8_hvt ad=0.14 pd=1.28 as=0.14 ps=1.28 w=1 l=0.15
X3 a_110_47# A VPWR VPB sky130_fd_pr__pfet_01v8_hvt ad=0.14 pd=1.28 as=0.265 ps=2.53 w=1 l=0.15
X4 X a_110_47# VGND VNB sky130_fd_pr__nfet_01v8 ad=0.0588 pd=0.7 as=0.0588 ps=0.7 w=0.42 l=0.15
X5 X a_110_47# VPWR VPB sky130_fd_pr__pfet_01v8_hvt ad=0.14 pd=1.28 as=0.14 ps=1.28 w=1 l=0.15
X6 VGND a_110_47# X VNB sky130_fd_pr__nfet_01v8 ad=0.0588 pd=0.7 as=0.0588 ps=0.7 w=0.42 l=0.15
X7 VPWR a_110_47# X VPB sky130_fd_pr__pfet_01v8_hvt ad=0.14 pd=1.28 as=0.14 ps=1.28 w=1 l=0.15
X8 VGND A a_110_47# VNB sky130_fd_pr__nfet_01v8 ad=0.0588 pd=0.7 as=0.0588 ps=0.7 w=0.42 l=0.15
X9 VGND a_110_47# X VNB sky130_fd_pr__nfet_01v8 ad=0.1134 pd=1.38 as=0.0588 ps=0.7 w=0.42 l=0.15
X10 a_110_47# A VGND VNB sky130_fd_pr__nfet_01v8 ad=0.0588 pd=0.7 as=0.1113 ps=1.37 w=0.42 l=0.15
X11 VPWR a_110_47# X VPB sky130_fd_pr__pfet_01v8_hvt ad=0.14 pd=1.28 as=0.14 ps=1.28 w=1 l=0.15
X12 X a_110_47# VPWR VPB sky130_fd_pr__pfet_01v8_hvt ad=0.14 pd=1.28 as=0.14 ps=1.28 w=1 l=0.15
X13 VGND a_110_47# X VNB sky130_fd_pr__nfet_01v8 ad=0.0588 pd=0.7 as=0.0588 ps=0.7 w=0.42 l=0.15
X14 VGND a_110_47# X VNB sky130_fd_pr__nfet_01v8 ad=0.0588 pd=0.7 as=0.0588 ps=0.7 w=0.42 l=0.15
X15 X a_110_47# VPWR VPB sky130_fd_pr__pfet_01v8_hvt ad=0.14 pd=1.28 as=0.14 ps=1.28 w=1 l=0.15
X16 X a_110_47# VGND VNB sky130_fd_pr__nfet_01v8 ad=0.0588 pd=0.7 as=0.0588 ps=0.7 w=0.42 l=0.15
X17 VPWR a_110_47# X VPB sky130_fd_pr__pfet_01v8_hvt ad=0.265 pd=2.53 as=0.14 ps=1.28 w=1 l=0.15
X18 X a_110_47# VGND VNB sky130_fd_pr__nfet_01v8 ad=0.0588 pd=0.7 as=0.0588 ps=0.7 w=0.42 l=0.15
X19 X a_110_47# VGND VNB sky130_fd_pr__nfet_01v8 ad=0.0588 pd=0.7 as=0.0588 ps=0.7 w=0.42 l=0.15
.ends

.subckt sky130_fd_sc_hd__nand3_4 A B C VGND VNB VPB VPWR Y
X0 a_27_47# B a_445_47# VNB sky130_fd_pr__nfet_01v8 ad=0.08775 pd=0.92 as=0.08775 ps=0.92 w=0.65 l=0.15
X1 a_27_47# B a_445_47# VNB sky130_fd_pr__nfet_01v8 ad=0.169 pd=1.82 as=0.08775 ps=0.92 w=0.65 l=0.15
X2 Y B VPWR VPB sky130_fd_pr__pfet_01v8_hvt ad=0.135 pd=1.27 as=0.135 ps=1.27 w=1 l=0.15
X3 VPWR C Y VPB sky130_fd_pr__pfet_01v8_hvt ad=0.135 pd=1.27 as=0.135 ps=1.27 w=1 l=0.15
X4 Y A a_445_47# VNB sky130_fd_pr__nfet_01v8 ad=0.08775 pd=0.92 as=0.08775 ps=0.92 w=0.65 l=0.15
X5 Y C VPWR VPB sky130_fd_pr__pfet_01v8_hvt ad=0.135 pd=1.27 as=0.135 ps=1.27 w=1 l=0.15
X6 Y A a_445_47# VNB sky130_fd_pr__nfet_01v8 ad=0.08775 pd=0.92 as=0.169 ps=1.82 w=0.65 l=0.15
X7 VPWR C Y VPB sky130_fd_pr__pfet_01v8_hvt ad=0.135 pd=1.27 as=0.135 ps=1.27 w=1 l=0.15
X8 a_27_47# C VGND VNB sky130_fd_pr__nfet_01v8 ad=0.08775 pd=0.92 as=0.08775 ps=0.92 w=0.65 l=0.15
X9 a_27_47# C VGND VNB sky130_fd_pr__nfet_01v8 ad=0.08775 pd=0.92 as=0.08775 ps=0.92 w=0.65 l=0.15
X10 a_445_47# A Y VNB sky130_fd_pr__nfet_01v8 ad=0.1755 pd=1.84 as=0.08775 ps=0.92 w=0.65 l=0.15
X11 VPWR B Y VPB sky130_fd_pr__pfet_01v8_hvt ad=0.26 pd=2.52 as=0.135 ps=1.27 w=1 l=0.15
X12 a_445_47# A Y VNB sky130_fd_pr__nfet_01v8 ad=0.08775 pd=0.92 as=0.08775 ps=0.92 w=0.65 l=0.15
X13 VGND C a_27_47# VNB sky130_fd_pr__nfet_01v8 ad=0.08775 pd=0.92 as=0.08775 ps=0.92 w=0.65 l=0.15
X14 a_445_47# B a_27_47# VNB sky130_fd_pr__nfet_01v8 ad=0.08775 pd=0.92 as=0.08775 ps=0.92 w=0.65 l=0.15
X15 Y B VPWR VPB sky130_fd_pr__pfet_01v8_hvt ad=0.135 pd=1.27 as=0.135 ps=1.27 w=1 l=0.15
X16 VPWR A Y VPB sky130_fd_pr__pfet_01v8_hvt ad=0.27 pd=2.54 as=0.135 ps=1.27 w=1 l=0.15
X17 a_445_47# B a_27_47# VNB sky130_fd_pr__nfet_01v8 ad=0.08775 pd=0.92 as=0.08775 ps=0.92 w=0.65 l=0.15
X18 VPWR B Y VPB sky130_fd_pr__pfet_01v8_hvt ad=0.135 pd=1.27 as=0.135 ps=1.27 w=1 l=0.15
X19 Y A VPWR VPB sky130_fd_pr__pfet_01v8_hvt ad=0.135 pd=1.27 as=0.135 ps=1.27 w=1 l=0.15
X20 VPWR A Y VPB sky130_fd_pr__pfet_01v8_hvt ad=0.135 pd=1.27 as=0.135 ps=1.27 w=1 l=0.15
X21 Y C VPWR VPB sky130_fd_pr__pfet_01v8_hvt ad=0.135 pd=1.27 as=0.26 ps=2.52 w=1 l=0.15
X22 Y A VPWR VPB sky130_fd_pr__pfet_01v8_hvt ad=0.135 pd=1.27 as=0.26 ps=2.52 w=1 l=0.15
X23 VGND C a_27_47# VNB sky130_fd_pr__nfet_01v8 ad=0.08775 pd=0.92 as=0.169 ps=1.82 w=0.65 l=0.15
.ends

.subckt sky130_fd_sc_hd__and3b_1 A_N B C VGND VNB VPB VPWR X
X0 a_109_93# A_N VGND VNB sky130_fd_pr__nfet_01v8 ad=0.10785 pd=1.36 as=0.1092 ps=1.36 w=0.42 l=0.15
X1 X a_209_311# VPWR VPB sky130_fd_pr__pfet_01v8_hvt ad=0.26 pd=2.52 as=0.14222 ps=1.335 w=1 l=0.15
X2 a_109_93# A_N VPWR VPB sky130_fd_pr__pfet_01v8_hvt ad=0.1087 pd=1.36 as=0.1092 ps=1.36 w=0.42 l=0.15
X3 a_296_53# a_109_93# a_209_311# VNB sky130_fd_pr__nfet_01v8 ad=0.0441 pd=0.63 as=0.10783 ps=1.36 w=0.42 l=0.15
X4 VPWR C a_209_311# VPB sky130_fd_pr__pfet_01v8_hvt ad=0.14222 pd=1.335 as=0.07438 ps=0.815 w=0.42 l=0.15
X5 a_368_53# B a_296_53# VNB sky130_fd_pr__nfet_01v8 ad=0.05355 pd=0.675 as=0.0441 ps=0.63 w=0.42 l=0.15
X6 X a_209_311# VGND VNB sky130_fd_pr__nfet_01v8 ad=0.169 pd=1.82 as=0.12228 ps=1.08 w=0.65 l=0.15
X7 a_209_311# B VPWR VPB sky130_fd_pr__pfet_01v8_hvt ad=0.07438 pd=0.815 as=0.0567 ps=0.69 w=0.42 l=0.15
X8 VPWR a_109_93# a_209_311# VPB sky130_fd_pr__pfet_01v8_hvt ad=0.0567 pd=0.69 as=0.1085 ps=1.36 w=0.42 l=0.15
X9 VGND C a_368_53# VNB sky130_fd_pr__nfet_01v8 ad=0.12228 pd=1.08 as=0.05355 ps=0.675 w=0.42 l=0.15
.ends

.subckt sky130_fd_sc_hd__xor2_1 A B VGND VNB VPB VPWR X
X0 X a_35_297# a_285_297# VPB sky130_fd_pr__pfet_01v8_hvt ad=0.3 pd=2.6 as=0.26 ps=2.52 w=1 l=0.15
X1 X B a_285_47# VNB sky130_fd_pr__nfet_01v8 ad=0.25025 pd=1.42 as=0.08775 ps=0.92 w=0.65 l=0.15
X2 a_35_297# B VGND VNB sky130_fd_pr__nfet_01v8 ad=0.08775 pd=0.92 as=0.169 ps=1.82 w=0.65 l=0.15
X3 a_117_297# B a_35_297# VPB sky130_fd_pr__pfet_01v8_hvt ad=0.135 pd=1.27 as=0.26 ps=2.52 w=1 l=0.15
X4 VPWR B a_285_297# VPB sky130_fd_pr__pfet_01v8_hvt ad=0.26 pd=2.52 as=0.135 ps=1.27 w=1 l=0.15
X5 VGND A a_35_297# VNB sky130_fd_pr__nfet_01v8 ad=0.08775 pd=0.92 as=0.08775 ps=0.92 w=0.65 l=0.15
X6 VGND a_35_297# X VNB sky130_fd_pr__nfet_01v8 ad=0.208 pd=1.94 as=0.25025 ps=1.42 w=0.65 l=0.15
X7 a_285_297# A VPWR VPB sky130_fd_pr__pfet_01v8_hvt ad=0.135 pd=1.27 as=0.135 ps=1.27 w=1 l=0.15
X8 VPWR A a_117_297# VPB sky130_fd_pr__pfet_01v8_hvt ad=0.135 pd=1.27 as=0.135 ps=1.27 w=1 l=0.15
X9 a_285_47# A VGND VNB sky130_fd_pr__nfet_01v8 ad=0.08775 pd=0.92 as=0.08775 ps=0.92 w=0.65 l=0.15
.ends

.subckt sky130_fd_sc_hd__and2_4 A B VGND VNB VPB VPWR X
X0 VPWR B a_27_47# VPB sky130_fd_pr__pfet_01v8_hvt ad=0.1775 pd=1.355 as=0.14 ps=1.28 w=1 l=0.15
X1 a_27_47# A VPWR VPB sky130_fd_pr__pfet_01v8_hvt ad=0.14 pd=1.28 as=0.265 ps=2.53 w=1 l=0.15
X2 X a_27_47# VGND VNB sky130_fd_pr__nfet_01v8 ad=0.091 pd=0.93 as=0.13813 ps=1.075 w=0.65 l=0.15
X3 VPWR a_27_47# X VPB sky130_fd_pr__pfet_01v8_hvt ad=0.14 pd=1.28 as=0.14 ps=1.28 w=1 l=0.15
X4 VGND B a_110_47# VNB sky130_fd_pr__nfet_01v8 ad=0.13813 pd=1.075 as=0.06825 ps=0.86 w=0.65 l=0.15
X5 X a_27_47# VPWR VPB sky130_fd_pr__pfet_01v8_hvt ad=0.14 pd=1.28 as=0.14 ps=1.28 w=1 l=0.15
X6 a_110_47# A a_27_47# VNB sky130_fd_pr__nfet_01v8 ad=0.06825 pd=0.86 as=0.17225 ps=1.83 w=0.65 l=0.15
X7 VPWR a_27_47# X VPB sky130_fd_pr__pfet_01v8_hvt ad=0.285 pd=2.57 as=0.14 ps=1.28 w=1 l=0.15
X8 VGND a_27_47# X VNB sky130_fd_pr__nfet_01v8 ad=0.18525 pd=1.87 as=0.091 ps=0.93 w=0.65 l=0.15
X9 VGND a_27_47# X VNB sky130_fd_pr__nfet_01v8 ad=0.091 pd=0.93 as=0.091 ps=0.93 w=0.65 l=0.15
X10 X a_27_47# VPWR VPB sky130_fd_pr__pfet_01v8_hvt ad=0.14 pd=1.28 as=0.1775 ps=1.355 w=1 l=0.15
X11 X a_27_47# VGND VNB sky130_fd_pr__nfet_01v8 ad=0.091 pd=0.93 as=0.091 ps=0.93 w=0.65 l=0.15
.ends

.subckt sky130_fd_sc_hd__buf_1 A VGND VNB VPB VPWR X
X0 VPWR A a_27_47# VPB sky130_fd_pr__pfet_01v8_hvt ad=0.11455 pd=1.08 as=0.2054 ps=2.1 w=0.79 l=0.15
X1 X a_27_47# VGND VNB sky130_fd_pr__nfet_01v8 ad=0.1352 pd=1.56 as=0.0754 ps=0.81 w=0.52 l=0.15
X2 X a_27_47# VPWR VPB sky130_fd_pr__pfet_01v8_hvt ad=0.2054 pd=2.1 as=0.11455 ps=1.08 w=0.79 l=0.15
X3 VGND A a_27_47# VNB sky130_fd_pr__nfet_01v8 ad=0.0754 pd=0.81 as=0.1352 ps=1.56 w=0.52 l=0.15
.ends

.subckt sky130_fd_sc_hd__and4b_4 A_N B C D VGND VNB VPB VPWR X
X0 VPWR a_174_21# X VPB sky130_fd_pr__pfet_01v8_hvt ad=0.3275 pd=1.655 as=0.135 ps=1.27 w=1 l=0.15
X1 X a_174_21# VPWR VPB sky130_fd_pr__pfet_01v8_hvt ad=0.135 pd=1.27 as=0.135 ps=1.27 w=1 l=0.15
X2 a_815_47# B a_701_47# VNB sky130_fd_pr__nfet_01v8 ad=0.143 pd=1.09 as=0.1365 ps=1.07 w=0.65 l=0.15
X3 VPWR a_174_21# X VPB sky130_fd_pr__pfet_01v8_hvt ad=0.135 pd=1.27 as=0.135 ps=1.27 w=1 l=0.15
X4 VPWR C a_174_21# VPB sky130_fd_pr__pfet_01v8_hvt ad=0.21 pd=1.42 as=0.135 ps=1.27 w=1 l=0.15
X5 a_174_21# a_27_47# a_815_47# VNB sky130_fd_pr__nfet_01v8 ad=0.169 pd=1.82 as=0.143 ps=1.09 w=0.65 l=0.15
X6 X a_174_21# VPWR VPB sky130_fd_pr__pfet_01v8_hvt ad=0.135 pd=1.27 as=0.14075 ps=1.325 w=1 l=0.15
X7 VPWR A_N a_27_47# VPB sky130_fd_pr__pfet_01v8_hvt ad=0.14075 pd=1.325 as=0.1092 ps=1.36 w=0.42 l=0.15
X8 a_701_47# C a_617_47# VNB sky130_fd_pr__nfet_01v8 ad=0.1365 pd=1.07 as=0.08775 ps=0.92 w=0.65 l=0.15
X9 a_174_21# D VPWR VPB sky130_fd_pr__pfet_01v8_hvt ad=0.135 pd=1.27 as=0.3275 ps=1.655 w=1 l=0.15
X10 a_174_21# B VPWR VPB sky130_fd_pr__pfet_01v8_hvt ad=0.22 pd=1.44 as=0.21 ps=1.42 w=1 l=0.15
X11 VPWR a_27_47# a_174_21# VPB sky130_fd_pr__pfet_01v8_hvt ad=0.26 pd=2.52 as=0.22 ps=1.44 w=1 l=0.15
X12 X a_174_21# VGND VNB sky130_fd_pr__nfet_01v8 ad=0.08775 pd=0.92 as=0.097 ps=0.975 w=0.65 l=0.15
X13 X a_174_21# VGND VNB sky130_fd_pr__nfet_01v8 ad=0.08775 pd=0.92 as=0.08775 ps=0.92 w=0.65 l=0.15
X14 a_617_47# D VGND VNB sky130_fd_pr__nfet_01v8 ad=0.08775 pd=0.92 as=0.21287 ps=1.305 w=0.65 l=0.15
X15 VGND a_174_21# X VNB sky130_fd_pr__nfet_01v8 ad=0.08775 pd=0.92 as=0.08775 ps=0.92 w=0.65 l=0.15
X16 VGND a_174_21# X VNB sky130_fd_pr__nfet_01v8 ad=0.21287 pd=1.305 as=0.08775 ps=0.92 w=0.65 l=0.15
X17 VGND A_N a_27_47# VNB sky130_fd_pr__nfet_01v8 ad=0.097 pd=0.975 as=0.1092 ps=1.36 w=0.42 l=0.15
.ends

.subckt sky130_fd_sc_hd__clkinv_2 A VGND VNB VPB VPWR Y
X0 Y A VGND VNB sky130_fd_pr__nfet_01v8 ad=0.0588 pd=0.7 as=0.1113 ps=1.37 w=0.42 l=0.15
X1 Y A VPWR VPB sky130_fd_pr__pfet_01v8_hvt ad=0.14 pd=1.28 as=0.14 ps=1.28 w=1 l=0.15
X2 VPWR A Y VPB sky130_fd_pr__pfet_01v8_hvt ad=0.14 pd=1.28 as=0.265 ps=2.53 w=1 l=0.15
X3 VGND A Y VNB sky130_fd_pr__nfet_01v8 ad=0.1092 pd=1.36 as=0.0588 ps=0.7 w=0.42 l=0.15
X4 VPWR A Y VPB sky130_fd_pr__pfet_01v8_hvt ad=0.265 pd=2.53 as=0.14 ps=1.28 w=1 l=0.15
.ends

.subckt sky130_fd_sc_hd__a21boi_1 A1 A2 B1_N VGND VNB VPB VPWR Y
X0 a_300_297# a_27_413# Y VPB sky130_fd_pr__pfet_01v8_hvt ad=0.14 pd=1.28 as=0.265 ps=2.53 w=1 l=0.15
X1 VGND A2 a_384_47# VNB sky130_fd_pr__nfet_01v8 ad=0.17225 pd=1.83 as=0.091 ps=0.93 w=0.65 l=0.15
X2 VPWR B1_N a_27_413# VPB sky130_fd_pr__pfet_01v8_hvt ad=0.1113 pd=1.37 as=0.1113 ps=1.37 w=0.42 l=0.15
X3 Y a_27_413# VGND VNB sky130_fd_pr__nfet_01v8 ad=0.143 pd=1.09 as=0.10187 ps=0.99 w=0.65 l=0.15
X4 VPWR A1 a_300_297# VPB sky130_fd_pr__pfet_01v8_hvt ad=0.14 pd=1.28 as=0.14 ps=1.28 w=1 l=0.15
X5 a_384_47# A1 Y VNB sky130_fd_pr__nfet_01v8 ad=0.091 pd=0.93 as=0.143 ps=1.09 w=0.65 l=0.15
X6 VGND B1_N a_27_413# VNB sky130_fd_pr__nfet_01v8 ad=0.10187 pd=0.99 as=0.1113 ps=1.37 w=0.42 l=0.15
X7 a_300_297# A2 VPWR VPB sky130_fd_pr__pfet_01v8_hvt ad=0.265 pd=2.53 as=0.14 ps=1.28 w=1 l=0.15
.ends

.subckt sky130_fd_sc_hd__a32o_1 A1 A2 A3 B1 B2 VGND VNB VPB VPWR X
X0 a_93_21# A1 a_346_47# VNB sky130_fd_pr__nfet_01v8 ad=0.143 pd=1.09 as=0.14625 ps=1.1 w=0.65 l=0.15
X1 a_93_21# B1 a_250_297# VPB sky130_fd_pr__pfet_01v8_hvt ad=0.14 pd=1.28 as=0.185 ps=1.37 w=1 l=0.15
X2 a_584_47# B1 a_93_21# VNB sky130_fd_pr__nfet_01v8 ad=0.06825 pd=0.86 as=0.143 ps=1.09 w=0.65 l=0.15
X3 VPWR a_93_21# X VPB sky130_fd_pr__pfet_01v8_hvt ad=0.2425 pd=1.485 as=0.33 ps=2.66 w=1 l=0.15
X4 VGND B2 a_584_47# VNB sky130_fd_pr__nfet_01v8 ad=0.17225 pd=1.83 as=0.06825 ps=0.86 w=0.65 l=0.15
X5 a_256_47# A3 VGND VNB sky130_fd_pr__nfet_01v8 ad=0.0975 pd=0.95 as=0.16737 ps=1.165 w=0.65 l=0.15
X6 a_250_297# B2 a_93_21# VPB sky130_fd_pr__pfet_01v8_hvt ad=0.265 pd=2.53 as=0.14 ps=1.28 w=1 l=0.15
X7 VGND a_93_21# X VNB sky130_fd_pr__nfet_01v8 ad=0.16737 pd=1.165 as=0.2145 ps=1.96 w=0.65 l=0.15
X8 a_250_297# A3 VPWR VPB sky130_fd_pr__pfet_01v8_hvt ad=0.165 pd=1.33 as=0.2425 ps=1.485 w=1 l=0.15
X9 VPWR A2 a_250_297# VPB sky130_fd_pr__pfet_01v8_hvt ad=0.225 pd=1.45 as=0.165 ps=1.33 w=1 l=0.15
X10 a_250_297# A1 VPWR VPB sky130_fd_pr__pfet_01v8_hvt ad=0.185 pd=1.37 as=0.225 ps=1.45 w=1 l=0.15
X11 a_346_47# A2 a_256_47# VNB sky130_fd_pr__nfet_01v8 ad=0.14625 pd=1.1 as=0.0975 ps=0.95 w=0.65 l=0.15
.ends

.subckt sky130_fd_sc_hd__o21bai_1 A1 A2 B1_N VGND VNB VPB VPWR Y
X0 a_388_297# A2 Y VPB sky130_fd_pr__pfet_01v8_hvt ad=0.1275 pd=1.255 as=0.1525 ps=1.305 w=1 l=0.15
X1 a_105_352# B1_N VGND VNB sky130_fd_pr__nfet_01v8 ad=0.1092 pd=1.36 as=0.1092 ps=1.36 w=0.42 l=0.15
X2 a_297_47# a_105_352# Y VNB sky130_fd_pr__nfet_01v8 ad=0.10075 pd=0.96 as=0.169 ps=1.82 w=0.65 l=0.15
X3 a_297_47# A1 VGND VNB sky130_fd_pr__nfet_01v8 ad=0.169 pd=1.82 as=0.08775 ps=0.92 w=0.65 l=0.15
X4 VPWR A1 a_388_297# VPB sky130_fd_pr__pfet_01v8_hvt ad=0.28 pd=2.56 as=0.1275 ps=1.255 w=1 l=0.15
X5 VGND A2 a_297_47# VNB sky130_fd_pr__nfet_01v8 ad=0.08775 pd=0.92 as=0.10075 ps=0.96 w=0.65 l=0.15
X6 VPWR B1_N a_105_352# VPB sky130_fd_pr__pfet_01v8_hvt ad=0.17825 pd=1.4 as=0.1092 ps=1.36 w=0.42 l=0.15
X7 Y a_105_352# VPWR VPB sky130_fd_pr__pfet_01v8_hvt ad=0.1525 pd=1.305 as=0.17825 ps=1.4 w=1 l=0.15
.ends

.subckt sky130_fd_sc_hd__and4b_1 A_N B C D VGND VNB VPB VPWR X
X0 a_297_47# a_27_47# a_193_413# VNB sky130_fd_pr__nfet_01v8 ad=0.0441 pd=0.63 as=0.1092 ps=1.36 w=0.42 l=0.15
X1 a_369_47# B a_297_47# VNB sky130_fd_pr__nfet_01v8 ad=0.0735 pd=0.77 as=0.0441 ps=0.63 w=0.42 l=0.15
X2 VPWR D a_193_413# VPB sky130_fd_pr__pfet_01v8_hvt ad=0.14075 pd=1.325 as=0.06615 ps=0.735 w=0.42 l=0.15
X3 X a_193_413# VGND VNB sky130_fd_pr__nfet_01v8 ad=0.169 pd=1.82 as=0.1034 ps=1 w=0.65 l=0.15
X4 VPWR A_N a_27_47# VPB sky130_fd_pr__pfet_01v8_hvt ad=0.0567 pd=0.69 as=0.1092 ps=1.36 w=0.42 l=0.15
X5 VGND D a_469_47# VNB sky130_fd_pr__nfet_01v8 ad=0.1034 pd=1 as=0.0609 ps=0.71 w=0.42 l=0.15
X6 X a_193_413# VPWR VPB sky130_fd_pr__pfet_01v8_hvt ad=0.26 pd=2.52 as=0.14075 ps=1.325 w=1 l=0.15
X7 VPWR B a_193_413# VPB sky130_fd_pr__pfet_01v8_hvt ad=0.1281 pd=1.03 as=0.0987 ps=0.89 w=0.42 l=0.15
X8 a_193_413# C VPWR VPB sky130_fd_pr__pfet_01v8_hvt ad=0.06615 pd=0.735 as=0.1281 ps=1.03 w=0.42 l=0.15
X9 a_193_413# a_27_47# VPWR VPB sky130_fd_pr__pfet_01v8_hvt ad=0.0987 pd=0.89 as=0.0567 ps=0.69 w=0.42 l=0.15
X10 a_469_47# C a_369_47# VNB sky130_fd_pr__nfet_01v8 ad=0.0609 pd=0.71 as=0.0735 ps=0.77 w=0.42 l=0.15
X11 VGND A_N a_27_47# VNB sky130_fd_pr__nfet_01v8 ad=0.1092 pd=1.36 as=0.1092 ps=1.36 w=0.42 l=0.15
.ends

.subckt sky130_fd_sc_hd__dfrtp_4 CLK D RESET_B VGND VNB VPB VPWR Q
X0 a_805_47# a_761_289# a_639_47# VNB sky130_fd_pr__nfet_01v8 ad=0.0441 pd=0.63 as=0.1401 ps=1.1 w=0.42 l=0.15
X1 a_1217_47# a_27_47# a_1108_47# VNB sky130_fd_pr__special_nfet_01v8 ad=0.0669 pd=0.75 as=0.0711 ps=0.755 w=0.36 l=0.15
X2 a_1283_21# a_1108_47# a_1462_47# VNB sky130_fd_pr__nfet_01v8 ad=0.1092 pd=1.36 as=0.06405 ps=0.725 w=0.42 l=0.15
X3 a_651_413# a_27_47# a_543_47# VPB sky130_fd_pr__pfet_01v8_hvt ad=0.1155 pd=0.97 as=0.07245 ps=0.765 w=0.42 l=0.15
X4 a_1108_47# a_193_47# a_761_289# VNB sky130_fd_pr__special_nfet_01v8 ad=0.0711 pd=0.755 as=0.0999 ps=0.985 w=0.36 l=0.15
X5 VGND RESET_B a_805_47# VNB sky130_fd_pr__nfet_01v8 ad=0.1346 pd=1.15 as=0.0441 ps=0.63 w=0.42 l=0.15
X6 VPWR a_1283_21# Q VPB sky130_fd_pr__pfet_01v8_hvt ad=0.305 pd=2.61 as=0.135 ps=1.27 w=1 l=0.15
X7 VPWR CLK a_27_47# VPB sky130_fd_pr__pfet_01v8_hvt ad=0.0864 pd=0.91 as=0.1664 ps=1.8 w=0.64 l=0.15
X8 a_448_47# D VPWR VPB sky130_fd_pr__pfet_01v8_hvt ad=0.0651 pd=0.73 as=0.1092 ps=1.36 w=0.42 l=0.15
X9 Q a_1283_21# VPWR VPB sky130_fd_pr__pfet_01v8_hvt ad=0.135 pd=1.27 as=0.135 ps=1.27 w=1 l=0.15
X10 VPWR a_1283_21# Q VPB sky130_fd_pr__pfet_01v8_hvt ad=0.135 pd=1.27 as=0.135 ps=1.27 w=1 l=0.15
X11 a_761_289# a_543_47# VGND VNB sky130_fd_pr__nfet_01v8 ad=0.0999 pd=0.985 as=0.1346 ps=1.15 w=0.64 l=0.15
X12 Q a_1283_21# VGND VNB sky130_fd_pr__nfet_01v8 ad=0.08775 pd=0.92 as=0.169 ps=1.82 w=0.65 l=0.15
X13 a_193_47# a_27_47# VGND VNB sky130_fd_pr__nfet_01v8 ad=0.1092 pd=1.36 as=0.0567 ps=0.69 w=0.42 l=0.15
X14 a_1108_47# a_27_47# a_761_289# VPB sky130_fd_pr__pfet_01v8_hvt ad=0.0588 pd=0.7 as=0.12915 ps=1.185 w=0.42 l=0.15
X15 a_1462_47# RESET_B VGND VNB sky130_fd_pr__nfet_01v8 ad=0.06405 pd=0.725 as=0.12495 ps=1.015 w=0.42 l=0.15
X16 a_543_47# a_27_47# a_448_47# VNB sky130_fd_pr__special_nfet_01v8 ad=0.0594 pd=0.69 as=0.066 ps=0.745 w=0.36 l=0.15
X17 a_543_47# a_193_47# a_448_47# VPB sky130_fd_pr__pfet_01v8_hvt ad=0.07245 pd=0.765 as=0.0651 ps=0.73 w=0.42 l=0.15
X18 a_448_47# D VGND VNB sky130_fd_pr__nfet_01v8 ad=0.066 pd=0.745 as=0.2205 ps=1.89 w=0.42 l=0.15
X19 VPWR a_1283_21# a_1270_413# VPB sky130_fd_pr__pfet_01v8_hvt ad=0.0819 pd=0.81 as=0.0567 ps=0.69 w=0.42 l=0.15
X20 VPWR a_1108_47# a_1283_21# VPB sky130_fd_pr__pfet_01v8_hvt ad=0.1134 pd=1.38 as=0.0567 ps=0.69 w=0.42 l=0.15
X21 Q a_1283_21# VPWR VPB sky130_fd_pr__pfet_01v8_hvt ad=0.135 pd=1.27 as=0.26 ps=2.52 w=1 l=0.15
X22 a_1270_413# a_193_47# a_1108_47# VPB sky130_fd_pr__pfet_01v8_hvt ad=0.0567 pd=0.69 as=0.0588 ps=0.7 w=0.42 l=0.15
X23 a_193_47# a_27_47# VPWR VPB sky130_fd_pr__pfet_01v8_hvt ad=0.1664 pd=1.8 as=0.0864 ps=0.91 w=0.64 l=0.15
X24 a_1283_21# RESET_B VPWR VPB sky130_fd_pr__pfet_01v8_hvt ad=0.0567 pd=0.69 as=0.0819 ps=0.81 w=0.42 l=0.15
X25 VGND a_1283_21# Q VNB sky130_fd_pr__nfet_01v8 ad=0.08775 pd=0.92 as=0.08775 ps=0.92 w=0.65 l=0.15
X26 VGND a_1283_21# Q VNB sky130_fd_pr__nfet_01v8 ad=0.182 pd=1.86 as=0.08775 ps=0.92 w=0.65 l=0.15
X27 VPWR a_761_289# a_651_413# VPB sky130_fd_pr__pfet_01v8_hvt ad=0.07035 pd=0.755 as=0.1155 ps=0.97 w=0.42 l=0.15
X28 a_639_47# a_193_47# a_543_47# VNB sky130_fd_pr__special_nfet_01v8 ad=0.1401 pd=1.1 as=0.0594 ps=0.69 w=0.36 l=0.15
X29 VGND a_1283_21# a_1217_47# VNB sky130_fd_pr__nfet_01v8 ad=0.12495 pd=1.015 as=0.0669 ps=0.75 w=0.42 l=0.15
X30 a_651_413# RESET_B VPWR VPB sky130_fd_pr__pfet_01v8_hvt ad=0.1092 pd=1.36 as=0.07035 ps=0.755 w=0.42 l=0.15
X31 VGND CLK a_27_47# VNB sky130_fd_pr__nfet_01v8 ad=0.0567 pd=0.69 as=0.1092 ps=1.36 w=0.42 l=0.15
X32 a_761_289# a_543_47# VPWR VPB sky130_fd_pr__pfet_01v8_hvt ad=0.12915 pd=1.185 as=0.2184 ps=2.2 w=0.84 l=0.15
X33 Q a_1283_21# VGND VNB sky130_fd_pr__nfet_01v8 ad=0.08775 pd=0.92 as=0.08775 ps=0.92 w=0.65 l=0.15
C0 VPB VNB 2.1109f
.ends

.subckt sky130_fd_sc_hd__inv_6 A VGND VNB VPB VPWR Y
X0 VPWR A Y VPB sky130_fd_pr__pfet_01v8_hvt ad=0.27 pd=2.54 as=0.135 ps=1.27 w=1 l=0.15
X1 Y A VPWR VPB sky130_fd_pr__pfet_01v8_hvt ad=0.135 pd=1.27 as=0.135 ps=1.27 w=1 l=0.15
X2 Y A VGND VNB sky130_fd_pr__nfet_01v8 ad=0.08775 pd=0.92 as=0.08775 ps=0.92 w=0.65 l=0.15
X3 VPWR A Y VPB sky130_fd_pr__pfet_01v8_hvt ad=0.135 pd=1.27 as=0.135 ps=1.27 w=1 l=0.15
X4 Y A VPWR VPB sky130_fd_pr__pfet_01v8_hvt ad=0.135 pd=1.27 as=0.135 ps=1.27 w=1 l=0.15
X5 VPWR A Y VPB sky130_fd_pr__pfet_01v8_hvt ad=0.135 pd=1.27 as=0.135 ps=1.27 w=1 l=0.15
X6 Y A VGND VNB sky130_fd_pr__nfet_01v8 ad=0.08775 pd=0.92 as=0.247 ps=2.06 w=0.65 l=0.15
X7 Y A VGND VNB sky130_fd_pr__nfet_01v8 ad=0.08775 pd=0.92 as=0.08775 ps=0.92 w=0.65 l=0.15
X8 Y A VPWR VPB sky130_fd_pr__pfet_01v8_hvt ad=0.135 pd=1.27 as=0.43 ps=2.86 w=1 l=0.15
X9 VGND A Y VNB sky130_fd_pr__nfet_01v8 ad=0.08775 pd=0.92 as=0.08775 ps=0.92 w=0.65 l=0.15
X10 VGND A Y VNB sky130_fd_pr__nfet_01v8 ad=0.08775 pd=0.92 as=0.08775 ps=0.92 w=0.65 l=0.15
X11 VGND A Y VNB sky130_fd_pr__nfet_01v8 ad=0.1755 pd=1.84 as=0.08775 ps=0.92 w=0.65 l=0.15
.ends

.subckt sky130_fd_sc_hd__or3b_1 A B C_N VGND VNB VPB VPWR X
X0 a_109_93# C_N VGND VNB sky130_fd_pr__nfet_01v8 ad=0.1092 pd=1.36 as=0.1092 ps=1.36 w=0.42 l=0.15
X1 a_215_53# B VGND VNB sky130_fd_pr__nfet_01v8 ad=0.0567 pd=0.69 as=0.0567 ps=0.69 w=0.42 l=0.15
X2 VGND a_109_93# a_215_53# VNB sky130_fd_pr__nfet_01v8 ad=0.0567 pd=0.69 as=0.1092 ps=1.36 w=0.42 l=0.15
X3 VGND A a_215_53# VNB sky130_fd_pr__nfet_01v8 ad=0.10025 pd=0.985 as=0.0567 ps=0.69 w=0.42 l=0.15
X4 VPWR A a_369_297# VPB sky130_fd_pr__pfet_01v8_hvt ad=0.14825 pd=1.34 as=0.06825 ps=0.745 w=0.42 l=0.15
X5 a_369_297# B a_297_297# VPB sky130_fd_pr__pfet_01v8_hvt ad=0.06825 pd=0.745 as=0.0441 ps=0.63 w=0.42 l=0.15
X6 X a_215_53# VPWR VPB sky130_fd_pr__pfet_01v8_hvt ad=0.275 pd=2.55 as=0.14825 ps=1.34 w=1 l=0.15
X7 a_297_297# a_109_93# a_215_53# VPB sky130_fd_pr__pfet_01v8_hvt ad=0.0441 pd=0.63 as=0.1092 ps=1.36 w=0.42 l=0.15
X8 a_109_93# C_N VPWR VPB sky130_fd_pr__pfet_01v8_hvt ad=0.1092 pd=1.36 as=0.1092 ps=1.36 w=0.42 l=0.15
X9 X a_215_53# VGND VNB sky130_fd_pr__nfet_01v8 ad=0.17875 pd=1.85 as=0.10025 ps=0.985 w=0.65 l=0.15
.ends

.subckt sky130_fd_sc_hd__clkbuf_16 A VGND VNB VPB VPWR X
X0 VPWR A a_110_47# VPB sky130_fd_pr__pfet_01v8_hvt ad=0.14 pd=1.28 as=0.14 ps=1.28 w=1 l=0.15
X1 VPWR a_110_47# X VPB sky130_fd_pr__pfet_01v8_hvt ad=0.14 pd=1.28 as=0.14 ps=1.28 w=1 l=0.15
X2 X a_110_47# VPWR VPB sky130_fd_pr__pfet_01v8_hvt ad=0.14 pd=1.28 as=0.14 ps=1.28 w=1 l=0.15
X3 X a_110_47# VPWR VPB sky130_fd_pr__pfet_01v8_hvt ad=0.14 pd=1.28 as=0.14 ps=1.28 w=1 l=0.15
X4 VPWR a_110_47# X VPB sky130_fd_pr__pfet_01v8_hvt ad=0.14 pd=1.28 as=0.14 ps=1.28 w=1 l=0.15
X5 VPWR a_110_47# X VPB sky130_fd_pr__pfet_01v8_hvt ad=0.265 pd=2.53 as=0.14 ps=1.28 w=1 l=0.15
X6 a_110_47# A VPWR VPB sky130_fd_pr__pfet_01v8_hvt ad=0.14 pd=1.28 as=0.265 ps=2.53 w=1 l=0.15
X7 a_110_47# A VGND VNB sky130_fd_pr__nfet_01v8 ad=0.0588 pd=0.7 as=0.0588 ps=0.7 w=0.42 l=0.15
X8 VGND a_110_47# X VNB sky130_fd_pr__nfet_01v8 ad=0.0588 pd=0.7 as=0.0588 ps=0.7 w=0.42 l=0.15
X9 X a_110_47# VGND VNB sky130_fd_pr__nfet_01v8 ad=0.0588 pd=0.7 as=0.0588 ps=0.7 w=0.42 l=0.15
X10 VGND a_110_47# X VNB sky130_fd_pr__nfet_01v8 ad=0.0588 pd=0.7 as=0.0588 ps=0.7 w=0.42 l=0.15
X11 a_110_47# A VPWR VPB sky130_fd_pr__pfet_01v8_hvt ad=0.14 pd=1.28 as=0.14 ps=1.28 w=1 l=0.15
X12 VGND A a_110_47# VNB sky130_fd_pr__nfet_01v8 ad=0.0588 pd=0.7 as=0.0588 ps=0.7 w=0.42 l=0.15
X13 VGND a_110_47# X VNB sky130_fd_pr__nfet_01v8 ad=0.05775 pd=0.695 as=0.0588 ps=0.7 w=0.42 l=0.15
X14 VPWR a_110_47# X VPB sky130_fd_pr__pfet_01v8_hvt ad=0.14 pd=1.28 as=0.14 ps=1.28 w=1 l=0.15
X15 X a_110_47# VPWR VPB sky130_fd_pr__pfet_01v8_hvt ad=0.14 pd=1.28 as=0.14 ps=1.28 w=1 l=0.15
X16 VGND A a_110_47# VNB sky130_fd_pr__nfet_01v8 ad=0.0588 pd=0.7 as=0.0588 ps=0.7 w=0.42 l=0.15
X17 VGND a_110_47# X VNB sky130_fd_pr__nfet_01v8 ad=0.1113 pd=1.37 as=0.0588 ps=0.7 w=0.42 l=0.15
X18 VPWR a_110_47# X VPB sky130_fd_pr__pfet_01v8_hvt ad=0.1375 pd=1.275 as=0.14 ps=1.28 w=1 l=0.15
X19 VGND a_110_47# X VNB sky130_fd_pr__nfet_01v8 ad=0.0588 pd=0.7 as=0.0588 ps=0.7 w=0.42 l=0.15
X20 X a_110_47# VPWR VPB sky130_fd_pr__pfet_01v8_hvt ad=0.14 pd=1.28 as=0.1375 ps=1.275 w=1 l=0.15
X21 a_110_47# A VGND VNB sky130_fd_pr__nfet_01v8 ad=0.0588 pd=0.7 as=0.1113 ps=1.37 w=0.42 l=0.15
X22 VPWR A a_110_47# VPB sky130_fd_pr__pfet_01v8_hvt ad=0.14 pd=1.28 as=0.14 ps=1.28 w=1 l=0.15
X23 VPWR a_110_47# X VPB sky130_fd_pr__pfet_01v8_hvt ad=0.14 pd=1.28 as=0.14 ps=1.28 w=1 l=0.15
X24 VPWR a_110_47# X VPB sky130_fd_pr__pfet_01v8_hvt ad=0.14 pd=1.28 as=0.14 ps=1.28 w=1 l=0.15
X25 VGND a_110_47# X VNB sky130_fd_pr__nfet_01v8 ad=0.0588 pd=0.7 as=0.0588 ps=0.7 w=0.42 l=0.15
X26 X a_110_47# VPWR VPB sky130_fd_pr__pfet_01v8_hvt ad=0.14 pd=1.28 as=0.14 ps=1.28 w=1 l=0.15
X27 VGND a_110_47# X VNB sky130_fd_pr__nfet_01v8 ad=0.0588 pd=0.7 as=0.0588 ps=0.7 w=0.42 l=0.15
X28 VGND a_110_47# X VNB sky130_fd_pr__nfet_01v8 ad=0.0588 pd=0.7 as=0.0588 ps=0.7 w=0.42 l=0.15
X29 X a_110_47# VGND VNB sky130_fd_pr__nfet_01v8 ad=0.0588 pd=0.7 as=0.0588 ps=0.7 w=0.42 l=0.15
X30 X a_110_47# VPWR VPB sky130_fd_pr__pfet_01v8_hvt ad=0.14 pd=1.28 as=0.14 ps=1.28 w=1 l=0.15
X31 X a_110_47# VPWR VPB sky130_fd_pr__pfet_01v8_hvt ad=0.14 pd=1.28 as=0.14 ps=1.28 w=1 l=0.15
X32 X a_110_47# VGND VNB sky130_fd_pr__nfet_01v8 ad=0.0588 pd=0.7 as=0.0588 ps=0.7 w=0.42 l=0.15
X33 VPWR a_110_47# X VPB sky130_fd_pr__pfet_01v8_hvt ad=0.14 pd=1.28 as=0.14 ps=1.28 w=1 l=0.15
X34 X a_110_47# VPWR VPB sky130_fd_pr__pfet_01v8_hvt ad=0.14 pd=1.28 as=0.14 ps=1.28 w=1 l=0.15
X35 X a_110_47# VGND VNB sky130_fd_pr__nfet_01v8 ad=0.0588 pd=0.7 as=0.0588 ps=0.7 w=0.42 l=0.15
X36 X a_110_47# VGND VNB sky130_fd_pr__nfet_01v8 ad=0.0588 pd=0.7 as=0.0588 ps=0.7 w=0.42 l=0.15
X37 X a_110_47# VGND VNB sky130_fd_pr__nfet_01v8 ad=0.0588 pd=0.7 as=0.0588 ps=0.7 w=0.42 l=0.15
X38 X a_110_47# VGND VNB sky130_fd_pr__nfet_01v8 ad=0.0588 pd=0.7 as=0.0588 ps=0.7 w=0.42 l=0.15
X39 X a_110_47# VGND VNB sky130_fd_pr__nfet_01v8 ad=0.0588 pd=0.7 as=0.05775 ps=0.695 w=0.42 l=0.15
.ends

.subckt sky130_fd_sc_hd__nor3_1 A B C VGND VNB VPB VPWR Y
X0 VPWR A a_193_297# VPB sky130_fd_pr__pfet_01v8_hvt ad=0.26 pd=2.52 as=0.135 ps=1.27 w=1 l=0.15
X1 a_193_297# B a_109_297# VPB sky130_fd_pr__pfet_01v8_hvt ad=0.135 pd=1.27 as=0.135 ps=1.27 w=1 l=0.15
X2 Y B VGND VNB sky130_fd_pr__nfet_01v8 ad=0.08775 pd=0.92 as=0.08775 ps=0.92 w=0.65 l=0.15
X3 VGND A Y VNB sky130_fd_pr__nfet_01v8 ad=0.169 pd=1.82 as=0.08775 ps=0.92 w=0.65 l=0.15
X4 a_109_297# C Y VPB sky130_fd_pr__pfet_01v8_hvt ad=0.135 pd=1.27 as=0.26 ps=2.52 w=1 l=0.15
X5 VGND C Y VNB sky130_fd_pr__nfet_01v8 ad=0.08775 pd=0.92 as=0.169 ps=1.82 w=0.65 l=0.15
.ends

.subckt sky130_fd_sc_hd__or4_4 A B C D VGND VNB VPB VPWR X
X0 VPWR A a_304_297# VPB sky130_fd_pr__pfet_01v8_hvt ad=0.19 pd=1.38 as=0.135 ps=1.27 w=1 l=0.15
X1 a_304_297# B a_220_297# VPB sky130_fd_pr__pfet_01v8_hvt ad=0.135 pd=1.27 as=0.135 ps=1.27 w=1 l=0.15
X2 VGND C a_32_297# VNB sky130_fd_pr__nfet_01v8 ad=0.08775 pd=0.92 as=0.1235 ps=1.03 w=0.65 l=0.15
X3 a_220_297# C a_114_297# VPB sky130_fd_pr__pfet_01v8_hvt ad=0.135 pd=1.27 as=0.19 ps=1.38 w=1 l=0.15
X4 a_32_297# D VGND VNB sky130_fd_pr__nfet_01v8 ad=0.1235 pd=1.03 as=0.169 ps=1.82 w=0.65 l=0.15
X5 a_32_297# B VGND VNB sky130_fd_pr__nfet_01v8 ad=0.08775 pd=0.92 as=0.08775 ps=0.92 w=0.65 l=0.15
X6 VPWR a_32_297# X VPB sky130_fd_pr__pfet_01v8_hvt ad=0.27 pd=2.54 as=0.135 ps=1.27 w=1 l=0.15
X7 X a_32_297# VPWR VPB sky130_fd_pr__pfet_01v8_hvt ad=0.135 pd=1.27 as=0.135 ps=1.27 w=1 l=0.15
X8 VGND A a_32_297# VNB sky130_fd_pr__nfet_01v8 ad=0.1235 pd=1.03 as=0.08775 ps=0.92 w=0.65 l=0.15
X9 VPWR a_32_297# X VPB sky130_fd_pr__pfet_01v8_hvt ad=0.135 pd=1.27 as=0.135 ps=1.27 w=1 l=0.15
X10 X a_32_297# VGND VNB sky130_fd_pr__nfet_01v8 ad=0.08775 pd=0.92 as=0.1235 ps=1.03 w=0.65 l=0.15
X11 X a_32_297# VGND VNB sky130_fd_pr__nfet_01v8 ad=0.08775 pd=0.92 as=0.08775 ps=0.92 w=0.65 l=0.15
X12 X a_32_297# VPWR VPB sky130_fd_pr__pfet_01v8_hvt ad=0.135 pd=1.27 as=0.19 ps=1.38 w=1 l=0.15
X13 a_114_297# D a_32_297# VPB sky130_fd_pr__pfet_01v8_hvt ad=0.19 pd=1.38 as=0.26 ps=2.52 w=1 l=0.15
X14 VGND a_32_297# X VNB sky130_fd_pr__nfet_01v8 ad=0.08775 pd=0.92 as=0.08775 ps=0.92 w=0.65 l=0.15
X15 VGND a_32_297# X VNB sky130_fd_pr__nfet_01v8 ad=0.17875 pd=1.85 as=0.08775 ps=0.92 w=0.65 l=0.15
.ends

.subckt sky130_fd_sc_hd__clkinvlp_4 A VGND VNB VPB VPWR Y
X0 Y A VPWR VPB sky130_fd_pr__pfet_01v8_hvt ad=0.14 pd=1.28 as=0.265 ps=2.53 w=1 l=0.25
X1 VGND A a_268_47# VNB sky130_fd_pr__nfet_01v8 ad=0.14575 pd=1.63 as=0.05775 ps=0.76 w=0.55 l=0.15
X2 Y A VPWR VPB sky130_fd_pr__pfet_01v8_hvt ad=0.14 pd=1.28 as=0.14 ps=1.28 w=1 l=0.25
X3 Y A a_110_47# VNB sky130_fd_pr__nfet_01v8 ad=0.077 pd=0.83 as=0.05775 ps=0.76 w=0.55 l=0.15
X4 VPWR A Y VPB sky130_fd_pr__pfet_01v8_hvt ad=0.14 pd=1.28 as=0.14 ps=1.28 w=1 l=0.25
X5 a_110_47# A VGND VNB sky130_fd_pr__nfet_01v8 ad=0.05775 pd=0.76 as=0.14575 ps=1.63 w=0.55 l=0.15
X6 a_268_47# A Y VNB sky130_fd_pr__nfet_01v8 ad=0.05775 pd=0.76 as=0.077 ps=0.83 w=0.55 l=0.15
X7 VPWR A Y VPB sky130_fd_pr__pfet_01v8_hvt ad=0.265 pd=2.53 as=0.14 ps=1.28 w=1 l=0.25
.ends

.subckt sky130_fd_sc_hd__a31o_1 A1 A2 A3 B1 VGND VNB VPB VPWR X
X0 VPWR a_80_21# X VPB sky130_fd_pr__pfet_01v8_hvt ad=0.1725 pd=1.345 as=0.265 ps=2.53 w=1 l=0.15
X1 a_209_297# A3 VPWR VPB sky130_fd_pr__pfet_01v8_hvt ad=0.16 pd=1.32 as=0.1725 ps=1.345 w=1 l=0.15
X2 a_303_47# A2 a_209_47# VNB sky130_fd_pr__nfet_01v8 ad=0.10725 pd=0.98 as=0.104 ps=0.97 w=0.65 l=0.15
X3 a_209_47# A3 VGND VNB sky130_fd_pr__nfet_01v8 ad=0.104 pd=0.97 as=0.11213 ps=0.995 w=0.65 l=0.15
X4 VGND a_80_21# X VNB sky130_fd_pr__nfet_01v8 ad=0.11213 pd=0.995 as=0.17225 ps=1.83 w=0.65 l=0.15
X5 VGND B1 a_80_21# VNB sky130_fd_pr__nfet_01v8 ad=0.208 pd=1.94 as=0.10725 ps=0.98 w=0.65 l=0.15
X6 a_80_21# A1 a_303_47# VNB sky130_fd_pr__nfet_01v8 ad=0.10725 pd=0.98 as=0.10725 ps=0.98 w=0.65 l=0.15
X7 VPWR A2 a_209_297# VPB sky130_fd_pr__pfet_01v8_hvt ad=0.165 pd=1.33 as=0.16 ps=1.32 w=1 l=0.15
X8 a_80_21# B1 a_209_297# VPB sky130_fd_pr__pfet_01v8_hvt ad=0.32 pd=2.64 as=0.165 ps=1.33 w=1 l=0.15
X9 a_209_297# A1 VPWR VPB sky130_fd_pr__pfet_01v8_hvt ad=0.165 pd=1.33 as=0.165 ps=1.33 w=1 l=0.15
.ends

.subckt sky130_fd_sc_hd__nor2_2 A B VGND VNB VPB VPWR Y
X0 Y B a_27_297# VPB sky130_fd_pr__pfet_01v8_hvt ad=0.135 pd=1.27 as=0.135 ps=1.27 w=1 l=0.15
X1 Y B VGND VNB sky130_fd_pr__nfet_01v8 ad=0.08775 pd=0.92 as=0.08775 ps=0.92 w=0.65 l=0.15
X2 a_27_297# A VPWR VPB sky130_fd_pr__pfet_01v8_hvt ad=0.135 pd=1.27 as=0.135 ps=1.27 w=1 l=0.15
X3 VGND A Y VNB sky130_fd_pr__nfet_01v8 ad=0.08775 pd=0.92 as=0.08775 ps=0.92 w=0.65 l=0.15
X4 Y A VGND VNB sky130_fd_pr__nfet_01v8 ad=0.08775 pd=0.92 as=0.182 ps=1.86 w=0.65 l=0.15
X5 VGND B Y VNB sky130_fd_pr__nfet_01v8 ad=0.169 pd=1.82 as=0.08775 ps=0.92 w=0.65 l=0.15
X6 VPWR A a_27_297# VPB sky130_fd_pr__pfet_01v8_hvt ad=0.135 pd=1.27 as=0.28 ps=2.56 w=1 l=0.15
X7 a_27_297# B Y VPB sky130_fd_pr__pfet_01v8_hvt ad=0.26 pd=2.52 as=0.135 ps=1.27 w=1 l=0.15
.ends

.subckt sky130_fd_sc_hd__inv_4 A VGND VNB VPB VPWR Y
X0 VPWR A Y VPB sky130_fd_pr__pfet_01v8_hvt ad=0.26 pd=2.52 as=0.135 ps=1.27 w=1 l=0.15
X1 Y A VPWR VPB sky130_fd_pr__pfet_01v8_hvt ad=0.135 pd=1.27 as=0.135 ps=1.27 w=1 l=0.15
X2 Y A VGND VNB sky130_fd_pr__nfet_01v8 ad=0.08775 pd=0.92 as=0.169 ps=1.82 w=0.65 l=0.15
X3 VPWR A Y VPB sky130_fd_pr__pfet_01v8_hvt ad=0.135 pd=1.27 as=0.135 ps=1.27 w=1 l=0.15
X4 VGND A Y VNB sky130_fd_pr__nfet_01v8 ad=0.08775 pd=0.92 as=0.08775 ps=0.92 w=0.65 l=0.15
X5 Y A VPWR VPB sky130_fd_pr__pfet_01v8_hvt ad=0.135 pd=1.27 as=0.26 ps=2.52 w=1 l=0.15
X6 VGND A Y VNB sky130_fd_pr__nfet_01v8 ad=0.169 pd=1.82 as=0.08775 ps=0.92 w=0.65 l=0.15
X7 Y A VGND VNB sky130_fd_pr__nfet_01v8 ad=0.08775 pd=0.92 as=0.08775 ps=0.92 w=0.65 l=0.15
.ends

.subckt sky130_fd_sc_hd__or2_2 A B VGND VNB VPB VPWR X
X0 a_121_297# B a_39_297# VPB sky130_fd_pr__pfet_01v8_hvt ad=0.0441 pd=0.63 as=0.1092 ps=1.36 w=0.42 l=0.15
X1 X a_39_297# VGND VNB sky130_fd_pr__nfet_01v8 ad=0.08775 pd=0.92 as=0.10675 ps=1.005 w=0.65 l=0.15
X2 VPWR a_39_297# X VPB sky130_fd_pr__pfet_01v8_hvt ad=0.26 pd=2.52 as=0.135 ps=1.27 w=1 l=0.15
X3 X a_39_297# VPWR VPB sky130_fd_pr__pfet_01v8_hvt ad=0.135 pd=1.27 as=0.15575 ps=1.355 w=1 l=0.15
X4 VGND a_39_297# X VNB sky130_fd_pr__nfet_01v8 ad=0.169 pd=1.82 as=0.08775 ps=0.92 w=0.65 l=0.15
X5 VPWR A a_121_297# VPB sky130_fd_pr__pfet_01v8_hvt ad=0.15575 pd=1.355 as=0.0441 ps=0.63 w=0.42 l=0.15
X6 VGND A a_39_297# VNB sky130_fd_pr__nfet_01v8 ad=0.10675 pd=1.005 as=0.0567 ps=0.69 w=0.42 l=0.15
X7 a_39_297# B VGND VNB sky130_fd_pr__nfet_01v8 ad=0.0567 pd=0.69 as=0.1092 ps=1.36 w=0.42 l=0.15
.ends

.subckt sky130_fd_sc_hd__nand3_1 A B C VGND VNB VPB VPWR Y
X0 VPWR B Y VPB sky130_fd_pr__pfet_01v8_hvt ad=0.165 pd=1.33 as=0.135 ps=1.27 w=1 l=0.15
X1 Y A VPWR VPB sky130_fd_pr__pfet_01v8_hvt ad=0.26 pd=2.52 as=0.165 ps=1.33 w=1 l=0.15
X2 a_193_47# B a_109_47# VNB sky130_fd_pr__nfet_01v8 ad=0.10725 pd=0.98 as=0.08775 ps=0.92 w=0.65 l=0.15
X3 Y A a_193_47# VNB sky130_fd_pr__nfet_01v8 ad=0.169 pd=1.82 as=0.10725 ps=0.98 w=0.65 l=0.15
X4 Y C VPWR VPB sky130_fd_pr__pfet_01v8_hvt ad=0.135 pd=1.27 as=0.26 ps=2.52 w=1 l=0.15
X5 a_109_47# C VGND VNB sky130_fd_pr__nfet_01v8 ad=0.08775 pd=0.92 as=0.169 ps=1.82 w=0.65 l=0.15
.ends

.subckt sky130_fd_sc_hd__nand2_4 A B VGND VNB VPB VPWR Y
X0 a_27_47# A Y VNB sky130_fd_pr__nfet_01v8 ad=0.08775 pd=0.92 as=0.08775 ps=0.92 w=0.65 l=0.15
X1 a_27_47# A Y VNB sky130_fd_pr__nfet_01v8 ad=0.169 pd=1.82 as=0.08775 ps=0.92 w=0.65 l=0.15
X2 Y A VPWR VPB sky130_fd_pr__pfet_01v8_hvt ad=0.135 pd=1.27 as=0.135 ps=1.27 w=1 l=0.15
X3 VPWR B Y VPB sky130_fd_pr__pfet_01v8_hvt ad=0.135 pd=1.27 as=0.135 ps=1.27 w=1 l=0.15
X4 Y B VPWR VPB sky130_fd_pr__pfet_01v8_hvt ad=0.135 pd=1.27 as=0.135 ps=1.27 w=1 l=0.15
X5 VPWR B Y VPB sky130_fd_pr__pfet_01v8_hvt ad=0.135 pd=1.27 as=0.135 ps=1.27 w=1 l=0.15
X6 a_27_47# B VGND VNB sky130_fd_pr__nfet_01v8 ad=0.08775 pd=0.92 as=0.08775 ps=0.92 w=0.65 l=0.15
X7 a_27_47# B VGND VNB sky130_fd_pr__nfet_01v8 ad=0.08775 pd=0.92 as=0.08775 ps=0.92 w=0.65 l=0.15
X8 VPWR A Y VPB sky130_fd_pr__pfet_01v8_hvt ad=0.26 pd=2.52 as=0.135 ps=1.27 w=1 l=0.15
X9 VGND B a_27_47# VNB sky130_fd_pr__nfet_01v8 ad=0.08775 pd=0.92 as=0.08775 ps=0.92 w=0.65 l=0.15
X10 Y A a_27_47# VNB sky130_fd_pr__nfet_01v8 ad=0.08775 pd=0.92 as=0.08775 ps=0.92 w=0.65 l=0.15
X11 Y A VPWR VPB sky130_fd_pr__pfet_01v8_hvt ad=0.135 pd=1.27 as=0.135 ps=1.27 w=1 l=0.15
X12 Y A a_27_47# VNB sky130_fd_pr__nfet_01v8 ad=0.08775 pd=0.92 as=0.08775 ps=0.92 w=0.65 l=0.15
X13 VPWR A Y VPB sky130_fd_pr__pfet_01v8_hvt ad=0.135 pd=1.27 as=0.135 ps=1.27 w=1 l=0.15
X14 Y B VPWR VPB sky130_fd_pr__pfet_01v8_hvt ad=0.135 pd=1.27 as=0.26 ps=2.52 w=1 l=0.15
X15 VGND B a_27_47# VNB sky130_fd_pr__nfet_01v8 ad=0.08775 pd=0.92 as=0.169 ps=1.82 w=0.65 l=0.15
.ends

.subckt sky130_fd_sc_hd__nor4b_2 A B C D_N VGND VNB VPB VPWR Y
X0 VPWR D_N a_694_21# VPB sky130_fd_pr__pfet_01v8_hvt ad=0.1092 pd=1.36 as=0.1092 ps=1.36 w=0.42 l=0.15
X1 a_27_297# B a_277_297# VPB sky130_fd_pr__pfet_01v8_hvt ad=0.26 pd=2.52 as=0.135 ps=1.27 w=1 l=0.15
X2 a_474_297# a_694_21# Y VPB sky130_fd_pr__pfet_01v8_hvt ad=0.26 pd=2.52 as=0.135 ps=1.27 w=1 l=0.15
X3 a_277_297# B a_27_297# VPB sky130_fd_pr__pfet_01v8_hvt ad=0.135 pd=1.27 as=0.135 ps=1.27 w=1 l=0.15
X4 Y a_694_21# a_474_297# VPB sky130_fd_pr__pfet_01v8_hvt ad=0.135 pd=1.27 as=0.135 ps=1.27 w=1 l=0.15
X5 VGND C Y VNB sky130_fd_pr__nfet_01v8 ad=0.08775 pd=0.92 as=0.08775 ps=0.92 w=0.65 l=0.15
X6 VGND D_N a_694_21# VNB sky130_fd_pr__nfet_01v8 ad=0.1092 pd=1.36 as=0.1092 ps=1.36 w=0.42 l=0.15
X7 a_27_297# A VPWR VPB sky130_fd_pr__pfet_01v8_hvt ad=0.135 pd=1.27 as=0.135 ps=1.27 w=1 l=0.15
X8 VGND A Y VNB sky130_fd_pr__nfet_01v8 ad=0.08775 pd=0.92 as=0.08775 ps=0.92 w=0.65 l=0.15
X9 VGND B Y VNB sky130_fd_pr__nfet_01v8 ad=0.169 pd=1.82 as=0.08775 ps=0.92 w=0.65 l=0.15
X10 Y C VGND VNB sky130_fd_pr__nfet_01v8 ad=0.08775 pd=0.92 as=0.169 ps=1.82 w=0.65 l=0.15
X11 a_474_297# C a_277_297# VPB sky130_fd_pr__pfet_01v8_hvt ad=0.135 pd=1.27 as=0.135 ps=1.27 w=1 l=0.15
X12 Y B VGND VNB sky130_fd_pr__nfet_01v8 ad=0.08775 pd=0.92 as=0.08775 ps=0.92 w=0.65 l=0.15
X13 Y a_694_21# VGND VNB sky130_fd_pr__nfet_01v8 ad=0.08775 pd=0.92 as=0.08775 ps=0.92 w=0.65 l=0.15
X14 a_277_297# C a_474_297# VPB sky130_fd_pr__pfet_01v8_hvt ad=0.135 pd=1.27 as=0.26 ps=2.52 w=1 l=0.15
X15 VGND a_694_21# Y VNB sky130_fd_pr__nfet_01v8 ad=0.169 pd=1.82 as=0.08775 ps=0.92 w=0.65 l=0.15
X16 VPWR A a_27_297# VPB sky130_fd_pr__pfet_01v8_hvt ad=0.135 pd=1.27 as=0.26 ps=2.52 w=1 l=0.15
X17 Y A VGND VNB sky130_fd_pr__nfet_01v8 ad=0.08775 pd=0.92 as=0.169 ps=1.82 w=0.65 l=0.15
.ends

.subckt sky130_fd_sc_hd__inv_8 A VGND VNB VPB VPWR Y
X0 VPWR A Y VPB sky130_fd_pr__pfet_01v8_hvt ad=0.135 pd=1.27 as=0.135 ps=1.27 w=1 l=0.15
X1 Y A VPWR VPB sky130_fd_pr__pfet_01v8_hvt ad=0.135 pd=1.27 as=0.135 ps=1.27 w=1 l=0.15
X2 Y A VGND VNB sky130_fd_pr__nfet_01v8 ad=0.08775 pd=0.92 as=0.08775 ps=0.92 w=0.65 l=0.15
X3 Y A VGND VNB sky130_fd_pr__nfet_01v8 ad=0.08775 pd=0.92 as=0.08775 ps=0.92 w=0.65 l=0.15
X4 VPWR A Y VPB sky130_fd_pr__pfet_01v8_hvt ad=0.135 pd=1.27 as=0.135 ps=1.27 w=1 l=0.15
X5 Y A VPWR VPB sky130_fd_pr__pfet_01v8_hvt ad=0.135 pd=1.27 as=0.26 ps=2.52 w=1 l=0.15
X6 Y A VGND VNB sky130_fd_pr__nfet_01v8 ad=0.08775 pd=0.92 as=0.169 ps=1.82 w=0.65 l=0.15
X7 VPWR A Y VPB sky130_fd_pr__pfet_01v8_hvt ad=0.26 pd=2.52 as=0.135 ps=1.27 w=1 l=0.15
X8 Y A VGND VNB sky130_fd_pr__nfet_01v8 ad=0.08775 pd=0.92 as=0.08775 ps=0.92 w=0.65 l=0.15
X9 Y A VPWR VPB sky130_fd_pr__pfet_01v8_hvt ad=0.135 pd=1.27 as=0.135 ps=1.27 w=1 l=0.15
X10 VPWR A Y VPB sky130_fd_pr__pfet_01v8_hvt ad=0.135 pd=1.27 as=0.135 ps=1.27 w=1 l=0.15
X11 VGND A Y VNB sky130_fd_pr__nfet_01v8 ad=0.08775 pd=0.92 as=0.08775 ps=0.92 w=0.65 l=0.15
X12 VGND A Y VNB sky130_fd_pr__nfet_01v8 ad=0.08775 pd=0.92 as=0.08775 ps=0.92 w=0.65 l=0.15
X13 VGND A Y VNB sky130_fd_pr__nfet_01v8 ad=0.08775 pd=0.92 as=0.08775 ps=0.92 w=0.65 l=0.15
X14 Y A VPWR VPB sky130_fd_pr__pfet_01v8_hvt ad=0.135 pd=1.27 as=0.135 ps=1.27 w=1 l=0.15
X15 VGND A Y VNB sky130_fd_pr__nfet_01v8 ad=0.169 pd=1.82 as=0.08775 ps=0.92 w=0.65 l=0.15
.ends

.subckt sky130_fd_sc_hd__o21ai_4 A1 A2 B1 VGND VNB VPB VPWR Y
X0 VPWR B1 Y VPB sky130_fd_pr__pfet_01v8_hvt ad=0.14 pd=1.28 as=0.14 ps=1.28 w=1 l=0.15
X1 a_115_297# A1 VPWR VPB sky130_fd_pr__pfet_01v8_hvt ad=0.14 pd=1.28 as=0.14 ps=1.28 w=1 l=0.15
X2 a_115_297# A2 Y VPB sky130_fd_pr__pfet_01v8_hvt ad=0.14 pd=1.28 as=0.14 ps=1.28 w=1 l=0.15
X3 VPWR A1 a_115_297# VPB sky130_fd_pr__pfet_01v8_hvt ad=0.16 pd=1.32 as=0.14 ps=1.28 w=1 l=0.15
X4 VGND A2 a_32_47# VNB sky130_fd_pr__nfet_01v8 ad=0.104 pd=0.97 as=0.091 ps=0.93 w=0.65 l=0.15
X5 Y B1 a_32_47# VNB sky130_fd_pr__nfet_01v8 ad=0.091 pd=0.93 as=0.091 ps=0.93 w=0.65 l=0.15
X6 VGND A1 a_32_47# VNB sky130_fd_pr__nfet_01v8 ad=0.091 pd=0.93 as=0.17225 ps=1.83 w=0.65 l=0.15
X7 Y B1 VPWR VPB sky130_fd_pr__pfet_01v8_hvt ad=0.14 pd=1.28 as=0.14 ps=1.28 w=1 l=0.15
X8 a_32_47# B1 Y VNB sky130_fd_pr__nfet_01v8 ad=0.18525 pd=1.87 as=0.091 ps=0.93 w=0.65 l=0.15
X9 Y B1 a_32_47# VNB sky130_fd_pr__nfet_01v8 ad=0.091 pd=0.93 as=0.091 ps=0.93 w=0.65 l=0.15
X10 Y A2 a_115_297# VPB sky130_fd_pr__pfet_01v8_hvt ad=0.14 pd=1.28 as=0.14 ps=1.28 w=1 l=0.15
X11 a_32_47# A2 VGND VNB sky130_fd_pr__nfet_01v8 ad=0.091 pd=0.93 as=0.091 ps=0.93 w=0.65 l=0.15
X12 a_32_47# B1 Y VNB sky130_fd_pr__nfet_01v8 ad=0.091 pd=0.93 as=0.091 ps=0.93 w=0.65 l=0.15
X13 a_32_47# A2 VGND VNB sky130_fd_pr__nfet_01v8 ad=0.091 pd=0.93 as=0.091 ps=0.93 w=0.65 l=0.15
X14 a_115_297# A2 Y VPB sky130_fd_pr__pfet_01v8_hvt ad=0.14 pd=1.28 as=0.14 ps=1.28 w=1 l=0.15
X15 a_32_47# A1 VGND VNB sky130_fd_pr__nfet_01v8 ad=0.091 pd=0.93 as=0.104 ps=0.97 w=0.65 l=0.15
X16 VPWR B1 Y VPB sky130_fd_pr__pfet_01v8_hvt ad=0.265 pd=2.53 as=0.14 ps=1.28 w=1 l=0.15
X17 a_32_47# A1 VGND VNB sky130_fd_pr__nfet_01v8 ad=0.091 pd=0.93 as=0.091 ps=0.93 w=0.65 l=0.15
X18 VGND A2 a_32_47# VNB sky130_fd_pr__nfet_01v8 ad=0.091 pd=0.93 as=0.091 ps=0.93 w=0.65 l=0.15
X19 Y B1 VPWR VPB sky130_fd_pr__pfet_01v8_hvt ad=0.14 pd=1.28 as=0.16 ps=1.32 w=1 l=0.15
X20 VPWR A1 a_115_297# VPB sky130_fd_pr__pfet_01v8_hvt ad=0.14 pd=1.28 as=0.14 ps=1.28 w=1 l=0.15
X21 Y A2 a_115_297# VPB sky130_fd_pr__pfet_01v8_hvt ad=0.14 pd=1.28 as=0.14 ps=1.28 w=1 l=0.15
X22 VGND A1 a_32_47# VNB sky130_fd_pr__nfet_01v8 ad=0.091 pd=0.93 as=0.091 ps=0.93 w=0.65 l=0.15
X23 a_115_297# A1 VPWR VPB sky130_fd_pr__pfet_01v8_hvt ad=0.14 pd=1.28 as=0.265 ps=2.53 w=1 l=0.15
.ends

.subckt sky130_fd_sc_hd__bufinv_16 A VGND VNB VPB VPWR Y
X0 a_361_47# a_27_47# VGND VNB sky130_fd_pr__nfet_01v8 ad=0.08775 pd=0.92 as=0.08775 ps=0.92 w=0.65 l=0.15
X1 VPWR a_361_47# Y VPB sky130_fd_pr__pfet_01v8_hvt ad=0.135 pd=1.27 as=0.135 ps=1.27 w=1 l=0.15
X2 a_361_47# a_27_47# VGND VNB sky130_fd_pr__nfet_01v8 ad=0.08775 pd=0.92 as=0.08775 ps=0.92 w=0.65 l=0.15
X3 Y a_361_47# VGND VNB sky130_fd_pr__nfet_01v8 ad=0.08775 pd=0.92 as=0.08775 ps=0.92 w=0.65 l=0.15
X4 VPWR a_361_47# Y VPB sky130_fd_pr__pfet_01v8_hvt ad=0.135 pd=1.27 as=0.135 ps=1.27 w=1 l=0.15
X5 Y a_361_47# VGND VNB sky130_fd_pr__nfet_01v8 ad=0.08775 pd=0.92 as=0.08775 ps=0.92 w=0.65 l=0.15
X6 Y a_361_47# VPWR VPB sky130_fd_pr__pfet_01v8_hvt ad=0.135 pd=1.27 as=0.135 ps=1.27 w=1 l=0.15
X7 VPWR a_27_47# a_361_47# VPB sky130_fd_pr__pfet_01v8_hvt ad=0.135 pd=1.27 as=0.135 ps=1.27 w=1 l=0.15
X8 VPWR a_361_47# Y VPB sky130_fd_pr__pfet_01v8_hvt ad=0.26 pd=2.52 as=0.135 ps=1.27 w=1 l=0.15
X9 VPWR a_361_47# Y VPB sky130_fd_pr__pfet_01v8_hvt ad=0.135 pd=1.27 as=0.135 ps=1.27 w=1 l=0.15
X10 VGND a_361_47# Y VNB sky130_fd_pr__nfet_01v8 ad=0.169 pd=1.82 as=0.08775 ps=0.92 w=0.65 l=0.15
X11 a_361_47# a_27_47# VPWR VPB sky130_fd_pr__pfet_01v8_hvt ad=0.135 pd=1.27 as=0.135 ps=1.27 w=1 l=0.15
X12 VGND a_361_47# Y VNB sky130_fd_pr__nfet_01v8 ad=0.08775 pd=0.92 as=0.08775 ps=0.92 w=0.65 l=0.15
X13 VGND a_361_47# Y VNB sky130_fd_pr__nfet_01v8 ad=0.08775 pd=0.92 as=0.08775 ps=0.92 w=0.65 l=0.15
X14 VGND a_361_47# Y VNB sky130_fd_pr__nfet_01v8 ad=0.08775 pd=0.92 as=0.08775 ps=0.92 w=0.65 l=0.15
X15 VGND a_361_47# Y VNB sky130_fd_pr__nfet_01v8 ad=0.08775 pd=0.92 as=0.08775 ps=0.92 w=0.65 l=0.15
X16 VPWR A a_27_47# VPB sky130_fd_pr__pfet_01v8_hvt ad=0.135 pd=1.27 as=0.135 ps=1.27 w=1 l=0.15
X17 Y a_361_47# VPWR VPB sky130_fd_pr__pfet_01v8_hvt ad=0.135 pd=1.27 as=0.135 ps=1.27 w=1 l=0.15
X18 VGND a_361_47# Y VNB sky130_fd_pr__nfet_01v8 ad=0.08775 pd=0.92 as=0.08775 ps=0.92 w=0.65 l=0.15
X19 VPWR a_361_47# Y VPB sky130_fd_pr__pfet_01v8_hvt ad=0.135 pd=1.27 as=0.135 ps=1.27 w=1 l=0.15
X20 a_27_47# A VPWR VPB sky130_fd_pr__pfet_01v8_hvt ad=0.135 pd=1.27 as=0.135 ps=1.27 w=1 l=0.15
X21 Y a_361_47# VPWR VPB sky130_fd_pr__pfet_01v8_hvt ad=0.135 pd=1.27 as=0.135 ps=1.27 w=1 l=0.15
X22 a_27_47# A VGND VNB sky130_fd_pr__nfet_01v8 ad=0.08775 pd=0.92 as=0.08775 ps=0.92 w=0.65 l=0.15
X23 a_361_47# a_27_47# VGND VNB sky130_fd_pr__nfet_01v8 ad=0.08775 pd=0.92 as=0.08775 ps=0.92 w=0.65 l=0.15
X24 Y a_361_47# VPWR VPB sky130_fd_pr__pfet_01v8_hvt ad=0.135 pd=1.27 as=0.135 ps=1.27 w=1 l=0.15
X25 Y a_361_47# VGND VNB sky130_fd_pr__nfet_01v8 ad=0.08775 pd=0.92 as=0.08775 ps=0.92 w=0.65 l=0.15
X26 VPWR a_27_47# a_361_47# VPB sky130_fd_pr__pfet_01v8_hvt ad=0.135 pd=1.27 as=0.135 ps=1.27 w=1 l=0.15
X27 Y a_361_47# VGND VNB sky130_fd_pr__nfet_01v8 ad=0.08775 pd=0.92 as=0.08775 ps=0.92 w=0.65 l=0.15
X28 Y a_361_47# VPWR VPB sky130_fd_pr__pfet_01v8_hvt ad=0.135 pd=1.27 as=0.135 ps=1.27 w=1 l=0.15
X29 Y a_361_47# VGND VNB sky130_fd_pr__nfet_01v8 ad=0.08775 pd=0.92 as=0.08775 ps=0.92 w=0.65 l=0.15
X30 a_361_47# a_27_47# VPWR VPB sky130_fd_pr__pfet_01v8_hvt ad=0.135 pd=1.27 as=0.135 ps=1.27 w=1 l=0.15
X31 VPWR a_361_47# Y VPB sky130_fd_pr__pfet_01v8_hvt ad=0.135 pd=1.27 as=0.135 ps=1.27 w=1 l=0.15
X32 Y a_361_47# VGND VNB sky130_fd_pr__nfet_01v8 ad=0.08775 pd=0.92 as=0.08775 ps=0.92 w=0.65 l=0.15
X33 VGND A a_27_47# VNB sky130_fd_pr__nfet_01v8 ad=0.08775 pd=0.92 as=0.08775 ps=0.92 w=0.65 l=0.15
X34 VGND a_27_47# a_361_47# VNB sky130_fd_pr__nfet_01v8 ad=0.08775 pd=0.92 as=0.08775 ps=0.92 w=0.65 l=0.15
X35 VPWR a_27_47# a_361_47# VPB sky130_fd_pr__pfet_01v8_hvt ad=0.135 pd=1.27 as=0.135 ps=1.27 w=1 l=0.15
X36 Y a_361_47# VPWR VPB sky130_fd_pr__pfet_01v8_hvt ad=0.135 pd=1.27 as=0.135 ps=1.27 w=1 l=0.15
X37 VGND a_27_47# a_361_47# VNB sky130_fd_pr__nfet_01v8 ad=0.08775 pd=0.92 as=0.08775 ps=0.92 w=0.65 l=0.15
X38 VGND a_27_47# a_361_47# VNB sky130_fd_pr__nfet_01v8 ad=0.08775 pd=0.92 as=0.08775 ps=0.92 w=0.65 l=0.15
X39 a_361_47# a_27_47# VPWR VPB sky130_fd_pr__pfet_01v8_hvt ad=0.135 pd=1.27 as=0.135 ps=1.27 w=1 l=0.15
X40 VPWR a_361_47# Y VPB sky130_fd_pr__pfet_01v8_hvt ad=0.135 pd=1.27 as=0.135 ps=1.27 w=1 l=0.15
X41 VPWR a_361_47# Y VPB sky130_fd_pr__pfet_01v8_hvt ad=0.135 pd=1.27 as=0.135 ps=1.27 w=1 l=0.15
X42 VGND a_361_47# Y VNB sky130_fd_pr__nfet_01v8 ad=0.08775 pd=0.92 as=0.08775 ps=0.92 w=0.65 l=0.15
X43 VGND a_361_47# Y VNB sky130_fd_pr__nfet_01v8 ad=0.08775 pd=0.92 as=0.08775 ps=0.92 w=0.65 l=0.15
X44 VPWR A a_27_47# VPB sky130_fd_pr__pfet_01v8_hvt ad=0.135 pd=1.27 as=0.26 ps=2.52 w=1 l=0.15
X45 Y a_361_47# VPWR VPB sky130_fd_pr__pfet_01v8_hvt ad=0.135 pd=1.27 as=0.135 ps=1.27 w=1 l=0.15
X46 Y a_361_47# VGND VNB sky130_fd_pr__nfet_01v8 ad=0.08775 pd=0.92 as=0.08775 ps=0.92 w=0.65 l=0.15
X47 Y a_361_47# VPWR VPB sky130_fd_pr__pfet_01v8_hvt ad=0.135 pd=1.27 as=0.135 ps=1.27 w=1 l=0.15
X48 VGND A a_27_47# VNB sky130_fd_pr__nfet_01v8 ad=0.08775 pd=0.92 as=0.169 ps=1.82 w=0.65 l=0.15
X49 Y a_361_47# VGND VNB sky130_fd_pr__nfet_01v8 ad=0.08775 pd=0.92 as=0.08775 ps=0.92 w=0.65 l=0.15
C0 VPB VNB 2.19949f
.ends

.subckt sky130_fd_sc_hd__o2bb2a_1 A1_N A2_N B1 B2 VGND VNB VPB VPWR X
X0 a_206_369# A1_N VPWR VPB sky130_fd_pr__pfet_01v8_hvt ad=0.129 pd=1.18 as=0.14575 ps=1.335 w=0.42 l=0.15
X1 a_206_369# A2_N a_205_47# VNB sky130_fd_pr__nfet_01v8 ad=0.1092 pd=1.36 as=0.06615 ps=0.735 w=0.42 l=0.15
X2 VGND B2 a_489_47# VNB sky130_fd_pr__nfet_01v8 ad=0.0567 pd=0.69 as=0.0567 ps=0.69 w=0.42 l=0.15
X3 a_585_369# B2 a_76_199# VPB sky130_fd_pr__pfet_01v8_hvt ad=0.0441 pd=0.63 as=0.0672 ps=0.74 w=0.42 l=0.15
X4 a_489_47# a_206_369# a_76_199# VNB sky130_fd_pr__nfet_01v8 ad=0.0567 pd=0.69 as=0.1092 ps=1.36 w=0.42 l=0.15
X5 a_489_47# B1 VGND VNB sky130_fd_pr__nfet_01v8 ad=0.1092 pd=1.36 as=0.0567 ps=0.69 w=0.42 l=0.15
X6 VPWR A2_N a_206_369# VPB sky130_fd_pr__pfet_01v8_hvt ad=0.20925 pd=1.345 as=0.129 ps=1.18 w=0.42 l=0.15
X7 a_76_199# a_206_369# VPWR VPB sky130_fd_pr__pfet_01v8_hvt ad=0.0672 pd=0.74 as=0.20925 ps=1.345 w=0.42 l=0.15
X8 a_205_47# A1_N VGND VNB sky130_fd_pr__nfet_01v8 ad=0.06615 pd=0.735 as=0.09862 ps=0.98 w=0.42 l=0.15
X9 VPWR a_76_199# X VPB sky130_fd_pr__pfet_01v8_hvt ad=0.14575 pd=1.335 as=0.26 ps=2.52 w=1 l=0.15
X10 VPWR B1 a_585_369# VPB sky130_fd_pr__pfet_01v8_hvt ad=0.1092 pd=1.36 as=0.0441 ps=0.63 w=0.42 l=0.15
X11 VGND a_76_199# X VNB sky130_fd_pr__nfet_01v8 ad=0.09862 pd=0.98 as=0.169 ps=1.82 w=0.65 l=0.15
.ends

.subckt sky130_fd_sc_hd__o31a_1 A1 A2 A3 B1 VGND VNB VPB VPWR X
X0 a_103_199# B1 a_253_47# VNB sky130_fd_pr__nfet_01v8 ad=0.2015 pd=1.92 as=0.10725 ps=0.98 w=0.65 l=0.15
X1 VPWR a_103_199# X VPB sky130_fd_pr__pfet_01v8_hvt ad=0.195 pd=1.39 as=0.36 ps=2.72 w=1 l=0.15
X2 a_337_297# A2 a_253_297# VPB sky130_fd_pr__pfet_01v8_hvt ad=0.165 pd=1.33 as=0.135 ps=1.27 w=1 l=0.15
X3 a_103_199# A3 a_337_297# VPB sky130_fd_pr__pfet_01v8_hvt ad=0.2125 pd=1.425 as=0.165 ps=1.33 w=1 l=0.15
X4 a_253_297# A1 VPWR VPB sky130_fd_pr__pfet_01v8_hvt ad=0.135 pd=1.27 as=0.195 ps=1.39 w=1 l=0.15
X5 VPWR B1 a_103_199# VPB sky130_fd_pr__pfet_01v8_hvt ad=0.345 pd=2.69 as=0.2125 ps=1.425 w=1 l=0.15
X6 VGND a_103_199# X VNB sky130_fd_pr__nfet_01v8 ad=0.12675 pd=1.04 as=0.234 ps=2.02 w=0.65 l=0.15
X7 a_253_47# A1 VGND VNB sky130_fd_pr__nfet_01v8 ad=0.08775 pd=0.92 as=0.12675 ps=1.04 w=0.65 l=0.15
X8 a_253_47# A3 VGND VNB sky130_fd_pr__nfet_01v8 ad=0.10725 pd=0.98 as=0.10725 ps=0.98 w=0.65 l=0.15
X9 VGND A2 a_253_47# VNB sky130_fd_pr__nfet_01v8 ad=0.10725 pd=0.98 as=0.08775 ps=0.92 w=0.65 l=0.15
.ends

.subckt sky130_fd_sc_hd__o21a_1 A1 A2 B1 VGND VNB VPB VPWR X
X0 VPWR A1 a_382_297# VPB sky130_fd_pr__pfet_01v8_hvt ad=0.26 pd=2.52 as=0.1525 ps=1.305 w=1 l=0.15
X1 a_297_47# B1 a_79_21# VNB sky130_fd_pr__nfet_01v8 ad=0.10075 pd=0.96 as=0.169 ps=1.82 w=0.65 l=0.15
X2 a_297_47# A1 VGND VNB sky130_fd_pr__nfet_01v8 ad=0.169 pd=1.82 as=0.08775 ps=0.92 w=0.65 l=0.15
X3 VGND A2 a_297_47# VNB sky130_fd_pr__nfet_01v8 ad=0.08775 pd=0.92 as=0.10075 ps=0.96 w=0.65 l=0.15
X4 VPWR a_79_21# X VPB sky130_fd_pr__pfet_01v8_hvt ad=0.3275 pd=1.655 as=0.28 ps=2.56 w=1 l=0.15
X5 a_79_21# B1 VPWR VPB sky130_fd_pr__pfet_01v8_hvt ad=0.195 pd=1.39 as=0.3275 ps=1.655 w=1 l=0.15
X6 a_382_297# A2 a_79_21# VPB sky130_fd_pr__pfet_01v8_hvt ad=0.1525 pd=1.305 as=0.195 ps=1.39 w=1 l=0.15
X7 VGND a_79_21# X VNB sky130_fd_pr__nfet_01v8 ad=0.169 pd=1.82 as=0.169 ps=1.82 w=0.65 l=0.15
.ends

.subckt sky130_fd_sc_hd__nand3b_1 A_N B C VGND VNB VPB VPWR Y
X0 Y a_53_93# VPWR VPB sky130_fd_pr__pfet_01v8_hvt ad=0.28 pd=2.56 as=0.1925 ps=1.385 w=1 l=0.15
X1 a_232_47# C VGND VNB sky130_fd_pr__nfet_01v8 ad=0.08775 pd=0.92 as=0.10025 ps=0.985 w=0.65 l=0.15
X2 VPWR B Y VPB sky130_fd_pr__pfet_01v8_hvt ad=0.1925 pd=1.385 as=0.135 ps=1.27 w=1 l=0.15
X3 VPWR A_N a_53_93# VPB sky130_fd_pr__pfet_01v8_hvt ad=0.14575 pd=1.335 as=0.1092 ps=1.36 w=0.42 l=0.15
X4 VGND A_N a_53_93# VNB sky130_fd_pr__nfet_01v8 ad=0.10025 pd=0.985 as=0.1092 ps=1.36 w=0.42 l=0.15
X5 a_316_47# B a_232_47# VNB sky130_fd_pr__nfet_01v8 ad=0.12513 pd=1.035 as=0.08775 ps=0.92 w=0.65 l=0.15
X6 Y a_53_93# a_316_47# VNB sky130_fd_pr__nfet_01v8 ad=0.182 pd=1.86 as=0.12513 ps=1.035 w=0.65 l=0.15
X7 Y C VPWR VPB sky130_fd_pr__pfet_01v8_hvt ad=0.135 pd=1.27 as=0.14575 ps=1.335 w=1 l=0.15
.ends

.subckt sky130_fd_sc_hd__a211oi_1 A1 A2 B1 C1 VGND VNB VPB VPWR Y
X0 a_56_297# A1 VPWR VPB sky130_fd_pr__pfet_01v8_hvt ad=0.14 pd=1.28 as=0.14 ps=1.28 w=1 l=0.15
X1 VPWR A2 a_56_297# VPB sky130_fd_pr__pfet_01v8_hvt ad=0.14 pd=1.28 as=0.265 ps=2.53 w=1 l=0.15
X2 Y C1 VGND VNB sky130_fd_pr__nfet_01v8 ad=0.17225 pd=1.83 as=0.10075 ps=0.96 w=0.65 l=0.15
X3 a_139_47# A2 VGND VNB sky130_fd_pr__nfet_01v8 ad=0.091 pd=0.93 as=0.2665 ps=2.12 w=0.65 l=0.15
X4 a_311_297# B1 a_56_297# VPB sky130_fd_pr__pfet_01v8_hvt ad=0.155 pd=1.31 as=0.14 ps=1.28 w=1 l=0.15
X5 Y C1 a_311_297# VPB sky130_fd_pr__pfet_01v8_hvt ad=0.265 pd=2.53 as=0.155 ps=1.31 w=1 l=0.15
X6 VGND B1 Y VNB sky130_fd_pr__nfet_01v8 ad=0.10075 pd=0.96 as=0.091 ps=0.93 w=0.65 l=0.15
X7 Y A1 a_139_47# VNB sky130_fd_pr__nfet_01v8 ad=0.091 pd=0.93 as=0.091 ps=0.93 w=0.65 l=0.15
.ends

.subckt sky130_fd_sc_hd__xor2_2 A B VGND VNB VPB VPWR X
X0 a_27_297# A VPWR VPB sky130_fd_pr__pfet_01v8_hvt ad=0.135 pd=1.27 as=0.135 ps=1.27 w=1 l=0.15
X1 a_470_47# A VGND VNB sky130_fd_pr__nfet_01v8 ad=0.08775 pd=0.92 as=0.08775 ps=0.92 w=0.65 l=0.15
X2 a_470_297# A VPWR VPB sky130_fd_pr__pfet_01v8_hvt ad=0.135 pd=1.27 as=0.135 ps=1.27 w=1 l=0.15
X3 VPWR A a_470_297# VPB sky130_fd_pr__pfet_01v8_hvt ad=0.135 pd=1.27 as=0.26 ps=2.52 w=1 l=0.15
X4 a_112_47# B VGND VNB sky130_fd_pr__nfet_01v8 ad=0.08775 pd=0.92 as=0.08775 ps=0.92 w=0.65 l=0.15
X5 a_470_47# B X VNB sky130_fd_pr__nfet_01v8 ad=0.169 pd=1.82 as=0.10563 ps=0.975 w=0.65 l=0.15
X6 VGND A a_112_47# VNB sky130_fd_pr__nfet_01v8 ad=0.08775 pd=0.92 as=0.08775 ps=0.92 w=0.65 l=0.15
X7 a_112_47# A VGND VNB sky130_fd_pr__nfet_01v8 ad=0.08775 pd=0.92 as=0.17875 ps=1.85 w=0.65 l=0.15
X8 VGND B a_112_47# VNB sky130_fd_pr__nfet_01v8 ad=0.169 pd=1.82 as=0.08775 ps=0.92 w=0.65 l=0.15
X9 VPWR A a_27_297# VPB sky130_fd_pr__pfet_01v8_hvt ad=0.135 pd=1.27 as=0.275 ps=2.55 w=1 l=0.15
X10 a_470_297# B VPWR VPB sky130_fd_pr__pfet_01v8_hvt ad=0.26 pd=2.52 as=0.1625 ps=1.325 w=1 l=0.15
X11 X a_112_47# VGND VNB sky130_fd_pr__nfet_01v8 ad=0.08775 pd=0.92 as=0.169 ps=1.82 w=0.65 l=0.15
X12 VPWR B a_470_297# VPB sky130_fd_pr__pfet_01v8_hvt ad=0.1625 pd=1.325 as=0.135 ps=1.27 w=1 l=0.15
X13 VGND a_112_47# X VNB sky130_fd_pr__nfet_01v8 ad=0.169 pd=1.82 as=0.08775 ps=0.92 w=0.65 l=0.15
X14 VGND A a_470_47# VNB sky130_fd_pr__nfet_01v8 ad=0.08775 pd=0.92 as=0.169 ps=1.82 w=0.65 l=0.15
X15 a_27_297# B a_112_47# VPB sky130_fd_pr__pfet_01v8_hvt ad=0.26 pd=2.52 as=0.135 ps=1.27 w=1 l=0.15
X16 X a_112_47# a_470_297# VPB sky130_fd_pr__pfet_01v8_hvt ad=0.135 pd=1.27 as=0.26 ps=2.52 w=1 l=0.15
X17 a_470_297# a_112_47# X VPB sky130_fd_pr__pfet_01v8_hvt ad=0.28 pd=2.56 as=0.135 ps=1.27 w=1 l=0.15
X18 X B a_470_47# VNB sky130_fd_pr__nfet_01v8 ad=0.10563 pd=0.975 as=0.08775 ps=0.92 w=0.65 l=0.15
X19 a_112_47# B a_27_297# VPB sky130_fd_pr__pfet_01v8_hvt ad=0.135 pd=1.27 as=0.135 ps=1.27 w=1 l=0.15
.ends

.subckt sky130_fd_sc_hd__a2bb2o_1 A1_N A2_N B1 B2 VGND VNB VPB VPWR X
X0 a_226_47# A2_N a_226_297# VPB sky130_fd_pr__pfet_01v8_hvt ad=0.1113 pd=1.37 as=0.0441 ps=0.63 w=0.42 l=0.15
X1 a_489_413# B1 VPWR VPB sky130_fd_pr__pfet_01v8_hvt ad=0.1092 pd=1.36 as=0.0567 ps=0.69 w=0.42 l=0.15
X2 a_226_297# A1_N VPWR VPB sky130_fd_pr__pfet_01v8_hvt ad=0.0441 pd=0.63 as=0.16675 ps=1.435 w=0.42 l=0.15
X3 VPWR B2 a_489_413# VPB sky130_fd_pr__pfet_01v8_hvt ad=0.0567 pd=0.69 as=0.0567 ps=0.69 w=0.42 l=0.15
X4 a_489_413# a_226_47# a_76_199# VPB sky130_fd_pr__pfet_01v8_hvt ad=0.0567 pd=0.69 as=0.1092 ps=1.36 w=0.42 l=0.15
X5 a_76_199# a_226_47# VGND VNB sky130_fd_pr__nfet_01v8 ad=0.0567 pd=0.69 as=0.1386 ps=1.08 w=0.42 l=0.15
X6 VGND B1 a_556_47# VNB sky130_fd_pr__nfet_01v8 ad=0.1092 pd=1.36 as=0.0567 ps=0.69 w=0.42 l=0.15
X7 a_556_47# B2 a_76_199# VNB sky130_fd_pr__nfet_01v8 ad=0.0567 pd=0.69 as=0.0567 ps=0.69 w=0.42 l=0.15
X8 VGND A2_N a_226_47# VNB sky130_fd_pr__nfet_01v8 ad=0.1386 pd=1.08 as=0.0567 ps=0.69 w=0.42 l=0.15
X9 a_226_47# A1_N VGND VNB sky130_fd_pr__nfet_01v8 ad=0.0567 pd=0.69 as=0.1201 ps=1.085 w=0.42 l=0.15
X10 VPWR a_76_199# X VPB sky130_fd_pr__pfet_01v8_hvt ad=0.16675 pd=1.435 as=0.26 ps=2.52 w=1 l=0.15
X11 VGND a_76_199# X VNB sky130_fd_pr__nfet_01v8 ad=0.1201 pd=1.085 as=0.169 ps=1.82 w=0.65 l=0.15
.ends

.subckt sky130_fd_sc_hd__clkinv_4 A VGND VNB VPB VPWR Y
X0 Y A VPWR VPB sky130_fd_pr__pfet_01v8_hvt ad=0.14 pd=1.28 as=0.14 ps=1.28 w=1 l=0.15
X1 VGND A Y VNB sky130_fd_pr__nfet_01v8 ad=0.1659 pd=1.63 as=0.0588 ps=0.7 w=0.42 l=0.15
X2 VGND A Y VNB sky130_fd_pr__nfet_01v8 ad=0.0588 pd=0.7 as=0.0588 ps=0.7 w=0.42 l=0.15
X3 VPWR A Y VPB sky130_fd_pr__pfet_01v8_hvt ad=0.14 pd=1.28 as=0.14 ps=1.28 w=1 l=0.15
X4 VPWR A Y VPB sky130_fd_pr__pfet_01v8_hvt ad=0.345 pd=2.69 as=0.14 ps=1.28 w=1 l=0.15
X5 Y A VGND VNB sky130_fd_pr__nfet_01v8 ad=0.0588 pd=0.7 as=0.0588 ps=0.7 w=0.42 l=0.15
X6 Y A VPWR VPB sky130_fd_pr__pfet_01v8_hvt ad=0.14 pd=1.28 as=0.305 ps=2.61 w=1 l=0.15
X7 Y A VGND VNB sky130_fd_pr__nfet_01v8 ad=0.0588 pd=0.7 as=0.1386 ps=1.5 w=0.42 l=0.15
X8 Y A VPWR VPB sky130_fd_pr__pfet_01v8_hvt ad=0.14 pd=1.28 as=0.14 ps=1.28 w=1 l=0.15
X9 VPWR A Y VPB sky130_fd_pr__pfet_01v8_hvt ad=0.14 pd=1.28 as=0.14 ps=1.28 w=1 l=0.15
.ends

.subckt sky130_fd_sc_hd__buf_4 A VGND VNB VPB VPWR X
X0 VPWR a_27_47# X VPB sky130_fd_pr__pfet_01v8_hvt ad=0.26 pd=2.52 as=0.135 ps=1.27 w=1 l=0.15
X1 X a_27_47# VPWR VPB sky130_fd_pr__pfet_01v8_hvt ad=0.135 pd=1.27 as=0.135 ps=1.27 w=1 l=0.15
X2 VPWR a_27_47# X VPB sky130_fd_pr__pfet_01v8_hvt ad=0.135 pd=1.27 as=0.135 ps=1.27 w=1 l=0.15
X3 X a_27_47# VPWR VPB sky130_fd_pr__pfet_01v8_hvt ad=0.135 pd=1.27 as=0.135 ps=1.27 w=1 l=0.15
X4 X a_27_47# VGND VNB sky130_fd_pr__nfet_01v8 ad=0.08775 pd=0.92 as=0.08775 ps=0.92 w=0.65 l=0.15
X5 X a_27_47# VGND VNB sky130_fd_pr__nfet_01v8 ad=0.08775 pd=0.92 as=0.08775 ps=0.92 w=0.65 l=0.15
X6 VGND a_27_47# X VNB sky130_fd_pr__nfet_01v8 ad=0.08775 pd=0.92 as=0.08775 ps=0.92 w=0.65 l=0.15
X7 VGND a_27_47# X VNB sky130_fd_pr__nfet_01v8 ad=0.169 pd=1.82 as=0.08775 ps=0.92 w=0.65 l=0.15
X8 VPWR A a_27_47# VPB sky130_fd_pr__pfet_01v8_hvt ad=0.135 pd=1.27 as=0.26 ps=2.52 w=1 l=0.15
X9 VGND A a_27_47# VNB sky130_fd_pr__nfet_01v8 ad=0.08775 pd=0.92 as=0.169 ps=1.82 w=0.65 l=0.15
.ends

.subckt sky130_fd_sc_hd__clkbuf_1 A VGND VNB VPB VPWR X
X0 VPWR a_75_212# X VPB sky130_fd_pr__pfet_01v8_hvt ad=0.11455 pd=1.08 as=0.2054 ps=2.1 w=0.79 l=0.15
X1 a_75_212# A VGND VNB sky130_fd_pr__nfet_01v8 ad=0.1352 pd=1.56 as=0.0754 ps=0.81 w=0.52 l=0.15
X2 a_75_212# A VPWR VPB sky130_fd_pr__pfet_01v8_hvt ad=0.2054 pd=2.1 as=0.11455 ps=1.08 w=0.79 l=0.15
X3 VGND a_75_212# X VNB sky130_fd_pr__nfet_01v8 ad=0.0754 pd=0.81 as=0.1352 ps=1.56 w=0.52 l=0.15
.ends

.subckt sky130_fd_sc_hd__dfxtp_2 CLK D VGND VNB VPB VPWR Q
X0 Q a_1059_315# VGND VNB sky130_fd_pr__nfet_01v8 ad=0.08775 pd=0.92 as=0.08775 ps=0.92 w=0.65 l=0.15
X1 VPWR a_1059_315# Q VPB sky130_fd_pr__pfet_01v8_hvt ad=0.26 pd=2.52 as=0.135 ps=1.27 w=1 l=0.15
X2 a_891_413# a_193_47# a_634_159# VNB sky130_fd_pr__special_nfet_01v8 ad=0.0684 pd=0.74 as=0.0989 ps=0.995 w=0.36 l=0.15
X3 a_561_413# a_27_47# a_466_413# VPB sky130_fd_pr__pfet_01v8_hvt ad=0.07665 pd=0.785 as=0.06825 ps=0.745 w=0.42 l=0.15
X4 VPWR CLK a_27_47# VPB sky130_fd_pr__pfet_01v8_hvt ad=0.0864 pd=0.91 as=0.1664 ps=1.8 w=0.64 l=0.15
X5 Q a_1059_315# VPWR VPB sky130_fd_pr__pfet_01v8_hvt ad=0.135 pd=1.27 as=0.135 ps=1.27 w=1 l=0.15
X6 a_381_47# D VPWR VPB sky130_fd_pr__pfet_01v8_hvt ad=0.05775 pd=0.695 as=0.1092 ps=1.36 w=0.42 l=0.15
X7 VGND a_634_159# a_592_47# VNB sky130_fd_pr__nfet_01v8 ad=0.12095 pd=1.085 as=0.0696 ps=0.765 w=0.42 l=0.15
X8 VGND a_1059_315# Q VNB sky130_fd_pr__nfet_01v8 ad=0.169 pd=1.82 as=0.08775 ps=0.92 w=0.65 l=0.15
X9 VPWR a_891_413# a_1059_315# VPB sky130_fd_pr__pfet_01v8_hvt ad=0.135 pd=1.27 as=0.27 ps=2.54 w=1 l=0.15
X10 a_466_413# a_193_47# a_381_47# VPB sky130_fd_pr__pfet_01v8_hvt ad=0.06825 pd=0.745 as=0.05775 ps=0.695 w=0.42 l=0.15
X11 VPWR a_634_159# a_561_413# VPB sky130_fd_pr__pfet_01v8_hvt ad=0.17887 pd=1.26 as=0.07665 ps=0.785 w=0.42 l=0.15
X12 a_634_159# a_466_413# VGND VNB sky130_fd_pr__nfet_01v8 ad=0.0989 pd=0.995 as=0.12095 ps=1.085 w=0.64 l=0.15
X13 a_634_159# a_466_413# VPWR VPB sky130_fd_pr__pfet_01v8_hvt ad=0.1095 pd=1.075 as=0.17887 ps=1.26 w=0.75 l=0.15
X14 a_975_413# a_193_47# a_891_413# VPB sky130_fd_pr__pfet_01v8_hvt ad=0.0882 pd=0.84 as=0.0567 ps=0.69 w=0.42 l=0.15
X15 VGND a_1059_315# a_1017_47# VNB sky130_fd_pr__nfet_01v8 ad=0.1092 pd=1.36 as=0.066 ps=0.745 w=0.42 l=0.15
X16 a_193_47# a_27_47# VGND VNB sky130_fd_pr__nfet_01v8 ad=0.1092 pd=1.36 as=0.0567 ps=0.69 w=0.42 l=0.15
X17 a_891_413# a_27_47# a_634_159# VPB sky130_fd_pr__pfet_01v8_hvt ad=0.0567 pd=0.69 as=0.1095 ps=1.075 w=0.42 l=0.15
X18 a_592_47# a_193_47# a_466_413# VNB sky130_fd_pr__special_nfet_01v8 ad=0.0696 pd=0.765 as=0.0621 ps=0.705 w=0.36 l=0.15
X19 VPWR a_1059_315# a_975_413# VPB sky130_fd_pr__pfet_01v8_hvt ad=0.1113 pd=1.37 as=0.0882 ps=0.84 w=0.42 l=0.15
X20 a_1017_47# a_27_47# a_891_413# VNB sky130_fd_pr__special_nfet_01v8 ad=0.066 pd=0.745 as=0.0684 ps=0.74 w=0.36 l=0.15
X21 a_193_47# a_27_47# VPWR VPB sky130_fd_pr__pfet_01v8_hvt ad=0.1664 pd=1.8 as=0.0864 ps=0.91 w=0.64 l=0.15
X22 a_466_413# a_27_47# a_381_47# VNB sky130_fd_pr__special_nfet_01v8 ad=0.0621 pd=0.705 as=0.0813 ps=0.83 w=0.36 l=0.15
X23 VGND a_891_413# a_1059_315# VNB sky130_fd_pr__nfet_01v8 ad=0.08775 pd=0.92 as=0.169 ps=1.82 w=0.65 l=0.15
X24 a_381_47# D VGND VNB sky130_fd_pr__nfet_01v8 ad=0.0813 pd=0.83 as=0.1092 ps=1.36 w=0.42 l=0.15
X25 VGND CLK a_27_47# VNB sky130_fd_pr__nfet_01v8 ad=0.0567 pd=0.69 as=0.1092 ps=1.36 w=0.42 l=0.15
.ends

.subckt sky130_fd_sc_hd__nor4_1 A B C D VGND VNB VPB VPWR Y
X0 Y B VGND VNB sky130_fd_pr__nfet_01v8 ad=0.08775 pd=0.92 as=0.08937 ps=0.925 w=0.65 l=0.15
X1 a_191_297# C a_109_297# VPB sky130_fd_pr__pfet_01v8_hvt ad=0.19 pd=1.38 as=0.13 ps=1.26 w=1 l=0.15
X2 VPWR A a_297_297# VPB sky130_fd_pr__pfet_01v8_hvt ad=0.26 pd=2.52 as=0.135 ps=1.27 w=1 l=0.15
X3 VGND C Y VNB sky130_fd_pr__nfet_01v8 ad=0.08937 pd=0.925 as=0.11863 ps=1.015 w=0.65 l=0.15
X4 VGND A Y VNB sky130_fd_pr__nfet_01v8 ad=0.169 pd=1.82 as=0.08775 ps=0.92 w=0.65 l=0.15
X5 a_297_297# B a_191_297# VPB sky130_fd_pr__pfet_01v8_hvt ad=0.135 pd=1.27 as=0.19 ps=1.38 w=1 l=0.15
X6 a_109_297# D Y VPB sky130_fd_pr__pfet_01v8_hvt ad=0.13 pd=1.26 as=0.26 ps=2.52 w=1 l=0.15
X7 Y D VGND VNB sky130_fd_pr__nfet_01v8 ad=0.11863 pd=1.015 as=0.169 ps=1.82 w=0.65 l=0.15
.ends

.subckt sky130_fd_sc_hd__a31o_2 A1 A2 A3 B1 VGND VNB VPB VPWR X
X0 VPWR A2 a_277_297# VPB sky130_fd_pr__pfet_01v8_hvt ad=0.165 pd=1.33 as=0.135 ps=1.27 w=1 l=0.15
X1 a_277_297# A1 VPWR VPB sky130_fd_pr__pfet_01v8_hvt ad=0.165 pd=1.33 as=0.165 ps=1.33 w=1 l=0.15
X2 a_79_21# B1 a_277_297# VPB sky130_fd_pr__pfet_01v8_hvt ad=0.32 pd=2.64 as=0.165 ps=1.33 w=1 l=0.15
X3 a_277_297# A3 VPWR VPB sky130_fd_pr__pfet_01v8_hvt ad=0.135 pd=1.27 as=0.135 ps=1.27 w=1 l=0.15
X4 VPWR a_79_21# X VPB sky130_fd_pr__pfet_01v8_hvt ad=0.135 pd=1.27 as=0.135 ps=1.27 w=1 l=0.15
X5 VGND a_79_21# X VNB sky130_fd_pr__nfet_01v8 ad=0.08775 pd=0.92 as=0.08775 ps=0.92 w=0.65 l=0.15
X6 a_361_47# A2 a_277_47# VNB sky130_fd_pr__nfet_01v8 ad=0.10725 pd=0.98 as=0.08775 ps=0.92 w=0.65 l=0.15
X7 a_277_47# A3 VGND VNB sky130_fd_pr__nfet_01v8 ad=0.08775 pd=0.92 as=0.08775 ps=0.92 w=0.65 l=0.15
X8 VGND B1 a_79_21# VNB sky130_fd_pr__nfet_01v8 ad=0.169 pd=1.82 as=0.12675 ps=1.04 w=0.65 l=0.15
X9 a_79_21# A1 a_361_47# VNB sky130_fd_pr__nfet_01v8 ad=0.12675 pd=1.04 as=0.10725 ps=0.98 w=0.65 l=0.15
X10 X a_79_21# VPWR VPB sky130_fd_pr__pfet_01v8_hvt ad=0.135 pd=1.27 as=0.26 ps=2.52 w=1 l=0.15
X11 X a_79_21# VGND VNB sky130_fd_pr__nfet_01v8 ad=0.08775 pd=0.92 as=0.169 ps=1.82 w=0.65 l=0.15
.ends

.subckt sky130_fd_sc_hd__nor3b_4 A B C_N VGND VNB VPB VPWR Y
X0 Y B VGND VNB sky130_fd_pr__nfet_01v8 ad=0.08775 pd=0.92 as=0.08775 ps=0.92 w=0.65 l=0.15
X1 VPWR A a_197_297# VPB sky130_fd_pr__pfet_01v8_hvt ad=0.135 pd=1.27 as=0.135 ps=1.27 w=1 l=0.15
X2 Y a_27_47# VGND VNB sky130_fd_pr__nfet_01v8 ad=0.08775 pd=0.92 as=0.08775 ps=0.92 w=0.65 l=0.15
X3 VGND A Y VNB sky130_fd_pr__nfet_01v8 ad=0.08775 pd=0.92 as=0.08775 ps=0.92 w=0.65 l=0.15
X4 a_555_297# a_27_47# Y VPB sky130_fd_pr__pfet_01v8_hvt ad=0.26 pd=2.52 as=0.135 ps=1.27 w=1 l=0.15
X5 a_197_297# A VPWR VPB sky130_fd_pr__pfet_01v8_hvt ad=0.135 pd=1.27 as=0.135 ps=1.27 w=1 l=0.15
X6 VGND a_27_47# Y VNB sky130_fd_pr__nfet_01v8 ad=0.08775 pd=0.92 as=0.08775 ps=0.92 w=0.65 l=0.15
X7 a_197_297# B a_555_297# VPB sky130_fd_pr__pfet_01v8_hvt ad=0.135 pd=1.27 as=0.26 ps=2.52 w=1 l=0.15
X8 VGND a_27_47# Y VNB sky130_fd_pr__nfet_01v8 ad=0.169 pd=1.82 as=0.08775 ps=0.92 w=0.65 l=0.15
X9 VGND B Y VNB sky130_fd_pr__nfet_01v8 ad=0.08775 pd=0.92 as=0.08775 ps=0.92 w=0.65 l=0.15
X10 Y A VGND VNB sky130_fd_pr__nfet_01v8 ad=0.08775 pd=0.92 as=0.08775 ps=0.92 w=0.65 l=0.15
X11 VGND C_N a_27_47# VNB sky130_fd_pr__nfet_01v8 ad=0.08775 pd=0.92 as=0.182 ps=1.86 w=0.65 l=0.15
X12 Y A VGND VNB sky130_fd_pr__nfet_01v8 ad=0.08775 pd=0.92 as=0.08775 ps=0.92 w=0.65 l=0.15
X13 Y a_27_47# a_555_297# VPB sky130_fd_pr__pfet_01v8_hvt ad=0.135 pd=1.27 as=0.135 ps=1.27 w=1 l=0.15
X14 Y a_27_47# a_555_297# VPB sky130_fd_pr__pfet_01v8_hvt ad=0.135 pd=1.27 as=0.135 ps=1.27 w=1 l=0.15
X15 VPWR C_N a_27_47# VPB sky130_fd_pr__pfet_01v8_hvt ad=0.135 pd=1.27 as=0.28 ps=2.56 w=1 l=0.15
X16 a_555_297# a_27_47# Y VPB sky130_fd_pr__pfet_01v8_hvt ad=0.135 pd=1.27 as=0.135 ps=1.27 w=1 l=0.15
X17 VGND A Y VNB sky130_fd_pr__nfet_01v8 ad=0.25675 pd=1.44 as=0.08775 ps=0.92 w=0.65 l=0.15
X18 a_555_297# B a_197_297# VPB sky130_fd_pr__pfet_01v8_hvt ad=0.135 pd=1.27 as=0.135 ps=1.27 w=1 l=0.15
X19 a_197_297# B a_555_297# VPB sky130_fd_pr__pfet_01v8_hvt ad=0.135 pd=1.27 as=0.135 ps=1.27 w=1 l=0.15
X20 VGND B Y VNB sky130_fd_pr__nfet_01v8 ad=0.08775 pd=0.92 as=0.08775 ps=0.92 w=0.65 l=0.15
X21 a_555_297# B a_197_297# VPB sky130_fd_pr__pfet_01v8_hvt ad=0.135 pd=1.27 as=0.135 ps=1.27 w=1 l=0.15
X22 VPWR A a_197_297# VPB sky130_fd_pr__pfet_01v8_hvt ad=0.26 pd=2.52 as=0.135 ps=1.27 w=1 l=0.15
X23 a_197_297# A VPWR VPB sky130_fd_pr__pfet_01v8_hvt ad=0.135 pd=1.27 as=0.135 ps=1.27 w=1 l=0.15
X24 Y B VGND VNB sky130_fd_pr__nfet_01v8 ad=0.08775 pd=0.92 as=0.25675 ps=1.44 w=0.65 l=0.15
X25 Y a_27_47# VGND VNB sky130_fd_pr__nfet_01v8 ad=0.08775 pd=0.92 as=0.08775 ps=0.92 w=0.65 l=0.15
.ends

.subckt sky130_fd_sc_hd__nor3b_1 A B C_N VGND VNB VPB VPWR Y
X0 VGND a_91_199# Y VNB sky130_fd_pr__nfet_01v8 ad=0.08775 pd=0.92 as=0.221 ps=1.98 w=0.65 l=0.15
X1 Y B VGND VNB sky130_fd_pr__nfet_01v8 ad=0.08775 pd=0.92 as=0.08775 ps=0.92 w=0.65 l=0.15
X2 VPWR A a_245_297# VPB sky130_fd_pr__pfet_01v8_hvt ad=0.14575 pd=1.335 as=0.135 ps=1.27 w=1 l=0.15
X3 a_91_199# C_N VGND VNB sky130_fd_pr__nfet_01v8 ad=0.1092 pd=1.36 as=0.10025 ps=0.985 w=0.42 l=0.15
X4 VGND A Y VNB sky130_fd_pr__nfet_01v8 ad=0.10025 pd=0.985 as=0.08775 ps=0.92 w=0.65 l=0.15
X5 a_245_297# B a_161_297# VPB sky130_fd_pr__pfet_01v8_hvt ad=0.135 pd=1.27 as=0.135 ps=1.27 w=1 l=0.15
X6 a_91_199# C_N VPWR VPB sky130_fd_pr__pfet_01v8_hvt ad=0.1092 pd=1.36 as=0.14575 ps=1.335 w=0.42 l=0.15
X7 a_161_297# a_91_199# Y VPB sky130_fd_pr__pfet_01v8_hvt ad=0.135 pd=1.27 as=0.32 ps=2.64 w=1 l=0.15
.ends

.subckt sky130_fd_sc_hd__a31oi_1 A1 A2 A3 B1 VGND VNB VPB VPWR Y
X0 Y A1 a_181_47# VNB sky130_fd_pr__nfet_01v8 ad=0.10563 pd=0.975 as=0.11863 ps=1.015 w=0.65 l=0.15
X1 a_181_47# A2 a_109_47# VNB sky130_fd_pr__nfet_01v8 ad=0.11863 pd=1.015 as=0.06825 ps=0.86 w=0.65 l=0.15
X2 VGND B1 Y VNB sky130_fd_pr__nfet_01v8 ad=0.1755 pd=1.84 as=0.10563 ps=0.975 w=0.65 l=0.15
X3 VPWR A2 a_109_297# VPB sky130_fd_pr__pfet_01v8_hvt ad=0.1525 pd=1.305 as=0.135 ps=1.27 w=1 l=0.15
X4 Y B1 a_109_297# VPB sky130_fd_pr__pfet_01v8_hvt ad=0.27 pd=2.54 as=0.1625 ps=1.325 w=1 l=0.15
X5 a_109_297# A1 VPWR VPB sky130_fd_pr__pfet_01v8_hvt ad=0.1625 pd=1.325 as=0.1525 ps=1.305 w=1 l=0.15
X6 a_109_297# A3 VPWR VPB sky130_fd_pr__pfet_01v8_hvt ad=0.135 pd=1.27 as=0.26 ps=2.52 w=1 l=0.15
X7 a_109_47# A3 VGND VNB sky130_fd_pr__nfet_01v8 ad=0.06825 pd=0.86 as=0.169 ps=1.82 w=0.65 l=0.15
.ends

.subckt sky130_fd_sc_hd__o32a_1 A1 A2 A3 B1 B2 VGND VNB VPB VPWR X
X0 a_77_199# B2 a_227_47# VNB sky130_fd_pr__nfet_01v8 ad=0.13325 pd=1.06 as=0.12675 ps=1.04 w=0.65 l=0.15
X1 a_323_297# A2 a_227_297# VPB sky130_fd_pr__pfet_01v8_hvt ad=0.195 pd=1.39 as=0.165 ps=1.33 w=1 l=0.15
X2 a_227_297# A1 VPWR VPB sky130_fd_pr__pfet_01v8_hvt ad=0.165 pd=1.33 as=0.135 ps=1.27 w=1 l=0.15
X3 a_227_47# B1 a_77_199# VNB sky130_fd_pr__nfet_01v8 ad=0.1885 pd=1.88 as=0.13325 ps=1.06 w=0.65 l=0.15
X4 VGND a_77_199# X VNB sky130_fd_pr__nfet_01v8 ad=0.08775 pd=0.92 as=0.169 ps=1.82 w=0.65 l=0.15
X5 VPWR B1 a_539_297# VPB sky130_fd_pr__pfet_01v8_hvt ad=0.29 pd=2.58 as=0.205 ps=1.41 w=1 l=0.15
X6 a_227_47# A3 VGND VNB sky130_fd_pr__nfet_01v8 ad=0.12675 pd=1.04 as=0.12675 ps=1.04 w=0.65 l=0.15
X7 VPWR a_77_199# X VPB sky130_fd_pr__pfet_01v8_hvt ad=0.135 pd=1.27 as=0.335 ps=2.67 w=1 l=0.15
X8 a_77_199# A3 a_323_297# VPB sky130_fd_pr__pfet_01v8_hvt ad=0.195 pd=1.39 as=0.195 ps=1.39 w=1 l=0.15
X9 VGND A2 a_227_47# VNB sky130_fd_pr__nfet_01v8 ad=0.12675 pd=1.04 as=0.10725 ps=0.98 w=0.65 l=0.15
X10 a_227_47# A1 VGND VNB sky130_fd_pr__nfet_01v8 ad=0.10725 pd=0.98 as=0.08775 ps=0.92 w=0.65 l=0.15
X11 a_539_297# B2 a_77_199# VPB sky130_fd_pr__pfet_01v8_hvt ad=0.205 pd=1.41 as=0.195 ps=1.39 w=1 l=0.15
.ends

.subckt sky130_fd_sc_hd__a21o_2 A1 A2 B1 VGND VNB VPB VPWR X
X0 VPWR a_80_199# X VPB sky130_fd_pr__pfet_01v8_hvt ad=0.265 pd=2.53 as=0.14 ps=1.28 w=1 l=0.15
X1 X a_80_199# VPWR VPB sky130_fd_pr__pfet_01v8_hvt ad=0.14 pd=1.28 as=0.265 ps=2.53 w=1 l=0.15
X2 VGND a_80_199# X VNB sky130_fd_pr__nfet_01v8 ad=0.1105 pd=0.99 as=0.091 ps=0.93 w=0.65 l=0.15
X3 a_386_297# A2 VPWR VPB sky130_fd_pr__pfet_01v8_hvt ad=0.26 pd=2.52 as=0.1575 ps=1.315 w=1 l=0.15
X4 X a_80_199# VGND VNB sky130_fd_pr__nfet_01v8 ad=0.091 pd=0.93 as=0.17225 ps=1.83 w=0.65 l=0.15
X5 a_80_199# B1 VGND VNB sky130_fd_pr__nfet_01v8 ad=0.1625 pd=1.15 as=0.1105 ps=0.99 w=0.65 l=0.15
X6 a_386_297# B1 a_80_199# VPB sky130_fd_pr__pfet_01v8_hvt ad=0.14 pd=1.28 as=0.265 ps=2.53 w=1 l=0.15
X7 a_458_47# A1 a_80_199# VNB sky130_fd_pr__nfet_01v8 ad=0.1235 pd=1.03 as=0.1625 ps=1.15 w=0.65 l=0.15
X8 VPWR A1 a_386_297# VPB sky130_fd_pr__pfet_01v8_hvt ad=0.1575 pd=1.315 as=0.14 ps=1.28 w=1 l=0.15
X9 VGND A2 a_458_47# VNB sky130_fd_pr__nfet_01v8 ad=0.17225 pd=1.83 as=0.1235 ps=1.03 w=0.65 l=0.15
.ends

.subckt sky130_fd_sc_hd__a311o_1 A1 A2 A3 B1 C1 VGND VNB VPB VPWR X
X0 a_75_199# C1 VGND VNB sky130_fd_pr__nfet_01v8 ad=0.169 pd=1.82 as=0.13487 ps=1.065 w=0.65 l=0.15
X1 a_208_47# A3 VGND VNB sky130_fd_pr__nfet_01v8 ad=0.12513 pd=1.035 as=0.11213 ps=0.995 w=0.65 l=0.15
X2 a_315_47# A2 a_208_47# VNB sky130_fd_pr__nfet_01v8 ad=0.169 pd=1.17 as=0.12513 ps=1.035 w=0.65 l=0.15
X3 VGND B1 a_75_199# VNB sky130_fd_pr__nfet_01v8 ad=0.13487 pd=1.065 as=0.10563 ps=0.975 w=0.65 l=0.15
X4 a_75_199# A1 a_315_47# VNB sky130_fd_pr__nfet_01v8 ad=0.10563 pd=0.975 as=0.169 ps=1.17 w=0.65 l=0.15
X5 a_75_199# C1 a_544_297# VPB sky130_fd_pr__pfet_01v8_hvt ad=0.26 pd=2.52 as=0.2075 ps=1.415 w=1 l=0.15
X6 a_544_297# B1 a_201_297# VPB sky130_fd_pr__pfet_01v8_hvt ad=0.2075 pd=1.415 as=0.1625 ps=1.325 w=1 l=0.15
X7 VPWR a_75_199# X VPB sky130_fd_pr__pfet_01v8_hvt ad=0.1425 pd=1.285 as=0.285 ps=2.57 w=1 l=0.15
X8 a_201_297# A3 VPWR VPB sky130_fd_pr__pfet_01v8_hvt ad=0.165 pd=1.33 as=0.1425 ps=1.285 w=1 l=0.15
X9 VPWR A2 a_201_297# VPB sky130_fd_pr__pfet_01v8_hvt ad=0.305 pd=1.61 as=0.165 ps=1.33 w=1 l=0.15
X10 a_201_297# A1 VPWR VPB sky130_fd_pr__pfet_01v8_hvt ad=0.1625 pd=1.325 as=0.305 ps=1.61 w=1 l=0.15
X11 VGND a_75_199# X VNB sky130_fd_pr__nfet_01v8 ad=0.11213 pd=0.995 as=0.169 ps=1.82 w=0.65 l=0.15
.ends

.subckt sky130_fd_sc_hd__o31ai_1 A1 A2 A3 B1 VGND VNB VPB VPWR Y
X0 Y B1 a_109_47# VNB sky130_fd_pr__nfet_01v8 ad=0.221 pd=1.98 as=0.19825 ps=1.26 w=0.65 l=0.15
X1 Y A3 a_193_297# VPB sky130_fd_pr__pfet_01v8_hvt ad=0.3925 pd=1.785 as=0.135 ps=1.27 w=1 l=0.15
X2 a_193_297# A2 a_109_297# VPB sky130_fd_pr__pfet_01v8_hvt ad=0.135 pd=1.27 as=0.135 ps=1.27 w=1 l=0.15
X3 VGND A2 a_109_47# VNB sky130_fd_pr__nfet_01v8 ad=0.08775 pd=0.92 as=0.08775 ps=0.92 w=0.65 l=0.15
X4 VPWR B1 Y VPB sky130_fd_pr__pfet_01v8_hvt ad=0.3 pd=2.6 as=0.3925 ps=1.785 w=1 l=0.15
X5 a_109_47# A3 VGND VNB sky130_fd_pr__nfet_01v8 ad=0.19825 pd=1.26 as=0.08775 ps=0.92 w=0.65 l=0.15
X6 a_109_297# A1 VPWR VPB sky130_fd_pr__pfet_01v8_hvt ad=0.135 pd=1.27 as=0.26 ps=2.52 w=1 l=0.15
X7 a_109_47# A1 VGND VNB sky130_fd_pr__nfet_01v8 ad=0.08775 pd=0.92 as=0.169 ps=1.82 w=0.65 l=0.15
.ends

.subckt sky130_fd_sc_hd__nand4_1 A B C D VGND VNB VPB VPWR Y
X0 Y B VPWR VPB sky130_fd_pr__pfet_01v8_hvt ad=0.165 pd=1.33 as=0.135 ps=1.27 w=1 l=0.15
X1 VPWR A Y VPB sky130_fd_pr__pfet_01v8_hvt ad=0.3 pd=2.6 as=0.165 ps=1.33 w=1 l=0.15
X2 VPWR C Y VPB sky130_fd_pr__pfet_01v8_hvt ad=0.135 pd=1.27 as=0.135 ps=1.27 w=1 l=0.15
X3 a_193_47# C a_109_47# VNB sky130_fd_pr__nfet_01v8 ad=0.08775 pd=0.92 as=0.08775 ps=0.92 w=0.65 l=0.15
X4 Y A a_277_47# VNB sky130_fd_pr__nfet_01v8 ad=0.195 pd=1.9 as=0.10725 ps=0.98 w=0.65 l=0.15
X5 a_277_47# B a_193_47# VNB sky130_fd_pr__nfet_01v8 ad=0.10725 pd=0.98 as=0.08775 ps=0.92 w=0.65 l=0.15
X6 Y D VPWR VPB sky130_fd_pr__pfet_01v8_hvt ad=0.135 pd=1.27 as=0.26 ps=2.52 w=1 l=0.15
X7 a_109_47# D VGND VNB sky130_fd_pr__nfet_01v8 ad=0.08775 pd=0.92 as=0.169 ps=1.82 w=0.65 l=0.15
.ends

.subckt jt49_bus A8 A[0] A[1] A[2] A[3] A[4] B[0] B[1] B[2] B[3] B[4] C[0] C[1] C[2]
+ C[3] C[4] IOA_in[0] IOA_in[1] IOA_in[2] IOA_in[3] IOA_in[4] IOA_in[5] IOA_in[6]
+ IOA_in[7] IOA_oe IOA_out[0] IOA_out[1] IOA_out[2] IOA_out[3] IOA_out[4] IOA_out[5]
+ IOA_out[6] IOA_out[7] IOB_in[0] IOB_in[1] IOB_in[2] IOB_in[3] IOB_in[4] IOB_in[5]
+ IOB_in[6] IOB_in[7] IOB_oe IOB_out[0] IOB_out[1] IOB_out[2] IOB_out[3] IOB_out[4]
+ IOB_out[5] IOB_out[6] IOB_out[7] VGND VPWR bc1 bc2 bdir clk clk_en din[0] din[1]
+ din[2] din[3] din[4] din[5] din[6] din[7] dout[0] dout[1] dout[2] dout[3] dout[4]
+ dout[5] dout[6] dout[7] nA9 rst_n sample sel
XFILLER_52_29 VGND VGND VPWR VPWR sky130_fd_sc_hd__decap_4
XFILLER_13_133 VGND VGND VPWR VPWR sky130_fd_sc_hd__decap_8
XFILLER_9_137 VGND VPWR VPWR VGND sky130_ef_sc_hd__decap_12
XFILLER_13_177 VGND VGND VPWR VPWR sky130_fd_sc_hd__decap_3
XFILLER_3_45 VGND VGND VPWR VPWR sky130_fd_sc_hd__decap_8
X_1270_ _0304_ _0305_ net84 VGND VGND VPWR VPWR _0307_ sky130_fd_sc_hd__a21o_1
XFILLER_3_89 VGND VPWR VPWR VGND sky130_ef_sc_hd__decap_12
X_1606_ clknet_leaf_28_clk _0029_ net119 VGND VGND VPWR VPWR u_jt49.u_chC.count\[5\]
+ sky130_fd_sc_hd__dfrtp_2
X_0985_ _0484_ u_jt49.u_ng.u_div.count\[2\] u_jt49.u_ng.u_div.count\[1\] _0481_ _0610_
+ VGND VGND VPWR VPWR _0611_ sky130_fd_sc_hd__o221a_1
XFILLER_59_317 VGND VPWR VPWR VGND sky130_ef_sc_hd__decap_12
Xfanout105 din_latch\[3\] VGND VGND VPWR VPWR net105 sky130_fd_sc_hd__clkbuf_4
XFILLER_47_18 VGND VPWR VPWR VGND sky130_ef_sc_hd__decap_12
Xfanout127 net128 VGND VGND VPWR VPWR net127 sky130_fd_sc_hd__clkbuf_4
X_1399_ u_jt49.eg_period\[8\] net112 _0405_ VGND VGND VPWR VPWR _0119_ sky130_fd_sc_hd__mux2_1
X_1468_ net183 net99 _0412_ VGND VGND VPWR VPWR _0181_ sky130_fd_sc_hd__mux2_1
Xfanout138 net145 VGND VGND VPWR VPWR net138 sky130_fd_sc_hd__clkbuf_2
Xfanout116 net122 VGND VGND VPWR VPWR net116 sky130_fd_sc_hd__clkbuf_2
X_1537_ u_jt49.periodA\[3\] net105 _0420_ VGND VGND VPWR VPWR _0242_ sky130_fd_sc_hd__mux2_1
XFILLER_42_206 VGND VPWR VPWR VGND sky130_ef_sc_hd__decap_12
XFILLER_10_169 VGND VGND VPWR VPWR sky130_fd_sc_hd__decap_8
XFILLER_12_65 VGND VGND VPWR VPWR sky130_fd_sc_hd__decap_6
XFILLER_37_51 VGND VGND VPWR VPWR sky130_fd_sc_hd__decap_4
X_1253_ u_jt49.periodB\[1\] u_jt49.u_chB.count\[1\] VGND VGND VPWR VPWR _0291_ sky130_fd_sc_hd__nand2b_1
X_1322_ _0345_ _0346_ VGND VGND VPWR VPWR _0347_ sky130_fd_sc_hd__nand2_1
X_1184_ net74 _0767_ _0768_ VGND VGND VPWR VPWR _0057_ sky130_fd_sc_hd__and3_1
X_0968_ _0600_ _0601_ _0604_ VGND VGND VPWR VPWR _0605_ sky130_fd_sc_hd__or3_1
X_0899_ net9 _0541_ _0542_ net1 _0540_ VGND VGND VPWR VPWR _0266_ sky130_fd_sc_hd__a221o_1
XFILLER_59_169 VGND VPWR VPWR VGND sky130_ef_sc_hd__decap_12
XFILLER_59_125 VGND VGND VPWR VPWR sky130_fd_sc_hd__decap_4
XFILLER_23_272 VGND VGND VPWR VPWR sky130_fd_sc_hd__decap_8
XFILLER_38_309 VGND VGND VPWR VPWR sky130_fd_sc_hd__decap_3
XFILLER_2_121 VGND VGND VPWR VPWR sky130_fd_sc_hd__decap_4
XFILLER_0_57 VGND VGND VPWR VPWR sky130_fd_sc_hd__decap_6
X_0822_ u_jt49.u_envdiv.count\[14\] VGND VGND VPWR VPWR _0473_ sky130_fd_sc_hd__inv_2
XFILLER_50_3 VGND VPWR VPWR VGND sky130_ef_sc_hd__decap_12
X_1236_ _0275_ _0276_ _0277_ _0499_ _0498_ VGND VGND VPWR VPWR _0278_ sky130_fd_sc_hd__o311a_1
X_1305_ _0307_ _0331_ _0332_ VGND VGND VPWR VPWR _0098_ sky130_fd_sc_hd__and3_1
XFILLER_52_356 VGND VGND VPWR VPWR sky130_fd_sc_hd__decap_8
XFILLER_52_301 VGND VGND VPWR VPWR sky130_fd_sc_hd__decap_6
X_1167_ _0755_ VGND VGND VPWR VPWR _0756_ sky130_fd_sc_hd__inv_2
X_1098_ u_jt49.regarray\[13\]\[3\] _0451_ u_jt49.u_env.gain\[4\] _0696_ u_jt49.u_env.rst_latch
+ VGND VGND VPWR VPWR _0701_ sky130_fd_sc_hd__a2111o_1
XFILLER_60_29 VGND VGND VPWR VPWR sky130_fd_sc_hd__decap_8
XFILLER_20_253 VGND VGND VPWR VPWR sky130_fd_sc_hd__decap_4
XFILLER_62_109 VGND VPWR VPWR VGND sky130_ef_sc_hd__decap_12
XFILLER_18_97 VGND VPWR VPWR VGND sky130_ef_sc_hd__decap_12
XFILLER_43_367 VGND VGND VPWR VPWR sky130_fd_sc_hd__decap_4
XFILLER_11_253 VGND VGND VPWR VPWR sky130_fd_sc_hd__decap_4
XFILLER_11_275 VGND VGND VPWR VPWR sky130_fd_sc_hd__decap_4
XFILLER_34_323 VGND VPWR VPWR VGND sky130_ef_sc_hd__decap_12
X_1021_ u_jt49.periodC\[4\] u_jt49.u_chC.count\[4\] VGND VGND VPWR VPWR _0639_ sky130_fd_sc_hd__and2b_1
X_0805_ u_jt49.u_chB.count\[8\] VGND VGND VPWR VPWR _0456_ sky130_fd_sc_hd__inv_2
X_1854_ clknet_leaf_22_clk _0264_ VGND VGND VPWR VPWR net45 sky130_fd_sc_hd__dfxtp_1
X_1785_ clknet_leaf_27_clk _0204_ net120 VGND VGND VPWR VPWR u_jt49.periodC\[5\] sky130_fd_sc_hd__dfrtp_1
X_1219_ u_jt49.u_ng.poly17\[3\] net234 net78 VGND VGND VPWR VPWR _0071_ sky130_fd_sc_hd__mux2_1
XFILLER_40_315 VGND VGND VPWR VPWR sky130_fd_sc_hd__decap_6
Xhold74 u_jt49.u_ng.poly17\[15\] VGND VGND VPWR VPWR net219 sky130_fd_sc_hd__dlygate4sd3_1
Xhold52 net61 VGND VGND VPWR VPWR net197 sky130_fd_sc_hd__dlygate4sd3_1
Xhold30 net54 VGND VGND VPWR VPWR net175 sky130_fd_sc_hd__dlygate4sd3_1
Xhold41 u_jt49.regarray\[10\]\[6\] VGND VGND VPWR VPWR net186 sky130_fd_sc_hd__dlygate4sd3_1
Xhold63 u_jt49.last_write VGND VGND VPWR VPWR net208 sky130_fd_sc_hd__dlygate4sd3_1
Xhold85 u_jt49.u_ng.poly17\[0\] VGND VGND VPWR VPWR net230 sky130_fd_sc_hd__dlygate4sd3_1
Xhold96 u_jt49.u_chA.count\[3\] VGND VGND VPWR VPWR net241 sky130_fd_sc_hd__dlygate4sd3_1
XFILLER_31_304 VGND VPWR VPWR VGND sky130_ef_sc_hd__decap_12
XANTENNA_5 net104 VGND VGND VPWR VPWR sky130_fd_sc_hd__diode_2
X_1570_ u_jt49.Cmix net20 VGND VGND VPWR VPWR _0436_ sky130_fd_sc_hd__and2_1
X_1004_ net26 net25 net28 net27 VGND VGND VPWR VPWR _0625_ sky130_fd_sc_hd__or4_1
XFILLER_34_120 VGND VGND VPWR VPWR sky130_fd_sc_hd__decap_3
X_1837_ clknet_leaf_24_clk _0255_ VGND VGND VPWR VPWR net36 sky130_fd_sc_hd__dfxtp_1
X_1768_ clknet_leaf_18_clk _0187_ net134 VGND VGND VPWR VPWR u_jt49.regarray\[13\]\[4\]
+ sky130_fd_sc_hd__dfrtp_1
XFILLER_57_201 VGND VPWR VPWR VGND sky130_ef_sc_hd__decap_12
X_1699_ clknet_leaf_24_clk _0118_ VGND VGND VPWR VPWR u_jt49.Cmix sky130_fd_sc_hd__dfxtp_1
XFILLER_31_53 VGND VGND VPWR VPWR sky130_fd_sc_hd__decap_3
XFILLER_25_186 VGND VPWR VPWR VGND sky130_ef_sc_hd__decap_12
Xoutput53 net53 VGND VGND VPWR VPWR IOA_out[6] sky130_fd_sc_hd__buf_2
Xoutput42 net42 VGND VGND VPWR VPWR C[1] sky130_fd_sc_hd__buf_2
Xoutput64 net64 VGND VGND VPWR VPWR dout[0] sky130_fd_sc_hd__buf_2
Xoutput31 net31 VGND VGND VPWR VPWR A[0] sky130_fd_sc_hd__buf_2
XFILLER_63_237 VGND VPWR VPWR VGND sky130_ef_sc_hd__decap_12
XFILLER_48_289 VGND VGND VPWR VPWR sky130_fd_sc_hd__decap_8
X_1622_ clknet_leaf_17_clk _0045_ net143 VGND VGND VPWR VPWR u_jt49.eg_step sky130_fd_sc_hd__dfrtp_1
XFILLER_39_234 VGND VGND VPWR VPWR sky130_fd_sc_hd__decap_3
X_1484_ net181 net103 _0414_ VGND VGND VPWR VPWR _0195_ sky130_fd_sc_hd__mux2_1
X_1553_ net113 net154 _0424_ _0426_ VGND VGND VPWR VPWR _0252_ sky130_fd_sc_hd__a22o_1
XFILLER_39_267 VGND VPWR VPWR VGND sky130_ef_sc_hd__decap_12
XFILLER_53_281 VGND VPWR VPWR VGND sky130_ef_sc_hd__decap_12
XFILLER_53_270 VGND VGND VPWR VPWR sky130_fd_sc_hd__decap_8
XFILLER_42_85 VGND VPWR VPWR VGND sky130_ef_sc_hd__decap_12
XFILLER_9_149 VGND VGND VPWR VPWR sky130_fd_sc_hd__decap_4
X_0984_ _0481_ u_jt49.u_ng.u_div.count\[1\] u_jt49.u_ng.u_div.count\[0\] _0482_ VGND
+ VGND VPWR VPWR _0610_ sky130_fd_sc_hd__a211o_1
X_1605_ clknet_leaf_28_clk _0028_ net119 VGND VGND VPWR VPWR u_jt49.u_chC.count\[4\]
+ sky130_fd_sc_hd__dfrtp_1
XFILLER_8_193 VGND VGND VPWR VPWR sky130_fd_sc_hd__decap_3
X_1536_ u_jt49.periodA\[2\] net107 _0420_ VGND VGND VPWR VPWR _0241_ sky130_fd_sc_hd__mux2_1
XFILLER_59_329 VGND VGND VPWR VPWR sky130_fd_sc_hd__decap_6
Xfanout139 net140 VGND VGND VPWR VPWR net139 sky130_fd_sc_hd__clkbuf_4
Xfanout128 net130 VGND VGND VPWR VPWR net128 sky130_fd_sc_hd__clkbuf_4
Xfanout106 din_latch\[3\] VGND VGND VPWR VPWR net106 sky130_fd_sc_hd__clkbuf_2
X_1398_ net82 _0526_ VGND VGND VPWR VPWR _0405_ sky130_fd_sc_hd__and2_2
Xfanout117 net122 VGND VGND VPWR VPWR net117 sky130_fd_sc_hd__clkbuf_4
X_1467_ net207 net101 _0412_ VGND VGND VPWR VPWR _0180_ sky130_fd_sc_hd__mux2_1
XFILLER_42_218 VGND VPWR VPWR VGND sky130_ef_sc_hd__decap_12
XPHY_EDGE_ROW_19_Left_84 VGND VGND VPWR VPWR sky130_fd_sc_hd__decap_3
XFILLER_6_108 VGND VGND VPWR VPWR sky130_fd_sc_hd__decap_3
XFILLER_6_119 VGND VPWR VPWR VGND sky130_ef_sc_hd__decap_12
XFILLER_26_292 VGND VPWR VPWR VGND sky130_ef_sc_hd__decap_12
X_1252_ _0455_ u_jt49.periodB\[9\] _0456_ u_jt49.periodB\[8\] VGND VGND VPWR VPWR
+ _0290_ sky130_fd_sc_hd__o22a_1
X_1321_ u_jt49.periodA\[5\] u_jt49.u_chA.count\[5\] VGND VGND VPWR VPWR _0346_ sky130_fd_sc_hd__nand2b_1
XFILLER_64_365 VGND VGND VPWR VPWR sky130_fd_sc_hd__decap_6
X_1183_ u_jt49.u_envdiv.count\[5\] _0764_ VGND VGND VPWR VPWR _0768_ sky130_fd_sc_hd__or2_1
X_0967_ u_jt49.regarray\[5\]\[7\] _0525_ _0602_ _0603_ VGND VGND VPWR VPWR _0604_
+ sky130_fd_sc_hd__a211o_1
X_1519_ u_jt49.periodA\[11\] net105 _0418_ VGND VGND VPWR VPWR _0226_ sky130_fd_sc_hd__mux2_1
X_0898_ net95 _0539_ VGND VGND VPWR VPWR _0542_ sky130_fd_sc_hd__nor2_4
XPHY_EDGE_ROW_12_Right_12 VGND VGND VPWR VPWR sky130_fd_sc_hd__decap_3
XPHY_EDGE_ROW_21_Right_21 VGND VGND VPWR VPWR sky130_fd_sc_hd__decap_3
XPHY_EDGE_ROW_4_Left_69 VGND VGND VPWR VPWR sky130_fd_sc_hd__decap_3
XFILLER_23_240 VGND VGND VPWR VPWR sky130_fd_sc_hd__decap_3
XPHY_EDGE_ROW_30_Right_30 VGND VGND VPWR VPWR sky130_fd_sc_hd__decap_3
XFILLER_46_365 VGND VGND VPWR VPWR sky130_fd_sc_hd__decap_6
XFILLER_46_321 VGND VPWR VPWR VGND sky130_ef_sc_hd__decap_12
XFILLER_0_25 VGND VGND VPWR VPWR sky130_fd_sc_hd__decap_3
X_0821_ net250 VGND VGND VPWR VPWR _0472_ sky130_fd_sc_hd__inv_2
XFILLER_43_3 VGND VGND VPWR VPWR sky130_fd_sc_hd__decap_6
X_1304_ _0453_ _0329_ VGND VGND VPWR VPWR _0332_ sky130_fd_sc_hd__or2_1
X_1235_ u_jt49.u_ng.poly17\[1\] u_jt49.u_ng.poly17\[2\] u_jt49.u_ng.poly17\[5\] u_jt49.u_ng.poly17\[4\]
+ VGND VGND VPWR VPWR _0277_ sky130_fd_sc_hd__or4_1
X_1166_ net85 u_jt49.u_envdiv.count\[1\] u_jt49.u_envdiv.count\[0\] VGND VGND VPWR
+ VPWR _0755_ sky130_fd_sc_hd__and3_1
X_1097_ u_jt49.eg_step net199 _0700_ VGND VGND VPWR VPWR _0038_ sky130_fd_sc_hd__mux2_1
XFILLER_28_354 VGND VGND VPWR VPWR sky130_fd_sc_hd__decap_8
XFILLER_28_365 VGND VGND VPWR VPWR sky130_fd_sc_hd__decap_4
XFILLER_28_321 VGND VGND VPWR VPWR sky130_fd_sc_hd__decap_3
XFILLER_11_221 VGND VGND VPWR VPWR sky130_fd_sc_hd__decap_3
X_1020_ _0636_ _0637_ VGND VGND VPWR VPWR _0638_ sky130_fd_sc_hd__nor2_1
XFILLER_19_365 VGND VPWR VPWR VGND sky130_ef_sc_hd__decap_12
XFILLER_34_335 VGND VGND VPWR VPWR sky130_fd_sc_hd__decap_4
X_0804_ u_jt49.u_chB.count\[9\] VGND VGND VPWR VPWR _0455_ sky130_fd_sc_hd__inv_2
X_1853_ clknet_leaf_22_clk _0263_ VGND VGND VPWR VPWR net44 sky130_fd_sc_hd__dfxtp_1
X_1784_ clknet_leaf_27_clk _0203_ net120 VGND VGND VPWR VPWR u_jt49.periodC\[4\] sky130_fd_sc_hd__dfrtp_1
X_1218_ net237 u_jt49.u_ng.poly17\[3\] net78 VGND VGND VPWR VPWR _0070_ sky130_fd_sc_hd__mux2_1
X_1149_ _0717_ _0745_ u_jt49.u_env.cen VGND VGND VPWR VPWR _0746_ sky130_fd_sc_hd__a21bo_1
XFILLER_20_66 VGND VGND VPWR VPWR sky130_fd_sc_hd__decap_8
Xhold75 _0083_ VGND VGND VPWR VPWR net220 sky130_fd_sc_hd__dlygate4sd3_1
Xhold31 net53 VGND VGND VPWR VPWR net176 sky130_fd_sc_hd__dlygate4sd3_1
Xhold64 u_jt49.regarray\[3\]\[6\] VGND VGND VPWR VPWR net209 sky130_fd_sc_hd__dlygate4sd3_1
Xhold86 u_jt49.regarray\[3\]\[4\] VGND VGND VPWR VPWR net231 sky130_fd_sc_hd__dlygate4sd3_1
Xhold42 u_jt49.regarray\[8\]\[5\] VGND VGND VPWR VPWR net187 sky130_fd_sc_hd__dlygate4sd3_1
Xhold53 u_jt49.regarray\[5\]\[6\] VGND VGND VPWR VPWR net198 sky130_fd_sc_hd__dlygate4sd3_1
Xhold20 net40 VGND VGND VPWR VPWR net165 sky130_fd_sc_hd__dlygate4sd3_1
Xhold97 u_jt49.regarray\[7\]\[1\] VGND VGND VPWR VPWR net242 sky130_fd_sc_hd__dlygate4sd3_1
XFILLER_31_316 VGND VGND VPWR VPWR sky130_fd_sc_hd__decap_6
XPHY_EDGE_ROW_7_Left_72 VGND VGND VPWR VPWR sky130_fd_sc_hd__decap_3
XFILLER_19_151 VGND VGND VPWR VPWR sky130_fd_sc_hd__decap_8
X_1003_ _0616_ _0624_ VGND VGND VPWR VPWR _0016_ sky130_fd_sc_hd__and2_1
X_1698_ clknet_leaf_15_clk _0003_ VGND VGND VPWR VPWR u_jt49.u_env.cen sky130_fd_sc_hd__dfxtp_1
X_1836_ clknet_leaf_28_clk _0254_ VGND VGND VPWR VPWR net35 sky130_fd_sc_hd__dfxtp_1
XPHY_EDGE_ROW_6_Right_6 VGND VGND VPWR VPWR sky130_fd_sc_hd__decap_3
X_1767_ clknet_leaf_19_clk _0186_ net135 VGND VGND VPWR VPWR u_jt49.regarray\[13\]\[3\]
+ sky130_fd_sc_hd__dfrtp_1
XFILLER_57_268 VGND VPWR VPWR VGND sky130_ef_sc_hd__decap_12
XFILLER_57_213 VGND VGND VPWR VPWR sky130_fd_sc_hd__decap_8
XFILLER_25_198 VGND VPWR VPWR VGND sky130_ef_sc_hd__decap_12
XFILLER_13_316 VGND VGND VPWR VPWR sky130_fd_sc_hd__decap_8
Xoutput54 net54 VGND VGND VPWR VPWR IOA_out[7] sky130_fd_sc_hd__buf_2
XPHY_EDGE_ROW_33_Left_98 VGND VGND VPWR VPWR sky130_fd_sc_hd__decap_3
Xoutput43 net43 VGND VGND VPWR VPWR C[2] sky130_fd_sc_hd__buf_2
Xoutput65 net65 VGND VGND VPWR VPWR dout[1] sky130_fd_sc_hd__buf_2
Xoutput32 net32 VGND VGND VPWR VPWR A[1] sky130_fd_sc_hd__buf_2
XFILLER_0_220 VGND VGND VPWR VPWR sky130_fd_sc_hd__decap_4
XFILLER_63_249 VGND VPWR VPWR VGND sky130_ef_sc_hd__decap_12
XFILLER_63_205 VGND VPWR VPWR VGND sky130_ef_sc_hd__decap_12
XPHY_EDGE_ROW_59_Right_59 VGND VGND VPWR VPWR sky130_fd_sc_hd__decap_3
X_1552_ u_jt49.regarray\[8\]\[1\] u_jt49.envelope\[2\] u_jt49.regarray\[8\]\[4\] VGND
+ VGND VPWR VPWR _0426_ sky130_fd_sc_hd__mux2_1
X_1621_ clknet_leaf_23_clk _0044_ net137 VGND VGND VPWR VPWR u_jt49.u_env.gain\[4\]
+ sky130_fd_sc_hd__dfstp_1
X_1483_ u_jt49.periodC\[11\] net105 _0414_ VGND VGND VPWR VPWR _0194_ sky130_fd_sc_hd__mux2_1
X_1819_ clknet_leaf_7_clk _0238_ net125 VGND VGND VPWR VPWR net63 sky130_fd_sc_hd__dfrtp_1
XFILLER_53_293 VGND VPWR VPWR VGND sky130_ef_sc_hd__decap_12
XFILLER_26_54 VGND VPWR VPWR VGND sky130_ef_sc_hd__decap_12
XFILLER_5_345 VGND VPWR VPWR VGND sky130_ef_sc_hd__decap_12
X_0983_ net86 u_jt49.u_ng.u_div.count\[0\] VGND VGND VPWR VPWR _0609_ sky130_fd_sc_hd__or2_1
Xfanout107 din_latch\[2\] VGND VGND VPWR VPWR net107 sky130_fd_sc_hd__clkbuf_4
Xfanout129 net130 VGND VGND VPWR VPWR net129 sky130_fd_sc_hd__buf_2
Xfanout118 net122 VGND VGND VPWR VPWR net118 sky130_fd_sc_hd__clkbuf_4
X_1604_ clknet_leaf_28_clk _0027_ net119 VGND VGND VPWR VPWR u_jt49.u_chC.count\[3\]
+ sky130_fd_sc_hd__dfrtp_1
X_1535_ u_jt49.periodA\[1\] net109 _0420_ VGND VGND VPWR VPWR _0240_ sky130_fd_sc_hd__mux2_1
X_1397_ net151 net113 _0404_ VGND VGND VPWR VPWR _0118_ sky130_fd_sc_hd__a21o_1
X_1466_ u_jt49.regarray\[6\]\[4\] net104 _0412_ VGND VGND VPWR VPWR _0179_ sky130_fd_sc_hd__mux2_1
XFILLER_63_19 VGND VPWR VPWR VGND sky130_ef_sc_hd__decap_12
XFILLER_50_285 VGND VGND VPWR VPWR sky130_fd_sc_hd__decap_3
XFILLER_50_241 VGND VGND VPWR VPWR sky130_fd_sc_hd__decap_8
XFILLER_50_296 VGND VGND VPWR VPWR sky130_fd_sc_hd__decap_8
XFILLER_5_6 VGND VPWR VPWR VGND sky130_ef_sc_hd__decap_12
XFILLER_53_74 VGND VPWR VPWR VGND sky130_ef_sc_hd__decap_12
XFILLER_53_52 VGND VGND VPWR VPWR sky130_fd_sc_hd__decap_4
XFILLER_41_241 VGND VPWR VPWR VGND sky130_ef_sc_hd__decap_12
XFILLER_45_7 VGND VGND VPWR VPWR sky130_fd_sc_hd__decap_6
X_1320_ u_jt49.periodA\[4\] u_jt49.u_chA.count\[4\] VGND VGND VPWR VPWR _0345_ sky130_fd_sc_hd__nand2b_1
XFILLER_5_175 VGND VPWR VPWR VGND sky130_ef_sc_hd__decap_12
XFILLER_5_131 VGND VGND VPWR VPWR sky130_fd_sc_hd__decap_8
X_1251_ _0455_ u_jt49.periodB\[9\] _0286_ _0288_ VGND VGND VPWR VPWR _0289_ sky130_fd_sc_hd__a211o_1
X_1182_ u_jt49.u_envdiv.count\[5\] u_jt49.u_envdiv.count\[4\] _0755_ _0762_ VGND VGND
+ VPWR VPWR _0767_ sky130_fd_sc_hd__nand4_2
XFILLER_17_271 VGND VGND VPWR VPWR sky130_fd_sc_hd__decap_8
XPHY_EDGE_ROW_20_Left_85 VGND VGND VPWR VPWR sky130_fd_sc_hd__decap_3
X_0966_ net55 _0519_ _0522_ u_jt49.regarray\[3\]\[7\] _0589_ VGND VGND VPWR VPWR _0603_
+ sky130_fd_sc_hd__a221o_1
X_0897_ net89 net91 net93 net95 VGND VGND VPWR VPWR _0541_ sky130_fd_sc_hd__and4_4
XFILLER_58_19 VGND VGND VPWR VPWR sky130_fd_sc_hd__decap_8
X_1518_ u_jt49.periodA\[10\] net107 _0418_ VGND VGND VPWR VPWR _0225_ sky130_fd_sc_hd__mux2_1
X_1449_ net187 net102 _0410_ VGND VGND VPWR VPWR _0164_ sky130_fd_sc_hd__mux2_1
XFILLER_23_66 VGND VGND VPWR VPWR sky130_fd_sc_hd__decap_8
XFILLER_3_3 VGND VGND VPWR VPWR sky130_fd_sc_hd__decap_8
XFILLER_46_333 VGND VPWR VPWR VGND sky130_ef_sc_hd__decap_12
XFILLER_2_178 VGND VGND VPWR VPWR sky130_fd_sc_hd__decap_6
XFILLER_61_369 VGND VGND VPWR VPWR sky130_fd_sc_hd__decap_3
XFILLER_0_48 VGND VGND VPWR VPWR sky130_fd_sc_hd__decap_3
XFILLER_14_230 VGND VPWR VPWR VGND sky130_ef_sc_hd__decap_12
X_0820_ net254 VGND VGND VPWR VPWR _0471_ sky130_fd_sc_hd__inv_2
XFILLER_9_57 VGND VGND VPWR VPWR sky130_fd_sc_hd__decap_8
X_1303_ _0453_ _0329_ VGND VGND VPWR VPWR _0331_ sky130_fd_sc_hd__nand2_1
X_1234_ u_jt49.u_ng.poly17\[7\] u_jt49.u_ng.poly17\[6\] u_jt49.u_ng.poly17\[9\] u_jt49.u_ng.poly17\[8\]
+ VGND VGND VPWR VPWR _0276_ sky130_fd_sc_hd__or4_1
X_1165_ u_jt49.u_env.cen u_jt49.u_envdiv.count\[0\] _0754_ VGND VGND VPWR VPWR _0052_
+ sky130_fd_sc_hd__o21ba_1
X_1096_ net143 u_jt49.u_env.cen VGND VGND VPWR VPWR _0700_ sky130_fd_sc_hd__nand2_1
X_0949_ net14 _0541_ _0542_ net6 _0587_ VGND VGND VPWR VPWR _0271_ sky130_fd_sc_hd__a221o_1
XFILLER_46_141 VGND VGND VPWR VPWR sky130_fd_sc_hd__decap_4
X_1852_ clknet_leaf_22_clk _0262_ VGND VGND VPWR VPWR net43 sky130_fd_sc_hd__dfxtp_1
X_0803_ u_jt49.periodB\[10\] VGND VGND VPWR VPWR _0454_ sky130_fd_sc_hd__inv_2
X_1783_ clknet_leaf_27_clk _0202_ net120 VGND VGND VPWR VPWR u_jt49.periodC\[3\] sky130_fd_sc_hd__dfrtp_1
XFILLER_52_133 VGND VGND VPWR VPWR sky130_fd_sc_hd__decap_6
X_1217_ net225 u_jt49.u_ng.poly17\[2\] net78 VGND VGND VPWR VPWR _0069_ sky130_fd_sc_hd__mux2_1
X_1148_ _0742_ _0744_ _0737_ VGND VGND VPWR VPWR _0745_ sky130_fd_sc_hd__a21oi_1
X_1079_ u_jt49.u_chC.count\[11\] _0683_ VGND VGND VPWR VPWR _0686_ sky130_fd_sc_hd__nand2_1
XPHY_EDGE_ROW_42_Left_107 VGND VGND VPWR VPWR sky130_fd_sc_hd__decap_3
Xhold76 u_jt49.u_ng.poly17\[13\] VGND VGND VPWR VPWR net221 sky130_fd_sc_hd__dlygate4sd3_1
Xhold87 u_jt49.u_ng.poly17\[6\] VGND VGND VPWR VPWR net232 sky130_fd_sc_hd__dlygate4sd3_1
Xhold32 net49 VGND VGND VPWR VPWR net177 sky130_fd_sc_hd__dlygate4sd3_1
Xhold54 u_jt49.u_env.last_step VGND VGND VPWR VPWR net199 sky130_fd_sc_hd__dlygate4sd3_1
Xhold43 u_jt49.regarray\[1\]\[6\] VGND VGND VPWR VPWR net188 sky130_fd_sc_hd__dlygate4sd3_1
Xhold65 u_jt49.regarray\[13\]\[7\] VGND VGND VPWR VPWR net210 sky130_fd_sc_hd__dlygate4sd3_1
Xhold21 net43 VGND VGND VPWR VPWR net166 sky130_fd_sc_hd__dlygate4sd3_1
Xhold10 net35 VGND VGND VPWR VPWR net155 sky130_fd_sc_hd__dlygate4sd3_1
Xhold98 u_jt49.regarray\[10\]\[5\] VGND VGND VPWR VPWR net243 sky130_fd_sc_hd__dlygate4sd3_1
XFILLER_61_52 VGND VGND VPWR VPWR sky130_fd_sc_hd__decap_4
XPHY_EDGE_ROW_51_Left_116 VGND VGND VPWR VPWR sky130_fd_sc_hd__decap_3
XPHY_EDGE_ROW_60_Left_125 VGND VGND VPWR VPWR sky130_fd_sc_hd__decap_3
XFILLER_20_6 VGND VGND VPWR VPWR sky130_fd_sc_hd__decap_4
X_1002_ u_jt49.u_ng.u_div.count\[4\] _0622_ VGND VGND VPWR VPWR _0624_ sky130_fd_sc_hd__xnor2_1
X_1835_ clknet_leaf_28_clk _0253_ VGND VGND VPWR VPWR net34 sky130_fd_sc_hd__dfxtp_1
X_1697_ clknet_leaf_15_clk _0002_ VGND VGND VPWR VPWR net72 sky130_fd_sc_hd__dfxtp_1
X_1766_ clknet_leaf_21_clk _0185_ net135 VGND VGND VPWR VPWR u_jt49.regarray\[13\]\[2\]
+ sky130_fd_sc_hd__dfrtp_1
XFILLER_57_225 VGND VPWR VPWR VGND sky130_ef_sc_hd__decap_12
XFILLER_31_66 VGND VPWR VPWR VGND sky130_ef_sc_hd__decap_12
Xoutput55 net55 VGND VGND VPWR VPWR IOB_oe sky130_fd_sc_hd__buf_2
Xoutput44 net44 VGND VGND VPWR VPWR C[3] sky130_fd_sc_hd__buf_2
Xoutput66 net66 VGND VGND VPWR VPWR dout[2] sky130_fd_sc_hd__buf_2
Xoutput33 net33 VGND VGND VPWR VPWR A[2] sky130_fd_sc_hd__buf_2
XFILLER_63_217 VGND VGND VPWR VPWR sky130_fd_sc_hd__decap_6
XFILLER_8_321 VGND VPWR VPWR VGND sky130_ef_sc_hd__decap_12
X_1551_ net113 net157 _0424_ _0425_ VGND VGND VPWR VPWR _0251_ sky130_fd_sc_hd__a22o_1
X_1620_ clknet_leaf_21_clk _0043_ net137 VGND VGND VPWR VPWR u_jt49.u_env.gain\[3\]
+ sky130_fd_sc_hd__dfstp_1
XFILLER_8_365 VGND VPWR VPWR VGND sky130_ef_sc_hd__decap_12
X_1482_ u_jt49.periodC\[10\] net107 _0414_ VGND VGND VPWR VPWR _0193_ sky130_fd_sc_hd__mux2_1
X_1818_ clknet_leaf_7_clk _0237_ net125 VGND VGND VPWR VPWR net62 sky130_fd_sc_hd__dfrtp_1
X_1749_ clknet_leaf_26_clk _0168_ net121 VGND VGND VPWR VPWR u_jt49.regarray\[7\]\[1\]
+ sky130_fd_sc_hd__dfrtp_1
XFILLER_60_209 VGND VPWR VPWR VGND sky130_ef_sc_hd__decap_12
XFILLER_26_66 VGND VPWR VPWR VGND sky130_ef_sc_hd__decap_12
XFILLER_13_169 VGND VGND VPWR VPWR sky130_fd_sc_hd__decap_8
XFILLER_5_357 VGND VPWR VPWR VGND sky130_ef_sc_hd__decap_12
X_0982_ net98 net28 _0608_ VGND VGND VPWR VPWR _0011_ sky130_fd_sc_hd__mux2_1
Xfanout108 din_latch\[2\] VGND VGND VPWR VPWR net108 sky130_fd_sc_hd__buf_2
X_1603_ clknet_leaf_28_clk _0026_ net119 VGND VGND VPWR VPWR u_jt49.u_chC.count\[2\]
+ sky130_fd_sc_hd__dfrtp_1
Xfanout119 net122 VGND VGND VPWR VPWR net119 sky130_fd_sc_hd__clkbuf_4
X_1465_ u_jt49.regarray\[6\]\[3\] net105 _0412_ VGND VGND VPWR VPWR _0178_ sky130_fd_sc_hd__mux2_1
X_1534_ u_jt49.periodA\[0\] net111 _0420_ VGND VGND VPWR VPWR _0239_ sky130_fd_sc_hd__mux2_1
X_1396_ u_jt49.bitC u_jt49.regarray\[7\]\[2\] u_jt49.regarray\[7\]\[5\] u_jt49.noise
+ net20 VGND VGND VPWR VPWR _0404_ sky130_fd_sc_hd__o221a_1
XFILLER_50_253 VGND VPWR VPWR VGND sky130_ef_sc_hd__decap_12
XFILLER_50_220 VGND VGND VPWR VPWR sky130_fd_sc_hd__decap_6
XFILLER_12_35 VGND VPWR VPWR VGND sky130_ef_sc_hd__decap_12
XFILLER_58_342 VGND VGND VPWR VPWR sky130_fd_sc_hd__decap_3
XFILLER_53_86 VGND VGND VPWR VPWR sky130_fd_sc_hd__decap_8
XFILLER_41_253 VGND VPWR VPWR VGND sky130_ef_sc_hd__decap_12
XFILLER_5_187 VGND VGND VPWR VPWR sky130_fd_sc_hd__decap_4
X_1250_ u_jt49.u_chB.count\[10\] _0454_ _0287_ VGND VGND VPWR VPWR _0288_ sky130_fd_sc_hd__o21ai_1
X_1181_ net74 _0765_ _0766_ VGND VGND VPWR VPWR _0056_ sky130_fd_sc_hd__and3_1
XFILLER_32_253 VGND VPWR VPWR VGND sky130_ef_sc_hd__decap_12
X_0965_ u_jt49.regarray\[6\]\[7\] _0523_ _0527_ u_jt49.regarray\[1\]\[7\] VGND VGND
+ VPWR VPWR _0602_ sky130_fd_sc_hd__a22o_1
X_0896_ u_jt49.periodA\[0\] _0518_ _0538_ _0539_ VGND VGND VPWR VPWR _0540_ sky130_fd_sc_hd__o211a_1
X_1517_ u_jt49.periodA\[9\] net109 _0418_ VGND VGND VPWR VPWR _0224_ sky130_fd_sc_hd__mux2_1
X_1448_ u_jt49.regarray\[8\]\[4\] net104 _0410_ VGND VGND VPWR VPWR _0163_ sky130_fd_sc_hd__mux2_1
X_1379_ u_jt49.u_chA.count\[9\] _0390_ u_jt49.u_chA.count\[10\] VGND VGND VPWR VPWR
+ _0394_ sky130_fd_sc_hd__a21o_1
XFILLER_58_150 VGND VGND VPWR VPWR sky130_fd_sc_hd__decap_4
XFILLER_46_345 VGND VPWR VPWR VGND sky130_ef_sc_hd__decap_12
XFILLER_64_85 VGND VPWR VPWR VGND sky130_ef_sc_hd__decap_12
XFILLER_64_41 VGND VPWR VPWR VGND sky130_ef_sc_hd__decap_12
XFILLER_61_337 VGND VPWR VPWR VGND sky130_ef_sc_hd__decap_12
XFILLER_14_242 VGND VGND VPWR VPWR sky130_fd_sc_hd__decap_4
XFILLER_14_253 VGND VGND VPWR VPWR sky130_fd_sc_hd__decap_8
Xfanout90 addr\[3\] VGND VGND VPWR VPWR net90 sky130_fd_sc_hd__dlymetal6s2s_1
X_1233_ u_jt49.u_ng.poly17\[15\] u_jt49.u_ng.poly17\[14\] u_jt49.u_ng.poly17\[16\]
+ _0274_ VGND VGND VPWR VPWR _0275_ sky130_fd_sc_hd__or4_1
X_1302_ net73 _0329_ _0330_ VGND VGND VPWR VPWR _0097_ sky130_fd_sc_hd__and3_1
XFILLER_64_197 VGND VPWR VPWR VGND sky130_ef_sc_hd__decap_12
XFILLER_49_194 VGND VPWR VPWR VGND sky130_ef_sc_hd__decap_12
XFILLER_49_172 VGND VPWR VPWR VGND sky130_ef_sc_hd__decap_12
X_1164_ u_jt49.u_env.cen u_jt49.u_envdiv.count\[0\] _0717_ _0745_ VGND VGND VPWR VPWR
+ _0754_ sky130_fd_sc_hd__and4_1
X_1095_ u_jt49.u_env.inv _0699_ _0698_ VGND VGND VPWR VPWR _0037_ sky130_fd_sc_hd__mux2_1
X_0948_ u_jt49.periodA\[5\] _0518_ _0539_ _0586_ u_jt49.read_mask\[5\] VGND VGND VPWR
+ VPWR _0587_ sky130_fd_sc_hd__o2111a_1
X_0879_ net90 net95 net94 net92 VGND VGND VPWR VPWR _0523_ sky130_fd_sc_hd__and4bb_4
XFILLER_59_85 VGND VPWR VPWR VGND sky130_ef_sc_hd__decap_12
XFILLER_19_301 VGND VGND VPWR VPWR sky130_fd_sc_hd__decap_6
X_0802_ u_jt49.u_chB.count\[10\] VGND VGND VPWR VPWR _0453_ sky130_fd_sc_hd__inv_2
X_1851_ clknet_leaf_22_clk _0261_ VGND VGND VPWR VPWR net42 sky130_fd_sc_hd__dfxtp_1
X_1782_ clknet_leaf_26_clk _0201_ net121 VGND VGND VPWR VPWR u_jt49.periodC\[2\] sky130_fd_sc_hd__dfrtp_1
X_1216_ net230 net225 net78 VGND VGND VPWR VPWR _0068_ sky130_fd_sc_hd__mux2_1
X_1147_ _0719_ _0724_ _0727_ _0743_ VGND VGND VPWR VPWR _0744_ sky130_fd_sc_hd__and4bb_1
X_1078_ u_jt49.u_chC.count\[11\] _0683_ VGND VGND VPWR VPWR _0685_ sky130_fd_sc_hd__or2_1
XFILLER_4_208 VGND VGND VPWR VPWR sky130_fd_sc_hd__decap_4
XFILLER_29_44 VGND VPWR VPWR VGND sky130_ef_sc_hd__decap_12
Xhold22 net45 VGND VGND VPWR VPWR net167 sky130_fd_sc_hd__dlygate4sd3_1
Xhold11 net39 VGND VGND VPWR VPWR net156 sky130_fd_sc_hd__dlygate4sd3_1
Xhold77 _0081_ VGND VGND VPWR VPWR net222 sky130_fd_sc_hd__dlygate4sd3_1
Xhold88 _0074_ VGND VGND VPWR VPWR net233 sky130_fd_sc_hd__dlygate4sd3_1
Xhold33 net51 VGND VGND VPWR VPWR net178 sky130_fd_sc_hd__dlygate4sd3_1
Xhold44 net58 VGND VGND VPWR VPWR net189 sky130_fd_sc_hd__dlygate4sd3_1
Xhold55 _0038_ VGND VGND VPWR VPWR net200 sky130_fd_sc_hd__dlygate4sd3_1
XFILLER_28_131 VGND VGND VPWR VPWR sky130_fd_sc_hd__decap_6
Xhold99 u_jt49.regarray\[9\]\[0\] VGND VGND VPWR VPWR net244 sky130_fd_sc_hd__dlygate4sd3_1
Xhold66 net47 VGND VGND VPWR VPWR net211 sky130_fd_sc_hd__dlygate4sd3_1
XFILLER_61_20 VGND VPWR VPWR VGND sky130_ef_sc_hd__decap_12
XFILLER_43_156 VGND VPWR VPWR VGND sky130_ef_sc_hd__decap_12
XFILLER_31_329 VGND VGND VPWR VPWR sky130_fd_sc_hd__decap_6
XFILLER_24_370 VGND VGND VPWR VPWR sky130_fd_sc_hd__decap_4
XFILLER_6_15 VGND VPWR VPWR VGND sky130_ef_sc_hd__decap_12
XFILLER_3_241 VGND VGND VPWR VPWR sky130_fd_sc_hd__decap_6
XFILLER_13_6 VGND VPWR VPWR VGND sky130_ef_sc_hd__decap_12
X_1001_ _0616_ _0622_ _0623_ VGND VGND VPWR VPWR _0015_ sky130_fd_sc_hd__and3_1
X_1834_ clknet_leaf_28_clk _0252_ VGND VGND VPWR VPWR net33 sky130_fd_sc_hd__dfxtp_1
X_1765_ clknet_leaf_19_clk _0184_ net135 VGND VGND VPWR VPWR u_jt49.regarray\[13\]\[1\]
+ sky130_fd_sc_hd__dfrtp_1
X_1696_ clknet_leaf_15_clk _0117_ net144 VGND VGND VPWR VPWR u_jt49.u_cen.cencnt\[3\]
+ sky130_fd_sc_hd__dfrtp_1
XFILLER_57_237 VGND VPWR VPWR VGND sky130_ef_sc_hd__decap_12
XFILLER_15_57 VGND VPWR VPWR VGND sky130_ef_sc_hd__decap_12
XFILLER_31_78 VGND VPWR VPWR VGND sky130_ef_sc_hd__decap_12
Xoutput34 net34 VGND VGND VPWR VPWR A[3] sky130_fd_sc_hd__buf_2
Xoutput56 net56 VGND VGND VPWR VPWR IOB_out[0] sky130_fd_sc_hd__buf_2
Xoutput45 net45 VGND VGND VPWR VPWR C[4] sky130_fd_sc_hd__buf_2
Xoutput67 net67 VGND VGND VPWR VPWR dout[3] sky130_fd_sc_hd__buf_2
XFILLER_31_148 VGND VGND VPWR VPWR sky130_fd_sc_hd__decap_3
XFILLER_8_333 VGND VPWR VPWR VGND sky130_ef_sc_hd__decap_12
X_1550_ u_jt49.regarray\[8\]\[0\] u_jt49.envelope\[1\] u_jt49.regarray\[8\]\[4\] VGND
+ VGND VPWR VPWR _0425_ sky130_fd_sc_hd__mux2_1
X_1481_ u_jt49.periodC\[9\] net109 _0414_ VGND VGND VPWR VPWR _0192_ sky130_fd_sc_hd__mux2_1
XFILLER_47_281 VGND VPWR VPWR VGND sky130_ef_sc_hd__decap_12
XFILLER_11_3 VGND VPWR VPWR VGND sky130_ef_sc_hd__decap_12
XFILLER_22_104 VGND VGND VPWR VPWR sky130_fd_sc_hd__decap_4
XFILLER_22_137 VGND VGND VPWR VPWR sky130_fd_sc_hd__decap_3
X_1817_ clknet_leaf_7_clk _0236_ net125 VGND VGND VPWR VPWR net61 sky130_fd_sc_hd__dfrtp_1
X_1748_ clknet_leaf_2_clk _0167_ net120 VGND VGND VPWR VPWR u_jt49.regarray\[7\]\[0\]
+ sky130_fd_sc_hd__dfrtp_1
X_1679_ clknet_leaf_12_clk _0100_ net141 VGND VGND VPWR VPWR u_jt49.bitB sky130_fd_sc_hd__dfrtp_1
XFILLER_26_78 VGND VGND VPWR VPWR sky130_fd_sc_hd__decap_6
XFILLER_13_104 VGND VGND VPWR VPWR sky130_fd_sc_hd__decap_8
XFILLER_5_369 VGND VGND VPWR VPWR sky130_fd_sc_hd__decap_8
X_0981_ net100 net27 _0608_ VGND VGND VPWR VPWR _0010_ sky130_fd_sc_hd__mux2_1
X_1602_ clknet_leaf_28_clk _0025_ net119 VGND VGND VPWR VPWR u_jt49.u_chC.count\[1\]
+ sky130_fd_sc_hd__dfrtp_1
XFILLER_8_185 VGND VGND VPWR VPWR sky130_fd_sc_hd__decap_8
Xfanout109 din_latch\[1\] VGND VGND VPWR VPWR net109 sky130_fd_sc_hd__clkbuf_4
X_1395_ net168 _0403_ VGND VGND VPWR VPWR _0117_ sky130_fd_sc_hd__xnor2_1
X_1464_ u_jt49.regarray\[6\]\[2\] net107 _0412_ VGND VGND VPWR VPWR _0177_ sky130_fd_sc_hd__mux2_1
X_1533_ net81 _0517_ VGND VGND VPWR VPWR _0420_ sky130_fd_sc_hd__and2_2
XFILLER_50_265 VGND VPWR VPWR VGND sky130_ef_sc_hd__decap_12
Xclkbuf_leaf_30_clk clknet_2_0__leaf_clk VGND VGND VPWR VPWR clknet_leaf_30_clk sky130_fd_sc_hd__clkbuf_8
Xhold130 u_jt49.periodB\[0\] VGND VGND VPWR VPWR net275 sky130_fd_sc_hd__dlygate4sd3_1
XFILLER_12_47 VGND VPWR VPWR VGND sky130_ef_sc_hd__decap_12
XFILLER_58_365 VGND VPWR VPWR VGND sky130_ef_sc_hd__decap_12
XFILLER_41_265 VGND VPWR VPWR VGND sky130_ef_sc_hd__decap_12
Xclkbuf_leaf_21_clk clknet_2_2__leaf_clk VGND VGND VPWR VPWR clknet_leaf_21_clk sky130_fd_sc_hd__clkbuf_8
X_1180_ _0480_ _0763_ VGND VGND VPWR VPWR _0766_ sky130_fd_sc_hd__nand2_1
Xclkbuf_leaf_12_clk clknet_2_3__leaf_clk VGND VGND VPWR VPWR clknet_leaf_12_clk sky130_fd_sc_hd__clkbuf_8
XFILLER_32_265 VGND VPWR VPWR VGND sky130_ef_sc_hd__decap_12
X_0964_ u_jt49.eg_period\[15\] _0526_ _0528_ u_jt49.periodB\[7\] _0598_ VGND VGND
+ VPWR VPWR _0601_ sky130_fd_sc_hd__a221o_1
X_1516_ u_jt49.periodA\[8\] net111 _0418_ VGND VGND VPWR VPWR _0223_ sky130_fd_sc_hd__mux2_1
X_0895_ net89 net91 net93 VGND VGND VPWR VPWR _0539_ sky130_fd_sc_hd__nand3_4
X_1378_ net83 u_jt49.u_chA.count\[9\] _0367_ _0393_ VGND VGND VPWR VPWR _0110_ sky130_fd_sc_hd__a22o_1
X_1447_ net274 net105 _0410_ VGND VGND VPWR VPWR _0162_ sky130_fd_sc_hd__mux2_1
XFILLER_23_210 VGND VGND VPWR VPWR sky130_fd_sc_hd__decap_6
XFILLER_64_53 VGND VGND VPWR VPWR sky130_fd_sc_hd__decap_3
XFILLER_61_305 VGND VPWR VPWR VGND sky130_ef_sc_hd__decap_12
XFILLER_58_184 VGND VPWR VPWR VGND sky130_ef_sc_hd__decap_12
XFILLER_46_357 VGND VGND VPWR VPWR sky130_fd_sc_hd__decap_6
XFILLER_64_97 VGND VGND VPWR VPWR sky130_fd_sc_hd__decap_8
XFILLER_61_349 VGND VPWR VPWR VGND sky130_ef_sc_hd__decap_12
Xfanout91 net92 VGND VGND VPWR VPWR net91 sky130_fd_sc_hd__clkbuf_4
X_1232_ u_jt49.u_ng.poly17\[11\] u_jt49.u_ng.poly17\[10\] u_jt49.u_ng.poly17\[13\]
+ u_jt49.u_ng.poly17\[12\] VGND VGND VPWR VPWR _0274_ sky130_fd_sc_hd__or4_1
X_1301_ u_jt49.u_chB.count\[9\] _0326_ VGND VGND VPWR VPWR _0330_ sky130_fd_sc_hd__or2_1
Xclkbuf_leaf_1_clk clknet_2_0__leaf_clk VGND VGND VPWR VPWR clknet_leaf_1_clk sky130_fd_sc_hd__clkbuf_8
XFILLER_64_165 VGND VGND VPWR VPWR sky130_fd_sc_hd__decap_3
X_1163_ u_jt49.u_ng.noise_en net152 _0753_ VGND VGND VPWR VPWR _0051_ sky130_fd_sc_hd__mux2_1
X_1094_ _0494_ u_jt49.regarray\[13\]\[2\] u_jt49.u_env.rst_latch VGND VGND VPWR VPWR
+ _0699_ sky130_fd_sc_hd__mux2_1
X_0947_ _0582_ _0583_ _0585_ VGND VGND VPWR VPWR _0586_ sky130_fd_sc_hd__or3_1
X_0878_ net90 net92 net94 net96 VGND VGND VPWR VPWR _0522_ sky130_fd_sc_hd__and4bb_4
Xclkload0 clknet_2_3__leaf_clk VGND VGND VPWR VPWR clkload0/X sky130_fd_sc_hd__clkbuf_8
XFILLER_59_97 VGND VPWR VPWR VGND sky130_ef_sc_hd__decap_12
XFILLER_59_31 VGND VGND VPWR VPWR sky130_fd_sc_hd__decap_4
XFILLER_61_113 VGND VPWR VPWR VGND sky130_ef_sc_hd__decap_12
X_0801_ net247 VGND VGND VPWR VPWR _0452_ sky130_fd_sc_hd__inv_2
XFILLER_42_360 VGND VGND VPWR VPWR sky130_fd_sc_hd__decap_4
X_1850_ clknet_leaf_22_clk _0260_ VGND VGND VPWR VPWR net41 sky130_fd_sc_hd__dfxtp_1
X_1781_ clknet_leaf_26_clk _0200_ net121 VGND VGND VPWR VPWR u_jt49.periodC\[1\] sky130_fd_sc_hd__dfrtp_1
X_1215_ u_jt49.u_ng.last_en u_jt49.u_ng.noise_en net87 VGND VGND VPWR VPWR _0789_
+ sky130_fd_sc_hd__and3b_1
X_1146_ u_jt49.eg_period\[8\] _0476_ _0726_ VGND VGND VPWR VPWR _0743_ sky130_fd_sc_hd__a21oi_1
X_1077_ _0659_ _0682_ _0684_ VGND VGND VPWR VPWR _0034_ sky130_fd_sc_hd__and3_1
XFILLER_20_25 VGND VGND VPWR VPWR sky130_fd_sc_hd__decap_3
Xhold23 u_jt49.u_cen.cencnt\[3\] VGND VGND VPWR VPWR net168 sky130_fd_sc_hd__dlygate4sd3_1
Xhold34 net50 VGND VGND VPWR VPWR net179 sky130_fd_sc_hd__dlygate4sd3_1
Xhold56 u_jt49.regarray\[8\]\[6\] VGND VGND VPWR VPWR net201 sky130_fd_sc_hd__dlygate4sd3_1
Xhold45 net56 VGND VGND VPWR VPWR net190 sky130_fd_sc_hd__dlygate4sd3_1
Xhold12 net32 VGND VGND VPWR VPWR net157 sky130_fd_sc_hd__dlygate4sd3_1
Xhold78 u_jt49.u_cen.cencnt\[1\] VGND VGND VPWR VPWR net223 sky130_fd_sc_hd__dlygate4sd3_1
Xhold89 u_jt49.u_ng.poly17\[4\] VGND VGND VPWR VPWR net234 sky130_fd_sc_hd__dlygate4sd3_1
Xhold67 u_jt49.regarray\[13\]\[6\] VGND VGND VPWR VPWR net212 sky130_fd_sc_hd__dlygate4sd3_1
XFILLER_61_32 VGND VPWR VPWR VGND sky130_ef_sc_hd__decap_12
X_1000_ u_jt49.u_ng.u_div.count\[3\] _0620_ VGND VGND VPWR VPWR _0623_ sky130_fd_sc_hd__or2_1
XFILLER_19_132 VGND VGND VPWR VPWR sky130_fd_sc_hd__decap_4
XFILLER_15_371 VGND VGND VPWR VPWR sky130_fd_sc_hd__decap_8
XFILLER_30_341 VGND VGND VPWR VPWR sky130_fd_sc_hd__decap_3
X_1833_ clknet_leaf_28_clk _0251_ VGND VGND VPWR VPWR net32 sky130_fd_sc_hd__dfxtp_1
X_1764_ clknet_leaf_25_clk _0183_ net134 VGND VGND VPWR VPWR u_jt49.regarray\[13\]\[0\]
+ sky130_fd_sc_hd__dfrtp_1
X_1695_ clknet_leaf_15_clk _0116_ net144 VGND VGND VPWR VPWR u_jt49.u_cen.cencnt\[2\]
+ sky130_fd_sc_hd__dfrtp_1
XFILLER_57_249 VGND VGND VPWR VPWR sky130_fd_sc_hd__decap_3
X_1129_ _0720_ _0721_ _0723_ _0725_ VGND VGND VPWR VPWR _0726_ sky130_fd_sc_hd__or4_1
XFILLER_25_113 VGND VPWR VPWR VGND sky130_ef_sc_hd__decap_12
XFILLER_15_69 VGND VPWR VPWR VGND sky130_ef_sc_hd__decap_12
Xoutput46 net46 VGND VGND VPWR VPWR IOA_oe sky130_fd_sc_hd__buf_2
Xoutput57 net57 VGND VGND VPWR VPWR IOB_out[1] sky130_fd_sc_hd__buf_2
Xoutput35 net35 VGND VGND VPWR VPWR A[4] sky130_fd_sc_hd__buf_2
XFILLER_0_201 VGND VPWR VPWR VGND sky130_ef_sc_hd__decap_12
Xoutput68 net68 VGND VGND VPWR VPWR dout[4] sky130_fd_sc_hd__buf_2
XPHY_EDGE_ROW_19_Right_19 VGND VGND VPWR VPWR sky130_fd_sc_hd__decap_3
XFILLER_8_345 VGND VPWR VPWR VGND sky130_ef_sc_hd__decap_12
XPHY_EDGE_ROW_28_Right_28 VGND VGND VPWR VPWR sky130_fd_sc_hd__decap_3
X_1480_ u_jt49.periodC\[8\] net111 _0414_ VGND VGND VPWR VPWR _0191_ sky130_fd_sc_hd__mux2_1
XFILLER_54_208 VGND VPWR VPWR VGND sky130_ef_sc_hd__decap_12
XFILLER_47_293 VGND VPWR VPWR VGND sky130_ef_sc_hd__decap_12
XPHY_EDGE_ROW_37_Right_37 VGND VGND VPWR VPWR sky130_fd_sc_hd__decap_3
X_1816_ clknet_leaf_6_clk _0235_ net124 VGND VGND VPWR VPWR net60 sky130_fd_sc_hd__dfrtp_1
XPHY_EDGE_ROW_46_Right_46 VGND VGND VPWR VPWR sky130_fd_sc_hd__decap_3
X_1678_ clknet_leaf_12_clk _0099_ net141 VGND VGND VPWR VPWR u_jt49.u_chB.count\[11\]
+ sky130_fd_sc_hd__dfrtp_1
X_1747_ clknet_leaf_3_clk _0166_ net128 VGND VGND VPWR VPWR u_jt49.regarray\[8\]\[7\]
+ sky130_fd_sc_hd__dfrtp_1
XPHY_EDGE_ROW_55_Right_55 VGND VGND VPWR VPWR sky130_fd_sc_hd__decap_3
XFILLER_38_293 VGND VPWR VPWR VGND sky130_ef_sc_hd__decap_12
XPHY_EDGE_ROW_64_Right_64 VGND VGND VPWR VPWR sky130_fd_sc_hd__decap_3
XPHY_EDGE_ROW_39_Left_104 VGND VGND VPWR VPWR sky130_fd_sc_hd__decap_3
XPHY_EDGE_ROW_48_Left_113 VGND VGND VPWR VPWR sky130_fd_sc_hd__decap_3
X_0980_ net101 net26 _0608_ VGND VGND VPWR VPWR _0009_ sky130_fd_sc_hd__mux2_1
XFILLER_44_263 VGND VPWR VPWR VGND sky130_ef_sc_hd__decap_12
XFILLER_8_120 VGND VGND VPWR VPWR sky130_fd_sc_hd__decap_6
X_1532_ net97 net206 _0419_ VGND VGND VPWR VPWR _0238_ sky130_fd_sc_hd__mux2_1
XPHY_EDGE_ROW_57_Left_122 VGND VGND VPWR VPWR sky130_fd_sc_hd__decap_3
X_1601_ clknet_leaf_27_clk _0024_ net119 VGND VGND VPWR VPWR u_jt49.u_chC.count\[0\]
+ sky130_fd_sc_hd__dfstp_1
X_1394_ net170 _0401_ VGND VGND VPWR VPWR _0116_ sky130_fd_sc_hd__xor2_1
X_1463_ u_jt49.regarray\[6\]\[1\] net109 _0412_ VGND VGND VPWR VPWR _0176_ sky130_fd_sc_hd__mux2_1
XFILLER_50_200 VGND VPWR VPWR VGND sky130_ef_sc_hd__decap_12
XFILLER_50_277 VGND VGND VPWR VPWR sky130_fd_sc_hd__decap_8
XFILLER_12_15 VGND VPWR VPWR VGND sky130_ef_sc_hd__decap_12
Xhold131 u_jt49.u_cen.cencnt\[0\] VGND VGND VPWR VPWR net276 sky130_fd_sc_hd__dlygate4sd3_1
XFILLER_2_329 VGND VGND VPWR VPWR sky130_fd_sc_hd__decap_4
Xhold120 u_jt49.regarray\[8\]\[1\] VGND VGND VPWR VPWR net265 sky130_fd_sc_hd__dlygate4sd3_1
XFILLER_58_377 VGND VGND VPWR VPWR sky130_fd_sc_hd__decap_4
XFILLER_41_277 VGND VGND VPWR VPWR sky130_fd_sc_hd__decap_3
XFILLER_32_277 VGND VGND VPWR VPWR sky130_fd_sc_hd__decap_3
X_0963_ u_jt49.regarray\[10\]\[7\] _0520_ _0521_ u_jt49.eg_period\[7\] _0599_ VGND
+ VGND VPWR VPWR _0600_ sky130_fd_sc_hd__a221o_1
X_0894_ _0533_ _0535_ _0537_ VGND VGND VPWR VPWR _0538_ sky130_fd_sc_hd__or3_1
X_1515_ net81 net77 VGND VGND VPWR VPWR _0418_ sky130_fd_sc_hd__and2_4
XFILLER_55_358 VGND VPWR VPWR VGND sky130_ef_sc_hd__decap_12
XFILLER_55_314 VGND VPWR VPWR VGND sky130_ef_sc_hd__decap_12
X_1377_ u_jt49.u_chA.count\[9\] _0390_ _0392_ _0387_ VGND VGND VPWR VPWR _0393_ sky130_fd_sc_hd__o22a_1
XFILLER_4_93 VGND VPWR VPWR VGND sky130_ef_sc_hd__decap_12
X_1446_ net256 net108 _0410_ VGND VGND VPWR VPWR _0161_ sky130_fd_sc_hd__mux2_1
XFILLER_23_36 VGND VGND VPWR VPWR sky130_fd_sc_hd__decap_6
XFILLER_64_10 VGND VPWR VPWR VGND sky130_ef_sc_hd__decap_12
XFILLER_61_317 VGND VPWR VPWR VGND sky130_ef_sc_hd__decap_12
Xfanout81 u_jt49.write VGND VGND VPWR VPWR net81 sky130_fd_sc_hd__clkbuf_4
Xfanout92 addr\[2\] VGND VGND VPWR VPWR net92 sky130_fd_sc_hd__buf_1
XPHY_EDGE_ROW_24_Left_89 VGND VGND VPWR VPWR sky130_fd_sc_hd__decap_3
X_1231_ net219 u_jt49.u_ng.poly17\[16\] net79 VGND VGND VPWR VPWR _0083_ sky130_fd_sc_hd__mux2_1
X_1300_ u_jt49.u_chB.count\[9\] _0326_ VGND VGND VPWR VPWR _0329_ sky130_fd_sc_hd__nand2_1
X_1162_ net124 net87 VGND VGND VPWR VPWR _0753_ sky130_fd_sc_hd__nand2_1
XFILLER_37_347 VGND VGND VPWR VPWR sky130_fd_sc_hd__decap_4
XFILLER_60_361 VGND VGND VPWR VPWR sky130_fd_sc_hd__decap_3
X_1093_ u_jt49.u_env.rst_latch _0694_ _0697_ _0693_ VGND VGND VPWR VPWR _0698_ sky130_fd_sc_hd__o211a_1
X_0946_ u_jt49.regarray\[3\]\[5\] _0522_ _0528_ u_jt49.periodB\[5\] _0584_ VGND VGND
+ VPWR VPWR _0585_ sky130_fd_sc_hd__a221o_1
X_0877_ net91 net93 net96 net89 VGND VGND VPWR VPWR _0521_ sky130_fd_sc_hd__and4b_4
X_1429_ u_jt49.regarray\[10\]\[3\] net106 _0408_ VGND VGND VPWR VPWR _0146_ sky130_fd_sc_hd__mux2_1
XFILLER_34_46 VGND VPWR VPWR VGND sky130_ef_sc_hd__decap_12
XFILLER_11_225 VGND VGND VPWR VPWR sky130_fd_sc_hd__decap_8
Xclkload1 clknet_leaf_0_clk VGND VGND VPWR VPWR clkload1/Y sky130_fd_sc_hd__clkinv_2
XFILLER_61_169 VGND VPWR VPWR VGND sky130_ef_sc_hd__decap_12
XFILLER_61_125 VGND VPWR VPWR VGND sky130_ef_sc_hd__decap_12
XFILLER_6_240 VGND VPWR VPWR VGND sky130_ef_sc_hd__decap_12
X_0800_ u_jt49.regarray\[13\]\[0\] VGND VGND VPWR VPWR _0451_ sky130_fd_sc_hd__inv_2
X_1780_ clknet_leaf_26_clk _0199_ net121 VGND VGND VPWR VPWR u_jt49.periodC\[0\] sky130_fd_sc_hd__dfrtp_1
XFILLER_34_3 VGND VPWR VPWR VGND sky130_ef_sc_hd__decap_12
XFILLER_52_114 VGND VGND VPWR VPWR sky130_fd_sc_hd__decap_3
X_1214_ _0472_ _0788_ net75 VGND VGND VPWR VPWR _0067_ sky130_fd_sc_hd__a21boi_1
X_1145_ _0731_ _0740_ _0741_ _0732_ _0736_ VGND VGND VPWR VPWR _0742_ sky130_fd_sc_hd__a32o_1
XFILLER_52_158 VGND VGND VPWR VPWR sky130_fd_sc_hd__decap_6
X_1076_ _0683_ VGND VGND VPWR VPWR _0684_ sky130_fd_sc_hd__inv_2
X_0929_ net12 _0541_ _0542_ net4 _0569_ VGND VGND VPWR VPWR _0269_ sky130_fd_sc_hd__a221o_1
Xhold79 u_jt49.u_ng.poly17\[14\] VGND VGND VPWR VPWR net224 sky130_fd_sc_hd__dlygate4sd3_1
Xhold57 net62 VGND VGND VPWR VPWR net202 sky130_fd_sc_hd__dlygate4sd3_1
Xhold46 net52 VGND VGND VPWR VPWR net191 sky130_fd_sc_hd__dlygate4sd3_1
Xhold24 u_jt49.regarray\[8\]\[7\] VGND VGND VPWR VPWR net169 sky130_fd_sc_hd__dlygate4sd3_1
XFILLER_29_57 VGND VGND VPWR VPWR sky130_fd_sc_hd__decap_4
Xhold13 net34 VGND VGND VPWR VPWR net158 sky130_fd_sc_hd__dlygate4sd3_1
Xhold68 u_jt49.regarray\[13\]\[5\] VGND VGND VPWR VPWR net213 sky130_fd_sc_hd__dlygate4sd3_1
Xhold35 u_jt49.regarray\[1\]\[4\] VGND VGND VPWR VPWR net180 sky130_fd_sc_hd__dlygate4sd3_1
XFILLER_45_45 VGND VGND VPWR VPWR sky130_fd_sc_hd__decap_4
XFILLER_43_169 VGND VGND VPWR VPWR sky130_fd_sc_hd__decap_6
XFILLER_24_361 VGND VGND VPWR VPWR sky130_fd_sc_hd__decap_3
XFILLER_19_199 VGND VGND VPWR VPWR sky130_fd_sc_hd__decap_4
XFILLER_34_136 VGND VGND VPWR VPWR sky130_fd_sc_hd__decap_4
X_1832_ clknet_leaf_28_clk _0250_ VGND VGND VPWR VPWR net31 sky130_fd_sc_hd__dfxtp_1
X_1694_ clknet_leaf_14_clk _0115_ net144 VGND VGND VPWR VPWR u_jt49.u_cen.cencnt\[1\]
+ sky130_fd_sc_hd__dfrtp_1
X_1763_ clknet_leaf_3_clk _0182_ net127 VGND VGND VPWR VPWR u_jt49.regarray\[6\]\[7\]
+ sky130_fd_sc_hd__dfrtp_1
XPHY_EDGE_ROW_27_Left_92 VGND VGND VPWR VPWR sky130_fd_sc_hd__decap_3
X_1128_ u_jt49.u_envdiv.count\[10\] u_jt49.eg_period\[10\] VGND VGND VPWR VPWR _0725_
+ sky130_fd_sc_hd__and2b_1
XFILLER_40_106 VGND VPWR VPWR VGND sky130_ef_sc_hd__decap_12
X_1059_ net84 u_jt49.u_chC.count\[5\] _0657_ _0671_ VGND VGND VPWR VPWR _0029_ sky130_fd_sc_hd__a22o_1
XPHY_EDGE_ROW_11_Left_76 VGND VGND VPWR VPWR sky130_fd_sc_hd__decap_3
XFILLER_25_125 VGND VGND VPWR VPWR sky130_fd_sc_hd__decap_8
Xoutput58 net58 VGND VGND VPWR VPWR IOB_out[2] sky130_fd_sc_hd__buf_2
Xoutput69 net69 VGND VGND VPWR VPWR dout[5] sky130_fd_sc_hd__buf_2
Xoutput36 net36 VGND VGND VPWR VPWR B[0] sky130_fd_sc_hd__buf_2
XFILLER_0_213 VGND VGND VPWR VPWR sky130_fd_sc_hd__decap_3
Xoutput47 net47 VGND VGND VPWR VPWR IOA_out[0] sky130_fd_sc_hd__buf_2
XFILLER_56_283 VGND VGND VPWR VPWR sky130_fd_sc_hd__decap_3
XFILLER_56_55 VGND VGND VPWR VPWR sky130_fd_sc_hd__decap_4
XFILLER_48_239 VGND VPWR VPWR VGND sky130_ef_sc_hd__decap_12
XFILLER_8_357 VGND VGND VPWR VPWR sky130_fd_sc_hd__decap_6
XFILLER_62_253 VGND VPWR VPWR VGND sky130_ef_sc_hd__decap_12
X_1815_ clknet_leaf_5_clk _0234_ net123 VGND VGND VPWR VPWR net59 sky130_fd_sc_hd__dfrtp_1
X_1677_ clknet_leaf_13_clk _0098_ net141 VGND VGND VPWR VPWR u_jt49.u_chB.count\[10\]
+ sky130_fd_sc_hd__dfrtp_1
X_1746_ clknet_leaf_11_clk _0165_ net139 VGND VGND VPWR VPWR u_jt49.regarray\[8\]\[6\]
+ sky130_fd_sc_hd__dfrtp_1
X_1531_ net100 net202 _0419_ VGND VGND VPWR VPWR _0237_ sky130_fd_sc_hd__mux2_1
X_1600_ clknet_leaf_20_clk _0023_ net136 VGND VGND VPWR VPWR u_jt49.u_env.rst_clr
+ sky130_fd_sc_hd__dfrtp_1
X_1462_ u_jt49.regarray\[6\]\[0\] net111 _0412_ VGND VGND VPWR VPWR _0175_ sky130_fd_sc_hd__mux2_1
X_1393_ net277 _0401_ VGND VGND VPWR VPWR _0403_ sky130_fd_sc_hd__nand2_1
XFILLER_50_212 VGND VGND VPWR VPWR sky130_fd_sc_hd__decap_4
XFILLER_35_297 VGND VGND VPWR VPWR sky130_fd_sc_hd__decap_8
XFILLER_35_275 VGND VGND VPWR VPWR sky130_fd_sc_hd__decap_4
XFILLER_10_109 VGND VGND VPWR VPWR sky130_fd_sc_hd__decap_4
Xhold110 u_jt49.regarray\[7\]\[2\] VGND VGND VPWR VPWR net255 sky130_fd_sc_hd__dlygate4sd3_1
Xhold132 u_jt49.u_cen.cencnt\[2\] VGND VGND VPWR VPWR net277 sky130_fd_sc_hd__dlygate4sd3_1
Xhold121 u_jt49.regarray\[13\]\[1\] VGND VGND VPWR VPWR net266 sky130_fd_sc_hd__dlygate4sd3_1
X_1729_ clknet_leaf_25_clk _0148_ net133 VGND VGND VPWR VPWR u_jt49.regarray\[10\]\[5\]
+ sky130_fd_sc_hd__dfrtp_1
XFILLER_58_334 VGND VGND VPWR VPWR sky130_fd_sc_hd__decap_8
XFILLER_18_209 VGND VPWR VPWR VGND sky130_ef_sc_hd__decap_12
XFILLER_64_315 VGND VPWR VPWR VGND sky130_ef_sc_hd__decap_12
XFILLER_64_337 VGND VGND VPWR VPWR sky130_fd_sc_hd__decap_8
XFILLER_64_3 VGND VGND VPWR VPWR sky130_fd_sc_hd__decap_3
X_0893_ u_jt49.eg_period\[8\] _0526_ _0528_ u_jt49.periodB\[0\] _0536_ VGND VGND VPWR
+ VPWR _0537_ sky130_fd_sc_hd__a221o_1
X_0962_ u_jt49.regarray\[13\]\[7\] _0524_ _0530_ u_jt49.regarray\[9\]\[7\] VGND VGND
+ VPWR VPWR _0599_ sky130_fd_sc_hd__a22o_1
XFILLER_59_109 VGND VGND VPWR VPWR sky130_fd_sc_hd__decap_3
X_1514_ u_jt49.periodB\[7\] net97 _0417_ VGND VGND VPWR VPWR _0222_ sky130_fd_sc_hd__mux2_1
X_1445_ net265 net109 _0410_ VGND VGND VPWR VPWR _0160_ sky130_fd_sc_hd__mux2_1
XFILLER_55_326 VGND VGND VPWR VPWR sky130_fd_sc_hd__decap_8
XFILLER_55_337 VGND VGND VPWR VPWR sky130_fd_sc_hd__decap_4
X_1376_ u_jt49.u_chA.count\[9\] u_jt49.u_chA.count\[8\] VGND VGND VPWR VPWR _0392_
+ sky130_fd_sc_hd__nand2_1
XFILLER_48_23 VGND VGND VPWR VPWR sky130_fd_sc_hd__decap_4
XFILLER_64_22 VGND VGND VPWR VPWR sky130_fd_sc_hd__decap_6
XFILLER_61_329 VGND VGND VPWR VPWR sky130_fd_sc_hd__decap_6
XFILLER_58_197 VGND VPWR VPWR VGND sky130_ef_sc_hd__decap_12
Xfanout93 net94 VGND VGND VPWR VPWR net93 sky130_fd_sc_hd__buf_2
Xfanout82 u_jt49.write VGND VGND VPWR VPWR net82 sky130_fd_sc_hd__clkbuf_4
XFILLER_64_145 VGND VPWR VPWR VGND sky130_ef_sc_hd__decap_12
X_1230_ net224 net219 net79 VGND VGND VPWR VPWR _0082_ sky130_fd_sc_hd__mux2_1
XFILLER_49_153 VGND VGND VPWR VPWR sky130_fd_sc_hd__decap_3
XFILLER_37_337 VGND VGND VPWR VPWR sky130_fd_sc_hd__decap_4
X_1161_ net259 _0752_ net85 VGND VGND VPWR VPWR _0050_ sky130_fd_sc_hd__mux2_1
X_1092_ u_jt49.u_env.gain\[4\] _0696_ u_jt49.u_env.rst_latch VGND VGND VPWR VPWR _0697_
+ sky130_fd_sc_hd__o21bai_1
X_0945_ u_jt49.eg_period\[13\] _0526_ _0529_ u_jt49.regarray\[8\]\[5\] VGND VGND VPWR
+ VPWR _0584_ sky130_fd_sc_hd__a22o_1
X_0876_ net92 net95 net94 net90 VGND VGND VPWR VPWR _0520_ sky130_fd_sc_hd__and4bb_4
X_1428_ u_jt49.regarray\[10\]\[2\] net107 _0408_ VGND VGND VPWR VPWR _0145_ sky130_fd_sc_hd__mux2_1
XFILLER_55_178 VGND VPWR VPWR VGND sky130_ef_sc_hd__decap_12
X_1359_ net87 _0375_ u_jt49.u_chA.count\[4\] VGND VGND VPWR VPWR _0380_ sky130_fd_sc_hd__a21o_1
Xclkload2 clknet_leaf_1_clk VGND VGND VPWR VPWR clkload2/X sky130_fd_sc_hd__clkbuf_8
XFILLER_46_167 VGND VPWR VPWR VGND sky130_ef_sc_hd__decap_12
XFILLER_61_137 VGND VPWR VPWR VGND sky130_ef_sc_hd__decap_12
X_1213_ net75 _0787_ _0788_ VGND VGND VPWR VPWR _0066_ sky130_fd_sc_hd__and3_1
XFILLER_27_3 VGND VPWR VPWR VGND sky130_ef_sc_hd__decap_12
XFILLER_37_178 VGND VGND VPWR VPWR sky130_fd_sc_hd__decap_6
X_1144_ _0729_ _0730_ _0734_ _0736_ VGND VGND VPWR VPWR _0741_ sky130_fd_sc_hd__and4b_1
X_1075_ u_jt49.u_chC.count\[10\] u_jt49.u_chC.count\[9\] _0678_ VGND VGND VPWR VPWR
+ _0683_ sky130_fd_sc_hd__and3_1
X_0859_ net22 addr\[1\] _0504_ VGND VGND VPWR VPWR _0508_ sky130_fd_sc_hd__mux2_1
X_0928_ u_jt49.periodA\[3\] _0518_ _0539_ _0568_ VGND VGND VPWR VPWR _0569_ sky130_fd_sc_hd__o211a_1
Xhold69 u_jt49.u_ng.poly17\[8\] VGND VGND VPWR VPWR net214 sky130_fd_sc_hd__dlygate4sd3_1
Xhold25 u_jt49.u_cen.cencnt\[2\] VGND VGND VPWR VPWR net170 sky130_fd_sc_hd__dlygate4sd3_1
Xhold47 u_jt49.regarray\[3\]\[7\] VGND VGND VPWR VPWR net192 sky130_fd_sc_hd__dlygate4sd3_1
Xhold36 u_jt49.regarray\[5\]\[4\] VGND VGND VPWR VPWR net181 sky130_fd_sc_hd__dlygate4sd3_1
Xhold14 net37 VGND VGND VPWR VPWR net159 sky130_fd_sc_hd__dlygate4sd3_1
Xhold58 u_jt49.regarray\[1\]\[5\] VGND VGND VPWR VPWR net203 sky130_fd_sc_hd__dlygate4sd3_1
XFILLER_45_57 VGND VPWR VPWR VGND sky130_ef_sc_hd__decap_12
XFILLER_6_29 VGND VPWR VPWR VGND sky130_ef_sc_hd__decap_12
XFILLER_3_233 VGND VGND VPWR VPWR sky130_fd_sc_hd__decap_3
XFILLER_59_281 VGND VPWR VPWR VGND sky130_ef_sc_hd__decap_12
XFILLER_19_101 VGND VGND VPWR VPWR sky130_fd_sc_hd__decap_8
XFILLER_30_365 VGND VPWR VPWR VGND sky130_ef_sc_hd__decap_12
X_1831_ clknet_leaf_20_clk net82 net136 VGND VGND VPWR VPWR u_jt49.last_write sky130_fd_sc_hd__dfrtp_1
X_1693_ clknet_leaf_14_clk _0114_ net144 VGND VGND VPWR VPWR u_jt49.u_cen.cencnt\[0\]
+ sky130_fd_sc_hd__dfrtp_1
X_1762_ clknet_leaf_18_clk _0181_ net139 VGND VGND VPWR VPWR u_jt49.regarray\[6\]\[6\]
+ sky130_fd_sc_hd__dfrtp_1
X_1127_ u_jt49.eg_period\[9\] _0475_ VGND VGND VPWR VPWR _0724_ sky130_fd_sc_hd__and2_1
X_1058_ u_jt49.u_chC.count\[5\] _0667_ _0670_ VGND VGND VPWR VPWR _0671_ sky130_fd_sc_hd__o21ba_1
XFILLER_33_192 VGND VGND VPWR VPWR sky130_fd_sc_hd__decap_3
Xoutput59 net59 VGND VGND VPWR VPWR IOB_out[3] sky130_fd_sc_hd__buf_2
Xoutput48 net48 VGND VGND VPWR VPWR IOA_out[1] sky130_fd_sc_hd__buf_2
XPHY_EDGE_ROW_1_Right_1 VGND VGND VPWR VPWR sky130_fd_sc_hd__decap_3
Xoutput37 net37 VGND VGND VPWR VPWR B[1] sky130_fd_sc_hd__buf_2
XFILLER_56_23 VGND VGND VPWR VPWR sky130_fd_sc_hd__decap_4
XFILLER_12_321 VGND VGND VPWR VPWR sky130_fd_sc_hd__decap_4
XFILLER_12_365 VGND VGND VPWR VPWR sky130_fd_sc_hd__decap_6
XFILLER_62_265 VGND VPWR VPWR VGND sky130_ef_sc_hd__decap_12
XFILLER_62_221 VGND VPWR VPWR VGND sky130_ef_sc_hd__decap_12
X_1814_ clknet_leaf_5_clk _0233_ net123 VGND VGND VPWR VPWR net58 sky130_fd_sc_hd__dfrtp_1
X_1745_ clknet_leaf_11_clk _0164_ net128 VGND VGND VPWR VPWR u_jt49.regarray\[8\]\[5\]
+ sky130_fd_sc_hd__dfrtp_1
X_1676_ clknet_leaf_13_clk _0097_ net141 VGND VGND VPWR VPWR u_jt49.u_chB.count\[9\]
+ sky130_fd_sc_hd__dfrtp_1
XFILLER_5_317 VGND VGND VPWR VPWR sky130_fd_sc_hd__decap_4
XFILLER_21_184 VGND VPWR VPWR VGND sky130_ef_sc_hd__decap_12
Xclkbuf_leaf_24_clk clknet_2_2__leaf_clk VGND VGND VPWR VPWR clknet_leaf_24_clk sky130_fd_sc_hd__clkbuf_8
XFILLER_8_133 VGND VGND VPWR VPWR sky130_fd_sc_hd__decap_6
X_1530_ net102 net197 _0419_ VGND VGND VPWR VPWR _0236_ sky130_fd_sc_hd__mux2_1
X_1392_ _0401_ _0402_ VGND VGND VPWR VPWR _0115_ sky130_fd_sc_hd__nor2_1
X_1461_ net81 _0523_ VGND VGND VPWR VPWR _0412_ sky130_fd_sc_hd__and2_4
XFILLER_4_361 VGND VGND VPWR VPWR sky130_fd_sc_hd__decap_3
Xclkbuf_leaf_15_clk clknet_2_3__leaf_clk VGND VGND VPWR VPWR clknet_leaf_15_clk sky130_fd_sc_hd__clkbuf_8
Xhold122 u_jt49.eg_step VGND VGND VPWR VPWR net267 sky130_fd_sc_hd__dlygate4sd3_1
XFILLER_2_309 VGND VPWR VPWR VGND sky130_ef_sc_hd__decap_12
Xhold111 u_jt49.regarray\[8\]\[2\] VGND VGND VPWR VPWR net256 sky130_fd_sc_hd__dlygate4sd3_1
X_1728_ clknet_leaf_25_clk _0147_ net132 VGND VGND VPWR VPWR u_jt49.regarray\[10\]\[4\]
+ sky130_fd_sc_hd__dfrtp_4
Xhold100 u_jt49.regarray\[7\]\[5\] VGND VGND VPWR VPWR net245 sky130_fd_sc_hd__dlygate4sd3_1
X_1659_ clknet_leaf_7_clk _0082_ net126 VGND VGND VPWR VPWR u_jt49.u_ng.poly17\[14\]
+ sky130_fd_sc_hd__dfrtp_1
XFILLER_53_57 VGND VGND VPWR VPWR sky130_fd_sc_hd__decap_8
XFILLER_5_103 VGND VGND VPWR VPWR sky130_fd_sc_hd__decap_4
XFILLER_1_353 VGND VPWR VPWR VGND sky130_ef_sc_hd__decap_12
XFILLER_64_349 VGND VPWR VPWR VGND sky130_ef_sc_hd__decap_12
XFILLER_64_327 VGND VGND VPWR VPWR sky130_fd_sc_hd__decap_8
X_0961_ u_jt49.periodC\[7\] _0515_ _0529_ u_jt49.regarray\[8\]\[7\] VGND VGND VPWR
+ VPWR _0598_ sky130_fd_sc_hd__a22o_1
XFILLER_17_232 VGND VGND VPWR VPWR sky130_fd_sc_hd__decap_6
X_0892_ u_jt49.periodB\[8\] _0522_ _0529_ u_jt49.regarray\[8\]\[0\] VGND VGND VPWR
+ VPWR _0536_ sky130_fd_sc_hd__a22o_1
X_1375_ _0369_ _0389_ _0391_ VGND VGND VPWR VPWR _0109_ sky130_fd_sc_hd__and3_1
X_1513_ u_jt49.periodB\[6\] net100 _0417_ VGND VGND VPWR VPWR _0221_ sky130_fd_sc_hd__mux2_1
Xclkbuf_leaf_4_clk clknet_2_1__leaf_clk VGND VGND VPWR VPWR clknet_leaf_4_clk sky130_fd_sc_hd__clkbuf_8
XFILLER_4_191 VGND VGND VPWR VPWR sky130_fd_sc_hd__decap_4
X_1444_ u_jt49.regarray\[8\]\[0\] net111 _0410_ VGND VGND VPWR VPWR _0159_ sky130_fd_sc_hd__mux2_1
XFILLER_9_18 VGND VPWR VPWR VGND sky130_ef_sc_hd__decap_12
Xfanout94 addr\[1\] VGND VGND VPWR VPWR net94 sky130_fd_sc_hd__clkbuf_2
Xfanout83 net84 VGND VGND VPWR VPWR net83 sky130_fd_sc_hd__clkbuf_4
XFILLER_1_194 VGND VGND VPWR VPWR sky130_fd_sc_hd__decap_6
XFILLER_64_179 VGND VPWR VPWR VGND sky130_ef_sc_hd__decap_12
XFILLER_64_157 VGND VGND VPWR VPWR sky130_fd_sc_hd__decap_8
XFILLER_64_113 VGND VPWR VPWR VGND sky130_ef_sc_hd__decap_12
X_1160_ u_jt49.u_env.gain\[4\] u_jt49.u_env.inv VGND VGND VPWR VPWR _0752_ sky130_fd_sc_hd__xor2_1
X_1091_ u_jt49.u_env.gain\[0\] u_jt49.u_env.gain\[1\] u_jt49.u_env.gain\[3\] u_jt49.u_env.gain\[2\]
+ VGND VGND VPWR VPWR _0696_ sky130_fd_sc_hd__or4_1
X_0944_ u_jt49.periodC\[5\] net80 _0520_ u_jt49.regarray\[10\]\[5\] _0517_ VGND VGND
+ VPWR VPWR _0583_ sky130_fd_sc_hd__a221o_1
X_0875_ net89 net91 net94 net96 VGND VGND VPWR VPWR _0519_ sky130_fd_sc_hd__and4b_4
Xclkload20 clknet_leaf_23_clk VGND VGND VPWR VPWR clkload20/Y sky130_fd_sc_hd__inv_6
X_1358_ _0378_ VGND VGND VPWR VPWR _0379_ sky130_fd_sc_hd__inv_2
XFILLER_28_327 VGND VPWR VPWR VGND sky130_ef_sc_hd__decap_12
X_1427_ u_jt49.regarray\[10\]\[1\] net110 _0408_ VGND VGND VPWR VPWR _0144_ sky130_fd_sc_hd__mux2_1
XFILLER_55_146 VGND VGND VPWR VPWR sky130_fd_sc_hd__decap_4
X_1289_ u_jt49.u_chB.count\[6\] _0318_ VGND VGND VPWR VPWR _0321_ sky130_fd_sc_hd__nand2_1
XFILLER_34_15 VGND VGND VPWR VPWR sky130_fd_sc_hd__decap_6
XFILLER_11_205 VGND VGND VPWR VPWR sky130_fd_sc_hd__decap_6
Xclkload3 clknet_leaf_2_clk VGND VGND VPWR VPWR clkload3/X sky130_fd_sc_hd__clkbuf_4
XFILLER_61_105 VGND VGND VPWR VPWR sky130_fd_sc_hd__decap_6
XFILLER_46_179 VGND VGND VPWR VPWR sky130_fd_sc_hd__decap_6
XFILLER_19_316 VGND VPWR VPWR VGND sky130_ef_sc_hd__decap_12
XFILLER_61_149 VGND VPWR VPWR VGND sky130_ef_sc_hd__decap_12
XFILLER_40_80 VGND VGND VPWR VPWR sky130_fd_sc_hd__decap_4
XFILLER_6_253 VGND VGND VPWR VPWR sky130_fd_sc_hd__decap_4
X_1212_ _0473_ _0474_ _0782_ VGND VGND VPWR VPWR _0788_ sky130_fd_sc_hd__or3b_1
XFILLER_37_113 VGND VPWR VPWR VGND sky130_ef_sc_hd__decap_12
XFILLER_37_102 VGND VGND VPWR VPWR sky130_fd_sc_hd__decap_8
X_1143_ _0733_ _0738_ _0739_ _0735_ VGND VGND VPWR VPWR _0740_ sky130_fd_sc_hd__a22o_1
X_1074_ u_jt49.u_chC.count\[9\] _0678_ u_jt49.u_chC.count\[10\] VGND VGND VPWR VPWR
+ _0682_ sky130_fd_sc_hd__a21o_1
XFILLER_60_171 VGND VPWR VPWR VGND sky130_ef_sc_hd__decap_12
X_0927_ _0563_ _0565_ _0567_ VGND VGND VPWR VPWR _0568_ sky130_fd_sc_hd__or3_1
X_0858_ _0505_ _0020_ VGND VGND VPWR VPWR _0507_ sky130_fd_sc_hd__nand2b_1
XFILLER_20_17 VGND VGND VPWR VPWR sky130_fd_sc_hd__decap_8
Xhold37 u_jt49.regarray\[3\]\[5\] VGND VGND VPWR VPWR net182 sky130_fd_sc_hd__dlygate4sd3_1
Xhold26 u_jt49.regarray\[5\]\[7\] VGND VGND VPWR VPWR net171 sky130_fd_sc_hd__dlygate4sd3_1
Xhold59 u_jt49.regarray\[9\]\[7\] VGND VGND VPWR VPWR net204 sky130_fd_sc_hd__dlygate4sd3_1
Xhold15 net31 VGND VGND VPWR VPWR net160 sky130_fd_sc_hd__dlygate4sd3_1
Xhold48 u_jt49.regarray\[5\]\[5\] VGND VGND VPWR VPWR net193 sky130_fd_sc_hd__dlygate4sd3_1
XFILLER_61_57 VGND VPWR VPWR VGND sky130_ef_sc_hd__decap_12
XFILLER_45_69 VGND VPWR VPWR VGND sky130_ef_sc_hd__decap_12
XFILLER_3_267 VGND VPWR VPWR VGND sky130_ef_sc_hd__decap_12
XFILLER_19_113 VGND VGND VPWR VPWR sky130_fd_sc_hd__decap_8
XFILLER_59_293 VGND VPWR VPWR VGND sky130_ef_sc_hd__decap_12
XFILLER_30_377 VGND VGND VPWR VPWR sky130_fd_sc_hd__decap_4
X_1830_ clknet_leaf_24_clk _0249_ VGND VGND VPWR VPWR u_jt49.Bmix sky130_fd_sc_hd__dfxtp_1
X_1761_ clknet_leaf_25_clk _0180_ net133 VGND VGND VPWR VPWR u_jt49.regarray\[6\]\[5\]
+ sky130_fd_sc_hd__dfrtp_1
X_1692_ clknet_leaf_4_clk _0113_ net126 VGND VGND VPWR VPWR u_jt49.bitA sky130_fd_sc_hd__dfrtp_1
X_1126_ u_jt49.u_envdiv.count\[11\] u_jt49.eg_period\[11\] VGND VGND VPWR VPWR _0723_
+ sky130_fd_sc_hd__and2b_1
X_1057_ u_jt49.u_chC.count\[5\] u_jt49.u_chC.count\[4\] _0665_ VGND VGND VPWR VPWR
+ _0670_ sky130_fd_sc_hd__and3_1
XFILLER_21_333 VGND VGND VPWR VPWR sky130_fd_sc_hd__decap_3
XFILLER_31_38 VGND VGND VPWR VPWR sky130_fd_sc_hd__decap_8
Xoutput49 net49 VGND VGND VPWR VPWR IOA_out[2] sky130_fd_sc_hd__buf_2
Xoutput38 net38 VGND VGND VPWR VPWR B[2] sky130_fd_sc_hd__buf_2
XFILLER_56_263 VGND VPWR VPWR VGND sky130_ef_sc_hd__decap_12
XFILLER_39_219 VGND VGND VPWR VPWR sky130_fd_sc_hd__decap_4
XFILLER_62_277 VGND VPWR VPWR VGND sky130_ef_sc_hd__decap_12
XFILLER_62_233 VGND VPWR VPWR VGND sky130_ef_sc_hd__decap_12
Xclkbuf_0_clk clk VGND VGND VPWR VPWR clknet_0_clk sky130_fd_sc_hd__clkbuf_16
Xmax_cap80 _0515_ VGND VGND VPWR VPWR net80 sky130_fd_sc_hd__clkbuf_2
X_1813_ clknet_leaf_5_clk _0232_ net123 VGND VGND VPWR VPWR net57 sky130_fd_sc_hd__dfrtp_1
XFILLER_7_51 VGND VGND VPWR VPWR sky130_fd_sc_hd__decap_4
X_1744_ clknet_leaf_27_clk _0163_ net122 VGND VGND VPWR VPWR u_jt49.regarray\[8\]\[4\]
+ sky130_fd_sc_hd__dfrtp_4
X_1675_ clknet_leaf_12_clk _0096_ net141 VGND VGND VPWR VPWR u_jt49.u_chB.count\[8\]
+ sky130_fd_sc_hd__dfrtp_1
XPHY_EDGE_ROW_15_Right_15 VGND VGND VPWR VPWR sky130_fd_sc_hd__decap_3
X_1109_ _0693_ _0695_ u_jt49.u_env.gain\[3\] VGND VGND VPWR VPWR _0708_ sky130_fd_sc_hd__a21boi_1
XPHY_EDGE_ROW_24_Right_24 VGND VGND VPWR VPWR sky130_fd_sc_hd__decap_3
XFILLER_42_15 VGND VPWR VPWR VGND sky130_ef_sc_hd__decap_12
XFILLER_21_196 VGND VGND VPWR VPWR sky130_fd_sc_hd__decap_4
XPHY_EDGE_ROW_33_Right_33 VGND VGND VPWR VPWR sky130_fd_sc_hd__decap_3
XPHY_EDGE_ROW_42_Right_42 VGND VGND VPWR VPWR sky130_fd_sc_hd__decap_3
XFILLER_16_93 VGND VGND VPWR VPWR sky130_fd_sc_hd__decap_6
XPHY_EDGE_ROW_51_Right_51 VGND VGND VPWR VPWR sky130_fd_sc_hd__decap_3
XFILLER_32_70 VGND VPWR VPWR VGND sky130_ef_sc_hd__decap_12
XFILLER_12_141 VGND VPWR VPWR VGND sky130_ef_sc_hd__decap_12
XFILLER_12_163 VGND VPWR VPWR VGND sky130_ef_sc_hd__decap_12
X_1391_ net276 net20 net223 VGND VGND VPWR VPWR _0402_ sky130_fd_sc_hd__a21oi_1
X_1460_ net97 net55 _0411_ VGND VGND VPWR VPWR _0174_ sky130_fd_sc_hd__mux2_1
XPHY_EDGE_ROW_60_Right_60 VGND VGND VPWR VPWR sky130_fd_sc_hd__decap_3
XPHY_EDGE_ROW_35_Left_100 VGND VGND VPWR VPWR sky130_fd_sc_hd__decap_3
X_1658_ clknet_leaf_8_clk net222 net125 VGND VGND VPWR VPWR u_jt49.u_ng.poly17\[13\]
+ sky130_fd_sc_hd__dfrtp_1
Xhold123 u_jt49.u_chA.count\[5\] VGND VGND VPWR VPWR net268 sky130_fd_sc_hd__dlygate4sd3_1
Xhold112 u_jt49.u_chC.count\[3\] VGND VGND VPWR VPWR net257 sky130_fd_sc_hd__dlygate4sd3_1
X_1727_ clknet_leaf_25_clk _0146_ net132 VGND VGND VPWR VPWR u_jt49.regarray\[10\]\[3\]
+ sky130_fd_sc_hd__dfrtp_1
Xhold101 u_jt49.regarray\[7\]\[0\] VGND VGND VPWR VPWR net246 sky130_fd_sc_hd__dlygate4sd3_1
XFILLER_58_358 VGND VGND VPWR VPWR sky130_fd_sc_hd__decap_6
X_1589_ clknet_leaf_0_clk _0012_ net115 VGND VGND VPWR VPWR u_jt49.u_ng.u_div.count\[0\]
+ sky130_fd_sc_hd__dfstp_1
XFILLER_41_214 VGND VGND VPWR VPWR sky130_fd_sc_hd__decap_8
XFILLER_1_365 VGND VPWR VPWR VGND sky130_ef_sc_hd__decap_12
XFILLER_49_358 VGND VGND VPWR VPWR sky130_fd_sc_hd__decap_4
X_0960_ net15 _0541_ _0542_ net7 _0597_ VGND VGND VPWR VPWR _0272_ sky130_fd_sc_hd__a221o_1
X_1512_ u_jt49.periodB\[5\] net102 _0417_ VGND VGND VPWR VPWR _0220_ sky130_fd_sc_hd__mux2_1
X_0891_ u_jt49.regarray\[6\]\[0\] _0523_ net77 u_jt49.periodA\[8\] _0534_ VGND VGND
+ VPWR VPWR _0535_ sky130_fd_sc_hd__a221o_1
X_1374_ _0390_ VGND VGND VPWR VPWR _0391_ sky130_fd_sc_hd__inv_2
X_1443_ net81 _0529_ VGND VGND VPWR VPWR _0410_ sky130_fd_sc_hd__and2_2
XFILLER_4_41 VGND VPWR VPWR VGND sky130_ef_sc_hd__decap_12
XFILLER_63_361 VGND VPWR VPWR VGND sky130_ef_sc_hd__decap_12
XFILLER_23_225 VGND VGND VPWR VPWR sky130_fd_sc_hd__decap_6
XFILLER_64_57 VGND VPWR VPWR VGND sky130_ef_sc_hd__decap_12
Xfanout73 _0307_ VGND VGND VPWR VPWR net73 sky130_fd_sc_hd__clkbuf_2
Xfanout95 net96 VGND VGND VPWR VPWR net95 sky130_fd_sc_hd__clkbuf_4
Xfanout84 _0464_ VGND VGND VPWR VPWR net84 sky130_fd_sc_hd__clkbuf_4
XFILLER_13_50 VGND VGND VPWR VPWR sky130_fd_sc_hd__decap_6
XFILLER_49_133 VGND VPWR VPWR VGND sky130_ef_sc_hd__decap_12
XFILLER_64_169 VGND VGND VPWR VPWR sky130_fd_sc_hd__decap_6
XFILLER_64_125 VGND VPWR VPWR VGND sky130_ef_sc_hd__decap_12
X_1090_ u_jt49.u_env.gain\[0\] u_jt49.u_env.gain\[1\] u_jt49.u_env.gain\[2\] VGND
+ VGND VPWR VPWR _0695_ sky130_fd_sc_hd__nor3_1
Xclkload10 clknet_leaf_5_clk VGND VGND VPWR VPWR clkload10/X sky130_fd_sc_hd__clkbuf_8
X_0874_ net89 net91 net93 net95 VGND VGND VPWR VPWR _0518_ sky130_fd_sc_hd__or4_4
XFILLER_20_217 VGND VGND VPWR VPWR sky130_fd_sc_hd__decap_8
X_0943_ u_jt49.regarray\[5\]\[5\] _0525_ _0579_ _0581_ VGND VGND VPWR VPWR _0582_
+ sky130_fd_sc_hd__a211o_1
Xclkload21 clknet_leaf_24_clk VGND VGND VPWR VPWR clkload21/Y sky130_fd_sc_hd__clkinv_2
XFILLER_55_125 VGND VPWR VPWR VGND sky130_ef_sc_hd__decap_12
X_1288_ net73 _0319_ _0320_ VGND VGND VPWR VPWR _0093_ sky130_fd_sc_hd__and3_1
X_1357_ net87 u_jt49.u_chA.count\[4\] _0375_ VGND VGND VPWR VPWR _0378_ sky130_fd_sc_hd__and3_1
XFILLER_28_339 VGND VGND VPWR VPWR sky130_fd_sc_hd__decap_4
X_1426_ net249 net112 _0408_ VGND VGND VPWR VPWR _0143_ sky130_fd_sc_hd__mux2_1
XFILLER_36_361 VGND VGND VPWR VPWR sky130_fd_sc_hd__decap_3
XFILLER_50_15 VGND VPWR VPWR VGND sky130_ef_sc_hd__decap_12
Xclkload4 clknet_leaf_26_clk VGND VGND VPWR VPWR clkload4/Y sky130_fd_sc_hd__clkinvlp_4
XFILLER_34_309 VGND VGND VPWR VPWR sky130_fd_sc_hd__decap_6
XFILLER_19_328 VGND VGND VPWR VPWR sky130_fd_sc_hd__decap_8
XFILLER_24_71 VGND VGND VPWR VPWR sky130_fd_sc_hd__decap_4
XFILLER_41_7 VGND VGND VPWR VPWR sky130_fd_sc_hd__decap_8
XFILLER_40_70 VGND VGND VPWR VPWR sky130_fd_sc_hd__decap_6
X_1211_ u_jt49.u_envdiv.count\[13\] u_jt49.u_envdiv.count\[12\] _0779_ u_jt49.u_envdiv.count\[14\]
+ VGND VGND VPWR VPWR _0787_ sky130_fd_sc_hd__a31o_1
XFILLER_37_125 VGND VPWR VPWR VGND sky130_ef_sc_hd__decap_12
X_1142_ _0445_ u_jt49.u_envdiv.count\[3\] u_jt49.u_envdiv.count\[2\] _0446_ VGND VGND
+ VPWR VPWR _0739_ sky130_fd_sc_hd__a22o_1
XFILLER_60_183 VGND VPWR VPWR VGND sky130_ef_sc_hd__decap_12
XFILLER_52_106 VGND VGND VPWR VPWR sky130_fd_sc_hd__decap_8
X_1073_ _0657_ _0680_ _0681_ u_jt49.u_chC.count\[9\] net84 VGND VGND VPWR VPWR _0033_
+ sky130_fd_sc_hd__a32o_1
X_0857_ net129 _0506_ VGND VGND VPWR VPWR _0020_ sky130_fd_sc_hd__and2_1
XFILLER_20_29 VGND VPWR VPWR VGND sky130_ef_sc_hd__decap_12
X_0926_ u_jt49.periodC\[11\] _0525_ _0528_ u_jt49.periodB\[3\] _0566_ VGND VGND VPWR
+ VPWR _0567_ sky130_fd_sc_hd__a221o_1
Xhold27 u_jt49.regarray\[1\]\[7\] VGND VGND VPWR VPWR net172 sky130_fd_sc_hd__dlygate4sd3_1
Xhold38 u_jt49.regarray\[6\]\[6\] VGND VGND VPWR VPWR net183 sky130_fd_sc_hd__dlygate4sd3_1
X_1409_ net110 net196 _0406_ VGND VGND VPWR VPWR _0128_ sky130_fd_sc_hd__mux2_1
Xhold16 net42 VGND VGND VPWR VPWR net161 sky130_fd_sc_hd__dlygate4sd3_1
Xhold49 net59 VGND VGND VPWR VPWR net194 sky130_fd_sc_hd__dlygate4sd3_1
XFILLER_16_309 VGND VGND VPWR VPWR sky130_fd_sc_hd__decap_3
XFILLER_61_69 VGND VPWR VPWR VGND sky130_ef_sc_hd__decap_12
XFILLER_3_257 VGND VGND VPWR VPWR sky130_fd_sc_hd__decap_3
XFILLER_59_261 VGND VPWR VPWR VGND sky130_ef_sc_hd__decap_12
XFILLER_19_169 VGND VGND VPWR VPWR sky130_fd_sc_hd__decap_6
X_1691_ clknet_leaf_10_clk _0112_ net127 VGND VGND VPWR VPWR u_jt49.u_chA.count\[11\]
+ sky130_fd_sc_hd__dfrtp_1
XFILLER_30_356 VGND VGND VPWR VPWR sky130_fd_sc_hd__decap_8
X_1760_ clknet_leaf_2_clk _0179_ net118 VGND VGND VPWR VPWR u_jt49.regarray\[6\]\[4\]
+ sky130_fd_sc_hd__dfrtp_1
X_1125_ _0720_ _0721_ VGND VGND VPWR VPWR _0722_ sky130_fd_sc_hd__nor2_1
X_1056_ _0659_ _0668_ _0669_ VGND VGND VPWR VPWR _0028_ sky130_fd_sc_hd__and3_1
X_0909_ net10 _0541_ _0542_ net2 _0551_ VGND VGND VPWR VPWR _0267_ sky130_fd_sc_hd__a221o_1
Xoutput39 net39 VGND VGND VPWR VPWR B[3] sky130_fd_sc_hd__buf_2
XFILLER_56_275 VGND VGND VPWR VPWR sky130_fd_sc_hd__decap_8
XFILLER_8_305 VGND VGND VPWR VPWR sky130_fd_sc_hd__decap_3
XFILLER_47_220 VGND VGND VPWR VPWR sky130_fd_sc_hd__decap_4
XFILLER_62_289 VGND VPWR VPWR VGND sky130_ef_sc_hd__decap_12
XFILLER_62_245 VGND VGND VPWR VPWR sky130_fd_sc_hd__decap_6
X_1674_ clknet_leaf_12_clk _0095_ net141 VGND VGND VPWR VPWR u_jt49.u_chB.count\[7\]
+ sky130_fd_sc_hd__dfrtp_1
X_1812_ clknet_leaf_5_clk _0231_ net123 VGND VGND VPWR VPWR net56 sky130_fd_sc_hd__dfrtp_1
XFILLER_30_197 VGND VGND VPWR VPWR sky130_fd_sc_hd__decap_4
X_1743_ clknet_leaf_27_clk _0162_ net119 VGND VGND VPWR VPWR u_jt49.regarray\[8\]\[3\]
+ sky130_fd_sc_hd__dfrtp_1
XFILLER_38_253 VGND VPWR VPWR VGND sky130_ef_sc_hd__decap_12
X_1108_ u_jt49.u_env.gain\[2\] _0706_ _0707_ VGND VGND VPWR VPWR _0042_ sky130_fd_sc_hd__a21o_1
X_1039_ _0630_ _0631_ _0653_ _0656_ VGND VGND VPWR VPWR _0657_ sky130_fd_sc_hd__o211a_1
XFILLER_44_245 VGND VGND VPWR VPWR sky130_fd_sc_hd__decap_6
XFILLER_12_153 VGND VGND VPWR VPWR sky130_fd_sc_hd__decap_4
XFILLER_4_341 VGND VPWR VPWR VGND sky130_ef_sc_hd__decap_12
X_1390_ u_jt49.u_cen.cencnt\[0\] u_jt49.u_cen.cencnt\[1\] net20 VGND VGND VPWR VPWR
+ _0401_ sky130_fd_sc_hd__and3_1
XFILLER_35_234 VGND VGND VPWR VPWR sky130_fd_sc_hd__decap_8
X_1657_ clknet_leaf_7_clk net218 net124 VGND VGND VPWR VPWR u_jt49.u_ng.poly17\[12\]
+ sky130_fd_sc_hd__dfrtp_1
X_1588_ clknet_leaf_14_clk _0011_ VGND VGND VPWR VPWR din_latch\[7\] sky130_fd_sc_hd__dfxtp_1
Xhold124 u_jt49.u_chB.count\[0\] VGND VGND VPWR VPWR net269 sky130_fd_sc_hd__dlygate4sd3_1
Xhold102 u_jt49.u_chB.count\[11\] VGND VGND VPWR VPWR net247 sky130_fd_sc_hd__dlygate4sd3_1
Xhold113 u_jt49.u_chA.count\[7\] VGND VGND VPWR VPWR net258 sky130_fd_sc_hd__dlygate4sd3_1
X_1726_ clknet_leaf_23_clk _0145_ net132 VGND VGND VPWR VPWR u_jt49.regarray\[10\]\[2\]
+ sky130_fd_sc_hd__dfrtp_1
XFILLER_37_16 VGND VGND VPWR VPWR sky130_fd_sc_hd__decap_3
XFILLER_53_15 VGND VGND VPWR VPWR sky130_fd_sc_hd__decap_3
XFILLER_26_278 VGND VGND VPWR VPWR sky130_fd_sc_hd__decap_4
Xclkbuf_2_0__f_clk clknet_0_clk VGND VGND VPWR VPWR clknet_2_0__leaf_clk sky130_fd_sc_hd__clkbuf_16
X_0890_ u_jt49.regarray\[7\]\[0\] _0519_ _0525_ u_jt49.periodC\[8\] VGND VGND VPWR
+ VPWR _0534_ sky130_fd_sc_hd__a22o_1
X_1511_ u_jt49.periodB\[4\] net104 _0417_ VGND VGND VPWR VPWR _0219_ sky130_fd_sc_hd__mux2_1
X_1442_ net204 net98 _0409_ VGND VGND VPWR VPWR _0158_ sky130_fd_sc_hd__mux2_1
X_1373_ net87 u_jt49.u_chA.count\[8\] _0386_ VGND VGND VPWR VPWR _0390_ sky130_fd_sc_hd__and3_1
XFILLER_4_53 VGND VPWR VPWR VGND sky130_ef_sc_hd__decap_12
XFILLER_31_292 VGND VGND VPWR VPWR sky130_fd_sc_hd__decap_3
X_1709_ clknet_leaf_20_clk _0128_ net136 VGND VGND VPWR VPWR net48 sky130_fd_sc_hd__dfrtp_1
XPHY_EDGE_ROW_18_Left_83 VGND VGND VPWR VPWR sky130_fd_sc_hd__decap_3
XFILLER_64_69 VGND VGND VPWR VPWR sky130_fd_sc_hd__decap_4
XPHY_EDGE_ROW_54_Left_119 VGND VGND VPWR VPWR sky130_fd_sc_hd__decap_3
Xfanout96 addr\[0\] VGND VGND VPWR VPWR net96 sky130_fd_sc_hd__clkbuf_2
Xfanout74 _0746_ VGND VGND VPWR VPWR net74 sky130_fd_sc_hd__clkbuf_2
Xfanout85 u_jt49.u_env.cen VGND VGND VPWR VPWR net85 sky130_fd_sc_hd__clkbuf_4
XPHY_EDGE_ROW_63_Left_128 VGND VGND VPWR VPWR sky130_fd_sc_hd__decap_3
XFILLER_49_145 VGND VGND VPWR VPWR sky130_fd_sc_hd__decap_8
XFILLER_37_329 VGND VGND VPWR VPWR sky130_fd_sc_hd__decap_6
XFILLER_64_137 VGND VGND VPWR VPWR sky130_fd_sc_hd__decap_3
XFILLER_60_365 VGND VPWR VPWR VGND sky130_ef_sc_hd__decap_12
XFILLER_60_321 VGND VPWR VPWR VGND sky130_ef_sc_hd__decap_12
XFILLER_62_3 VGND VPWR VPWR VGND sky130_ef_sc_hd__decap_12
Xclkload11 clknet_leaf_6_clk VGND VGND VPWR VPWR clkload11/X sky130_fd_sc_hd__clkbuf_4
Xclkload22 clknet_leaf_11_clk VGND VGND VPWR VPWR clkload22/X sky130_fd_sc_hd__clkbuf_8
X_0873_ _0514_ _0516_ VGND VGND VPWR VPWR _0517_ sky130_fd_sc_hd__nor2_2
X_0942_ u_jt49.eg_period\[5\] _0521_ net77 u_jt49.regarray\[1\]\[5\] _0580_ VGND VGND
+ VPWR VPWR _0581_ sky130_fd_sc_hd__a221o_1
X_1425_ net82 _0520_ VGND VGND VPWR VPWR _0408_ sky130_fd_sc_hd__and2_2
X_1287_ u_jt49.u_chB.count\[5\] _0315_ VGND VGND VPWR VPWR _0320_ sky130_fd_sc_hd__or2_1
X_1356_ _0367_ _0376_ _0377_ net241 net83 VGND VGND VPWR VPWR _0104_ sky130_fd_sc_hd__a32o_1
XFILLER_18_29 VGND VGND VPWR VPWR sky130_fd_sc_hd__decap_3
XFILLER_63_181 VGND VPWR VPWR VGND sky130_ef_sc_hd__decap_12
Xclkload5 clknet_leaf_27_clk VGND VGND VPWR VPWR clkload5/Y sky130_fd_sc_hd__inv_4
XFILLER_50_49 VGND VGND VPWR VPWR sky130_fd_sc_hd__decap_3
XPHY_EDGE_ROW_3_Left_68 VGND VGND VPWR VPWR sky130_fd_sc_hd__decap_3
XFILLER_46_137 VGND VGND VPWR VPWR sky130_fd_sc_hd__decap_3
XFILLER_42_321 VGND VGND VPWR VPWR sky130_fd_sc_hd__decap_4
XFILLER_27_340 VGND VGND VPWR VPWR sky130_fd_sc_hd__decap_4
XFILLER_42_365 VGND VGND VPWR VPWR sky130_fd_sc_hd__decap_4
XFILLER_10_284 VGND VPWR VPWR VGND sky130_ef_sc_hd__decap_12
X_1210_ net75 _0785_ _0786_ VGND VGND VPWR VPWR _0065_ sky130_fd_sc_hd__and3_1
XFILLER_37_137 VGND VGND VPWR VPWR sky130_fd_sc_hd__decap_3
X_1141_ _0446_ u_jt49.u_envdiv.count\[2\] u_jt49.u_envdiv.count\[1\] _0443_ _0735_
+ VGND VGND VPWR VPWR _0738_ sky130_fd_sc_hd__o221a_1
XFILLER_1_10 VGND VGND VPWR VPWR sky130_fd_sc_hd__decap_4
X_1072_ u_jt49.u_chC.count\[9\] _0678_ VGND VGND VPWR VPWR _0681_ sky130_fd_sc_hd__or2_1
X_0856_ net24 addr\[3\] _0504_ VGND VGND VPWR VPWR _0506_ sky130_fd_sc_hd__mux2_1
X_0925_ u_jt49.eg_period\[3\] _0521_ _0524_ u_jt49.regarray\[13\]\[3\] VGND VGND VPWR
+ VPWR _0566_ sky130_fd_sc_hd__a22o_1
Xhold39 u_jt49.regarray\[10\]\[7\] VGND VGND VPWR VPWR net184 sky130_fd_sc_hd__dlygate4sd3_1
Xhold28 u_jt49.regarray\[6\]\[7\] VGND VGND VPWR VPWR net173 sky130_fd_sc_hd__dlygate4sd3_1
X_1408_ net112 net211 _0406_ VGND VGND VPWR VPWR _0127_ sky130_fd_sc_hd__mux2_1
Xhold17 net38 VGND VGND VPWR VPWR net162 sky130_fd_sc_hd__dlygate4sd3_1
X_1339_ _0487_ u_jt49.periodA\[8\] _0353_ VGND VGND VPWR VPWR _0364_ sky130_fd_sc_hd__a21oi_1
XFILLER_10_85 VGND VPWR VPWR VGND sky130_ef_sc_hd__decap_12
XFILLER_59_273 VGND VGND VPWR VPWR sky130_fd_sc_hd__decap_6
XFILLER_30_335 VGND VGND VPWR VPWR sky130_fd_sc_hd__decap_3
X_1690_ clknet_leaf_6_clk _0111_ net126 VGND VGND VPWR VPWR u_jt49.u_chA.count\[10\]
+ sky130_fd_sc_hd__dfrtp_1
X_1124_ u_jt49.eg_period\[11\] u_jt49.u_envdiv.count\[11\] VGND VGND VPWR VPWR _0721_
+ sky130_fd_sc_hd__and2b_1
X_1055_ net88 _0665_ u_jt49.u_chC.count\[4\] VGND VGND VPWR VPWR _0669_ sky130_fd_sc_hd__a21o_1
XFILLER_18_181 VGND VPWR VPWR VGND sky130_ef_sc_hd__decap_12
X_0839_ u_jt49.u_chA.count\[3\] VGND VGND VPWR VPWR _0490_ sky130_fd_sc_hd__inv_2
X_0908_ u_jt49.periodA\[1\] _0518_ _0545_ _0550_ _0539_ VGND VGND VPWR VPWR _0551_
+ sky130_fd_sc_hd__o221a_1
XFILLER_56_221 VGND VPWR VPWR VGND sky130_ef_sc_hd__decap_12
XFILLER_47_265 VGND VGND VPWR VPWR sky130_fd_sc_hd__decap_8
XFILLER_47_210 VGND VGND VPWR VPWR sky130_fd_sc_hd__decap_3
XPHY_EDGE_ROW_6_Left_71 VGND VGND VPWR VPWR sky130_fd_sc_hd__decap_3
Xclkbuf_leaf_27_clk clknet_2_0__leaf_clk VGND VGND VPWR VPWR clknet_leaf_27_clk sky130_fd_sc_hd__clkbuf_8
X_1811_ clknet_leaf_3_clk _0230_ net127 VGND VGND VPWR VPWR u_jt49.regarray\[1\]\[7\]
+ sky130_fd_sc_hd__dfrtp_1
X_1673_ clknet_leaf_13_clk _0094_ net141 VGND VGND VPWR VPWR u_jt49.u_chB.count\[6\]
+ sky130_fd_sc_hd__dfrtp_1
X_1742_ clknet_leaf_24_clk _0161_ net131 VGND VGND VPWR VPWR u_jt49.regarray\[8\]\[2\]
+ sky130_fd_sc_hd__dfrtp_1
XFILLER_7_361 VGND VPWR VPWR VGND sky130_ef_sc_hd__decap_12
XFILLER_53_246 VGND VPWR VPWR VGND sky130_ef_sc_hd__decap_12
XFILLER_38_265 VGND VPWR VPWR VGND sky130_ef_sc_hd__decap_12
Xclkbuf_leaf_18_clk clknet_2_2__leaf_clk VGND VGND VPWR VPWR clknet_leaf_18_clk sky130_fd_sc_hd__clkbuf_8
XFILLER_26_29 VGND VGND VPWR VPWR sky130_fd_sc_hd__decap_4
XPHY_EDGE_ROW_5_Right_5 VGND VGND VPWR VPWR sky130_fd_sc_hd__decap_3
X_1038_ _0638_ _0649_ _0652_ _0655_ VGND VGND VPWR VPWR _0656_ sky130_fd_sc_hd__a31o_1
X_1107_ _0693_ _0695_ _0701_ _0627_ VGND VGND VPWR VPWR _0707_ sky130_fd_sc_hd__a31o_1
XPHY_EDGE_ROW_32_Left_97 VGND VGND VPWR VPWR sky130_fd_sc_hd__decap_3
XFILLER_16_73 VGND VGND VPWR VPWR sky130_fd_sc_hd__decap_3
XFILLER_4_353 VGND VGND VPWR VPWR sky130_fd_sc_hd__decap_8
XFILLER_50_249 VGND VGND VPWR VPWR sky130_fd_sc_hd__decap_3
X_1725_ clknet_leaf_23_clk _0144_ net131 VGND VGND VPWR VPWR u_jt49.regarray\[10\]\[1\]
+ sky130_fd_sc_hd__dfrtp_1
X_1656_ clknet_leaf_7_clk _0079_ net124 VGND VGND VPWR VPWR u_jt49.u_ng.poly17\[11\]
+ sky130_fd_sc_hd__dfrtp_1
X_1587_ clknet_leaf_14_clk _0010_ VGND VGND VPWR VPWR din_latch\[6\] sky130_fd_sc_hd__dfxtp_1
Xclkbuf_leaf_7_clk clknet_2_1__leaf_clk VGND VGND VPWR VPWR clknet_leaf_7_clk sky130_fd_sc_hd__clkbuf_8
Xhold114 u_jt49.envelope\[4\] VGND VGND VPWR VPWR net259 sky130_fd_sc_hd__dlygate4sd3_1
Xhold103 u_jt49.envelope\[1\] VGND VGND VPWR VPWR net248 sky130_fd_sc_hd__dlygate4sd3_1
Xhold125 u_jt49.regarray\[13\]\[0\] VGND VGND VPWR VPWR net270 sky130_fd_sc_hd__dlygate4sd3_1
XFILLER_37_39 VGND VPWR VPWR VGND sky130_ef_sc_hd__decap_12
XFILLER_5_139 VGND VGND VPWR VPWR sky130_fd_sc_hd__decap_3
XFILLER_32_227 VGND VGND VPWR VPWR sky130_fd_sc_hd__decap_4
XFILLER_17_246 VGND VGND VPWR VPWR sky130_fd_sc_hd__decap_6
XFILLER_43_71 VGND VPWR VPWR VGND sky130_ef_sc_hd__decap_12
XFILLER_32_249 VGND VGND VPWR VPWR sky130_fd_sc_hd__decap_3
X_1510_ u_jt49.periodB\[3\] net105 _0417_ VGND VGND VPWR VPWR _0218_ sky130_fd_sc_hd__mux2_1
X_1441_ net185 net99 _0409_ VGND VGND VPWR VPWR _0157_ sky130_fd_sc_hd__mux2_1
XFILLER_4_65 VGND VPWR VPWR VGND sky130_ef_sc_hd__decap_12
XFILLER_48_360 VGND VGND VPWR VPWR sky130_fd_sc_hd__decap_4
X_1372_ net87 _0386_ u_jt49.u_chA.count\[8\] VGND VGND VPWR VPWR _0389_ sky130_fd_sc_hd__a21o_1
X_1708_ clknet_leaf_20_clk _0127_ net136 VGND VGND VPWR VPWR net47 sky130_fd_sc_hd__dfrtp_1
X_1639_ clknet_leaf_16_clk _0062_ net142 VGND VGND VPWR VPWR u_jt49.u_envdiv.count\[10\]
+ sky130_fd_sc_hd__dfrtp_1
Xfanout97 din_latch\[7\] VGND VGND VPWR VPWR net97 sky130_fd_sc_hd__clkbuf_4
Xfanout75 _0746_ VGND VGND VPWR VPWR net75 sky130_fd_sc_hd__buf_1
Xfanout86 net88 VGND VGND VPWR VPWR net86 sky130_fd_sc_hd__buf_2
XFILLER_64_105 VGND VGND VPWR VPWR sky130_fd_sc_hd__decap_3
XFILLER_49_113 VGND VPWR VPWR VGND sky130_ef_sc_hd__decap_12
XFILLER_45_330 VGND VGND VPWR VPWR sky130_fd_sc_hd__decap_6
XFILLER_38_60 VGND VPWR VPWR VGND sky130_ef_sc_hd__decap_12
XFILLER_60_377 VGND VGND VPWR VPWR sky130_fd_sc_hd__decap_4
XFILLER_60_333 VGND VPWR VPWR VGND sky130_ef_sc_hd__decap_12
X_0941_ u_jt49.regarray\[6\]\[5\] _0523_ _0524_ u_jt49.regarray\[13\]\[5\] VGND VGND
+ VPWR VPWR _0580_ sky130_fd_sc_hd__a22o_1
XFILLER_55_3 VGND VGND VPWR VPWR sky130_fd_sc_hd__decap_4
Xclkload12 clknet_leaf_8_clk VGND VGND VPWR VPWR clkload12/X sky130_fd_sc_hd__clkbuf_8
Xclkload23 clknet_leaf_12_clk VGND VGND VPWR VPWR clkload23/X sky130_fd_sc_hd__clkbuf_4
X_0872_ net89 net91 VGND VGND VPWR VPWR _0516_ sky130_fd_sc_hd__or2_2
X_1355_ net83 _0490_ _0374_ VGND VGND VPWR VPWR _0377_ sky130_fd_sc_hd__o21ai_1
X_1424_ net98 u_jt49.eg_period\[7\] _0407_ VGND VGND VPWR VPWR _0142_ sky130_fd_sc_hd__mux2_1
X_1286_ _0318_ VGND VGND VPWR VPWR _0319_ sky130_fd_sc_hd__inv_2
XFILLER_63_193 VGND VPWR VPWR VGND sky130_ef_sc_hd__decap_12
Xclkload6 clknet_leaf_29_clk VGND VGND VPWR VPWR clkload6/Y sky130_fd_sc_hd__clkinv_2
XFILLER_10_296 VGND VPWR VPWR VGND sky130_ef_sc_hd__decap_12
X_1140_ _0719_ _0728_ VGND VGND VPWR VPWR _0737_ sky130_fd_sc_hd__nor2_1
X_1071_ u_jt49.u_chC.count\[9\] u_jt49.u_chC.count\[8\] _0674_ VGND VGND VPWR VPWR
+ _0680_ sky130_fd_sc_hd__nand3_1
X_0924_ u_jt49.periodB\[11\] _0522_ net77 u_jt49.periodA\[11\] _0564_ VGND VGND VPWR
+ VPWR _0565_ sky130_fd_sc_hd__a221o_1
X_0855_ net23 addr\[2\] _0504_ VGND VGND VPWR VPWR _0505_ sky130_fd_sc_hd__mux2_1
X_1338_ _0338_ _0353_ _0356_ _0362_ _0352_ VGND VGND VPWR VPWR _0363_ sky130_fd_sc_hd__o311a_1
Xhold29 net57 VGND VGND VPWR VPWR net174 sky130_fd_sc_hd__dlygate4sd3_1
X_1407_ net82 _0542_ VGND VGND VPWR VPWR _0406_ sky130_fd_sc_hd__nand2_4
Xhold18 net44 VGND VGND VPWR VPWR net163 sky130_fd_sc_hd__dlygate4sd3_1
X_1269_ _0463_ net83 _0306_ VGND VGND VPWR VPWR _0088_ sky130_fd_sc_hd__a21oi_1
XFILLER_10_75 VGND VGND VPWR VPWR sky130_fd_sc_hd__decap_8
XFILLER_10_97 VGND VPWR VPWR VGND sky130_ef_sc_hd__decap_12
XFILLER_42_152 VGND VGND VPWR VPWR sky130_fd_sc_hd__decap_3
XFILLER_27_182 VGND VGND VPWR VPWR sky130_fd_sc_hd__decap_6
X_1123_ u_jt49.eg_period\[10\] u_jt49.u_envdiv.count\[10\] VGND VGND VPWR VPWR _0720_
+ sky130_fd_sc_hd__and2b_1
X_1054_ _0667_ VGND VGND VPWR VPWR _0668_ sky130_fd_sc_hd__inv_2
XFILLER_18_193 VGND VGND VPWR VPWR sky130_fd_sc_hd__decap_3
XFILLER_25_108 VGND VGND VPWR VPWR sky130_fd_sc_hd__decap_4
X_0907_ _0547_ _0549_ VGND VGND VPWR VPWR _0550_ sky130_fd_sc_hd__or2_1
X_0838_ u_jt49.u_chA.count\[4\] VGND VGND VPWR VPWR _0489_ sky130_fd_sc_hd__inv_2
XFILLER_56_233 VGND VPWR VPWR VGND sky130_ef_sc_hd__decap_12
X_1810_ clknet_leaf_17_clk _0229_ net139 VGND VGND VPWR VPWR u_jt49.regarray\[1\]\[6\]
+ sky130_fd_sc_hd__dfrtp_1
X_1741_ clknet_leaf_28_clk _0160_ net119 VGND VGND VPWR VPWR u_jt49.regarray\[8\]\[1\]
+ sky130_fd_sc_hd__dfrtp_1
XFILLER_15_196 VGND VGND VPWR VPWR sky130_fd_sc_hd__decap_8
X_1672_ clknet_leaf_9_clk _0093_ net130 VGND VGND VPWR VPWR u_jt49.u_chB.count\[5\]
+ sky130_fd_sc_hd__dfrtp_1
XFILLER_7_76 VGND VPWR VPWR VGND sky130_ef_sc_hd__decap_12
XFILLER_7_373 VGND VGND VPWR VPWR sky130_fd_sc_hd__decap_8
XFILLER_38_277 VGND VPWR VPWR VGND sky130_ef_sc_hd__decap_12
X_1106_ _0627_ _0705_ _0706_ VGND VGND VPWR VPWR _0041_ sky130_fd_sc_hd__or3b_1
XFILLER_53_258 VGND VPWR VPWR VGND sky130_ef_sc_hd__decap_12
XFILLER_53_225 VGND VPWR VPWR VGND sky130_ef_sc_hd__decap_12
XFILLER_42_29 VGND VGND VPWR VPWR sky130_fd_sc_hd__decap_4
X_1037_ _0467_ u_jt49.periodC\[7\] _0634_ _0635_ _0654_ VGND VGND VPWR VPWR _0655_
+ sky130_fd_sc_hd__a2111o_1
XFILLER_29_233 VGND VGND VPWR VPWR sky130_fd_sc_hd__decap_3
XFILLER_16_41 VGND VPWR VPWR VGND sky130_ef_sc_hd__decap_12
XPHY_EDGE_ROW_11_Right_11 VGND VGND VPWR VPWR sky130_fd_sc_hd__decap_3
XFILLER_4_365 VGND VPWR VPWR VGND sky130_ef_sc_hd__decap_12
XPHY_EDGE_ROW_20_Right_20 VGND VGND VPWR VPWR sky130_fd_sc_hd__decap_3
XFILLER_57_92 VGND VPWR VPWR VGND sky130_ef_sc_hd__decap_12
XFILLER_7_192 VGND VGND VPWR VPWR sky130_fd_sc_hd__decap_4
X_1724_ clknet_leaf_23_clk _0143_ net131 VGND VGND VPWR VPWR u_jt49.regarray\[10\]\[0\]
+ sky130_fd_sc_hd__dfrtp_1
Xhold104 u_jt49.regarray\[10\]\[0\] VGND VGND VPWR VPWR net249 sky130_fd_sc_hd__dlygate4sd3_1
Xhold115 u_jt49.regarray\[7\]\[4\] VGND VGND VPWR VPWR net260 sky130_fd_sc_hd__dlygate4sd3_1
Xhold126 u_jt49.u_env.gain\[4\] VGND VGND VPWR VPWR net271 sky130_fd_sc_hd__dlygate4sd3_1
X_1586_ clknet_leaf_14_clk _0009_ VGND VGND VPWR VPWR din_latch\[5\] sky130_fd_sc_hd__dfxtp_1
X_1655_ clknet_leaf_7_clk _0078_ net124 VGND VGND VPWR VPWR u_jt49.u_ng.poly17\[10\]
+ sky130_fd_sc_hd__dfrtp_1
XFILLER_64_309 VGND VGND VPWR VPWR sky130_fd_sc_hd__decap_3
XFILLER_43_50 VGND VGND VPWR VPWR sky130_fd_sc_hd__decap_6
XFILLER_57_7 VGND VPWR VPWR VGND sky130_ef_sc_hd__decap_12
X_1371_ _0367_ _0387_ _0388_ net258 net83 VGND VGND VPWR VPWR _0108_ sky130_fd_sc_hd__a32o_1
XFILLER_4_77 VGND VGND VPWR VPWR sky130_fd_sc_hd__decap_6
X_1440_ net205 net101 _0409_ VGND VGND VPWR VPWR _0156_ sky130_fd_sc_hd__mux2_1
X_1707_ clknet_leaf_12_clk _0126_ net140 VGND VGND VPWR VPWR u_jt49.eg_period\[15\]
+ sky130_fd_sc_hd__dfrtp_2
X_1638_ clknet_leaf_16_clk _0061_ net142 VGND VGND VPWR VPWR u_jt49.u_envdiv.count\[9\]
+ sky130_fd_sc_hd__dfrtp_1
XFILLER_46_309 VGND VPWR VPWR VGND sky130_ef_sc_hd__decap_12
X_1569_ u_jt49.regarray\[10\]\[3\] u_jt49.envelope\[0\] u_jt49.regarray\[10\]\[4\]
+ VGND VGND VPWR VPWR _0435_ sky130_fd_sc_hd__mux2_1
Xfanout98 din_latch\[7\] VGND VGND VPWR VPWR net98 sky130_fd_sc_hd__buf_2
Xfanout87 net88 VGND VGND VPWR VPWR net87 sky130_fd_sc_hd__buf_2
XFILLER_49_125 VGND VGND VPWR VPWR sky130_fd_sc_hd__decap_3
XFILLER_45_353 VGND VGND VPWR VPWR sky130_fd_sc_hd__decap_8
XFILLER_60_345 VGND VGND VPWR VPWR sky130_fd_sc_hd__decap_4
XFILLER_60_301 VGND VGND VPWR VPWR sky130_fd_sc_hd__decap_6
XFILLER_13_261 VGND VGND VPWR VPWR sky130_fd_sc_hd__decap_3
X_0940_ u_jt49.regarray\[7\]\[5\] _0519_ _0530_ u_jt49.regarray\[9\]\[5\] VGND VGND
+ VPWR VPWR _0579_ sky130_fd_sc_hd__a22o_1
Xclkload13 clknet_leaf_9_clk VGND VGND VPWR VPWR clkload13/X sky130_fd_sc_hd__clkbuf_4
Xclkload24 clknet_leaf_13_clk VGND VGND VPWR VPWR clkload24/Y sky130_fd_sc_hd__inv_6
X_0871_ net90 net94 net95 net92 VGND VGND VPWR VPWR _0515_ sky130_fd_sc_hd__nor4b_2
XFILLER_55_106 VGND VGND VPWR VPWR sky130_fd_sc_hd__decap_6
X_1285_ u_jt49.u_chB.count\[5\] u_jt49.u_chB.count\[4\] u_jt49.u_chB.count\[3\] _0310_
+ VGND VGND VPWR VPWR _0318_ sky130_fd_sc_hd__and4_1
X_1354_ _0375_ VGND VGND VPWR VPWR _0376_ sky130_fd_sc_hd__inv_2
X_1423_ net99 u_jt49.eg_period\[6\] _0407_ VGND VGND VPWR VPWR _0141_ sky130_fd_sc_hd__mux2_1
XFILLER_28_309 VGND VPWR VPWR VGND sky130_ef_sc_hd__decap_12
XFILLER_63_161 VGND VGND VPWR VPWR sky130_fd_sc_hd__decap_6
XFILLER_51_345 VGND VPWR VPWR VGND sky130_ef_sc_hd__decap_12
Xclkload7 clknet_leaf_30_clk VGND VGND VPWR VPWR clkload7/Y sky130_fd_sc_hd__inv_8
XFILLER_46_106 VGND VGND VPWR VPWR sky130_fd_sc_hd__decap_6
XFILLER_10_253 VGND VGND VPWR VPWR sky130_fd_sc_hd__decap_3
X_1070_ _0659_ _0677_ _0679_ VGND VGND VPWR VPWR _0032_ sky130_fd_sc_hd__and3_1
XFILLER_60_197 VGND VPWR VPWR VGND sky130_ef_sc_hd__decap_12
X_0854_ net18 _0502_ _0503_ VGND VGND VPWR VPWR _0504_ sky130_fd_sc_hd__o21ai_4
X_0923_ u_jt49.regarray\[6\]\[3\] _0523_ _0530_ u_jt49.regarray\[9\]\[3\] VGND VGND
+ VPWR VPWR _0564_ sky130_fd_sc_hd__a22o_1
XPHY_EDGE_ROW_49_Right_49 VGND VGND VPWR VPWR sky130_fd_sc_hd__decap_3
XPHY_EDGE_ROW_58_Right_58 VGND VGND VPWR VPWR sky130_fd_sc_hd__decap_3
X_1268_ u_jt49.u_chB.count\[0\] net87 _0304_ _0305_ VGND VGND VPWR VPWR _0306_ sky130_fd_sc_hd__and4_1
X_1406_ u_jt49.eg_period\[15\] net98 _0405_ VGND VGND VPWR VPWR _0126_ sky130_fd_sc_hd__mux2_1
X_1337_ u_jt49.periodA\[10\] _0354_ u_jt49.u_chA.count\[10\] VGND VGND VPWR VPWR _0362_
+ sky130_fd_sc_hd__or3b_1
Xhold19 net41 VGND VGND VPWR VPWR net164 sky130_fd_sc_hd__dlygate4sd3_1
X_1199_ net74 _0778_ VGND VGND VPWR VPWR _0062_ sky130_fd_sc_hd__and2_1
XFILLER_10_65 VGND VGND VPWR VPWR sky130_fd_sc_hd__decap_4
XFILLER_19_52 VGND VGND VPWR VPWR sky130_fd_sc_hd__decap_4
XFILLER_19_74 VGND VGND VPWR VPWR sky130_fd_sc_hd__decap_6
XFILLER_42_175 VGND VGND VPWR VPWR sky130_fd_sc_hd__decap_4
X_1122_ _0711_ _0713_ _0715_ _0718_ VGND VGND VPWR VPWR _0719_ sky130_fd_sc_hd__or4_1
X_1053_ net88 u_jt49.u_chC.count\[4\] _0665_ VGND VGND VPWR VPWR _0667_ sky130_fd_sc_hd__and3_1
XFILLER_21_337 VGND VPWR VPWR VGND sky130_ef_sc_hd__decap_12
X_0837_ u_jt49.u_chA.count\[7\] VGND VGND VPWR VPWR _0488_ sky130_fd_sc_hd__inv_2
X_0906_ u_jt49.periodB\[1\] _0528_ _0529_ u_jt49.regarray\[8\]\[1\] _0548_ VGND VGND
+ VPWR VPWR _0549_ sky130_fd_sc_hd__a221o_1
XFILLER_56_245 VGND VGND VPWR VPWR sky130_fd_sc_hd__decap_6
XFILLER_24_120 VGND VPWR VPWR VGND sky130_ef_sc_hd__decap_12
XFILLER_21_53 VGND VGND VPWR VPWR sky130_fd_sc_hd__decap_3
X_1671_ clknet_leaf_9_clk _0092_ net130 VGND VGND VPWR VPWR u_jt49.u_chB.count\[4\]
+ sky130_fd_sc_hd__dfrtp_1
XFILLER_30_156 VGND VPWR VPWR VGND sky130_ef_sc_hd__decap_12
X_1740_ clknet_leaf_24_clk _0159_ net131 VGND VGND VPWR VPWR u_jt49.regarray\[8\]\[0\]
+ sky130_fd_sc_hd__dfrtp_1
XFILLER_30_3 VGND VPWR VPWR VGND sky130_ef_sc_hd__decap_12
X_1105_ u_jt49.u_env.gain\[0\] u_jt49.u_env.gain\[1\] _0703_ VGND VGND VPWR VPWR _0706_
+ sky130_fd_sc_hd__or3_1
XFILLER_61_281 VGND VPWR VPWR VGND sky130_ef_sc_hd__decap_12
X_1036_ u_jt49.u_chC.count\[8\] _0466_ _0633_ VGND VGND VPWR VPWR _0654_ sky130_fd_sc_hd__o21ai_1
XFILLER_16_20 VGND VGND VPWR VPWR sky130_fd_sc_hd__decap_8
XFILLER_16_53 VGND VPWR VPWR VGND sky130_ef_sc_hd__decap_12
XFILLER_32_85 VGND VGND VPWR VPWR sky130_fd_sc_hd__decap_4
XFILLER_4_377 VGND VGND VPWR VPWR sky130_fd_sc_hd__decap_4
XFILLER_50_229 VGND VGND VPWR VPWR sky130_fd_sc_hd__decap_8
XFILLER_43_281 VGND VGND VPWR VPWR sky130_fd_sc_hd__decap_3
XFILLER_35_248 VGND VGND VPWR VPWR sky130_fd_sc_hd__decap_6
X_1654_ clknet_leaf_7_clk _0077_ net124 VGND VGND VPWR VPWR u_jt49.u_ng.poly17\[9\]
+ sky130_fd_sc_hd__dfrtp_1
Xhold105 u_jt49.u_envdiv.count\[15\] VGND VGND VPWR VPWR net250 sky130_fd_sc_hd__dlygate4sd3_1
X_1723_ clknet_leaf_19_clk _0142_ net135 VGND VGND VPWR VPWR u_jt49.eg_period\[7\]
+ sky130_fd_sc_hd__dfrtp_1
Xhold127 u_jt49.envelope\[0\] VGND VGND VPWR VPWR net272 sky130_fd_sc_hd__dlygate4sd3_1
Xhold116 u_jt49.regarray\[9\]\[2\] VGND VGND VPWR VPWR net261 sky130_fd_sc_hd__dlygate4sd3_1
X_1585_ clknet_leaf_13_clk _0008_ VGND VGND VPWR VPWR din_latch\[4\] sky130_fd_sc_hd__dfxtp_1
XFILLER_41_229 VGND VPWR VPWR VGND sky130_ef_sc_hd__decap_12
X_1019_ u_jt49.periodC\[6\] u_jt49.u_chC.count\[6\] VGND VGND VPWR VPWR _0637_ sky130_fd_sc_hd__and2b_1
XFILLER_5_119 VGND VPWR VPWR VGND sky130_ef_sc_hd__decap_12
XFILLER_27_41 VGND VPWR VPWR VGND sky130_ef_sc_hd__decap_12
XFILLER_17_259 VGND VPWR VPWR VGND sky130_ef_sc_hd__decap_12
X_1370_ net83 _0488_ _0384_ VGND VGND VPWR VPWR _0388_ sky130_fd_sc_hd__o21ai_1
X_1706_ clknet_leaf_12_clk _0125_ net145 VGND VGND VPWR VPWR u_jt49.eg_period\[14\]
+ sky130_fd_sc_hd__dfrtp_2
X_1637_ clknet_leaf_16_clk _0060_ net142 VGND VGND VPWR VPWR u_jt49.u_envdiv.count\[8\]
+ sky130_fd_sc_hd__dfrtp_1
XFILLER_54_321 VGND VPWR VPWR VGND sky130_ef_sc_hd__decap_12
X_1499_ u_jt49.periodB\[9\] net110 _0416_ VGND VGND VPWR VPWR _0208_ sky130_fd_sc_hd__mux2_1
X_1568_ net114 net165 _0430_ _0434_ VGND VGND VPWR VPWR _0259_ sky130_fd_sc_hd__a22o_1
Xfanout88 net72 VGND VGND VPWR VPWR net88 sky130_fd_sc_hd__buf_2
Xfanout99 net100 VGND VGND VPWR VPWR net99 sky130_fd_sc_hd__buf_2
XFILLER_8_3 VGND VPWR VPWR VGND sky130_ef_sc_hd__decap_12
XPHY_EDGE_ROW_41_Left_106 VGND VGND VPWR VPWR sky130_fd_sc_hd__decap_3
X_0870_ net93 net96 VGND VGND VPWR VPWR _0514_ sky130_fd_sc_hd__or2_1
XFILLER_9_244 VGND VPWR VPWR VGND sky130_ef_sc_hd__decap_12
XFILLER_13_273 VGND VGND VPWR VPWR sky130_fd_sc_hd__decap_6
Xclkload25 clknet_leaf_14_clk VGND VGND VPWR VPWR clkload25/Y sky130_fd_sc_hd__bufinv_16
Xclkload14 clknet_leaf_10_clk VGND VGND VPWR VPWR clkload14/X sky130_fd_sc_hd__clkbuf_4
X_1422_ net101 u_jt49.eg_period\[5\] _0407_ VGND VGND VPWR VPWR _0140_ sky130_fd_sc_hd__mux2_1
X_1284_ net73 _0316_ _0317_ VGND VGND VPWR VPWR _0092_ sky130_fd_sc_hd__and3_1
XPHY_EDGE_ROW_50_Left_115 VGND VGND VPWR VPWR sky130_fd_sc_hd__decap_3
XFILLER_48_170 VGND VGND VPWR VPWR sky130_fd_sc_hd__decap_3
X_1353_ u_jt49.u_chA.count\[3\] u_jt49.u_chA.count\[2\] u_jt49.u_chA.count\[1\] u_jt49.u_chA.count\[0\]
+ VGND VGND VPWR VPWR _0375_ sky130_fd_sc_hd__and4_1
XFILLER_51_357 VGND VPWR VPWR VGND sky130_ef_sc_hd__decap_12
XFILLER_36_365 VGND VGND VPWR VPWR sky130_fd_sc_hd__decap_4
Xclkload8 clknet_leaf_3_clk VGND VGND VPWR VPWR clkload8/Y sky130_fd_sc_hd__clkinv_2
X_0999_ u_jt49.u_ng.u_div.count\[3\] _0620_ VGND VGND VPWR VPWR _0622_ sky130_fd_sc_hd__nand2_1
XFILLER_54_162 VGND VGND VPWR VPWR sky130_fd_sc_hd__decap_3
XFILLER_40_85 VGND VPWR VPWR VGND sky130_ef_sc_hd__decap_12
XFILLER_60_121 VGND VPWR VPWR VGND sky130_ef_sc_hd__decap_12
XFILLER_1_57 VGND VGND VPWR VPWR sky130_fd_sc_hd__decap_8
XFILLER_18_365 VGND VPWR VPWR VGND sky130_ef_sc_hd__decap_12
X_0853_ net17 net19 net18 VGND VGND VPWR VPWR _0503_ sky130_fd_sc_hd__a21bo_1
XFILLER_60_3 VGND VGND VPWR VPWR sky130_fd_sc_hd__decap_8
X_0922_ u_jt49.periodC\[3\] net80 _0517_ _0562_ VGND VGND VPWR VPWR _0563_ sky130_fd_sc_hd__a211o_1
X_1405_ u_jt49.eg_period\[14\] net99 _0405_ VGND VGND VPWR VPWR _0125_ sky130_fd_sc_hd__mux2_1
X_1267_ _0286_ _0287_ _0289_ _0290_ VGND VGND VPWR VPWR _0305_ sky130_fd_sc_hd__o2bb2a_1
X_1198_ u_jt49.u_envdiv.count\[10\] _0776_ VGND VGND VPWR VPWR _0778_ sky130_fd_sc_hd__xnor2_1
X_1336_ _0344_ _0351_ _0358_ _0360_ VGND VGND VPWR VPWR _0361_ sky130_fd_sc_hd__o31a_1
Xinput1 IOA_in[0] VGND VGND VPWR VPWR net1 sky130_fd_sc_hd__buf_1
XFILLER_35_85 VGND VGND VPWR VPWR sky130_fd_sc_hd__decap_6
XFILLER_35_52 VGND VGND VPWR VPWR sky130_fd_sc_hd__decap_4
XFILLER_51_51 VGND VGND VPWR VPWR sky130_fd_sc_hd__decap_4
X_1121_ _0448_ u_jt49.u_envdiv.count\[12\] _0714_ VGND VGND VPWR VPWR _0718_ sky130_fd_sc_hd__o21bai_1
X_1052_ net84 net257 _0657_ _0666_ VGND VGND VPWR VPWR _0027_ sky130_fd_sc_hd__a22o_1
XFILLER_25_6 VGND VGND VPWR VPWR sky130_fd_sc_hd__decap_6
XFILLER_21_349 VGND VPWR VPWR VGND sky130_ef_sc_hd__decap_12
X_0836_ u_jt49.u_chA.count\[8\] VGND VGND VPWR VPWR _0487_ sky130_fd_sc_hd__inv_2
X_0905_ u_jt49.periodC\[1\] _0515_ _0526_ u_jt49.eg_period\[9\] VGND VGND VPWR VPWR
+ _0548_ sky130_fd_sc_hd__a22o_1
XFILLER_56_29 VGND VGND VPWR VPWR sky130_fd_sc_hd__decap_6
X_1319_ _0340_ _0342_ _0343_ VGND VGND VPWR VPWR _0344_ sky130_fd_sc_hd__or3_1
XFILLER_24_132 VGND VGND VPWR VPWR sky130_fd_sc_hd__decap_8
XFILLER_8_309 VGND VPWR VPWR VGND sky130_ef_sc_hd__decap_12
XFILLER_12_305 VGND VGND VPWR VPWR sky130_fd_sc_hd__decap_3
XFILLER_24_165 VGND VPWR VPWR VGND sky130_ef_sc_hd__decap_12
X_1670_ clknet_leaf_9_clk _0091_ net129 VGND VGND VPWR VPWR u_jt49.u_chB.count\[3\]
+ sky130_fd_sc_hd__dfrtp_1
XFILLER_30_168 VGND VGND VPWR VPWR sky130_fd_sc_hd__decap_8
XFILLER_23_3 VGND VPWR VPWR VGND sky130_ef_sc_hd__decap_12
X_1104_ u_jt49.u_env.gain\[0\] _0703_ u_jt49.u_env.gain\[1\] VGND VGND VPWR VPWR _0705_
+ sky130_fd_sc_hd__o21a_1
X_1035_ _0634_ _0635_ _0633_ VGND VGND VPWR VPWR _0653_ sky130_fd_sc_hd__nand3b_1
XFILLER_61_293 VGND VPWR VPWR VGND sky130_ef_sc_hd__decap_12
XFILLER_21_113 VGND VGND VPWR VPWR sky130_fd_sc_hd__decap_6
X_1799_ clknet_leaf_10_clk _0218_ net127 VGND VGND VPWR VPWR u_jt49.periodB\[3\] sky130_fd_sc_hd__dfrtp_1
X_0819_ u_jt49.u_chC.count\[2\] VGND VGND VPWR VPWR _0470_ sky130_fd_sc_hd__inv_2
XFILLER_16_65 VGND VGND VPWR VPWR sky130_fd_sc_hd__decap_8
XFILLER_4_301 VGND VGND VPWR VPWR sky130_fd_sc_hd__decap_3
X_1584_ clknet_leaf_9_clk _0007_ VGND VGND VPWR VPWR din_latch\[3\] sky130_fd_sc_hd__dfxtp_1
X_1653_ clknet_leaf_6_clk _0076_ net124 VGND VGND VPWR VPWR u_jt49.u_ng.poly17\[8\]
+ sky130_fd_sc_hd__dfrtp_1
X_1722_ clknet_leaf_19_clk _0141_ net135 VGND VGND VPWR VPWR u_jt49.eg_period\[6\]
+ sky130_fd_sc_hd__dfrtp_1
Xhold106 u_jt49.u_chC.count\[7\] VGND VGND VPWR VPWR net251 sky130_fd_sc_hd__dlygate4sd3_1
XPHY_EDGE_ROW_9_Right_9 VGND VGND VPWR VPWR sky130_fd_sc_hd__decap_3
Xhold128 u_jt49.periodC\[0\] VGND VGND VPWR VPWR net273 sky130_fd_sc_hd__dlygate4sd3_1
Xhold117 u_jt49.regarray\[7\]\[3\] VGND VGND VPWR VPWR net262 sky130_fd_sc_hd__dlygate4sd3_1
X_1018_ u_jt49.periodC\[7\] u_jt49.u_chC.count\[7\] VGND VGND VPWR VPWR _0636_ sky130_fd_sc_hd__and2b_1
XFILLER_27_53 VGND VGND VPWR VPWR sky130_fd_sc_hd__decap_3
XFILLER_0_370 VGND VGND VPWR VPWR sky130_fd_sc_hd__decap_8
X_1705_ clknet_leaf_12_clk _0124_ net140 VGND VGND VPWR VPWR u_jt49.eg_period\[13\]
+ sky130_fd_sc_hd__dfrtp_2
X_1636_ clknet_leaf_16_clk _0059_ net142 VGND VGND VPWR VPWR u_jt49.u_envdiv.count\[7\]
+ sky130_fd_sc_hd__dfrtp_1
X_1567_ u_jt49.regarray\[9\]\[3\] u_jt49.envelope\[4\] u_jt49.regarray\[9\]\[4\] VGND
+ VGND VPWR VPWR _0434_ sky130_fd_sc_hd__mux2_1
XFILLER_64_29 VGND VPWR VPWR VGND sky130_ef_sc_hd__decap_12
XFILLER_54_333 VGND VPWR VPWR VGND sky130_ef_sc_hd__decap_12
X_1498_ u_jt49.periodB\[8\] net112 _0416_ VGND VGND VPWR VPWR _0207_ sky130_fd_sc_hd__mux2_1
Xfanout78 _0789_ VGND VGND VPWR VPWR net78 sky130_fd_sc_hd__clkbuf_4
Xfanout89 net90 VGND VGND VPWR VPWR net89 sky130_fd_sc_hd__buf_2
Xclkload26 clknet_leaf_15_clk VGND VGND VPWR VPWR clkload26/X sky130_fd_sc_hd__clkbuf_4
Xclkload15 clknet_leaf_18_clk VGND VGND VPWR VPWR clkload15/Y sky130_fd_sc_hd__inv_6
XFILLER_9_256 VGND VGND VPWR VPWR sky130_fd_sc_hd__decap_3
X_1421_ net103 u_jt49.eg_period\[4\] _0407_ VGND VGND VPWR VPWR _0139_ sky130_fd_sc_hd__mux2_1
X_1283_ _0460_ _0313_ VGND VGND VPWR VPWR _0317_ sky130_fd_sc_hd__nand2_1
XFILLER_36_300 VGND VGND VPWR VPWR sky130_fd_sc_hd__decap_4
X_1352_ _0369_ _0373_ _0374_ VGND VGND VPWR VPWR _0103_ sky130_fd_sc_hd__and3_1
XFILLER_51_369 VGND VGND VPWR VPWR sky130_fd_sc_hd__decap_8
Xclkload9 clknet_leaf_4_clk VGND VGND VPWR VPWR clkload9/Y sky130_fd_sc_hd__inv_6
X_0998_ net86 _0614_ _0620_ _0621_ VGND VGND VPWR VPWR _0014_ sky130_fd_sc_hd__a211oi_1
X_1619_ clknet_leaf_21_clk _0042_ net137 VGND VGND VPWR VPWR u_jt49.u_env.gain\[2\]
+ sky130_fd_sc_hd__dfstp_1
XFILLER_40_97 VGND VGND VPWR VPWR sky130_fd_sc_hd__decap_3
XFILLER_49_84 VGND VPWR VPWR VGND sky130_ef_sc_hd__decap_12
XFILLER_60_133 VGND VGND VPWR VPWR sky130_fd_sc_hd__decap_6
XFILLER_18_377 VGND VGND VPWR VPWR sky130_fd_sc_hd__decap_4
X_0921_ u_jt49.regarray\[10\]\[3\] _0520_ _0529_ u_jt49.regarray\[8\]\[3\] _0561_
+ VGND VGND VPWR VPWR _0562_ sky130_fd_sc_hd__a221o_1
XPHY_EDGE_ROW_23_Left_88 VGND VGND VPWR VPWR sky130_fd_sc_hd__decap_3
X_0852_ net17 net19 VGND VGND VPWR VPWR _0502_ sky130_fd_sc_hd__xor2_2
X_1404_ u_jt49.eg_period\[13\] net102 _0405_ VGND VGND VPWR VPWR _0124_ sky130_fd_sc_hd__mux2_1
X_1335_ _0488_ u_jt49.periodA\[7\] _0341_ _0359_ VGND VGND VPWR VPWR _0360_ sky130_fd_sc_hd__a22o_1
X_1266_ _0457_ u_jt49.periodB\[7\] _0300_ _0301_ _0303_ VGND VGND VPWR VPWR _0304_
+ sky130_fd_sc_hd__a221o_1
X_1197_ net74 _0776_ _0777_ VGND VGND VPWR VPWR _0061_ sky130_fd_sc_hd__and3_1
XFILLER_36_141 VGND VGND VPWR VPWR sky130_fd_sc_hd__decap_6
Xinput2 IOA_in[1] VGND VGND VPWR VPWR net2 sky130_fd_sc_hd__buf_1
XFILLER_51_63 VGND VGND VPWR VPWR sky130_fd_sc_hd__decap_4
X_1120_ _0714_ _0716_ VGND VGND VPWR VPWR _0717_ sky130_fd_sc_hd__or2_1
X_1051_ _0469_ _0663_ _0665_ VGND VGND VPWR VPWR _0666_ sky130_fd_sc_hd__a21oi_1
XFILLER_18_141 VGND VPWR VPWR VGND sky130_ef_sc_hd__decap_12
X_0904_ u_jt49.regarray\[13\]\[1\] _0524_ _0530_ u_jt49.regarray\[9\]\[1\] _0546_
+ VGND VGND VPWR VPWR _0547_ sky130_fd_sc_hd__a221o_1
X_0835_ u_jt49.u_chA.count\[9\] VGND VGND VPWR VPWR _0486_ sky130_fd_sc_hd__inv_2
X_1318_ u_jt49.u_chA.count\[6\] u_jt49.periodA\[6\] VGND VGND VPWR VPWR _0343_ sky130_fd_sc_hd__and2b_1
X_1249_ u_jt49.u_chB.count\[11\] u_jt49.periodB\[11\] VGND VGND VPWR VPWR _0287_ sky130_fd_sc_hd__nand2b_1
XFILLER_24_177 VGND VGND VPWR VPWR sky130_fd_sc_hd__decap_4
XFILLER_21_77 VGND VGND VPWR VPWR sky130_fd_sc_hd__decap_3
XFILLER_46_85 VGND VPWR VPWR VGND sky130_ef_sc_hd__decap_12
XFILLER_15_133 VGND VGND VPWR VPWR sky130_fd_sc_hd__decap_3
XFILLER_7_57 VGND VGND VPWR VPWR sky130_fd_sc_hd__decap_8
XFILLER_38_236 VGND VGND VPWR VPWR sky130_fd_sc_hd__decap_3
XFILLER_16_3 VGND VPWR VPWR VGND sky130_ef_sc_hd__decap_12
XFILLER_61_261 VGND VPWR VPWR VGND sky130_ef_sc_hd__decap_12
X_1034_ _0645_ _0646_ _0650_ _0651_ VGND VGND VPWR VPWR _0652_ sky130_fd_sc_hd__a211o_1
X_1103_ u_jt49.u_env.gain\[0\] _0703_ _0704_ VGND VGND VPWR VPWR _0040_ sky130_fd_sc_hd__o21bai_1
XPHY_EDGE_ROW_26_Left_91 VGND VGND VPWR VPWR sky130_fd_sc_hd__decap_3
XFILLER_21_169 VGND VGND VPWR VPWR sky130_fd_sc_hd__decap_8
X_1798_ clknet_leaf_10_clk _0217_ net128 VGND VGND VPWR VPWR u_jt49.periodB\[2\] sky130_fd_sc_hd__dfrtp_1
X_0818_ u_jt49.u_chC.count\[3\] VGND VGND VPWR VPWR _0469_ sky130_fd_sc_hd__inv_2
XPHY_EDGE_ROW_10_Left_75 VGND VGND VPWR VPWR sky130_fd_sc_hd__decap_3
XFILLER_29_258 VGND VGND VPWR VPWR sky130_fd_sc_hd__decap_3
XFILLER_32_32 VGND VPWR VPWR VGND sky130_ef_sc_hd__decap_12
X_1721_ clknet_leaf_19_clk _0140_ net135 VGND VGND VPWR VPWR u_jt49.eg_period\[5\]
+ sky130_fd_sc_hd__dfrtp_2
X_1583_ clknet_leaf_9_clk _0006_ VGND VGND VPWR VPWR din_latch\[2\] sky130_fd_sc_hd__dfxtp_1
X_1652_ clknet_leaf_6_clk net215 net124 VGND VGND VPWR VPWR u_jt49.u_ng.poly17\[7\]
+ sky130_fd_sc_hd__dfrtp_1
Xhold118 u_jt49.u_chA.count\[0\] VGND VGND VPWR VPWR net263 sky130_fd_sc_hd__dlygate4sd3_1
Xhold107 u_jt49.envelope\[3\] VGND VGND VPWR VPWR net252 sky130_fd_sc_hd__dlygate4sd3_1
Xhold129 u_jt49.regarray\[8\]\[3\] VGND VGND VPWR VPWR net274 sky130_fd_sc_hd__dlygate4sd3_1
XFILLER_58_309 VGND VGND VPWR VPWR sky130_fd_sc_hd__decap_4
XFILLER_26_206 VGND VGND VPWR VPWR sky130_fd_sc_hd__decap_8
X_1017_ u_jt49.u_chC.count\[9\] _0465_ u_jt49.u_chC.count\[8\] _0466_ VGND VGND VPWR
+ VPWR _0635_ sky130_fd_sc_hd__a22o_1
X_1704_ clknet_leaf_17_clk _0123_ net140 VGND VGND VPWR VPWR u_jt49.eg_period\[12\]
+ sky130_fd_sc_hd__dfrtp_2
XFILLER_58_106 VGND VPWR VPWR VGND sky130_ef_sc_hd__decap_12
X_1497_ net81 _0522_ VGND VGND VPWR VPWR _0416_ sky130_fd_sc_hd__and2_2
X_1635_ clknet_leaf_16_clk _0058_ net142 VGND VGND VPWR VPWR u_jt49.u_envdiv.count\[6\]
+ sky130_fd_sc_hd__dfrtp_1
X_1566_ net114 net156 _0430_ _0433_ VGND VGND VPWR VPWR _0258_ sky130_fd_sc_hd__a22o_1
XFILLER_54_301 VGND VGND VPWR VPWR sky130_fd_sc_hd__decap_6
Xfanout79 _0789_ VGND VGND VPWR VPWR net79 sky130_fd_sc_hd__buf_2
XFILLER_22_253 VGND VGND VPWR VPWR sky130_fd_sc_hd__decap_4
Xclkload27 clknet_leaf_16_clk VGND VGND VPWR VPWR clkload27/X sky130_fd_sc_hd__clkbuf_4
XFILLER_9_268 VGND VGND VPWR VPWR sky130_fd_sc_hd__decap_3
XFILLER_13_253 VGND VGND VPWR VPWR sky130_fd_sc_hd__decap_8
Xclkload16 clknet_leaf_19_clk VGND VGND VPWR VPWR clkload16/X sky130_fd_sc_hd__clkbuf_8
X_1351_ u_jt49.u_chA.count\[2\] _0370_ VGND VGND VPWR VPWR _0374_ sky130_fd_sc_hd__nand2_1
X_1420_ net106 u_jt49.eg_period\[3\] _0407_ VGND VGND VPWR VPWR _0138_ sky130_fd_sc_hd__mux2_1
X_1282_ _0315_ VGND VGND VPWR VPWR _0316_ sky130_fd_sc_hd__inv_2
X_1618_ clknet_leaf_21_clk _0041_ net137 VGND VGND VPWR VPWR u_jt49.u_env.gain\[1\]
+ sky130_fd_sc_hd__dfstp_1
X_0997_ u_jt49.u_ng.u_div.count\[2\] _0617_ VGND VGND VPWR VPWR _0621_ sky130_fd_sc_hd__nor2_1
X_1549_ net113 net160 _0423_ _0424_ VGND VGND VPWR VPWR _0250_ sky130_fd_sc_hd__a22o_1
XFILLER_42_348 VGND VPWR VPWR VGND sky130_ef_sc_hd__decap_12
XFILLER_49_96 VGND VPWR VPWR VGND sky130_ef_sc_hd__decap_12
XFILLER_45_175 VGND VPWR VPWR VGND sky130_ef_sc_hd__decap_12
X_0920_ u_jt49.regarray\[7\]\[3\] _0519_ _0526_ u_jt49.eg_period\[11\] VGND VGND VPWR
+ VPWR _0561_ sky130_fd_sc_hd__a22o_1
X_0851_ u_jt49.wr_n cs_n VGND VGND VPWR VPWR u_jt49.write sky130_fd_sc_hd__nor2_1
X_1265_ _0289_ _0302_ _0290_ VGND VGND VPWR VPWR _0303_ sky130_fd_sc_hd__or3b_1
XFILLER_46_3 VGND VPWR VPWR VGND sky130_ef_sc_hd__decap_12
X_1403_ u_jt49.eg_period\[12\] net104 _0405_ VGND VGND VPWR VPWR _0123_ sky130_fd_sc_hd__mux2_1
X_1334_ _0345_ _0346_ _0340_ _0342_ _0343_ VGND VGND VPWR VPWR _0359_ sky130_fd_sc_hd__a2111o_1
XPHY_EDGE_ROW_18_Right_18 VGND VGND VPWR VPWR sky130_fd_sc_hd__decap_3
X_1196_ u_jt49.u_envdiv.count\[9\] net76 VGND VGND VPWR VPWR _0777_ sky130_fd_sc_hd__or2_1
XFILLER_36_197 VGND VGND VPWR VPWR sky130_fd_sc_hd__decap_4
XPHY_EDGE_ROW_27_Right_27 VGND VGND VPWR VPWR sky130_fd_sc_hd__decap_3
Xinput3 IOA_in[2] VGND VGND VPWR VPWR net3 sky130_fd_sc_hd__buf_1
XFILLER_24_315 VGND VPWR VPWR VGND sky130_ef_sc_hd__decap_12
XFILLER_51_189 VGND VGND VPWR VPWR sky130_fd_sc_hd__decap_3
XPHY_EDGE_ROW_36_Right_36 VGND VGND VPWR VPWR sky130_fd_sc_hd__decap_3
XFILLER_27_131 VGND VGND VPWR VPWR sky130_fd_sc_hd__decap_6
XFILLER_19_109 VGND VGND VPWR VPWR sky130_fd_sc_hd__decap_3
XPHY_EDGE_ROW_45_Right_45 VGND VGND VPWR VPWR sky130_fd_sc_hd__decap_3
XFILLER_42_189 VGND VGND VPWR VPWR sky130_fd_sc_hd__decap_6
XFILLER_15_337 VGND VGND VPWR VPWR sky130_fd_sc_hd__decap_8
XFILLER_15_359 VGND VPWR VPWR VGND sky130_ef_sc_hd__decap_12
XPHY_EDGE_ROW_54_Right_54 VGND VGND VPWR VPWR sky130_fd_sc_hd__decap_3
XPHY_EDGE_ROW_63_Right_63 VGND VGND VPWR VPWR sky130_fd_sc_hd__decap_3
XPHY_EDGE_ROW_38_Left_103 VGND VGND VPWR VPWR sky130_fd_sc_hd__decap_3
X_1050_ u_jt49.u_chC.count\[3\] u_jt49.u_chC.count\[2\] u_jt49.u_chC.count\[1\] u_jt49.u_chC.count\[0\]
+ VGND VGND VPWR VPWR _0665_ sky130_fd_sc_hd__and4_1
XFILLER_18_153 VGND VGND VPWR VPWR sky130_fd_sc_hd__decap_6
XFILLER_18_197 VGND VPWR VPWR VGND sky130_ef_sc_hd__decap_12
X_0903_ u_jt49.regarray\[7\]\[1\] _0519_ _0525_ u_jt49.periodC\[9\] VGND VGND VPWR
+ VPWR _0546_ sky130_fd_sc_hd__a22o_1
X_0834_ u_jt49.regarray\[6\]\[4\] VGND VGND VPWR VPWR _0485_ sky130_fd_sc_hd__inv_2
XPHY_EDGE_ROW_47_Left_112 VGND VGND VPWR VPWR sky130_fd_sc_hd__decap_3
X_1248_ _0452_ u_jt49.periodB\[11\] u_jt49.u_chB.count\[10\] _0454_ VGND VGND VPWR
+ VPWR _0286_ sky130_fd_sc_hd__a2bb2o_1
X_1317_ u_jt49.u_chA.count\[5\] u_jt49.periodA\[5\] VGND VGND VPWR VPWR _0342_ sky130_fd_sc_hd__and2b_1
XPHY_EDGE_ROW_56_Left_121 VGND VGND VPWR VPWR sky130_fd_sc_hd__decap_3
X_1179_ _0764_ VGND VGND VPWR VPWR _0765_ sky130_fd_sc_hd__inv_2
XFILLER_21_23 VGND VGND VPWR VPWR sky130_fd_sc_hd__decap_4
XFILLER_21_45 VGND VGND VPWR VPWR sky130_fd_sc_hd__decap_8
XFILLER_55_281 VGND VGND VPWR VPWR sky130_fd_sc_hd__decap_8
Xmax_cap76 _0773_ VGND VGND VPWR VPWR net76 sky130_fd_sc_hd__buf_1
XFILLER_62_85 VGND VPWR VPWR VGND sky130_ef_sc_hd__decap_12
XFILLER_62_41 VGND VPWR VPWR VGND sky130_ef_sc_hd__decap_12
XFILLER_7_333 VGND VGND VPWR VPWR sky130_fd_sc_hd__decap_3
XFILLER_15_178 VGND VGND VPWR VPWR sky130_fd_sc_hd__decap_8
XFILLER_38_248 VGND VGND VPWR VPWR sky130_fd_sc_hd__decap_4
X_1102_ u_jt49.u_env.rst_latch _0703_ u_jt49.u_env.gain\[0\] VGND VGND VPWR VPWR _0704_
+ sky130_fd_sc_hd__o21a_1
XFILLER_61_273 VGND VGND VPWR VPWR sky130_fd_sc_hd__decap_6
XFILLER_53_207 VGND VGND VPWR VPWR sky130_fd_sc_hd__decap_3
X_1033_ u_jt49.u_chC.count\[5\] _0468_ _0636_ _0639_ _0648_ VGND VGND VPWR VPWR _0651_
+ sky130_fd_sc_hd__a2111o_1
X_1797_ clknet_leaf_10_clk _0216_ net127 VGND VGND VPWR VPWR u_jt49.periodB\[1\] sky130_fd_sc_hd__dfrtp_1
X_0817_ u_jt49.periodC\[5\] VGND VGND VPWR VPWR _0468_ sky130_fd_sc_hd__inv_2
XFILLER_37_281 VGND VGND VPWR VPWR sky130_fd_sc_hd__decap_8
XFILLER_32_55 VGND VGND VPWR VPWR sky130_fd_sc_hd__decap_8
XFILLER_32_44 VGND VGND VPWR VPWR sky130_fd_sc_hd__decap_3
XPHY_EDGE_ROW_0_Right_0 VGND VGND VPWR VPWR sky130_fd_sc_hd__decap_3
X_1651_ clknet_leaf_6_clk net233 net124 VGND VGND VPWR VPWR u_jt49.u_ng.poly17\[6\]
+ sky130_fd_sc_hd__dfrtp_1
Xhold108 u_jt49.regarray\[9\]\[1\] VGND VGND VPWR VPWR net253 sky130_fd_sc_hd__dlygate4sd3_1
XFILLER_11_181 VGND VPWR VPWR VGND sky130_ef_sc_hd__decap_12
X_1720_ clknet_leaf_19_clk _0139_ net135 VGND VGND VPWR VPWR u_jt49.eg_period\[4\]
+ sky130_fd_sc_hd__dfrtp_2
X_1582_ clknet_leaf_9_clk _0005_ VGND VGND VPWR VPWR din_latch\[1\] sky130_fd_sc_hd__dfxtp_1
Xhold119 u_jt49.envelope\[2\] VGND VGND VPWR VPWR net264 sky130_fd_sc_hd__dlygate4sd3_1
XFILLER_26_229 VGND VGND VPWR VPWR sky130_fd_sc_hd__decap_3
X_1016_ _0628_ _0629_ _0631_ _0632_ VGND VGND VPWR VPWR _0634_ sky130_fd_sc_hd__or4_1
X_1849_ clknet_leaf_29_clk _0273_ net119 VGND VGND VPWR VPWR net71 sky130_fd_sc_hd__dfrtp_1
XFILLER_27_66 VGND VPWR VPWR VGND sky130_ef_sc_hd__decap_12
XFILLER_25_240 VGND VPWR VPWR VGND sky130_ef_sc_hd__decap_12
XFILLER_17_218 VGND VGND VPWR VPWR sky130_fd_sc_hd__decap_6
Xclkbuf_leaf_20_clk clknet_2_2__leaf_clk VGND VGND VPWR VPWR clknet_leaf_20_clk sky130_fd_sc_hd__clkbuf_8
XFILLER_4_15 VGND VPWR VPWR VGND sky130_ef_sc_hd__decap_12
XFILLER_48_365 VGND VGND VPWR VPWR sky130_fd_sc_hd__decap_6
X_1703_ clknet_leaf_12_clk _0122_ net140 VGND VGND VPWR VPWR u_jt49.eg_period\[11\]
+ sky130_fd_sc_hd__dfrtp_2
Xclkbuf_leaf_11_clk clknet_2_3__leaf_clk VGND VGND VPWR VPWR clknet_leaf_11_clk sky130_fd_sc_hd__clkbuf_8
X_1634_ clknet_leaf_16_clk _0057_ net142 VGND VGND VPWR VPWR u_jt49.u_envdiv.count\[5\]
+ sky130_fd_sc_hd__dfrtp_1
XFILLER_58_118 VGND VPWR VPWR VGND sky130_ef_sc_hd__decap_12
XFILLER_39_310 VGND VGND VPWR VPWR sky130_fd_sc_hd__decap_4
X_1496_ u_jt49.periodC\[7\] net97 _0415_ VGND VGND VPWR VPWR _0206_ sky130_fd_sc_hd__mux2_1
X_1565_ u_jt49.regarray\[9\]\[2\] u_jt49.envelope\[3\] u_jt49.regarray\[9\]\[4\] VGND
+ VGND VPWR VPWR _0433_ sky130_fd_sc_hd__mux2_1
XFILLER_54_368 VGND VGND VPWR VPWR sky130_fd_sc_hd__decap_8
XFILLER_45_302 VGND VGND VPWR VPWR sky130_fd_sc_hd__decap_8
Xclkload17 clknet_leaf_20_clk VGND VGND VPWR VPWR clkload17/Y sky130_fd_sc_hd__bufinv_16
X_1281_ _0460_ _0313_ VGND VGND VPWR VPWR _0315_ sky130_fd_sc_hd__nor2_1
X_1350_ u_jt49.u_chA.count\[2\] _0370_ VGND VGND VPWR VPWR _0373_ sky130_fd_sc_hd__or2_1
XFILLER_51_305 VGND VPWR VPWR VGND sky130_ef_sc_hd__decap_12
XFILLER_36_324 VGND VGND VPWR VPWR sky130_fd_sc_hd__decap_8
Xclkbuf_leaf_0_clk clknet_2_0__leaf_clk VGND VGND VPWR VPWR clknet_leaf_0_clk sky130_fd_sc_hd__clkbuf_8
X_0996_ u_jt49.u_ng.u_div.count\[2\] _0617_ VGND VGND VPWR VPWR _0620_ sky130_fd_sc_hd__and2_1
X_1617_ clknet_leaf_21_clk _0040_ net137 VGND VGND VPWR VPWR u_jt49.u_env.gain\[0\]
+ sky130_fd_sc_hd__dfstp_1
X_1548_ u_jt49.Amix net20 VGND VGND VPWR VPWR _0424_ sky130_fd_sc_hd__and2_1
X_1479_ net81 _0525_ VGND VGND VPWR VPWR _0414_ sky130_fd_sc_hd__and2_2
XFILLER_6_3 VGND VPWR VPWR VGND sky130_ef_sc_hd__decap_12
XFILLER_45_132 VGND VPWR VPWR VGND sky130_ef_sc_hd__decap_12
XFILLER_18_302 VGND VGND VPWR VPWR sky130_fd_sc_hd__decap_6
X_0850_ net20 VGND VGND VPWR VPWR _0501_ sky130_fd_sc_hd__inv_2
X_1402_ u_jt49.eg_period\[11\] net106 _0405_ VGND VGND VPWR VPWR _0122_ sky130_fd_sc_hd__mux2_1
X_1264_ _0456_ u_jt49.periodB\[8\] VGND VGND VPWR VPWR _0302_ sky130_fd_sc_hd__and2_1
X_1333_ _0489_ u_jt49.periodA\[4\] _0339_ _0347_ _0357_ VGND VGND VPWR VPWR _0358_
+ sky130_fd_sc_hd__a2111o_1
Xinput4 IOA_in[3] VGND VGND VPWR VPWR net4 sky130_fd_sc_hd__buf_1
XFILLER_51_113 VGND VPWR VPWR VGND sky130_ef_sc_hd__decap_12
X_1195_ u_jt49.u_envdiv.count\[9\] net76 VGND VGND VPWR VPWR _0776_ sky130_fd_sc_hd__nand2_1
Xclkbuf_2_1__f_clk clknet_0_clk VGND VGND VPWR VPWR clknet_2_1__leaf_clk sky130_fd_sc_hd__clkbuf_16
XFILLER_24_327 VGND VGND VPWR VPWR sky130_fd_sc_hd__decap_8
X_0979_ net103 net25 _0608_ VGND VGND VPWR VPWR _0008_ sky130_fd_sc_hd__mux2_1
XFILLER_33_113 VGND VGND VPWR VPWR sky130_fd_sc_hd__decap_4
X_0833_ u_jt49.regarray\[6\]\[2\] VGND VGND VPWR VPWR _0484_ sky130_fd_sc_hd__inv_2
X_0902_ u_jt49.periodA\[9\] net77 _0543_ _0544_ VGND VGND VPWR VPWR _0545_ sky130_fd_sc_hd__a211o_1
X_1316_ _0339_ _0340_ VGND VGND VPWR VPWR _0341_ sky130_fd_sc_hd__nor2_1
X_1178_ _0480_ _0763_ VGND VGND VPWR VPWR _0764_ sky130_fd_sc_hd__nor2_1
XFILLER_2_81 VGND VGND VPWR VPWR sky130_fd_sc_hd__decap_3
X_1247_ _0285_ u_jt49.bitC _0659_ VGND VGND VPWR VPWR _0087_ sky130_fd_sc_hd__mux2_1
XFILLER_24_157 VGND VGND VPWR VPWR sky130_fd_sc_hd__decap_3
Xmax_cap77 _0527_ VGND VGND VPWR VPWR net77 sky130_fd_sc_hd__buf_2
XFILLER_15_113 VGND VPWR VPWR VGND sky130_ef_sc_hd__decap_12
XFILLER_62_97 VGND VPWR VPWR VGND sky130_ef_sc_hd__decap_12
XFILLER_62_53 VGND VPWR VPWR VGND sky130_ef_sc_hd__decap_12
XFILLER_7_15 VGND VPWR VPWR VGND sky130_ef_sc_hd__decap_12
XFILLER_11_352 VGND VPWR VPWR VGND sky130_ef_sc_hd__decap_12
XFILLER_38_216 VGND VPWR VPWR VGND sky130_ef_sc_hd__decap_12
X_1032_ _0469_ u_jt49.periodC\[3\] _0637_ _0641_ _0647_ VGND VGND VPWR VPWR _0650_
+ sky130_fd_sc_hd__a2111o_1
X_1101_ _0693_ _0701_ VGND VGND VPWR VPWR _0703_ sky130_fd_sc_hd__nand2_1
X_1796_ clknet_leaf_10_clk _0215_ net128 VGND VGND VPWR VPWR u_jt49.periodB\[0\] sky130_fd_sc_hd__dfrtp_1
X_0816_ u_jt49.u_chC.count\[7\] VGND VGND VPWR VPWR _0467_ sky130_fd_sc_hd__inv_2
XFILLER_32_23 VGND VGND VPWR VPWR sky130_fd_sc_hd__decap_4
XFILLER_20_193 VGND VGND VPWR VPWR sky130_fd_sc_hd__decap_3
XFILLER_57_31 VGND VGND VPWR VPWR sky130_fd_sc_hd__decap_4
X_1581_ clknet_leaf_9_clk _0004_ VGND VGND VPWR VPWR din_latch\[0\] sky130_fd_sc_hd__dfxtp_1
X_1650_ clknet_leaf_6_clk _0073_ net124 VGND VGND VPWR VPWR u_jt49.u_ng.poly17\[5\]
+ sky130_fd_sc_hd__dfrtp_1
Xhold109 u_jt49.u_chC.count\[0\] VGND VGND VPWR VPWR net254 sky130_fd_sc_hd__dlygate4sd3_1
XFILLER_11_193 VGND VPWR VPWR VGND sky130_ef_sc_hd__decap_12
X_1015_ u_jt49.u_chC.count\[9\] u_jt49.periodC\[9\] VGND VGND VPWR VPWR _0633_ sky130_fd_sc_hd__nand2b_1
X_1779_ clknet_leaf_3_clk _0198_ net120 VGND VGND VPWR VPWR u_jt49.regarray\[5\]\[7\]
+ sky130_fd_sc_hd__dfrtp_1
X_1848_ clknet_leaf_29_clk _0272_ net116 VGND VGND VPWR VPWR net70 sky130_fd_sc_hd__dfrtp_1
XFILLER_57_366 VGND VPWR VPWR VGND sky130_ef_sc_hd__decap_12
XFILLER_57_333 VGND VGND VPWR VPWR sky130_fd_sc_hd__decap_3
XFILLER_27_78 VGND VGND VPWR VPWR sky130_fd_sc_hd__decap_4
XFILLER_25_252 VGND VPWR VPWR VGND sky130_ef_sc_hd__decap_12
XFILLER_31_277 VGND VGND VPWR VPWR sky130_fd_sc_hd__decap_3
X_1702_ clknet_leaf_17_clk _0121_ net140 VGND VGND VPWR VPWR u_jt49.eg_period\[10\]
+ sky130_fd_sc_hd__dfrtp_2
X_1633_ clknet_leaf_20_clk _0056_ net136 VGND VGND VPWR VPWR u_jt49.u_envdiv.count\[4\]
+ sky130_fd_sc_hd__dfrtp_1
X_1564_ net113 net162 _0430_ _0432_ VGND VGND VPWR VPWR _0257_ sky130_fd_sc_hd__a22o_1
XFILLER_39_344 VGND VPWR VPWR VGND sky130_ef_sc_hd__decap_12
X_1495_ u_jt49.periodC\[6\] net100 _0415_ VGND VGND VPWR VPWR _0205_ sky130_fd_sc_hd__mux2_1
XFILLER_22_222 VGND VGND VPWR VPWR sky130_fd_sc_hd__decap_4
XFILLER_13_69 VGND VGND VPWR VPWR sky130_fd_sc_hd__decap_8
XFILLER_49_108 VGND VGND VPWR VPWR sky130_fd_sc_hd__decap_4
XFILLER_38_11 VGND VGND VPWR VPWR sky130_fd_sc_hd__decap_3
Xclkload18 clknet_leaf_21_clk VGND VGND VPWR VPWR clkload18/Y sky130_fd_sc_hd__clkinv_4
X_1280_ net73 _0313_ _0314_ VGND VGND VPWR VPWR _0091_ sky130_fd_sc_hd__and3_1
XFILLER_51_317 VGND VPWR VPWR VGND sky130_ef_sc_hd__decap_12
X_0995_ _0616_ _0618_ _0619_ VGND VGND VPWR VPWR _0013_ sky130_fd_sc_hd__and3_1
X_1547_ u_jt49.regarray\[8\]\[3\] u_jt49.envelope\[0\] u_jt49.regarray\[8\]\[4\] VGND
+ VGND VPWR VPWR _0423_ sky130_fd_sc_hd__mux2_1
X_1616_ clknet_leaf_21_clk _0039_ net137 VGND VGND VPWR VPWR u_jt49.u_env.stop sky130_fd_sc_hd__dfrtp_1
XFILLER_39_152 VGND VPWR VPWR VGND sky130_ef_sc_hd__decap_12
XFILLER_27_347 VGND VPWR VPWR VGND sky130_ef_sc_hd__decap_12
X_1478_ net98 net210 _0413_ VGND VGND VPWR VPWR _0190_ sky130_fd_sc_hd__mux2_1
XFILLER_24_57 VGND VGND VPWR VPWR sky130_fd_sc_hd__decap_3
XFILLER_40_23 VGND VGND VPWR VPWR sky130_fd_sc_hd__decap_4
XFILLER_45_144 VGND VPWR VPWR VGND sky130_ef_sc_hd__decap_12
XFILLER_33_306 VGND VGND VPWR VPWR sky130_fd_sc_hd__decap_8
XFILLER_60_147 VGND VPWR VPWR VGND sky130_ef_sc_hd__decap_12
X_1401_ u_jt49.eg_period\[10\] net108 _0405_ VGND VGND VPWR VPWR _0121_ sky130_fd_sc_hd__mux2_1
X_1263_ _0457_ u_jt49.periodB\[7\] _0458_ u_jt49.periodB\[6\] VGND VGND VPWR VPWR
+ _0301_ sky130_fd_sc_hd__o22a_1
X_1194_ net75 _0774_ _0775_ VGND VGND VPWR VPWR _0060_ sky130_fd_sc_hd__and3_1
X_1332_ _0488_ u_jt49.periodA\[7\] _0490_ u_jt49.periodA\[3\] VGND VGND VPWR VPWR
+ _0357_ sky130_fd_sc_hd__a22o_1
Xinput5 IOA_in[4] VGND VGND VPWR VPWR net5 sky130_fd_sc_hd__dlymetal6s2s_1
XFILLER_51_125 VGND VPWR VPWR VGND sky130_ef_sc_hd__decap_12
X_0978_ net105 net24 _0608_ VGND VGND VPWR VPWR _0007_ sky130_fd_sc_hd__mux2_1
XFILLER_10_15 VGND VPWR VPWR VGND sky130_ef_sc_hd__decap_12
XFILLER_59_225 VGND VPWR VPWR VGND sky130_ef_sc_hd__decap_12
XFILLER_19_57 VGND VGND VPWR VPWR sky130_fd_sc_hd__decap_8
XFILLER_30_309 VGND VGND VPWR VPWR sky130_fd_sc_hd__decap_3
XFILLER_33_169 VGND VGND VPWR VPWR sky130_fd_sc_hd__decap_6
XFILLER_21_309 VGND VGND VPWR VPWR sky130_fd_sc_hd__decap_3
X_0901_ u_jt49.eg_period\[1\] _0521_ _0522_ u_jt49.periodB\[9\] _0517_ VGND VGND VPWR
+ VPWR _0544_ sky130_fd_sc_hd__a221o_1
X_0832_ u_jt49.regarray\[6\]\[3\] VGND VGND VPWR VPWR _0483_ sky130_fd_sc_hd__inv_2
XFILLER_51_3 VGND VGND VPWR VPWR sky130_fd_sc_hd__decap_4
X_1315_ u_jt49.periodA\[7\] u_jt49.u_chA.count\[7\] VGND VGND VPWR VPWR _0340_ sky130_fd_sc_hd__and2b_1
XFILLER_2_93 VGND VGND VPWR VPWR sky130_fd_sc_hd__decap_8
X_1246_ _0282_ _0283_ _0284_ _0495_ VGND VGND VPWR VPWR _0285_ sky130_fd_sc_hd__o31a_1
X_1177_ net74 _0761_ _0763_ VGND VGND VPWR VPWR _0055_ sky130_fd_sc_hd__and3_1
XFILLER_32_191 VGND VGND VPWR VPWR sky130_fd_sc_hd__decap_4
XFILLER_12_309 VGND VPWR VPWR VGND sky130_ef_sc_hd__decap_12
XFILLER_62_209 VGND VPWR VPWR VGND sky130_ef_sc_hd__decap_12
XFILLER_55_261 VGND VPWR VPWR VGND sky130_ef_sc_hd__decap_12
XFILLER_46_77 VGND VGND VPWR VPWR sky130_fd_sc_hd__decap_6
XFILLER_30_117 VGND VGND VPWR VPWR sky130_fd_sc_hd__decap_3
XFILLER_15_125 VGND VGND VPWR VPWR sky130_fd_sc_hd__decap_8
XFILLER_62_65 VGND VPWR VPWR VGND sky130_ef_sc_hd__decap_12
XFILLER_7_27 VGND VPWR VPWR VGND sky130_ef_sc_hd__decap_12
XFILLER_11_364 VGND VPWR VPWR VGND sky130_ef_sc_hd__decap_12
XFILLER_38_228 VGND VGND VPWR VPWR sky130_fd_sc_hd__decap_8
X_1031_ _0636_ _0640_ _0647_ _0648_ VGND VGND VPWR VPWR _0649_ sky130_fd_sc_hd__or4_1
X_1100_ _0450_ _0627_ _0693_ _0702_ VGND VGND VPWR VPWR _0039_ sky130_fd_sc_hd__a2bb2o_1
XFILLER_14_191 VGND VGND VPWR VPWR sky130_fd_sc_hd__decap_4
Xinput30 sel VGND VGND VPWR VPWR net30 sky130_fd_sc_hd__buf_1
X_1795_ clknet_leaf_3_clk _0214_ net127 VGND VGND VPWR VPWR u_jt49.regarray\[3\]\[7\]
+ sky130_fd_sc_hd__dfrtp_1
X_0815_ u_jt49.periodC\[8\] VGND VGND VPWR VPWR _0466_ sky130_fd_sc_hd__inv_2
X_1229_ net221 u_jt49.u_ng.poly17\[14\] net78 VGND VGND VPWR VPWR _0081_ sky130_fd_sc_hd__mux2_1
XFILLER_52_253 VGND VPWR VPWR VGND sky130_ef_sc_hd__decap_12
XFILLER_37_294 VGND VPWR VPWR VGND sky130_ef_sc_hd__decap_12
XFILLER_11_150 VGND VGND VPWR VPWR sky130_fd_sc_hd__decap_6
X_1580_ net146 _0608_ VGND VGND VPWR VPWR _0265_ sky130_fd_sc_hd__nand2_1
X_1014_ u_jt49.u_chC.count\[10\] u_jt49.periodC\[10\] VGND VGND VPWR VPWR _0632_ sky130_fd_sc_hd__and2b_1
XPHY_EDGE_ROW_14_Left_79 VGND VGND VPWR VPWR sky130_fd_sc_hd__decap_3
X_1847_ clknet_leaf_29_clk _0271_ net116 VGND VGND VPWR VPWR net69 sky130_fd_sc_hd__dfrtp_1
XFILLER_8_81 VGND VGND VPWR VPWR sky130_fd_sc_hd__decap_3
X_1778_ clknet_leaf_26_clk _0197_ net133 VGND VGND VPWR VPWR u_jt49.regarray\[5\]\[6\]
+ sky130_fd_sc_hd__dfrtp_1
XFILLER_57_378 VGND VGND VPWR VPWR sky130_fd_sc_hd__decap_4
XFILLER_43_89 VGND VGND VPWR VPWR sky130_fd_sc_hd__decap_3
XFILLER_25_264 VGND VGND VPWR VPWR sky130_fd_sc_hd__decap_4
XFILLER_63_337 VGND VPWR VPWR VGND sky130_ef_sc_hd__decap_12
XFILLER_16_275 VGND VGND VPWR VPWR sky130_fd_sc_hd__decap_3
X_1701_ clknet_leaf_17_clk _0120_ net140 VGND VGND VPWR VPWR u_jt49.eg_period\[9\]
+ sky130_fd_sc_hd__dfrtp_2
X_1632_ clknet_leaf_20_clk _0055_ net136 VGND VGND VPWR VPWR u_jt49.u_envdiv.count\[3\]
+ sky130_fd_sc_hd__dfrtp_1
X_1563_ u_jt49.regarray\[9\]\[1\] u_jt49.envelope\[2\] u_jt49.regarray\[9\]\[4\] VGND
+ VGND VPWR VPWR _0432_ sky130_fd_sc_hd__mux2_1
X_1494_ u_jt49.periodC\[5\] net102 _0415_ VGND VGND VPWR VPWR _0204_ sky130_fd_sc_hd__mux2_1
XFILLER_39_356 VGND VGND VPWR VPWR sky130_fd_sc_hd__decap_6
Xclkload19 clknet_leaf_22_clk VGND VGND VPWR VPWR clkload19/Y sky130_fd_sc_hd__clkinv_2
XFILLER_51_329 VGND VGND VPWR VPWR sky130_fd_sc_hd__decap_6
XFILLER_48_197 VGND VPWR VPWR VGND sky130_ef_sc_hd__decap_12
XFILLER_8_293 VGND VPWR VPWR VGND sky130_ef_sc_hd__decap_12
X_0994_ net86 u_jt49.u_ng.u_div.count\[0\] u_jt49.u_ng.u_div.count\[1\] VGND VGND
+ VPWR VPWR _0619_ sky130_fd_sc_hd__a21o_1
X_1615_ clknet_leaf_17_clk net200 VGND VGND VPWR VPWR u_jt49.u_env.last_step sky130_fd_sc_hd__dfxtp_1
X_1477_ net99 net212 _0413_ VGND VGND VPWR VPWR _0189_ sky130_fd_sc_hd__mux2_1
X_1546_ net148 net113 _0422_ VGND VGND VPWR VPWR _0249_ sky130_fd_sc_hd__a21o_1
XFILLER_39_164 VGND VGND VPWR VPWR sky130_fd_sc_hd__decap_4
XFILLER_27_359 VGND VGND VPWR VPWR sky130_fd_sc_hd__decap_3
XFILLER_10_248 VGND VGND VPWR VPWR sky130_fd_sc_hd__decap_4
XPHY_EDGE_ROW_17_Left_82 VGND VGND VPWR VPWR sky130_fd_sc_hd__decap_3
XFILLER_40_46 VGND VGND VPWR VPWR sky130_fd_sc_hd__decap_6
XFILLER_45_101 VGND VGND VPWR VPWR sky130_fd_sc_hd__decap_8
XFILLER_60_159 VGND VPWR VPWR VGND sky130_ef_sc_hd__decap_12
XFILLER_45_156 VGND VPWR VPWR VGND sky130_ef_sc_hd__decap_12
XFILLER_53_7 VGND VGND VPWR VPWR sky130_fd_sc_hd__decap_8
X_1331_ _0355_ _0354_ _0352_ VGND VGND VPWR VPWR _0356_ sky130_fd_sc_hd__or3b_1
X_1400_ u_jt49.eg_period\[9\] net110 _0405_ VGND VGND VPWR VPWR _0120_ sky130_fd_sc_hd__mux2_1
X_1262_ _0297_ _0298_ _0299_ VGND VGND VPWR VPWR _0300_ sky130_fd_sc_hd__a21o_1
X_1193_ _0476_ _0772_ VGND VGND VPWR VPWR _0775_ sky130_fd_sc_hd__nand2_1
Xinput6 IOA_in[5] VGND VGND VPWR VPWR net6 sky130_fd_sc_hd__buf_1
X_0977_ net107 net23 _0608_ VGND VGND VPWR VPWR _0006_ sky130_fd_sc_hd__mux2_1
XFILLER_10_38 VGND VGND VPWR VPWR sky130_fd_sc_hd__decap_6
XFILLER_59_237 VGND VPWR VPWR VGND sky130_ef_sc_hd__decap_12
X_1529_ net104 net195 _0419_ VGND VGND VPWR VPWR _0235_ sky130_fd_sc_hd__mux2_1
XPHY_EDGE_ROW_2_Left_67 VGND VGND VPWR VPWR sky130_fd_sc_hd__decap_3
XPHY_EDGE_ROW_14_Right_14 VGND VGND VPWR VPWR sky130_fd_sc_hd__decap_3
XPHY_EDGE_ROW_23_Right_23 VGND VGND VPWR VPWR sky130_fd_sc_hd__decap_3
XPHY_EDGE_ROW_32_Right_32 VGND VGND VPWR VPWR sky130_fd_sc_hd__decap_3
X_0900_ u_jt49.regarray\[10\]\[1\] _0520_ _0523_ u_jt49.regarray\[6\]\[1\] VGND VGND
+ VPWR VPWR _0543_ sky130_fd_sc_hd__a22o_1
X_0831_ u_jt49.regarray\[6\]\[0\] VGND VGND VPWR VPWR _0482_ sky130_fd_sc_hd__inv_2
XPHY_EDGE_ROW_41_Right_41 VGND VGND VPWR VPWR sky130_fd_sc_hd__decap_3
X_1314_ u_jt49.periodA\[6\] u_jt49.u_chA.count\[6\] VGND VGND VPWR VPWR _0339_ sky130_fd_sc_hd__and2b_1
XFILLER_64_284 VGND VPWR VPWR VGND sky130_ef_sc_hd__decap_12
XPHY_EDGE_ROW_50_Right_50 VGND VGND VPWR VPWR sky130_fd_sc_hd__decap_3
X_1176_ _0755_ _0762_ VGND VGND VPWR VPWR _0763_ sky130_fd_sc_hd__nand2_1
X_1245_ u_jt49.periodC\[11\] u_jt49.periodC\[10\] u_jt49.periodC\[9\] u_jt49.periodC\[8\]
+ VGND VGND VPWR VPWR _0284_ sky130_fd_sc_hd__or4_1
XFILLER_20_343 VGND VPWR VPWR VGND sky130_ef_sc_hd__decap_12
XFILLER_20_365 VGND VPWR VPWR VGND sky130_ef_sc_hd__decap_12
XFILLER_62_77 VGND VGND VPWR VPWR sky130_fd_sc_hd__decap_6
XFILLER_55_273 VGND VGND VPWR VPWR sky130_fd_sc_hd__decap_6
XFILLER_7_39 VGND VPWR VPWR VGND sky130_ef_sc_hd__decap_12
XFILLER_7_325 VGND VGND VPWR VPWR sky130_fd_sc_hd__decap_8
XFILLER_11_376 VGND VGND VPWR VPWR sky130_fd_sc_hd__decap_6
XFILLER_11_70 VGND VGND VPWR VPWR sky130_fd_sc_hd__decap_4
XFILLER_46_262 VGND VPWR VPWR VGND sky130_ef_sc_hd__decap_12
X_1030_ u_jt49.u_chC.count\[6\] u_jt49.periodC\[6\] VGND VGND VPWR VPWR _0648_ sky130_fd_sc_hd__and2b_1
Xinput20 clk_en VGND VGND VPWR VPWR net20 sky130_fd_sc_hd__buf_4
X_0814_ u_jt49.periodC\[9\] VGND VGND VPWR VPWR _0465_ sky130_fd_sc_hd__inv_2
XFILLER_21_107 VGND VGND VPWR VPWR sky130_fd_sc_hd__decap_4
X_1794_ clknet_leaf_11_clk _0213_ net139 VGND VGND VPWR VPWR u_jt49.regarray\[3\]\[6\]
+ sky130_fd_sc_hd__dfrtp_1
X_1228_ net217 u_jt49.u_ng.poly17\[13\] net79 VGND VGND VPWR VPWR _0080_ sky130_fd_sc_hd__mux2_1
XFILLER_52_265 VGND VPWR VPWR VGND sky130_ef_sc_hd__decap_12
X_1159_ net252 _0751_ net85 VGND VGND VPWR VPWR _0049_ sky130_fd_sc_hd__mux2_1
XFILLER_28_262 VGND VPWR VPWR VGND sky130_ef_sc_hd__decap_12
Xclkbuf_leaf_23_clk clknet_2_2__leaf_clk VGND VGND VPWR VPWR clknet_leaf_23_clk sky130_fd_sc_hd__clkbuf_8
XFILLER_11_162 VGND VGND VPWR VPWR sky130_fd_sc_hd__decap_6
XPHY_EDGE_ROW_5_Left_70 VGND VGND VPWR VPWR sky130_fd_sc_hd__decap_3
XFILLER_3_361 VGND VPWR VPWR VGND sky130_ef_sc_hd__decap_12
X_1013_ u_jt49.u_chC.count\[11\] u_jt49.periodC\[11\] VGND VGND VPWR VPWR _0631_ sky130_fd_sc_hd__and2b_1
Xclkbuf_leaf_14_clk clknet_2_3__leaf_clk VGND VGND VPWR VPWR clknet_leaf_14_clk sky130_fd_sc_hd__clkbuf_8
X_1846_ clknet_leaf_29_clk _0270_ net116 VGND VGND VPWR VPWR net68 sky130_fd_sc_hd__dfrtp_1
X_1777_ clknet_leaf_25_clk _0196_ net133 VGND VGND VPWR VPWR u_jt49.regarray\[5\]\[5\]
+ sky130_fd_sc_hd__dfrtp_1
XPHY_EDGE_ROW_4_Right_4 VGND VGND VPWR VPWR sky130_fd_sc_hd__decap_3
XFILLER_25_210 VGND VPWR VPWR VGND sky130_ef_sc_hd__decap_12
XFILLER_4_29 VGND VPWR VPWR VGND sky130_ef_sc_hd__decap_12
XPHY_EDGE_ROW_31_Left_96 VGND VGND VPWR VPWR sky130_fd_sc_hd__decap_3
XFILLER_63_349 VGND VPWR VPWR VGND sky130_ef_sc_hd__decap_12
XFILLER_63_305 VGND VPWR VPWR VGND sky130_ef_sc_hd__decap_12
XFILLER_16_287 VGND VGND VPWR VPWR sky130_fd_sc_hd__decap_4
X_1700_ clknet_leaf_17_clk _0119_ net140 VGND VGND VPWR VPWR u_jt49.eg_period\[8\]
+ sky130_fd_sc_hd__dfrtp_2
X_1631_ clknet_leaf_20_clk _0054_ net136 VGND VGND VPWR VPWR u_jt49.u_envdiv.count\[2\]
+ sky130_fd_sc_hd__dfrtp_1
Xclkbuf_leaf_3_clk clknet_2_1__leaf_clk VGND VGND VPWR VPWR clknet_leaf_3_clk sky130_fd_sc_hd__clkbuf_8
X_1562_ net114 net159 _0430_ _0431_ VGND VGND VPWR VPWR _0256_ sky130_fd_sc_hd__a22o_1
X_1493_ u_jt49.periodC\[4\] net104 _0415_ VGND VGND VPWR VPWR _0203_ sky130_fd_sc_hd__mux2_1
XFILLER_13_38 VGND VPWR VPWR VGND sky130_ef_sc_hd__decap_12
XFILLER_22_246 VGND VGND VPWR VPWR sky130_fd_sc_hd__decap_6
X_1829_ clknet_leaf_20_clk _0248_ net136 VGND VGND VPWR VPWR u_jt49.eg_restart sky130_fd_sc_hd__dfrtp_1
XFILLER_63_113 VGND VPWR VPWR VGND sky130_ef_sc_hd__decap_12
XFILLER_36_349 VGND VGND VPWR VPWR sky130_fd_sc_hd__decap_3
X_0993_ _0617_ VGND VGND VPWR VPWR _0618_ sky130_fd_sc_hd__inv_2
X_1614_ clknet_leaf_21_clk _0037_ net137 VGND VGND VPWR VPWR u_jt49.u_env.inv sky130_fd_sc_hd__dfrtp_4
X_1545_ u_jt49.bitB u_jt49.regarray\[7\]\[1\] u_jt49.regarray\[7\]\[4\] u_jt49.noise
+ net20 VGND VGND VPWR VPWR _0422_ sky130_fd_sc_hd__o221a_1
X_1476_ net101 net213 _0413_ VGND VGND VPWR VPWR _0188_ sky130_fd_sc_hd__mux2_1
XFILLER_27_305 VGND VGND VPWR VPWR sky130_fd_sc_hd__decap_4
XFILLER_24_15 VGND VPWR VPWR VGND sky130_ef_sc_hd__decap_12
XFILLER_6_209 VGND VGND VPWR VPWR sky130_fd_sc_hd__decap_3
XFILLER_40_58 VGND VPWR VPWR VGND sky130_ef_sc_hd__decap_12
XFILLER_45_113 VGND VPWR VPWR VGND sky130_ef_sc_hd__decap_12
X_1261_ _0458_ u_jt49.periodB\[6\] _0459_ u_jt49.periodB\[5\] VGND VGND VPWR VPWR
+ _0299_ sky130_fd_sc_hd__a22o_1
X_1330_ u_jt49.u_chA.count\[10\] u_jt49.periodA\[10\] VGND VGND VPWR VPWR _0355_ sky130_fd_sc_hd__xor2_1
X_1192_ _0773_ VGND VGND VPWR VPWR _0774_ sky130_fd_sc_hd__inv_2
XFILLER_17_371 VGND VGND VPWR VPWR sky130_fd_sc_hd__decap_8
Xinput7 IOA_in[6] VGND VGND VPWR VPWR net7 sky130_fd_sc_hd__buf_1
X_0976_ net109 net22 _0608_ VGND VGND VPWR VPWR _0005_ sky130_fd_sc_hd__mux2_1
XFILLER_44_190 VGND VGND VPWR VPWR sky130_fd_sc_hd__decap_6
XFILLER_32_341 VGND VPWR VPWR VGND sky130_ef_sc_hd__decap_12
XFILLER_59_249 VGND VPWR VPWR VGND sky130_ef_sc_hd__decap_12
XFILLER_59_205 VGND VPWR VPWR VGND sky130_ef_sc_hd__decap_12
X_1459_ net100 net46 _0411_ VGND VGND VPWR VPWR _0173_ sky130_fd_sc_hd__mux2_1
X_1528_ net105 net194 _0419_ VGND VGND VPWR VPWR _0234_ sky130_fd_sc_hd__mux2_1
XFILLER_19_37 VGND VGND VPWR VPWR sky130_fd_sc_hd__decap_3
XFILLER_23_330 VGND VGND VPWR VPWR sky130_fd_sc_hd__decap_6
XFILLER_23_374 VGND VGND VPWR VPWR sky130_fd_sc_hd__decap_4
XFILLER_4_3 VGND VPWR VPWR VGND sky130_ef_sc_hd__decap_12
XFILLER_58_271 VGND VPWR VPWR VGND sky130_ef_sc_hd__decap_12
X_0830_ u_jt49.regarray\[6\]\[1\] VGND VGND VPWR VPWR _0481_ sky130_fd_sc_hd__inv_2
X_1313_ _0486_ u_jt49.periodA\[9\] _0487_ u_jt49.periodA\[8\] VGND VGND VPWR VPWR
+ _0338_ sky130_fd_sc_hd__o22a_1
X_1244_ u_jt49.periodC\[7\] u_jt49.periodC\[6\] u_jt49.periodC\[5\] u_jt49.periodC\[4\]
+ VGND VGND VPWR VPWR _0283_ sky130_fd_sc_hd__or4_1
XFILLER_64_296 VGND VPWR VPWR VGND sky130_ef_sc_hd__decap_12
X_1175_ u_jt49.u_envdiv.count\[3\] u_jt49.u_envdiv.count\[2\] VGND VGND VPWR VPWR
+ _0762_ sky130_fd_sc_hd__and2_1
X_0959_ u_jt49.periodA\[6\] _0518_ _0539_ _0596_ u_jt49.read_mask\[5\] VGND VGND VPWR
+ VPWR _0597_ sky130_fd_sc_hd__o2111a_1
XFILLER_20_355 VGND VGND VPWR VPWR sky130_fd_sc_hd__decap_8
XFILLER_20_377 VGND VGND VPWR VPWR sky130_fd_sc_hd__decap_4
XFILLER_46_46 VGND VGND VPWR VPWR sky130_fd_sc_hd__decap_3
XFILLER_23_193 VGND VGND VPWR VPWR sky130_fd_sc_hd__decap_8
XFILLER_7_337 VGND VPWR VPWR VGND sky130_ef_sc_hd__decap_12
XFILLER_46_274 VGND VPWR VPWR VGND sky130_ef_sc_hd__decap_12
XFILLER_46_230 VGND VGND VPWR VPWR sky130_fd_sc_hd__decap_3
Xinput21 din[0] VGND VGND VPWR VPWR net21 sky130_fd_sc_hd__clkbuf_1
X_1793_ clknet_leaf_11_clk _0212_ net139 VGND VGND VPWR VPWR u_jt49.regarray\[3\]\[5\]
+ sky130_fd_sc_hd__dfrtp_1
Xinput10 IOB_in[1] VGND VGND VPWR VPWR net10 sky130_fd_sc_hd__clkbuf_1
X_0813_ net86 VGND VGND VPWR VPWR _0464_ sky130_fd_sc_hd__inv_2
X_1227_ net227 net217 net79 VGND VGND VPWR VPWR _0079_ sky130_fd_sc_hd__mux2_1
X_1158_ u_jt49.u_env.gain\[3\] u_jt49.u_env.inv VGND VGND VPWR VPWR _0751_ sky130_fd_sc_hd__xor2_1
XFILLER_52_277 VGND VPWR VPWR VGND sky130_ef_sc_hd__decap_12
X_1089_ u_jt49.regarray\[13\]\[2\] u_jt49.regarray\[13\]\[1\] u_jt49.regarray\[13\]\[3\]
+ VGND VGND VPWR VPWR _0694_ sky130_fd_sc_hd__mux2_1
XFILLER_20_130 VGND VGND VPWR VPWR sky130_fd_sc_hd__decap_8
XFILLER_28_274 VGND VPWR VPWR VGND sky130_ef_sc_hd__decap_12
XPHY_EDGE_ROW_44_Left_109 VGND VGND VPWR VPWR sky130_fd_sc_hd__decap_3
XFILLER_3_373 VGND VGND VPWR VPWR sky130_fd_sc_hd__decap_8
XFILLER_22_81 VGND VGND VPWR VPWR sky130_fd_sc_hd__decap_3
XPHY_EDGE_ROW_53_Left_118 VGND VGND VPWR VPWR sky130_fd_sc_hd__decap_3
X_1012_ _0628_ _0629_ VGND VGND VPWR VPWR _0630_ sky130_fd_sc_hd__nor2_1
XFILLER_19_274 VGND VGND VPWR VPWR sky130_fd_sc_hd__decap_6
XPHY_EDGE_ROW_62_Left_127 VGND VGND VPWR VPWR sky130_fd_sc_hd__decap_3
X_1776_ clknet_leaf_26_clk _0195_ net133 VGND VGND VPWR VPWR u_jt49.regarray\[5\]\[4\]
+ sky130_fd_sc_hd__dfrtp_1
X_1845_ clknet_leaf_29_clk _0269_ net115 VGND VGND VPWR VPWR net67 sky130_fd_sc_hd__dfrtp_1
XFILLER_27_15 VGND VPWR VPWR VGND sky130_ef_sc_hd__decap_12
XFILLER_25_277 VGND VGND VPWR VPWR sky130_fd_sc_hd__decap_3
XFILLER_63_317 VGND VPWR VPWR VGND sky130_ef_sc_hd__decap_12
XFILLER_31_247 VGND VGND VPWR VPWR sky130_fd_sc_hd__decap_6
XFILLER_16_299 VGND VGND VPWR VPWR sky130_fd_sc_hd__decap_8
X_1630_ clknet_leaf_19_clk _0053_ net136 VGND VGND VPWR VPWR u_jt49.u_envdiv.count\[1\]
+ sky130_fd_sc_hd__dfrtp_1
X_1561_ u_jt49.regarray\[9\]\[0\] u_jt49.envelope\[1\] u_jt49.regarray\[9\]\[4\] VGND
+ VGND VPWR VPWR _0431_ sky130_fd_sc_hd__mux2_1
X_1492_ u_jt49.periodC\[3\] net105 _0415_ VGND VGND VPWR VPWR _0202_ sky130_fd_sc_hd__mux2_1
X_1828_ clknet_leaf_28_clk _0247_ VGND VGND VPWR VPWR u_jt49.Amix sky130_fd_sc_hd__dfxtp_1
X_1759_ clknet_leaf_0_clk _0178_ net118 VGND VGND VPWR VPWR u_jt49.regarray\[6\]\[3\]
+ sky130_fd_sc_hd__dfrtp_1
XFILLER_57_155 VGND VGND VPWR VPWR sky130_fd_sc_hd__decap_3
XFILLER_38_25 VGND VGND VPWR VPWR sky130_fd_sc_hd__decap_3
XFILLER_60_309 VGND VPWR VPWR VGND sky130_ef_sc_hd__decap_12
XFILLER_53_361 VGND VPWR VPWR VGND sky130_ef_sc_hd__decap_12
XFILLER_13_225 VGND VGND VPWR VPWR sky130_fd_sc_hd__decap_8
XFILLER_63_169 VGND VPWR VPWR VGND sky130_ef_sc_hd__decap_12
XFILLER_63_125 VGND VPWR VPWR VGND sky130_ef_sc_hd__decap_12
XFILLER_36_339 VGND VGND VPWR VPWR sky130_fd_sc_hd__decap_6
X_0992_ net86 u_jt49.u_ng.u_div.count\[1\] u_jt49.u_ng.u_div.count\[0\] VGND VGND
+ VPWR VPWR _0617_ sky130_fd_sc_hd__and3_1
XFILLER_8_262 VGND VGND VPWR VPWR sky130_fd_sc_hd__decap_4
X_1613_ clknet_leaf_20_clk net150 VGND VGND VPWR VPWR u_jt49.u_env.rst_latch sky130_fd_sc_hd__dfxtp_2
X_1544_ net208 _0413_ net82 net149 VGND VGND VPWR VPWR _0248_ sky130_fd_sc_hd__a2bb2o_1
XFILLER_27_317 VGND VGND VPWR VPWR sky130_fd_sc_hd__decap_6
X_1475_ net103 net239 _0413_ VGND VGND VPWR VPWR _0187_ sky130_fd_sc_hd__mux2_1
XFILLER_42_309 VGND VPWR VPWR VGND sky130_ef_sc_hd__decap_12
XFILLER_10_206 VGND VGND VPWR VPWR sky130_fd_sc_hd__decap_8
XFILLER_45_125 VGND VGND VPWR VPWR sky130_fd_sc_hd__decap_3
XFILLER_53_180 VGND VPWR VPWR VGND sky130_ef_sc_hd__decap_12
XFILLER_5_254 VGND VPWR VPWR VGND sky130_ef_sc_hd__decap_12
X_1260_ _0459_ u_jt49.periodB\[5\] _0460_ u_jt49.periodB\[4\] VGND VGND VPWR VPWR
+ _0298_ sky130_fd_sc_hd__o22a_1
X_1191_ _0476_ _0477_ _0478_ _0767_ VGND VGND VPWR VPWR _0773_ sky130_fd_sc_hd__nor4_1
Xinput8 IOA_in[7] VGND VGND VPWR VPWR net8 sky130_fd_sc_hd__buf_1
X_0975_ net111 net21 _0608_ VGND VGND VPWR VPWR _0004_ sky130_fd_sc_hd__mux2_1
XFILLER_59_217 VGND VGND VPWR VPWR sky130_fd_sc_hd__decap_6
X_1527_ net107 net189 _0419_ VGND VGND VPWR VPWR _0233_ sky130_fd_sc_hd__mux2_1
X_1389_ net236 net20 VGND VGND VPWR VPWR _0114_ sky130_fd_sc_hd__xor2_1
XFILLER_27_103 VGND VGND VPWR VPWR sky130_fd_sc_hd__decap_8
X_1458_ net101 net245 _0411_ VGND VGND VPWR VPWR _0172_ sky130_fd_sc_hd__mux2_1
XFILLER_42_128 VGND VPWR VPWR VGND sky130_ef_sc_hd__decap_12
XFILLER_58_283 VGND VPWR VPWR VGND sky130_ef_sc_hd__decap_12
XFILLER_18_169 VGND VPWR VPWR VGND sky130_ef_sc_hd__decap_12
XFILLER_56_209 VGND VPWR VPWR VGND sky130_ef_sc_hd__decap_12
XFILLER_49_261 VGND VPWR VPWR VGND sky130_ef_sc_hd__decap_12
X_1312_ net87 net263 VGND VGND VPWR VPWR _0337_ sky130_fd_sc_hd__nor2_1
XFILLER_2_41 VGND VGND VPWR VPWR sky130_fd_sc_hd__decap_8
X_1243_ u_jt49.periodC\[3\] u_jt49.periodC\[2\] u_jt49.periodC\[1\] u_jt49.periodC\[0\]
+ VGND VGND VPWR VPWR _0282_ sky130_fd_sc_hd__or4_1
X_1174_ u_jt49.u_envdiv.count\[3\] _0759_ VGND VGND VPWR VPWR _0761_ sky130_fd_sc_hd__or2_1
XFILLER_64_253 VGND VPWR VPWR VGND sky130_ef_sc_hd__decap_12
X_0958_ _0591_ _0592_ _0595_ VGND VGND VPWR VPWR _0596_ sky130_fd_sc_hd__or3_1
X_0889_ u_jt49.regarray\[10\]\[0\] _0520_ _0531_ _0532_ VGND VGND VPWR VPWR _0533_
+ sky130_fd_sc_hd__a211o_1
XFILLER_30_109 VGND VGND VPWR VPWR sky130_fd_sc_hd__decap_8
XFILLER_7_349 VGND VPWR VPWR VGND sky130_ef_sc_hd__decap_12
XFILLER_46_253 VGND VGND VPWR VPWR sky130_fd_sc_hd__decap_4
Xinput22 din[1] VGND VGND VPWR VPWR net22 sky130_fd_sc_hd__clkbuf_1
X_0812_ net269 VGND VGND VPWR VPWR _0463_ sky130_fd_sc_hd__inv_2
X_1792_ clknet_leaf_11_clk _0211_ net139 VGND VGND VPWR VPWR u_jt49.regarray\[3\]\[4\]
+ sky130_fd_sc_hd__dfrtp_1
Xinput11 IOB_in[2] VGND VGND VPWR VPWR net11 sky130_fd_sc_hd__clkbuf_1
X_1226_ net229 net227 net79 VGND VGND VPWR VPWR _0078_ sky130_fd_sc_hd__mux2_1
XFILLER_37_275 VGND VGND VPWR VPWR sky130_fd_sc_hd__decap_4
X_1157_ net264 _0750_ net85 VGND VGND VPWR VPWR _0048_ sky130_fd_sc_hd__mux2_1
XFILLER_52_289 VGND VPWR VPWR VGND sky130_ef_sc_hd__decap_12
X_1088_ _0450_ net85 _0692_ _0627_ VGND VGND VPWR VPWR _0693_ sky130_fd_sc_hd__a31o_2
X_1011_ u_jt49.periodC\[11\] u_jt49.u_chC.count\[11\] VGND VGND VPWR VPWR _0629_ sky130_fd_sc_hd__and2b_1
XFILLER_19_220 VGND VGND VPWR VPWR sky130_fd_sc_hd__decap_4
X_1844_ clknet_leaf_30_clk _0268_ net115 VGND VGND VPWR VPWR net66 sky130_fd_sc_hd__dfrtp_1
X_1775_ clknet_leaf_2_clk _0194_ net120 VGND VGND VPWR VPWR u_jt49.periodC\[11\] sky130_fd_sc_hd__dfrtp_1
XFILLER_27_27 VGND VGND VPWR VPWR sky130_fd_sc_hd__decap_3
X_1209_ u_jt49.u_envdiv.count\[13\] _0782_ VGND VGND VPWR VPWR _0786_ sky130_fd_sc_hd__nand2_1
XFILLER_43_26 VGND VPWR VPWR VGND sky130_ef_sc_hd__decap_12
XFILLER_4_116 VGND VPWR VPWR VGND sky130_ef_sc_hd__decap_12
XFILLER_0_355 VGND VGND VPWR VPWR sky130_fd_sc_hd__decap_8
XFILLER_63_329 VGND VGND VPWR VPWR sky130_fd_sc_hd__decap_6
X_1560_ net113 net153 _0429_ _0430_ VGND VGND VPWR VPWR _0255_ sky130_fd_sc_hd__a22o_1
XFILLER_39_337 VGND VGND VPWR VPWR sky130_fd_sc_hd__decap_4
XFILLER_12_3 VGND VPWR VPWR VGND sky130_ef_sc_hd__decap_12
X_1491_ u_jt49.periodC\[2\] net107 _0415_ VGND VGND VPWR VPWR _0201_ sky130_fd_sc_hd__mux2_1
X_1827_ clknet_leaf_1_clk _0246_ net118 VGND VGND VPWR VPWR u_jt49.periodA\[7\] sky130_fd_sc_hd__dfrtp_1
XFILLER_13_18 VGND VPWR VPWR VGND sky130_ef_sc_hd__decap_12
X_1689_ clknet_leaf_6_clk _0110_ net126 VGND VGND VPWR VPWR u_jt49.u_chA.count\[9\]
+ sky130_fd_sc_hd__dfrtp_2
X_1758_ clknet_leaf_0_clk _0177_ net118 VGND VGND VPWR VPWR u_jt49.regarray\[6\]\[2\]
+ sky130_fd_sc_hd__dfrtp_1
XFILLER_57_189 VGND VPWR VPWR VGND sky130_ef_sc_hd__decap_12
XFILLER_45_318 VGND VPWR VPWR VGND sky130_ef_sc_hd__decap_12
XFILLER_38_48 VGND VGND VPWR VPWR sky130_fd_sc_hd__decap_3
XFILLER_53_373 VGND VGND VPWR VPWR sky130_fd_sc_hd__decap_8
XFILLER_9_219 VGND VGND VPWR VPWR sky130_fd_sc_hd__decap_4
XFILLER_21_281 VGND VGND VPWR VPWR sky130_fd_sc_hd__decap_6
XFILLER_0_141 VGND VGND VPWR VPWR sky130_fd_sc_hd__decap_3
XFILLER_63_137 VGND VPWR VPWR VGND sky130_ef_sc_hd__decap_12
X_0991_ net86 _0614_ VGND VGND VPWR VPWR _0616_ sky130_fd_sc_hd__nand2_1
XFILLER_5_30 VGND VPWR VPWR VGND sky130_ef_sc_hd__decap_12
X_1543_ net147 net113 _0421_ VGND VGND VPWR VPWR _0247_ sky130_fd_sc_hd__a21o_1
X_1612_ clknet_leaf_0_clk _0035_ net116 VGND VGND VPWR VPWR u_jt49.u_chC.count\[11\]
+ sky130_fd_sc_hd__dfrtp_1
X_1474_ net106 u_jt49.regarray\[13\]\[3\] _0413_ VGND VGND VPWR VPWR _0186_ sky130_fd_sc_hd__mux2_1
XFILLER_39_189 VGND VGND VPWR VPWR sky130_fd_sc_hd__decap_6
XFILLER_39_134 VGND VGND VPWR VPWR sky130_fd_sc_hd__decap_8
XFILLER_50_365 VGND VGND VPWR VPWR sky130_fd_sc_hd__decap_6
XFILLER_50_321 VGND VGND VPWR VPWR sky130_fd_sc_hd__decap_6
XFILLER_26_351 VGND VPWR VPWR VGND sky130_ef_sc_hd__decap_12
XFILLER_18_329 VGND VGND VPWR VPWR sky130_fd_sc_hd__decap_4
XFILLER_41_354 VGND VGND VPWR VPWR sky130_fd_sc_hd__decap_8
XFILLER_41_310 VGND VPWR VPWR VGND sky130_ef_sc_hd__decap_12
XFILLER_5_266 VGND VPWR VPWR VGND sky130_ef_sc_hd__decap_12
XFILLER_5_233 VGND VPWR VPWR VGND sky130_ef_sc_hd__decap_12
X_1190_ net75 _0771_ _0772_ VGND VGND VPWR VPWR _0059_ sky130_fd_sc_hd__and3_1
Xinput9 IOB_in[0] VGND VGND VPWR VPWR net9 sky130_fd_sc_hd__clkbuf_1
XFILLER_32_365 VGND VGND VPWR VPWR sky130_fd_sc_hd__decap_6
X_0974_ net17 net19 net144 net18 VGND VGND VPWR VPWR _0608_ sky130_fd_sc_hd__and4b_4
X_1526_ net109 net174 _0419_ VGND VGND VPWR VPWR _0232_ sky130_fd_sc_hd__mux2_1
X_1457_ net103 net260 _0411_ VGND VGND VPWR VPWR _0171_ sky130_fd_sc_hd__mux2_1
X_1388_ _0400_ u_jt49.bitA _0369_ VGND VGND VPWR VPWR _0113_ sky130_fd_sc_hd__mux2_1
XFILLER_58_295 VGND VPWR VPWR VGND sky130_ef_sc_hd__decap_12
XFILLER_26_170 VGND VPWR VPWR VGND sky130_ef_sc_hd__decap_12
XFILLER_14_365 VGND VPWR VPWR VGND sky130_ef_sc_hd__decap_12
X_1311_ _0336_ u_jt49.bitB net73 VGND VGND VPWR VPWR _0100_ sky130_fd_sc_hd__mux2_1
XFILLER_64_265 VGND VPWR VPWR VGND sky130_ef_sc_hd__decap_12
XFILLER_64_221 VGND VGND VPWR VPWR sky130_fd_sc_hd__decap_3
XPHY_EDGE_ROW_10_Right_10 VGND VGND VPWR VPWR sky130_fd_sc_hd__decap_3
X_1242_ _0281_ u_jt49.u_ng.noise_en _0616_ VGND VGND VPWR VPWR _0086_ sky130_fd_sc_hd__mux2_1
X_1173_ net74 _0758_ _0760_ VGND VGND VPWR VPWR _0054_ sky130_fd_sc_hd__and3_1
X_0957_ u_jt49.regarray\[1\]\[6\] net77 _0593_ _0594_ VGND VGND VPWR VPWR _0595_ sky130_fd_sc_hd__a211o_1
X_0888_ u_jt49.periodC\[0\] net80 _0521_ u_jt49.eg_period\[0\] _0517_ VGND VGND VPWR
+ VPWR _0532_ sky130_fd_sc_hd__a221o_1
XFILLER_46_15 VGND VPWR VPWR VGND sky130_ef_sc_hd__decap_12
X_1509_ u_jt49.periodB\[2\] net107 _0417_ VGND VGND VPWR VPWR _0217_ sky130_fd_sc_hd__mux2_1
XFILLER_55_298 VGND VGND VPWR VPWR sky130_fd_sc_hd__decap_4
Xclkbuf_leaf_26_clk clknet_2_0__leaf_clk VGND VGND VPWR VPWR clknet_leaf_26_clk sky130_fd_sc_hd__clkbuf_8
Xinput23 din[2] VGND VGND VPWR VPWR net23 sky130_fd_sc_hd__clkbuf_1
X_0811_ u_jt49.u_chB.count\[2\] VGND VGND VPWR VPWR _0462_ sky130_fd_sc_hd__inv_2
X_1791_ clknet_leaf_12_clk _0210_ net140 VGND VGND VPWR VPWR u_jt49.periodB\[11\]
+ sky130_fd_sc_hd__dfrtp_2
Xinput12 IOB_in[3] VGND VGND VPWR VPWR net12 sky130_fd_sc_hd__clkbuf_1
XFILLER_42_3 VGND VPWR VPWR VGND sky130_ef_sc_hd__decap_12
X_1225_ net216 net229 net79 VGND VGND VPWR VPWR _0077_ sky130_fd_sc_hd__mux2_1
Xclkbuf_leaf_17_clk clknet_2_3__leaf_clk VGND VGND VPWR VPWR clknet_leaf_17_clk sky130_fd_sc_hd__clkbuf_8
X_1087_ _0689_ _0690_ _0691_ u_jt49.eg_step _0442_ VGND VGND VPWR VPWR _0692_ sky130_fd_sc_hd__a32o_1
X_1156_ u_jt49.u_env.gain\[2\] u_jt49.u_env.inv VGND VGND VPWR VPWR _0750_ sky130_fd_sc_hd__xor2_1
XFILLER_16_29 VGND VGND VPWR VPWR sky130_fd_sc_hd__decap_6
XFILLER_3_320 VGND VGND VPWR VPWR sky130_fd_sc_hd__decap_4
XFILLER_7_169 VGND VGND VPWR VPWR sky130_fd_sc_hd__decap_3
XFILLER_3_331 VGND VGND VPWR VPWR sky130_fd_sc_hd__decap_4
X_1010_ u_jt49.periodC\[10\] u_jt49.u_chC.count\[10\] VGND VGND VPWR VPWR _0628_ sky130_fd_sc_hd__and2b_1
X_1843_ clknet_leaf_30_clk _0267_ net115 VGND VGND VPWR VPWR net65 sky130_fd_sc_hd__dfrtp_1
Xclkbuf_leaf_6_clk clknet_2_1__leaf_clk VGND VGND VPWR VPWR clknet_leaf_6_clk sky130_fd_sc_hd__clkbuf_8
X_1774_ clknet_leaf_0_clk _0193_ net118 VGND VGND VPWR VPWR u_jt49.periodC\[10\] sky130_fd_sc_hd__dfrtp_1
X_1208_ u_jt49.u_envdiv.count\[13\] _0782_ VGND VGND VPWR VPWR _0785_ sky130_fd_sc_hd__or2_1
XFILLER_43_38 VGND VPWR VPWR VGND sky130_ef_sc_hd__decap_12
XFILLER_40_249 VGND VGND VPWR VPWR sky130_fd_sc_hd__decap_3
X_1139_ u_jt49.eg_period\[7\] _0477_ VGND VGND VPWR VPWR _0736_ sky130_fd_sc_hd__nand2_1
XFILLER_4_128 VGND VPWR VPWR VGND sky130_ef_sc_hd__decap_12
XFILLER_0_345 VGND VGND VPWR VPWR sky130_fd_sc_hd__decap_6
XPHY_EDGE_ROW_9_Left_74 VGND VGND VPWR VPWR sky130_fd_sc_hd__decap_3
X_1490_ u_jt49.periodC\[1\] net109 _0415_ VGND VGND VPWR VPWR _0200_ sky130_fd_sc_hd__mux2_1
Xhold1 addr_ok VGND VGND VPWR VPWR net146 sky130_fd_sc_hd__dlygate4sd3_1
XFILLER_3_183 VGND VGND VPWR VPWR sky130_fd_sc_hd__decap_3
XPHY_EDGE_ROW_8_Right_8 VGND VGND VPWR VPWR sky130_fd_sc_hd__decap_3
XFILLER_22_205 VGND VGND VPWR VPWR sky130_fd_sc_hd__decap_3
XFILLER_30_271 VGND VPWR VPWR VGND sky130_ef_sc_hd__decap_12
X_1826_ clknet_leaf_1_clk _0245_ net118 VGND VGND VPWR VPWR u_jt49.periodA\[6\] sky130_fd_sc_hd__dfrtp_1
X_1688_ clknet_leaf_6_clk _0109_ net126 VGND VGND VPWR VPWR u_jt49.u_chA.count\[8\]
+ sky130_fd_sc_hd__dfrtp_1
XPHY_EDGE_ROW_39_Right_39 VGND VGND VPWR VPWR sky130_fd_sc_hd__decap_3
X_1757_ clknet_leaf_2_clk _0176_ net118 VGND VGND VPWR VPWR u_jt49.regarray\[6\]\[1\]
+ sky130_fd_sc_hd__dfrtp_1
XFILLER_57_124 VGND VPWR VPWR VGND sky130_ef_sc_hd__decap_12
XFILLER_57_113 VGND VGND VPWR VPWR sky130_fd_sc_hd__decap_6
XFILLER_54_15 VGND VPWR VPWR VGND sky130_ef_sc_hd__decap_12
XPHY_EDGE_ROW_48_Right_48 VGND VGND VPWR VPWR sky130_fd_sc_hd__decap_3
XPHY_EDGE_ROW_57_Right_57 VGND VGND VPWR VPWR sky130_fd_sc_hd__decap_3
XFILLER_48_102 VGND VPWR VPWR VGND sky130_ef_sc_hd__decap_12
XFILLER_0_175 VGND VGND VPWR VPWR sky130_fd_sc_hd__decap_6
XFILLER_63_149 VGND VPWR VPWR VGND sky130_ef_sc_hd__decap_12
XFILLER_63_105 VGND VGND VPWR VPWR sky130_fd_sc_hd__decap_6
XFILLER_44_352 VGND VPWR VPWR VGND sky130_ef_sc_hd__decap_12
XFILLER_44_81 VGND VGND VPWR VPWR sky130_fd_sc_hd__decap_3
XFILLER_8_220 VGND VGND VPWR VPWR sky130_fd_sc_hd__decap_8
X_1611_ clknet_leaf_0_clk _0034_ net115 VGND VGND VPWR VPWR u_jt49.u_chC.count\[10\]
+ sky130_fd_sc_hd__dfrtp_1
X_0990_ _0614_ _0615_ _0609_ VGND VGND VPWR VPWR _0012_ sky130_fd_sc_hd__o21a_1
XFILLER_5_42 VGND VPWR VPWR VGND sky130_ef_sc_hd__decap_12
X_1473_ net108 u_jt49.regarray\[13\]\[2\] _0413_ VGND VGND VPWR VPWR _0185_ sky130_fd_sc_hd__mux2_1
X_1542_ u_jt49.bitA u_jt49.regarray\[7\]\[0\] u_jt49.regarray\[7\]\[3\] u_jt49.noise
+ net20 VGND VGND VPWR VPWR _0421_ sky130_fd_sc_hd__o221a_1
XFILLER_54_127 VGND VGND VPWR VPWR sky130_fd_sc_hd__decap_3
XPHY_EDGE_ROW_59_Left_124 VGND VGND VPWR VPWR sky130_fd_sc_hd__decap_3
XFILLER_24_29 VGND VGND VPWR VPWR sky130_fd_sc_hd__decap_8
X_1809_ clknet_leaf_25_clk _0228_ net133 VGND VGND VPWR VPWR u_jt49.regarray\[1\]\[5\]
+ sky130_fd_sc_hd__dfrtp_1
XFILLER_41_322 VGND VPWR VPWR VGND sky130_ef_sc_hd__decap_12
X_0973_ net170 _0500_ _0607_ VGND VGND VPWR VPWR _0003_ sky130_fd_sc_hd__a21oi_1
X_1387_ _0397_ _0398_ _0399_ _0497_ VGND VGND VPWR VPWR _0400_ sky130_fd_sc_hd__o31a_1
X_1525_ net111 net190 _0419_ VGND VGND VPWR VPWR _0231_ sky130_fd_sc_hd__mux2_1
XFILLER_19_18 VGND VPWR VPWR VGND sky130_ef_sc_hd__decap_12
X_1456_ net105 net262 _0411_ VGND VGND VPWR VPWR _0170_ sky130_fd_sc_hd__mux2_1
XFILLER_2_226 VGND VPWR VPWR VGND sky130_ef_sc_hd__decap_12
XFILLER_26_182 VGND VPWR VPWR VGND sky130_ef_sc_hd__decap_12
XFILLER_14_377 VGND VGND VPWR VPWR sky130_fd_sc_hd__decap_4
XFILLER_25_50 VGND VGND VPWR VPWR sky130_fd_sc_hd__decap_6
X_1310_ _0333_ _0334_ _0335_ _0496_ VGND VGND VPWR VPWR _0336_ sky130_fd_sc_hd__o31a_1
X_1241_ u_jt49.regarray\[6\]\[1\] _0280_ u_jt49.u_ng.noise_en VGND VGND VPWR VPWR
+ _0281_ sky130_fd_sc_hd__o21ba_1
XPHY_EDGE_ROW_22_Left_87 VGND VGND VPWR VPWR sky130_fd_sc_hd__decap_3
XFILLER_64_277 VGND VGND VPWR VPWR sky130_fd_sc_hd__decap_3
XFILLER_24_108 VGND VPWR VPWR VGND sky130_ef_sc_hd__decap_12
X_1172_ _0759_ VGND VGND VPWR VPWR _0760_ sky130_fd_sc_hd__inv_2
X_0956_ u_jt49.regarray\[10\]\[6\] _0520_ _0526_ u_jt49.eg_period\[14\] _0589_ VGND
+ VGND VPWR VPWR _0594_ sky130_fd_sc_hd__a221o_1
XFILLER_32_141 VGND VGND VPWR VPWR sky130_fd_sc_hd__decap_4
X_0887_ u_jt49.regarray\[13\]\[0\] _0524_ _0530_ u_jt49.regarray\[9\]\[0\] VGND VGND
+ VPWR VPWR _0531_ sky130_fd_sc_hd__a22o_1
X_1508_ u_jt49.periodB\[1\] net109 _0417_ VGND VGND VPWR VPWR _0216_ sky130_fd_sc_hd__mux2_1
X_1439_ u_jt49.regarray\[9\]\[4\] net103 _0409_ VGND VGND VPWR VPWR _0155_ sky130_fd_sc_hd__mux2_1
XFILLER_62_15 VGND VPWR VPWR VGND sky130_ef_sc_hd__decap_12
XFILLER_11_314 VGND VGND VPWR VPWR sky130_fd_sc_hd__decap_4
XFILLER_23_163 VGND VGND VPWR VPWR sky130_fd_sc_hd__decap_4
XFILLER_11_85 VGND VGND VPWR VPWR sky130_fd_sc_hd__decap_6
XFILLER_61_225 VGND VPWR VPWR VGND sky130_ef_sc_hd__decap_12
XFILLER_46_222 VGND VGND VPWR VPWR sky130_fd_sc_hd__decap_8
X_0810_ u_jt49.u_chB.count\[3\] VGND VGND VPWR VPWR _0461_ sky130_fd_sc_hd__inv_2
X_1790_ clknet_leaf_11_clk _0209_ net139 VGND VGND VPWR VPWR u_jt49.periodB\[10\]
+ sky130_fd_sc_hd__dfrtp_1
Xinput13 IOB_in[4] VGND VGND VPWR VPWR net13 sky130_fd_sc_hd__clkbuf_1
Xinput24 din[3] VGND VGND VPWR VPWR net24 sky130_fd_sc_hd__buf_1
X_1224_ net214 net216 net78 VGND VGND VPWR VPWR _0076_ sky130_fd_sc_hd__mux2_1
X_1086_ u_jt49.eg_period\[13\] u_jt49.eg_period\[12\] u_jt49.eg_period\[15\] u_jt49.eg_period\[14\]
+ VGND VGND VPWR VPWR _0691_ sky130_fd_sc_hd__nor4_1
X_1155_ net248 _0749_ net85 VGND VGND VPWR VPWR _0047_ sky130_fd_sc_hd__mux2_1
X_0939_ net13 _0541_ _0542_ net5 _0578_ VGND VGND VPWR VPWR _0270_ sky130_fd_sc_hd__a221o_1
Xclkbuf_2_2__f_clk clknet_0_clk VGND VGND VPWR VPWR clknet_2_2__leaf_clk sky130_fd_sc_hd__clkbuf_16
XFILLER_22_73 VGND VGND VPWR VPWR sky130_fd_sc_hd__decap_8
XFILLER_34_203 VGND VPWR VPWR VGND sky130_ef_sc_hd__decap_12
XFILLER_42_280 VGND VPWR VPWR VGND sky130_ef_sc_hd__decap_12
X_1842_ clknet_leaf_29_clk _0266_ net115 VGND VGND VPWR VPWR net64 sky130_fd_sc_hd__dfrtp_1
X_1773_ clknet_leaf_2_clk _0192_ net120 VGND VGND VPWR VPWR u_jt49.periodC\[9\] sky130_fd_sc_hd__dfrtp_2
X_1207_ net75 _0783_ _0784_ VGND VGND VPWR VPWR _0064_ sky130_fd_sc_hd__and3_1
XPHY_EDGE_ROW_40_Left_105 VGND VGND VPWR VPWR sky130_fd_sc_hd__decap_3
XPHY_EDGE_ROW_25_Left_90 VGND VGND VPWR VPWR sky130_fd_sc_hd__decap_3
X_1138_ u_jt49.u_envdiv.count\[3\] u_jt49.eg_period\[3\] VGND VGND VPWR VPWR _0735_
+ sky130_fd_sc_hd__nand2b_1
X_1069_ _0678_ VGND VGND VPWR VPWR _0679_ sky130_fd_sc_hd__inv_2
XFILLER_17_51 VGND VGND VPWR VPWR sky130_fd_sc_hd__decap_4
XFILLER_3_195 VGND VGND VPWR VPWR sky130_fd_sc_hd__decap_4
XFILLER_54_309 VGND VPWR VPWR VGND sky130_ef_sc_hd__decap_12
Xhold2 u_jt49.Amix VGND VGND VPWR VPWR net147 sky130_fd_sc_hd__dlygate4sd3_1
XFILLER_30_283 VGND VGND VPWR VPWR sky130_fd_sc_hd__decap_4
X_1756_ clknet_leaf_2_clk _0175_ net117 VGND VGND VPWR VPWR u_jt49.regarray\[6\]\[0\]
+ sky130_fd_sc_hd__dfrtp_1
X_1825_ clknet_leaf_1_clk _0244_ net118 VGND VGND VPWR VPWR u_jt49.periodA\[5\] sky130_fd_sc_hd__dfrtp_1
X_1687_ clknet_leaf_5_clk _0108_ net123 VGND VGND VPWR VPWR u_jt49.u_chA.count\[7\]
+ sky130_fd_sc_hd__dfrtp_1
XFILLER_57_169 VGND VGND VPWR VPWR sky130_fd_sc_hd__decap_4
XFILLER_57_136 VGND VGND VPWR VPWR sky130_fd_sc_hd__decap_3
XFILLER_54_49 VGND VGND VPWR VPWR sky130_fd_sc_hd__decap_6
XFILLER_48_114 VGND VPWR VPWR VGND sky130_ef_sc_hd__decap_12
XFILLER_60_70 VGND VPWR VPWR VGND sky130_ef_sc_hd__decap_12
X_1610_ clknet_leaf_30_clk _0033_ net115 VGND VGND VPWR VPWR u_jt49.u_chC.count\[9\]
+ sky130_fd_sc_hd__dfrtp_1
XFILLER_8_276 VGND VGND VPWR VPWR sky130_fd_sc_hd__decap_8
X_1541_ u_jt49.periodA\[7\] net97 _0420_ VGND VGND VPWR VPWR _0246_ sky130_fd_sc_hd__mux2_1
X_1472_ net110 net266 _0413_ VGND VGND VPWR VPWR _0184_ sky130_fd_sc_hd__mux2_1
X_1739_ clknet_leaf_18_clk _0158_ net134 VGND VGND VPWR VPWR u_jt49.regarray\[9\]\[7\]
+ sky130_fd_sc_hd__dfrtp_1
X_1808_ clknet_leaf_26_clk _0227_ net133 VGND VGND VPWR VPWR u_jt49.regarray\[1\]\[4\]
+ sky130_fd_sc_hd__dfrtp_1
XFILLER_60_109 VGND VPWR VPWR VGND sky130_ef_sc_hd__decap_12
XFILLER_53_150 VGND VPWR VPWR VGND sky130_ef_sc_hd__decap_12
XFILLER_38_180 VGND VGND VPWR VPWR sky130_fd_sc_hd__decap_6
XFILLER_14_85 VGND VPWR VPWR VGND sky130_ef_sc_hd__decap_12
X_0972_ net168 _0500_ _0607_ net170 VGND VGND VPWR VPWR _0002_ sky130_fd_sc_hd__a211oi_1
X_1524_ net81 _0541_ VGND VGND VPWR VPWR _0419_ sky130_fd_sc_hd__nand2_4
X_1386_ u_jt49.periodA\[11\] u_jt49.periodA\[10\] u_jt49.periodA\[9\] u_jt49.periodA\[8\]
+ VGND VGND VPWR VPWR _0399_ sky130_fd_sc_hd__or4_1
X_1455_ net108 net255 _0411_ VGND VGND VPWR VPWR _0169_ sky130_fd_sc_hd__mux2_1
XFILLER_51_17 VGND VGND VPWR VPWR sky130_fd_sc_hd__decap_6
XFILLER_50_186 VGND VGND VPWR VPWR sky130_fd_sc_hd__decap_6
XFILLER_2_238 VGND VGND VPWR VPWR sky130_fd_sc_hd__decap_6
XFILLER_58_253 VGND VGND VPWR VPWR sky130_fd_sc_hd__decap_6
XFILLER_33_109 VGND VGND VPWR VPWR sky130_fd_sc_hd__decap_3
XFILLER_18_117 VGND VGND VPWR VPWR sky130_fd_sc_hd__decap_3
XFILLER_26_150 VGND VGND VPWR VPWR sky130_fd_sc_hd__decap_8
XFILLER_14_301 VGND VGND VPWR VPWR sky130_fd_sc_hd__decap_6
XFILLER_41_94 VGND VPWR VPWR VGND sky130_ef_sc_hd__decap_12
X_1171_ u_jt49.u_envdiv.count\[2\] _0755_ VGND VGND VPWR VPWR _0759_ sky130_fd_sc_hd__and2_1
X_1240_ u_jt49.regarray\[6\]\[0\] u_jt49.regarray\[6\]\[3\] u_jt49.regarray\[6\]\[2\]
+ u_jt49.regarray\[6\]\[4\] VGND VGND VPWR VPWR _0280_ sky130_fd_sc_hd__or4_1
XFILLER_17_161 VGND VGND VPWR VPWR sky130_fd_sc_hd__decap_6
X_0955_ u_jt49.eg_period\[6\] _0521_ _0530_ u_jt49.regarray\[9\]\[6\] VGND VGND VPWR
+ VPWR _0593_ sky130_fd_sc_hd__a22o_1
X_0886_ net91 net93 net95 net89 VGND VGND VPWR VPWR _0530_ sky130_fd_sc_hd__and4bb_4
X_1507_ net275 net111 _0417_ VGND VGND VPWR VPWR _0215_ sky130_fd_sc_hd__mux2_1
X_1369_ _0386_ VGND VGND VPWR VPWR _0387_ sky130_fd_sc_hd__inv_2
X_1438_ u_jt49.regarray\[9\]\[3\] net106 _0409_ VGND VGND VPWR VPWR _0154_ sky130_fd_sc_hd__mux2_1
XFILLER_11_337 VGND VGND VPWR VPWR sky130_fd_sc_hd__decap_8
XFILLER_15_109 VGND VGND VPWR VPWR sky130_fd_sc_hd__decap_3
XFILLER_11_42 VGND VGND VPWR VPWR sky130_fd_sc_hd__decap_8
XFILLER_61_237 VGND VPWR VPWR VGND sky130_ef_sc_hd__decap_12
Xinput25 din[4] VGND VGND VPWR VPWR net25 sky130_fd_sc_hd__buf_1
Xinput14 IOB_in[5] VGND VGND VPWR VPWR net14 sky130_fd_sc_hd__clkbuf_1
X_1223_ u_jt49.u_ng.poly17\[7\] net214 net78 VGND VGND VPWR VPWR _0075_ sky130_fd_sc_hd__mux2_1
X_1154_ u_jt49.u_env.gain\[1\] u_jt49.u_env.inv VGND VGND VPWR VPWR _0749_ sky130_fd_sc_hd__xor2_1
X_1085_ u_jt49.eg_period\[9\] u_jt49.eg_period\[8\] u_jt49.eg_period\[11\] u_jt49.eg_period\[10\]
+ VGND VGND VPWR VPWR _0690_ sky130_fd_sc_hd__nor4_1
X_0869_ _0507_ _0510_ _0512_ _0513_ VGND VGND VPWR VPWR _0001_ sky130_fd_sc_hd__o22a_1
X_0938_ u_jt49.periodA\[4\] _0518_ _0539_ _0577_ u_jt49.read_mask\[4\] VGND VGND VPWR
+ VPWR _0578_ sky130_fd_sc_hd__o2111a_1
XFILLER_51_281 VGND VPWR VPWR VGND sky130_ef_sc_hd__decap_12
XFILLER_22_85 VGND VGND VPWR VPWR sky130_fd_sc_hd__decap_8
XFILLER_63_81 VGND VPWR VPWR VGND sky130_ef_sc_hd__decap_12
XFILLER_34_248 VGND VGND VPWR VPWR sky130_fd_sc_hd__decap_4
XFILLER_34_215 VGND VPWR VPWR VGND sky130_ef_sc_hd__decap_12
XFILLER_42_292 VGND VGND VPWR VPWR sky130_fd_sc_hd__decap_3
X_1841_ clknet_leaf_23_clk _0259_ VGND VGND VPWR VPWR net40 sky130_fd_sc_hd__dfxtp_1
X_1772_ clknet_leaf_2_clk _0191_ net120 VGND VGND VPWR VPWR u_jt49.periodC\[8\] sky130_fd_sc_hd__dfrtp_1
X_1206_ u_jt49.u_envdiv.count\[12\] _0779_ VGND VGND VPWR VPWR _0784_ sky130_fd_sc_hd__or2_1
X_1137_ u_jt49.eg_period\[4\] _0480_ VGND VGND VPWR VPWR _0734_ sky130_fd_sc_hd__nand2_1
X_1068_ net86 u_jt49.u_chC.count\[8\] _0674_ VGND VGND VPWR VPWR _0678_ sky130_fd_sc_hd__and3_1
XFILLER_62_321 VGND VPWR VPWR VGND sky130_ef_sc_hd__decap_12
Xhold3 u_jt49.Bmix VGND VGND VPWR VPWR net148 sky130_fd_sc_hd__dlygate4sd3_1
XFILLER_62_365 VGND VPWR VPWR VGND sky130_ef_sc_hd__decap_12
X_1755_ clknet_leaf_10_clk _0174_ net127 VGND VGND VPWR VPWR net55 sky130_fd_sc_hd__dfrtp_2
X_1686_ clknet_leaf_4_clk _0107_ net123 VGND VGND VPWR VPWR u_jt49.u_chA.count\[6\]
+ sky130_fd_sc_hd__dfrtp_1
X_1824_ clknet_leaf_2_clk _0243_ net118 VGND VGND VPWR VPWR u_jt49.periodA\[4\] sky130_fd_sc_hd__dfrtp_1
XFILLER_57_104 VGND VGND VPWR VPWR sky130_fd_sc_hd__decap_8
XFILLER_21_262 VGND VGND VPWR VPWR sky130_fd_sc_hd__decap_8
XFILLER_0_100 VGND VPWR VPWR VGND sky130_ef_sc_hd__decap_12
XFILLER_48_126 VGND VGND VPWR VPWR sky130_fd_sc_hd__decap_6
XFILLER_44_365 VGND VPWR VPWR VGND sky130_ef_sc_hd__decap_12
X_1540_ u_jt49.periodA\[6\] net100 _0420_ VGND VGND VPWR VPWR _0245_ sky130_fd_sc_hd__mux2_1
XFILLER_10_3 VGND VPWR VPWR VGND sky130_ef_sc_hd__decap_12
X_1471_ net112 net270 _0413_ VGND VGND VPWR VPWR _0183_ sky130_fd_sc_hd__mux2_1
X_1807_ clknet_leaf_3_clk _0226_ net128 VGND VGND VPWR VPWR u_jt49.periodA\[11\] sky130_fd_sc_hd__dfrtp_1
X_1669_ clknet_leaf_8_clk _0090_ net129 VGND VGND VPWR VPWR u_jt49.u_chB.count\[2\]
+ sky130_fd_sc_hd__dfrtp_1
XFILLER_49_17 VGND VGND VPWR VPWR sky130_fd_sc_hd__decap_4
X_1738_ clknet_leaf_17_clk _0157_ net134 VGND VGND VPWR VPWR u_jt49.regarray\[9\]\[6\]
+ sky130_fd_sc_hd__dfrtp_1
XFILLER_53_195 VGND VPWR VPWR VGND sky130_ef_sc_hd__decap_12
XFILLER_53_162 VGND VGND VPWR VPWR sky130_fd_sc_hd__decap_6
XFILLER_14_97 VGND VPWR VPWR VGND sky130_ef_sc_hd__decap_12
XFILLER_30_85 VGND VPWR VPWR VGND sky130_ef_sc_hd__decap_12
XFILLER_55_82 VGND VPWR VPWR VGND sky130_ef_sc_hd__decap_12
XFILLER_17_310 VGND VPWR VPWR VGND sky130_ef_sc_hd__decap_12
X_0971_ u_jt49.u_cen.cencnt\[0\] u_jt49.u_cen.cencnt\[1\] _0501_ VGND VGND VPWR VPWR
+ _0607_ sky130_fd_sc_hd__or3_1
XFILLER_32_357 VGND VGND VPWR VPWR sky130_fd_sc_hd__decap_6
XFILLER_58_3 VGND VGND VPWR VPWR sky130_fd_sc_hd__decap_6
X_1523_ net172 net97 _0418_ VGND VGND VPWR VPWR _0230_ sky130_fd_sc_hd__mux2_1
X_1454_ net109 net242 _0411_ VGND VGND VPWR VPWR _0168_ sky130_fd_sc_hd__mux2_1
X_1385_ u_jt49.periodA\[7\] u_jt49.periodA\[6\] u_jt49.periodA\[5\] u_jt49.periodA\[4\]
+ VGND VGND VPWR VPWR _0398_ sky130_fd_sc_hd__or4_1
XFILLER_23_302 VGND VGND VPWR VPWR sky130_fd_sc_hd__decap_8
XFILLER_58_221 VGND VPWR VPWR VGND sky130_ef_sc_hd__decap_12
XFILLER_25_85 VGND VGND VPWR VPWR sky130_fd_sc_hd__decap_8
XFILLER_64_213 VGND VGND VPWR VPWR sky130_fd_sc_hd__decap_8
X_1170_ u_jt49.u_envdiv.count\[2\] _0755_ VGND VGND VPWR VPWR _0758_ sky130_fd_sc_hd__or2_1
XFILLER_2_23 VGND VGND VPWR VPWR sky130_fd_sc_hd__decap_4
XFILLER_32_110 VGND VGND VPWR VPWR sky130_fd_sc_hd__decap_6
Xclkbuf_leaf_29_clk clknet_2_0__leaf_clk VGND VGND VPWR VPWR clknet_leaf_29_clk sky130_fd_sc_hd__clkbuf_8
XFILLER_20_305 VGND VGND VPWR VPWR sky130_fd_sc_hd__decap_3
X_0954_ u_jt49.regarray\[3\]\[6\] _0522_ _0529_ u_jt49.regarray\[8\]\[6\] _0588_ VGND
+ VGND VPWR VPWR _0592_ sky130_fd_sc_hd__a221o_1
X_0885_ net91 _0514_ net89 VGND VGND VPWR VPWR _0529_ sky130_fd_sc_hd__nor3b_4
XFILLER_9_361 VGND VPWR VPWR VGND sky130_ef_sc_hd__decap_12
X_1506_ net81 _0528_ VGND VGND VPWR VPWR _0417_ sky130_fd_sc_hd__and2_2
X_1437_ net261 net108 _0409_ VGND VGND VPWR VPWR _0153_ sky130_fd_sc_hd__mux2_1
X_1299_ net73 _0327_ _0328_ VGND VGND VPWR VPWR _0096_ sky130_fd_sc_hd__and3_1
XFILLER_46_29 VGND VGND VPWR VPWR sky130_fd_sc_hd__decap_3
X_1368_ u_jt49.u_chA.count\[7\] u_jt49.u_chA.count\[6\] _0381_ VGND VGND VPWR VPWR
+ _0386_ sky130_fd_sc_hd__and3_1
XFILLER_11_305 VGND VGND VPWR VPWR sky130_fd_sc_hd__decap_3
XFILLER_11_98 VGND VGND VPWR VPWR sky130_fd_sc_hd__decap_8
XFILLER_61_249 VGND VPWR VPWR VGND sky130_ef_sc_hd__decap_12
XFILLER_61_205 VGND VPWR VPWR VGND sky130_ef_sc_hd__decap_12
XFILLER_36_40 VGND VPWR VPWR VGND sky130_ef_sc_hd__decap_12
XFILLER_14_121 VGND VPWR VPWR VGND sky130_ef_sc_hd__decap_12
Xinput26 din[5] VGND VGND VPWR VPWR net26 sky130_fd_sc_hd__clkbuf_1
Xinput15 IOB_in[6] VGND VGND VPWR VPWR net15 sky130_fd_sc_hd__clkbuf_1
X_1222_ net232 u_jt49.u_ng.poly17\[7\] net78 VGND VGND VPWR VPWR _0074_ sky130_fd_sc_hd__mux2_1
X_1084_ _0687_ _0688_ VGND VGND VPWR VPWR _0689_ sky130_fd_sc_hd__nor2_1
X_1153_ net272 _0748_ net85 VGND VGND VPWR VPWR _0046_ sky130_fd_sc_hd__mux2_1
Xclkbuf_leaf_9_clk clknet_2_1__leaf_clk VGND VGND VPWR VPWR clknet_leaf_9_clk sky130_fd_sc_hd__clkbuf_8
X_0868_ _0509_ _0017_ VGND VGND VPWR VPWR _0513_ sky130_fd_sc_hd__xnor2_1
X_0937_ _0573_ _0574_ _0576_ VGND VGND VPWR VPWR _0577_ sky130_fd_sc_hd__or3_1
X_0799_ u_jt49.u_env.stop VGND VGND VPWR VPWR _0450_ sky130_fd_sc_hd__inv_2
XFILLER_51_293 VGND VPWR VPWR VGND sky130_ef_sc_hd__decap_12
XFILLER_11_113 VGND VGND VPWR VPWR sky130_fd_sc_hd__decap_4
XFILLER_63_93 VGND VPWR VPWR VGND sky130_ef_sc_hd__decap_12
XFILLER_34_227 VGND VPWR VPWR VGND sky130_ef_sc_hd__decap_12
X_1840_ clknet_leaf_23_clk _0258_ VGND VGND VPWR VPWR net39 sky130_fd_sc_hd__dfxtp_1
X_1771_ clknet_leaf_18_clk _0190_ net134 VGND VGND VPWR VPWR u_jt49.regarray\[13\]\[7\]
+ sky130_fd_sc_hd__dfrtp_1
X_1205_ _0782_ VGND VGND VPWR VPWR _0783_ sky130_fd_sc_hd__inv_2
X_1136_ _0443_ u_jt49.u_envdiv.count\[1\] u_jt49.u_envdiv.count\[0\] _0444_ VGND VGND
+ VPWR VPWR _0733_ sky130_fd_sc_hd__a211o_1
X_1067_ net86 _0674_ u_jt49.u_chC.count\[8\] VGND VGND VPWR VPWR _0677_ sky130_fd_sc_hd__a21o_1
XFILLER_18_290 VGND VPWR VPWR VGND sky130_ef_sc_hd__decap_12
XFILLER_31_208 VGND VGND VPWR VPWR sky130_fd_sc_hd__decap_6
Xhold4 u_jt49.eg_restart VGND VGND VPWR VPWR net149 sky130_fd_sc_hd__dlygate4sd3_1
XFILLER_62_333 VGND VPWR VPWR VGND sky130_ef_sc_hd__decap_12
XFILLER_62_377 VGND VGND VPWR VPWR sky130_fd_sc_hd__decap_4
XFILLER_30_296 VGND VPWR VPWR VGND sky130_ef_sc_hd__decap_12
X_1823_ clknet_leaf_1_clk _0242_ net117 VGND VGND VPWR VPWR u_jt49.periodA\[3\] sky130_fd_sc_hd__dfrtp_1
X_1754_ clknet_leaf_12_clk _0173_ net139 VGND VGND VPWR VPWR net46 sky130_fd_sc_hd__dfrtp_2
X_1685_ clknet_leaf_5_clk _0106_ net123 VGND VGND VPWR VPWR u_jt49.u_chA.count\[5\]
+ sky130_fd_sc_hd__dfrtp_2
X_1119_ _0712_ _0715_ _0711_ VGND VGND VPWR VPWR _0716_ sky130_fd_sc_hd__a21oi_1
XPHY_EDGE_ROW_17_Right_17 VGND VGND VPWR VPWR sky130_fd_sc_hd__decap_3
XPHY_EDGE_ROW_26_Right_26 VGND VGND VPWR VPWR sky130_fd_sc_hd__decap_3
XFILLER_56_182 VGND VPWR VPWR VGND sky130_ef_sc_hd__decap_12
XFILLER_28_85 VGND VGND VPWR VPWR sky130_fd_sc_hd__decap_3
XFILLER_44_377 VGND VGND VPWR VPWR sky130_fd_sc_hd__decap_4
XFILLER_44_73 VGND VGND VPWR VPWR sky130_fd_sc_hd__decap_8
XFILLER_44_40 VGND VGND VPWR VPWR sky130_fd_sc_hd__decap_8
XPHY_EDGE_ROW_35_Right_35 VGND VGND VPWR VPWR sky130_fd_sc_hd__decap_3
X_1470_ net82 _0524_ VGND VGND VPWR VPWR _0413_ sky130_fd_sc_hd__nand2_4
XPHY_EDGE_ROW_44_Right_44 VGND VGND VPWR VPWR sky130_fd_sc_hd__decap_3
XFILLER_62_141 VGND VPWR VPWR VGND sky130_ef_sc_hd__decap_12
XPHY_EDGE_ROW_53_Right_53 VGND VGND VPWR VPWR sky130_fd_sc_hd__decap_3
XFILLER_50_347 VGND VPWR VPWR VGND sky130_ef_sc_hd__decap_12
X_1806_ clknet_leaf_3_clk _0225_ net127 VGND VGND VPWR VPWR u_jt49.periodA\[10\] sky130_fd_sc_hd__dfrtp_2
XPHY_EDGE_ROW_62_Right_62 VGND VGND VPWR VPWR sky130_fd_sc_hd__decap_3
X_1599_ clknet_leaf_15_clk _0022_ VGND VGND VPWR VPWR cs_n sky130_fd_sc_hd__dfxtp_1
X_1668_ clknet_leaf_10_clk _0089_ net129 VGND VGND VPWR VPWR u_jt49.u_chB.count\[1\]
+ sky130_fd_sc_hd__dfrtp_1
XPHY_EDGE_ROW_37_Left_102 VGND VGND VPWR VPWR sky130_fd_sc_hd__decap_3
X_1737_ clknet_leaf_25_clk _0156_ net133 VGND VGND VPWR VPWR u_jt49.regarray\[9\]\[5\]
+ sky130_fd_sc_hd__dfrtp_1
XPHY_EDGE_ROW_46_Left_111 VGND VGND VPWR VPWR sky130_fd_sc_hd__decap_3
XFILLER_14_76 VGND VGND VPWR VPWR sky130_fd_sc_hd__decap_8
XPHY_EDGE_ROW_55_Left_120 VGND VGND VPWR VPWR sky130_fd_sc_hd__decap_3
XFILLER_30_97 VGND VPWR VPWR VGND sky130_ef_sc_hd__decap_12
XFILLER_55_94 VGND VPWR VPWR VGND sky130_ef_sc_hd__decap_12
XFILLER_17_322 VGND VPWR VPWR VGND sky130_ef_sc_hd__decap_12
X_0970_ net16 _0541_ _0542_ net8 _0606_ VGND VGND VPWR VPWR _0273_ sky130_fd_sc_hd__a221o_1
X_1522_ net188 net99 _0418_ VGND VGND VPWR VPWR _0229_ sky130_fd_sc_hd__mux2_1
XFILLER_4_281 VGND VPWR VPWR VGND sky130_ef_sc_hd__decap_12
X_1453_ net111 net246 _0411_ VGND VGND VPWR VPWR _0167_ sky130_fd_sc_hd__mux2_1
X_1384_ u_jt49.periodA\[3\] u_jt49.periodA\[2\] u_jt49.periodA\[1\] u_jt49.periodA\[0\]
+ VGND VGND VPWR VPWR _0397_ sky130_fd_sc_hd__or4_1
XFILLER_50_144 VGND VGND VPWR VPWR sky130_fd_sc_hd__decap_6
XFILLER_58_233 VGND VPWR VPWR VGND sky130_ef_sc_hd__decap_12
XFILLER_14_347 VGND VPWR VPWR VGND sky130_ef_sc_hd__decap_12
XFILLER_41_188 VGND VGND VPWR VPWR sky130_fd_sc_hd__decap_6
XFILLER_64_225 VGND VPWR VPWR VGND sky130_ef_sc_hd__decap_12
XFILLER_64_247 VGND VGND VPWR VPWR sky130_fd_sc_hd__decap_4
X_0953_ u_jt49.regarray\[13\]\[6\] _0524_ _0525_ u_jt49.regarray\[5\]\[6\] _0590_
+ VGND VGND VPWR VPWR _0591_ sky130_fd_sc_hd__a221o_1
X_0884_ net95 _0516_ net93 VGND VGND VPWR VPWR _0528_ sky130_fd_sc_hd__nor3b_4
XFILLER_9_373 VGND VGND VPWR VPWR sky130_fd_sc_hd__decap_8
X_1367_ _0369_ _0384_ _0385_ VGND VGND VPWR VPWR _0107_ sky130_fd_sc_hd__and3_1
X_1505_ net192 net97 _0416_ VGND VGND VPWR VPWR _0214_ sky130_fd_sc_hd__mux2_1
X_1436_ net253 net110 _0409_ VGND VGND VPWR VPWR _0152_ sky130_fd_sc_hd__mux2_1
XFILLER_55_225 VGND VPWR VPWR VGND sky130_ef_sc_hd__decap_12
X_1298_ u_jt49.u_chB.count\[8\] _0323_ VGND VGND VPWR VPWR _0328_ sky130_fd_sc_hd__or2_1
XFILLER_62_29 VGND VPWR VPWR VGND sky130_ef_sc_hd__decap_12
XFILLER_46_247 VGND VGND VPWR VPWR sky130_fd_sc_hd__decap_4
XFILLER_61_217 VGND VGND VPWR VPWR sky130_fd_sc_hd__decap_6
XFILLER_36_85 VGND VPWR VPWR VGND sky130_ef_sc_hd__decap_12
XFILLER_36_52 VGND VPWR VPWR VGND sky130_ef_sc_hd__decap_12
XFILLER_14_133 VGND VGND VPWR VPWR sky130_fd_sc_hd__decap_6
Xinput27 din[6] VGND VGND VPWR VPWR net27 sky130_fd_sc_hd__clkbuf_1
Xinput16 IOB_in[7] VGND VGND VPWR VPWR net16 sky130_fd_sc_hd__buf_1
XFILLER_6_365 VGND VPWR VPWR VGND sky130_ef_sc_hd__decap_12
XFILLER_10_361 VGND VGND VPWR VPWR sky130_fd_sc_hd__decap_3
X_1221_ net240 net232 net78 VGND VGND VPWR VPWR _0073_ sky130_fd_sc_hd__mux2_1
XFILLER_37_225 VGND VGND VPWR VPWR sky130_fd_sc_hd__decap_8
X_1152_ u_jt49.u_env.gain\[0\] u_jt49.u_env.inv VGND VGND VPWR VPWR _0748_ sky130_fd_sc_hd__xor2_1
X_1083_ u_jt49.eg_period\[1\] u_jt49.eg_period\[0\] u_jt49.eg_period\[3\] u_jt49.eg_period\[2\]
+ VGND VGND VPWR VPWR _0688_ sky130_fd_sc_hd__or4_1
XFILLER_20_169 VGND VGND VPWR VPWR sky130_fd_sc_hd__decap_8
X_0936_ u_jt49.regarray\[13\]\[4\] _0524_ _0575_ _0517_ VGND VGND VPWR VPWR _0576_
+ sky130_fd_sc_hd__a211o_1
X_0867_ net129 _0506_ _0508_ VGND VGND VPWR VPWR _0512_ sky130_fd_sc_hd__and3_1
X_0798_ u_jt49.eg_period\[14\] VGND VGND VPWR VPWR _0449_ sky130_fd_sc_hd__inv_2
XFILLER_28_214 VGND VGND VPWR VPWR sky130_fd_sc_hd__decap_3
X_1419_ net108 u_jt49.eg_period\[2\] _0407_ VGND VGND VPWR VPWR _0137_ sky130_fd_sc_hd__mux2_1
XFILLER_3_302 VGND VGND VPWR VPWR sky130_fd_sc_hd__decap_6
XFILLER_11_169 VGND VPWR VPWR VGND sky130_ef_sc_hd__decap_12
X_1770_ clknet_leaf_18_clk _0189_ net133 VGND VGND VPWR VPWR u_jt49.regarray\[13\]\[6\]
+ sky130_fd_sc_hd__dfrtp_1
XFILLER_8_34 VGND VGND VPWR VPWR sky130_fd_sc_hd__decap_8
XFILLER_6_151 VGND VGND VPWR VPWR sky130_fd_sc_hd__decap_4
XFILLER_6_162 VGND VPWR VPWR VGND sky130_ef_sc_hd__decap_12
X_1204_ u_jt49.u_envdiv.count\[12\] _0779_ VGND VGND VPWR VPWR _0782_ sky130_fd_sc_hd__and2_1
X_1135_ _0729_ _0730_ _0731_ VGND VGND VPWR VPWR _0732_ sky130_fd_sc_hd__o21ai_1
X_1066_ _0657_ _0675_ _0676_ net251 net84 VGND VGND VPWR VPWR _0031_ sky130_fd_sc_hd__a32o_1
X_0919_ net11 _0541_ _0542_ net3 _0560_ VGND VGND VPWR VPWR _0268_ sky130_fd_sc_hd__a221o_1
XFILLER_16_206 VGND VPWR VPWR VGND sky130_ef_sc_hd__decap_12
XFILLER_24_261 VGND VGND VPWR VPWR sky130_fd_sc_hd__decap_3
XFILLER_58_94 VGND VPWR VPWR VGND sky130_ef_sc_hd__decap_12
XFILLER_58_72 VGND VGND VPWR VPWR sky130_fd_sc_hd__decap_3
Xhold5 _0036_ VGND VGND VPWR VPWR net150 sky130_fd_sc_hd__dlygate4sd3_1
XFILLER_62_345 VGND VPWR VPWR VGND sky130_ef_sc_hd__decap_12
XFILLER_62_301 VGND VGND VPWR VPWR sky130_fd_sc_hd__decap_6
XFILLER_15_250 VGND VGND VPWR VPWR sky130_fd_sc_hd__decap_8
XPHY_EDGE_ROW_29_Left_94 VGND VGND VPWR VPWR sky130_fd_sc_hd__decap_3
X_1753_ clknet_leaf_25_clk _0172_ net131 VGND VGND VPWR VPWR u_jt49.regarray\[7\]\[5\]
+ sky130_fd_sc_hd__dfrtp_1
X_1822_ clknet_leaf_1_clk _0241_ net117 VGND VGND VPWR VPWR u_jt49.periodA\[2\] sky130_fd_sc_hd__dfrtp_1
X_1684_ clknet_leaf_5_clk _0105_ net123 VGND VGND VPWR VPWR u_jt49.u_chA.count\[4\]
+ sky130_fd_sc_hd__dfrtp_1
XPHY_EDGE_ROW_13_Left_78 VGND VGND VPWR VPWR sky130_fd_sc_hd__decap_3
X_1118_ _0447_ u_jt49.u_envdiv.count\[13\] u_jt49.u_envdiv.count\[12\] _0448_ VGND
+ VGND VPWR VPWR _0715_ sky130_fd_sc_hd__a22o_1
X_1049_ _0659_ _0663_ _0664_ VGND VGND VPWR VPWR _0026_ sky130_fd_sc_hd__and3_1
XFILLER_13_209 VGND VGND VPWR VPWR sky130_fd_sc_hd__decap_4
XFILLER_44_334 VGND VPWR VPWR VGND sky130_ef_sc_hd__decap_12
XFILLER_28_97 VGND VGND VPWR VPWR sky130_fd_sc_hd__decap_6
XFILLER_44_96 VGND VPWR VPWR VGND sky130_ef_sc_hd__decap_12
XFILLER_12_253 VGND VGND VPWR VPWR sky130_fd_sc_hd__decap_3
XFILLER_5_57 VGND VGND VPWR VPWR sky130_fd_sc_hd__decap_4
XFILLER_62_197 VGND VPWR VPWR VGND sky130_ef_sc_hd__decap_12
XFILLER_62_153 VGND VPWR VPWR VGND sky130_ef_sc_hd__decap_12
XFILLER_50_359 VGND VGND VPWR VPWR sky130_fd_sc_hd__decap_4
X_1805_ clknet_leaf_3_clk _0224_ net127 VGND VGND VPWR VPWR u_jt49.periodA\[9\] sky130_fd_sc_hd__dfrtp_1
X_1736_ clknet_leaf_24_clk _0155_ net131 VGND VGND VPWR VPWR u_jt49.regarray\[9\]\[4\]
+ sky130_fd_sc_hd__dfrtp_4
X_1598_ clknet_leaf_15_clk _0021_ VGND VGND VPWR VPWR addr_ok sky130_fd_sc_hd__dfxtp_1
X_1667_ clknet_leaf_10_clk _0088_ net129 VGND VGND VPWR VPWR u_jt49.u_chB.count\[0\]
+ sky130_fd_sc_hd__dfstp_1
XFILLER_45_109 VGND VGND VPWR VPWR sky130_fd_sc_hd__decap_3
XFILLER_41_337 VGND VGND VPWR VPWR sky130_fd_sc_hd__decap_4
XFILLER_44_131 VGND VGND VPWR VPWR sky130_fd_sc_hd__decap_8
X_1383_ _0369_ _0396_ VGND VGND VPWR VPWR _0112_ sky130_fd_sc_hd__and2_1
XFILLER_4_293 VGND VGND VPWR VPWR sky130_fd_sc_hd__decap_8
X_1452_ net81 _0519_ VGND VGND VPWR VPWR _0411_ sky130_fd_sc_hd__nand2_4
X_1521_ net203 net101 _0418_ VGND VGND VPWR VPWR _0228_ sky130_fd_sc_hd__mux2_1
XFILLER_35_197 VGND VGND VPWR VPWR sky130_fd_sc_hd__decap_4
XFILLER_23_337 VGND VPWR VPWR VGND sky130_ef_sc_hd__decap_12
X_1719_ clknet_leaf_19_clk _0138_ net135 VGND VGND VPWR VPWR u_jt49.eg_period\[3\]
+ sky130_fd_sc_hd__dfrtp_1
XFILLER_58_245 VGND VGND VPWR VPWR sky130_fd_sc_hd__decap_6
XPHY_EDGE_ROW_16_Left_81 VGND VGND VPWR VPWR sky130_fd_sc_hd__decap_3
XFILLER_18_109 VGND VGND VPWR VPWR sky130_fd_sc_hd__decap_8
XFILLER_14_359 VGND VGND VPWR VPWR sky130_fd_sc_hd__decap_4
XFILLER_64_237 VGND VGND VPWR VPWR sky130_fd_sc_hd__decap_6
XFILLER_2_69 VGND VPWR VPWR VGND sky130_ef_sc_hd__decap_12
X_0952_ net46 _0519_ _0523_ u_jt49.regarray\[6\]\[6\] VGND VGND VPWR VPWR _0590_ sky130_fd_sc_hd__a22o_1
X_1504_ net209 net99 _0416_ VGND VGND VPWR VPWR _0213_ sky130_fd_sc_hd__mux2_1
X_0883_ _0516_ net93 net95 VGND VGND VPWR VPWR _0527_ sky130_fd_sc_hd__nor3b_1
X_1366_ u_jt49.u_chA.count\[5\] _0378_ u_jt49.u_chA.count\[6\] VGND VGND VPWR VPWR
+ _0385_ sky130_fd_sc_hd__a21o_1
X_1435_ net244 net112 _0409_ VGND VGND VPWR VPWR _0151_ sky130_fd_sc_hd__mux2_1
XFILLER_63_281 VGND VPWR VPWR VGND sky130_ef_sc_hd__decap_12
XFILLER_55_237 VGND VPWR VPWR VGND sky130_ef_sc_hd__decap_12
X_1297_ _0326_ VGND VGND VPWR VPWR _0327_ sky130_fd_sc_hd__inv_2
XFILLER_52_85 VGND VGND VPWR VPWR sky130_fd_sc_hd__decap_8
XFILLER_36_97 VGND VGND VPWR VPWR sky130_fd_sc_hd__decap_3
XPHY_EDGE_ROW_1_Left_66 VGND VGND VPWR VPWR sky130_fd_sc_hd__decap_3
Xinput17 bc1 VGND VGND VPWR VPWR net17 sky130_fd_sc_hd__dlymetal6s2s_1
Xinput28 din[7] VGND VGND VPWR VPWR net28 sky130_fd_sc_hd__clkbuf_1
XFILLER_6_377 VGND VGND VPWR VPWR sky130_fd_sc_hd__decap_4
X_1220_ net234 u_jt49.u_ng.poly17\[5\] net78 VGND VGND VPWR VPWR _0072_ sky130_fd_sc_hd__mux2_1
XFILLER_37_204 VGND VGND VPWR VPWR sky130_fd_sc_hd__decap_4
X_1151_ _0747_ net267 net74 VGND VGND VPWR VPWR _0045_ sky130_fd_sc_hd__mux2_1
XFILLER_28_6 VGND VPWR VPWR VGND sky130_ef_sc_hd__decap_12
XFILLER_45_281 VGND VGND VPWR VPWR sky130_fd_sc_hd__decap_4
X_1082_ u_jt49.eg_period\[5\] u_jt49.eg_period\[4\] u_jt49.eg_period\[7\] u_jt49.eg_period\[6\]
+ VGND VGND VPWR VPWR _0687_ sky130_fd_sc_hd__or4_1
X_0866_ _0509_ _0511_ VGND VGND VPWR VPWR _0000_ sky130_fd_sc_hd__or2_1
X_0935_ u_jt49.periodB\[4\] _0528_ _0529_ u_jt49.regarray\[8\]\[4\] _0570_ VGND VGND
+ VPWR VPWR _0575_ sky130_fd_sc_hd__a221o_1
X_0797_ u_jt49.eg_period\[12\] VGND VGND VPWR VPWR _0448_ sky130_fd_sc_hd__inv_2
XFILLER_57_19 VGND VPWR VPWR VGND sky130_ef_sc_hd__decap_12
XFILLER_43_207 VGND VGND VPWR VPWR sky130_fd_sc_hd__decap_3
X_1349_ _0369_ _0371_ _0372_ VGND VGND VPWR VPWR _0102_ sky130_fd_sc_hd__and3_1
XFILLER_28_237 VGND VGND VPWR VPWR sky130_fd_sc_hd__decap_4
X_1418_ net110 u_jt49.eg_period\[1\] _0407_ VGND VGND VPWR VPWR _0136_ sky130_fd_sc_hd__mux2_1
XFILLER_51_240 VGND VPWR VPWR VGND sky130_ef_sc_hd__decap_12
XFILLER_47_52 VGND VGND VPWR VPWR sky130_fd_sc_hd__decap_4
XFILLER_27_281 VGND VPWR VPWR VGND sky130_ef_sc_hd__decap_12
XFILLER_6_174 VGND VGND VPWR VPWR sky130_fd_sc_hd__decap_3
X_1203_ net74 _0780_ _0781_ VGND VGND VPWR VPWR _0063_ sky130_fd_sc_hd__and3_1
X_1134_ u_jt49.eg_period\[7\] _0477_ _0478_ u_jt49.eg_period\[6\] VGND VGND VPWR VPWR
+ _0731_ sky130_fd_sc_hd__o22a_1
XFILLER_26_3 VGND VGND VPWR VPWR sky130_fd_sc_hd__decap_4
X_1065_ _0467_ _0672_ VGND VGND VPWR VPWR _0676_ sky130_fd_sc_hd__nand2_1
X_0849_ net30 VGND VGND VPWR VPWR _0500_ sky130_fd_sc_hd__inv_2
X_0918_ u_jt49.periodA\[2\] _0518_ _0539_ _0559_ VGND VGND VPWR VPWR _0560_ sky130_fd_sc_hd__o211a_1
XFILLER_56_365 VGND VPWR VPWR VGND sky130_ef_sc_hd__decap_12
XFILLER_16_218 VGND VGND VPWR VPWR sky130_fd_sc_hd__decap_4
XFILLER_17_77 VGND VPWR VPWR VGND sky130_ef_sc_hd__decap_12
XFILLER_59_181 VGND VPWR VPWR VGND sky130_ef_sc_hd__decap_12
Xhold6 u_jt49.Cmix VGND VGND VPWR VPWR net151 sky130_fd_sc_hd__dlygate4sd3_1
XFILLER_62_357 VGND VGND VPWR VPWR sky130_fd_sc_hd__decap_6
XFILLER_15_284 VGND VGND VPWR VPWR sky130_fd_sc_hd__decap_8
Xclkbuf_leaf_10_clk clknet_2_1__leaf_clk VGND VGND VPWR VPWR clknet_leaf_10_clk sky130_fd_sc_hd__clkbuf_8
X_1683_ clknet_leaf_5_clk _0104_ net123 VGND VGND VPWR VPWR u_jt49.u_chA.count\[3\]
+ sky130_fd_sc_hd__dfrtp_1
X_1752_ clknet_leaf_25_clk _0171_ net131 VGND VGND VPWR VPWR u_jt49.regarray\[7\]\[4\]
+ sky130_fd_sc_hd__dfrtp_1
X_1821_ clknet_leaf_1_clk _0240_ net117 VGND VGND VPWR VPWR u_jt49.periodA\[1\] sky130_fd_sc_hd__dfrtp_1
X_1117_ u_jt49.u_envdiv.count\[15\] u_jt49.eg_period\[15\] VGND VGND VPWR VPWR _0714_
+ sky130_fd_sc_hd__and2b_1
XFILLER_38_365 VGND VGND VPWR VPWR sky130_fd_sc_hd__decap_6
XPHY_EDGE_ROW_3_Right_3 VGND VGND VPWR VPWR sky130_fd_sc_hd__decap_3
X_1048_ u_jt49.u_chC.count\[2\] _0660_ VGND VGND VPWR VPWR _0664_ sky130_fd_sc_hd__or2_1
XFILLER_60_85 VGND VPWR VPWR VGND sky130_ef_sc_hd__decap_12
XPHY_EDGE_ROW_30_Left_95 VGND VGND VPWR VPWR sky130_fd_sc_hd__decap_3
XFILLER_62_121 VGND VPWR VPWR VGND sky130_ef_sc_hd__decap_12
XFILLER_62_165 VGND VPWR VPWR VGND sky130_ef_sc_hd__decap_12
X_1804_ clknet_leaf_4_clk _0223_ net127 VGND VGND VPWR VPWR u_jt49.periodA\[8\] sky130_fd_sc_hd__dfrtp_1
X_1666_ clknet_leaf_27_clk _0087_ net119 VGND VGND VPWR VPWR u_jt49.bitC sky130_fd_sc_hd__dfrtp_1
X_1735_ clknet_leaf_25_clk _0154_ net132 VGND VGND VPWR VPWR u_jt49.regarray\[9\]\[3\]
+ sky130_fd_sc_hd__dfrtp_1
X_1597_ clknet_leaf_9_clk _0020_ VGND VGND VPWR VPWR addr\[3\] sky130_fd_sc_hd__dfxtp_1
XFILLER_17_379 VGND VGND VPWR VPWR sky130_fd_sc_hd__decap_3
X_1520_ net180 net103 _0418_ VGND VGND VPWR VPWR _0227_ sky130_fd_sc_hd__mux2_1
X_1382_ u_jt49.u_chA.count\[11\] _0395_ VGND VGND VPWR VPWR _0396_ sky130_fd_sc_hd__xnor2_1
X_1451_ net169 net97 _0410_ VGND VGND VPWR VPWR _0166_ sky130_fd_sc_hd__mux2_1
XFILLER_50_113 VGND VGND VPWR VPWR sky130_fd_sc_hd__decap_6
XFILLER_35_165 VGND VGND VPWR VPWR sky130_fd_sc_hd__decap_3
XFILLER_50_179 VGND VGND VPWR VPWR sky130_fd_sc_hd__decap_4
X_1649_ clknet_leaf_6_clk net235 net125 VGND VGND VPWR VPWR u_jt49.u_ng.poly17\[4\]
+ sky130_fd_sc_hd__dfrtp_1
X_1718_ clknet_leaf_18_clk _0137_ net133 VGND VGND VPWR VPWR u_jt49.eg_period\[2\]
+ sky130_fd_sc_hd__dfrtp_1
XFILLER_41_113 VGND VPWR VPWR VGND sky130_ef_sc_hd__decap_12
XFILLER_26_132 VGND VGND VPWR VPWR sky130_fd_sc_hd__decap_8
XFILLER_41_65 VGND VGND VPWR VPWR sky130_fd_sc_hd__decap_4
X_0882_ net94 net96 net90 net92 VGND VGND VPWR VPWR _0526_ sky130_fd_sc_hd__and4bb_4
XFILLER_32_179 VGND VGND VPWR VPWR sky130_fd_sc_hd__decap_4
XFILLER_32_135 VGND VGND VPWR VPWR sky130_fd_sc_hd__decap_4
X_0951_ _0518_ _0539_ VGND VGND VPWR VPWR _0589_ sky130_fd_sc_hd__nand2_1
XFILLER_9_331 VGND VGND VPWR VPWR sky130_fd_sc_hd__decap_4
X_1503_ net182 net102 _0416_ VGND VGND VPWR VPWR _0212_ sky130_fd_sc_hd__mux2_1
XFILLER_55_249 VGND VPWR VPWR VGND sky130_ef_sc_hd__decap_12
XFILLER_55_216 VGND VGND VPWR VPWR sky130_fd_sc_hd__decap_8
X_1296_ u_jt49.u_chB.count\[8\] _0323_ VGND VGND VPWR VPWR _0326_ sky130_fd_sc_hd__and2_1
X_1365_ u_jt49.u_chA.count\[6\] u_jt49.u_chA.count\[5\] _0378_ VGND VGND VPWR VPWR
+ _0384_ sky130_fd_sc_hd__nand3_1
X_1434_ net82 _0530_ VGND VGND VPWR VPWR _0409_ sky130_fd_sc_hd__and2_2
XFILLER_63_293 VGND VPWR VPWR VGND sky130_ef_sc_hd__decap_12
XFILLER_46_216 VGND VGND VPWR VPWR sky130_fd_sc_hd__decap_3
Xinput18 bc2 VGND VGND VPWR VPWR net18 sky130_fd_sc_hd__clkbuf_2
XFILLER_52_42 VGND VGND VPWR VPWR sky130_fd_sc_hd__decap_4
XFILLER_14_179 VGND VPWR VPWR VGND sky130_ef_sc_hd__decap_12
Xinput29 rst_n VGND VGND VPWR VPWR net29 sky130_fd_sc_hd__clkbuf_2
X_1150_ _0689_ _0690_ _0691_ u_jt49.eg_step VGND VGND VPWR VPWR _0747_ sky130_fd_sc_hd__a31oi_1
X_1081_ u_jt49.u_env.rst_latch _0441_ net149 VGND VGND VPWR VPWR _0036_ sky130_fd_sc_hd__a21o_1
X_0865_ _0507_ _0017_ VGND VGND VPWR VPWR _0511_ sky130_fd_sc_hd__nand2_1
X_0934_ u_jt49.eg_period\[4\] _0521_ _0530_ u_jt49.regarray\[9\]\[4\] _0571_ VGND
+ VGND VPWR VPWR _0574_ sky130_fd_sc_hd__a221o_1
X_0796_ u_jt49.eg_period\[13\] VGND VGND VPWR VPWR _0447_ sky130_fd_sc_hd__inv_2
X_1417_ net112 u_jt49.eg_period\[0\] _0407_ VGND VGND VPWR VPWR _0135_ sky130_fd_sc_hd__mux2_1
X_1279_ u_jt49.u_chB.count\[3\] _0310_ VGND VGND VPWR VPWR _0314_ sky130_fd_sc_hd__or2_1
X_1348_ u_jt49.u_chA.count\[1\] _0368_ VGND VGND VPWR VPWR _0372_ sky130_fd_sc_hd__or2_1
XFILLER_51_252 VGND VPWR VPWR VGND sky130_ef_sc_hd__decap_12
XFILLER_3_337 VGND VPWR VPWR VGND sky130_ef_sc_hd__decap_12
Xfanout140 net141 VGND VGND VPWR VPWR net140 sky130_fd_sc_hd__clkbuf_4
XFILLER_42_230 VGND VGND VPWR VPWR sky130_fd_sc_hd__decap_8
XFILLER_27_293 VGND VPWR VPWR VGND sky130_ef_sc_hd__decap_12
XFILLER_6_131 VGND VGND VPWR VPWR sky130_fd_sc_hd__decap_8
XFILLER_6_197 VGND VPWR VPWR VGND sky130_ef_sc_hd__decap_12
X_1202_ u_jt49.u_envdiv.count\[10\] u_jt49.u_envdiv.count\[9\] net76 u_jt49.u_envdiv.count\[11\]
+ VGND VGND VPWR VPWR _0781_ sky130_fd_sc_hd__a31o_1
X_1133_ u_jt49.eg_period\[5\] _0479_ _0480_ u_jt49.eg_period\[4\] VGND VGND VPWR VPWR
+ _0730_ sky130_fd_sc_hd__o22a_1
X_1064_ _0674_ VGND VGND VPWR VPWR _0675_ sky130_fd_sc_hd__inv_2
XFILLER_19_3 VGND VPWR VPWR VGND sky130_ef_sc_hd__decap_12
X_0848_ u_jt49.u_ng.poly17\[3\] VGND VGND VPWR VPWR _0499_ sky130_fd_sc_hd__inv_2
X_0917_ _0554_ _0555_ _0558_ VGND VGND VPWR VPWR _0559_ sky130_fd_sc_hd__or3_1
XFILLER_56_377 VGND VGND VPWR VPWR sky130_fd_sc_hd__decap_4
XFILLER_17_89 VGND VGND VPWR VPWR sky130_fd_sc_hd__decap_4
XFILLER_3_156 VGND VPWR VPWR VGND sky130_ef_sc_hd__decap_12
XFILLER_3_101 VGND VGND VPWR VPWR sky130_fd_sc_hd__decap_8
XFILLER_59_193 VGND VPWR VPWR VGND sky130_ef_sc_hd__decap_12
XFILLER_47_344 VGND VPWR VPWR VGND sky130_ef_sc_hd__decap_12
Xhold7 u_jt49.u_ng.last_en VGND VGND VPWR VPWR net152 sky130_fd_sc_hd__dlygate4sd3_1
XFILLER_30_211 VGND VGND VPWR VPWR sky130_fd_sc_hd__decap_3
X_1820_ clknet_leaf_1_clk _0239_ net117 VGND VGND VPWR VPWR u_jt49.periodA\[0\] sky130_fd_sc_hd__dfrtp_1
X_1682_ clknet_leaf_5_clk _0103_ net123 VGND VGND VPWR VPWR u_jt49.u_chA.count\[2\]
+ sky130_fd_sc_hd__dfrtp_1
X_1751_ clknet_leaf_2_clk _0170_ net120 VGND VGND VPWR VPWR u_jt49.regarray\[7\]\[3\]
+ sky130_fd_sc_hd__dfrtp_1
X_1116_ u_jt49.eg_period\[14\] _0473_ _0474_ u_jt49.eg_period\[13\] VGND VGND VPWR
+ VPWR _0713_ sky130_fd_sc_hd__a22o_1
X_1047_ u_jt49.u_chC.count\[2\] _0660_ VGND VGND VPWR VPWR _0663_ sky130_fd_sc_hd__nand2_1
XFILLER_21_233 VGND VGND VPWR VPWR sky130_fd_sc_hd__decap_3
XFILLER_28_66 VGND VGND VPWR VPWR sky130_fd_sc_hd__decap_8
XFILLER_12_233 VGND VGND VPWR VPWR sky130_fd_sc_hd__decap_4
XFILLER_60_97 VGND VPWR VPWR VGND sky130_ef_sc_hd__decap_12
XFILLER_62_133 VGND VGND VPWR VPWR sky130_fd_sc_hd__decap_6
XPHY_EDGE_ROW_13_Right_13 VGND VGND VPWR VPWR sky130_fd_sc_hd__decap_3
XFILLER_62_177 VGND VPWR VPWR VGND sky130_ef_sc_hd__decap_12
X_1803_ clknet_leaf_10_clk _0222_ net128 VGND VGND VPWR VPWR u_jt49.periodB\[7\] sky130_fd_sc_hd__dfrtp_1
XPHY_EDGE_ROW_22_Right_22 VGND VGND VPWR VPWR sky130_fd_sc_hd__decap_3
X_1596_ clknet_leaf_9_clk _0019_ VGND VGND VPWR VPWR addr\[2\] sky130_fd_sc_hd__dfxtp_1
X_1665_ clknet_leaf_8_clk _0001_ VGND VGND VPWR VPWR u_jt49.read_mask\[5\] sky130_fd_sc_hd__dfxtp_1
X_1734_ clknet_leaf_24_clk _0153_ net131 VGND VGND VPWR VPWR u_jt49.regarray\[9\]\[2\]
+ sky130_fd_sc_hd__dfrtp_1
XFILLER_38_141 VGND VGND VPWR VPWR sky130_fd_sc_hd__decap_3
XPHY_EDGE_ROW_31_Right_31 VGND VGND VPWR VPWR sky130_fd_sc_hd__decap_3
XPHY_EDGE_ROW_40_Right_40 VGND VGND VPWR VPWR sky130_fd_sc_hd__decap_3
XFILLER_29_141 VGND VGND VPWR VPWR sky130_fd_sc_hd__decap_6
XFILLER_32_317 VGND VPWR VPWR VGND sky130_ef_sc_hd__decap_12
X_1450_ net201 net99 _0410_ VGND VGND VPWR VPWR _0165_ sky130_fd_sc_hd__mux2_1
X_1381_ _0369_ _0394_ _0395_ VGND VGND VPWR VPWR _0111_ sky130_fd_sc_hd__and3_1
X_1648_ clknet_leaf_7_clk _0071_ net125 VGND VGND VPWR VPWR u_jt49.u_ng.poly17\[3\]
+ sky130_fd_sc_hd__dfrtp_1
X_1717_ clknet_leaf_19_clk _0136_ net135 VGND VGND VPWR VPWR u_jt49.eg_period\[1\]
+ sky130_fd_sc_hd__dfrtp_1
X_1579_ net114 net167 _0436_ _0440_ VGND VGND VPWR VPWR _0264_ sky130_fd_sc_hd__a22o_1
XFILLER_41_169 VGND VGND VPWR VPWR sky130_fd_sc_hd__decap_8
XFILLER_41_125 VGND VPWR VPWR VGND sky130_ef_sc_hd__decap_12
XFILLER_49_225 VGND VGND VPWR VPWR sky130_fd_sc_hd__decap_3
X_0950_ u_jt49.periodC\[6\] _0515_ _0528_ u_jt49.periodB\[6\] VGND VGND VPWR VPWR
+ _0588_ sky130_fd_sc_hd__a22o_1
X_0881_ net89 net93 net95 net91 VGND VGND VPWR VPWR _0525_ sky130_fd_sc_hd__and4bb_4
XFILLER_20_309 VGND VPWR VPWR VGND sky130_ef_sc_hd__decap_12
X_1502_ net231 net103 _0416_ VGND VGND VPWR VPWR _0211_ sky130_fd_sc_hd__mux2_1
X_1433_ net184 net98 _0408_ VGND VGND VPWR VPWR _0150_ sky130_fd_sc_hd__mux2_1
X_1295_ net73 _0324_ _0325_ VGND VGND VPWR VPWR _0095_ sky130_fd_sc_hd__and3_1
X_1364_ _0367_ _0382_ _0383_ net268 net83 VGND VGND VPWR VPWR _0106_ sky130_fd_sc_hd__a32o_1
XFILLER_63_261 VGND VPWR VPWR VGND sky130_ef_sc_hd__decap_12
XFILLER_23_169 VGND VGND VPWR VPWR sky130_fd_sc_hd__decap_3
XFILLER_46_206 VGND VGND VPWR VPWR sky130_fd_sc_hd__decap_4
Xinput19 bdir VGND VGND VPWR VPWR net19 sky130_fd_sc_hd__dlymetal6s2s_1
XFILLER_6_302 VGND VGND VPWR VPWR sky130_fd_sc_hd__decap_6
XFILLER_10_353 VGND VGND VPWR VPWR sky130_fd_sc_hd__decap_8
XFILLER_6_346 VGND VPWR VPWR VGND sky130_ef_sc_hd__decap_12
X_1080_ _0659_ _0685_ _0686_ VGND VGND VPWR VPWR _0035_ sky130_fd_sc_hd__and3_1
XFILLER_60_253 VGND VPWR VPWR VGND sky130_ef_sc_hd__decap_12
XFILLER_45_272 VGND VGND VPWR VPWR sky130_fd_sc_hd__decap_8
X_0864_ net129 _0510_ VGND VGND VPWR VPWR _0017_ sky130_fd_sc_hd__and2_1
X_0933_ u_jt49.regarray\[10\]\[4\] _0520_ _0526_ u_jt49.eg_period\[12\] _0572_ VGND
+ VGND VPWR VPWR _0573_ sky130_fd_sc_hd__a221o_1
X_0795_ u_jt49.eg_period\[2\] VGND VGND VPWR VPWR _0446_ sky130_fd_sc_hd__inv_2
X_1347_ _0370_ VGND VGND VPWR VPWR _0371_ sky130_fd_sc_hd__inv_2
X_1416_ net82 _0521_ VGND VGND VPWR VPWR _0407_ sky130_fd_sc_hd__nand2_4
X_1278_ u_jt49.u_chB.count\[3\] _0310_ VGND VGND VPWR VPWR _0313_ sky130_fd_sc_hd__nand2_1
XFILLER_28_206 VGND VGND VPWR VPWR sky130_fd_sc_hd__decap_8
XFILLER_51_264 VGND VPWR VPWR VGND sky130_ef_sc_hd__decap_12
XFILLER_3_349 VGND VPWR VPWR VGND sky130_ef_sc_hd__decap_12
Xfanout130 net29 VGND VGND VPWR VPWR net130 sky130_fd_sc_hd__clkbuf_2
Xfanout141 net145 VGND VGND VPWR VPWR net141 sky130_fd_sc_hd__clkbuf_4
XFILLER_63_31 VGND VPWR VPWR VGND sky130_ef_sc_hd__decap_12
XFILLER_42_253 VGND VGND VPWR VPWR sky130_fd_sc_hd__decap_6
XFILLER_8_15 VGND VPWR VPWR VGND sky130_ef_sc_hd__decap_12
XFILLER_10_150 VGND VGND VPWR VPWR sky130_fd_sc_hd__decap_4
X_1201_ _0779_ VGND VGND VPWR VPWR _0780_ sky130_fd_sc_hd__inv_2
X_1132_ u_jt49.eg_period\[6\] _0478_ _0479_ u_jt49.eg_period\[5\] VGND VGND VPWR VPWR
+ _0729_ sky130_fd_sc_hd__a22o_1
X_1063_ u_jt49.u_chC.count\[7\] u_jt49.u_chC.count\[6\] _0670_ VGND VGND VPWR VPWR
+ _0674_ sky130_fd_sc_hd__and3_1
X_0916_ u_jt49.periodC\[2\] net80 _0517_ _0557_ VGND VGND VPWR VPWR _0558_ sky130_fd_sc_hd__a211o_1
X_0847_ u_jt49.u_ng.poly17\[0\] VGND VGND VPWR VPWR _0498_ sky130_fd_sc_hd__inv_2
XFILLER_56_345 VGND VPWR VPWR VGND sky130_ef_sc_hd__decap_12
XFILLER_3_113 VGND VGND VPWR VPWR sky130_fd_sc_hd__decap_6
XFILLER_47_356 VGND VPWR VPWR VGND sky130_ef_sc_hd__decap_12
Xhold8 net36 VGND VGND VPWR VPWR net153 sky130_fd_sc_hd__dlygate4sd3_1
X_1750_ clknet_leaf_25_clk _0169_ net131 VGND VGND VPWR VPWR u_jt49.regarray\[7\]\[2\]
+ sky130_fd_sc_hd__dfrtp_1
X_1681_ clknet_leaf_4_clk _0102_ net117 VGND VGND VPWR VPWR u_jt49.u_chA.count\[1\]
+ sky130_fd_sc_hd__dfrtp_1
XFILLER_38_323 VGND VPWR VPWR VGND sky130_ef_sc_hd__decap_12
XFILLER_31_3 VGND VGND VPWR VPWR sky130_fd_sc_hd__decap_4
XFILLER_53_337 VGND VPWR VPWR VGND sky130_ef_sc_hd__decap_12
X_1115_ _0449_ u_jt49.u_envdiv.count\[14\] u_jt49.u_envdiv.count\[13\] _0447_ VGND
+ VGND VPWR VPWR _0712_ sky130_fd_sc_hd__o22a_1
X_1046_ _0659_ _0661_ _0662_ VGND VGND VPWR VPWR _0025_ sky130_fd_sc_hd__and3_1
XFILLER_56_197 VGND VPWR VPWR VGND sky130_ef_sc_hd__decap_12
XFILLER_8_249 VGND VGND VPWR VPWR sky130_fd_sc_hd__decap_3
XFILLER_62_189 VGND VGND VPWR VPWR sky130_fd_sc_hd__decap_6
XFILLER_47_186 VGND VPWR VPWR VGND sky130_ef_sc_hd__decap_12
XFILLER_35_315 VGND VPWR VPWR VGND sky130_ef_sc_hd__decap_12
Xclkbuf_2_3__f_clk clknet_0_clk VGND VGND VPWR VPWR clknet_2_3__leaf_clk sky130_fd_sc_hd__clkbuf_16
X_1802_ clknet_leaf_10_clk _0221_ net128 VGND VGND VPWR VPWR u_jt49.periodB\[6\] sky130_fd_sc_hd__dfrtp_1
X_1733_ clknet_leaf_24_clk _0152_ net131 VGND VGND VPWR VPWR u_jt49.regarray\[9\]\[1\]
+ sky130_fd_sc_hd__dfrtp_1
X_1595_ clknet_leaf_9_clk _0018_ VGND VGND VPWR VPWR addr\[1\] sky130_fd_sc_hd__dfxtp_1
X_1664_ clknet_leaf_8_clk _0000_ VGND VGND VPWR VPWR u_jt49.read_mask\[4\] sky130_fd_sc_hd__dfxtp_1
XFILLER_38_164 VGND VGND VPWR VPWR sky130_fd_sc_hd__decap_6
XFILLER_38_131 VGND VGND VPWR VPWR sky130_fd_sc_hd__decap_8
XFILLER_26_304 VGND VGND VPWR VPWR sky130_fd_sc_hd__decap_4
X_1029_ u_jt49.u_chC.count\[5\] u_jt49.periodC\[5\] VGND VGND VPWR VPWR _0647_ sky130_fd_sc_hd__and2b_1
XFILLER_32_329 VGND VPWR VPWR VGND sky130_ef_sc_hd__decap_12
XFILLER_17_337 VGND VGND VPWR VPWR sky130_fd_sc_hd__decap_4
XFILLER_17_359 VGND VPWR VPWR VGND sky130_ef_sc_hd__decap_12
X_1380_ u_jt49.u_chA.count\[10\] u_jt49.u_chA.count\[9\] _0390_ VGND VGND VPWR VPWR
+ _0395_ sky130_fd_sc_hd__nand3_1
XFILLER_50_159 VGND VPWR VPWR VGND sky130_ef_sc_hd__decap_12
XFILLER_6_70 VGND VPWR VPWR VGND sky130_ef_sc_hd__decap_12
X_1716_ clknet_leaf_19_clk _0135_ net135 VGND VGND VPWR VPWR u_jt49.eg_period\[0\]
+ sky130_fd_sc_hd__dfrtp_2
X_1647_ clknet_leaf_8_clk _0070_ net125 VGND VGND VPWR VPWR u_jt49.u_ng.poly17\[2\]
+ sky130_fd_sc_hd__dfrtp_1
X_1578_ u_jt49.regarray\[10\]\[3\] u_jt49.envelope\[4\] u_jt49.regarray\[10\]\[4\]
+ VGND VGND VPWR VPWR _0440_ sky130_fd_sc_hd__mux2_1
XFILLER_57_281 VGND VPWR VPWR VGND sky130_ef_sc_hd__decap_12
XFILLER_13_340 VGND VGND VPWR VPWR sky130_fd_sc_hd__decap_6
XFILLER_17_189 VGND VGND VPWR VPWR sky130_fd_sc_hd__decap_4
X_0880_ net93 net96 net89 net91 VGND VGND VPWR VPWR _0524_ sky130_fd_sc_hd__and4b_4
X_1501_ u_jt49.periodB\[11\] net106 _0416_ VGND VGND VPWR VPWR _0210_ sky130_fd_sc_hd__mux2_1
X_1363_ net87 u_jt49.u_chA.count\[5\] _0378_ VGND VGND VPWR VPWR _0383_ sky130_fd_sc_hd__a21o_1
X_1432_ net186 net99 _0408_ VGND VGND VPWR VPWR _0149_ sky130_fd_sc_hd__mux2_1
XFILLER_63_273 VGND VGND VPWR VPWR sky130_fd_sc_hd__decap_6
X_1294_ _0457_ _0321_ VGND VGND VPWR VPWR _0325_ sky130_fd_sc_hd__nand2_1
XPHY_EDGE_ROW_43_Left_108 VGND VGND VPWR VPWR sky130_fd_sc_hd__decap_3
XPHY_EDGE_ROW_52_Left_117 VGND VGND VPWR VPWR sky130_fd_sc_hd__decap_3
XFILLER_11_15 VGND VGND VPWR VPWR sky130_fd_sc_hd__decap_6
XPHY_EDGE_ROW_61_Left_126 VGND VGND VPWR VPWR sky130_fd_sc_hd__decap_3
XFILLER_39_281 VGND VGND VPWR VPWR sky130_fd_sc_hd__decap_4
XFILLER_36_78 VGND VGND VPWR VPWR sky130_fd_sc_hd__decap_6
XFILLER_36_23 VGND VGND VPWR VPWR sky130_fd_sc_hd__decap_4
XFILLER_52_77 VGND VGND VPWR VPWR sky130_fd_sc_hd__decap_6
XFILLER_6_358 VGND VGND VPWR VPWR sky130_fd_sc_hd__decap_6
XFILLER_10_365 VGND VPWR VPWR VGND sky130_ef_sc_hd__decap_12
XFILLER_60_265 VGND VPWR VPWR VGND sky130_ef_sc_hd__decap_12
XFILLER_60_221 VGND VPWR VPWR VGND sky130_ef_sc_hd__decap_12
X_0932_ u_jt49.regarray\[3\]\[4\] _0522_ _0525_ u_jt49.regarray\[5\]\[4\] VGND VGND
+ VPWR VPWR _0572_ sky130_fd_sc_hd__a22o_1
X_0863_ net21 addr\[0\] _0504_ VGND VGND VPWR VPWR _0510_ sky130_fd_sc_hd__mux2_1
XFILLER_9_163 VGND VGND VPWR VPWR sky130_fd_sc_hd__decap_4
X_0794_ u_jt49.eg_period\[3\] VGND VGND VPWR VPWR _0445_ sky130_fd_sc_hd__inv_2
X_1415_ net98 net175 _0406_ VGND VGND VPWR VPWR _0134_ sky130_fd_sc_hd__mux2_1
X_1346_ net87 u_jt49.u_chA.count\[1\] u_jt49.u_chA.count\[0\] VGND VGND VPWR VPWR
+ _0370_ sky130_fd_sc_hd__and3_1
X_1277_ net73 _0311_ _0312_ VGND VGND VPWR VPWR _0090_ sky130_fd_sc_hd__and3_1
XFILLER_51_276 VGND VGND VPWR VPWR sky130_fd_sc_hd__decap_4
XFILLER_22_25 VGND VGND VPWR VPWR sky130_fd_sc_hd__decap_3
Xfanout120 net121 VGND VGND VPWR VPWR net120 sky130_fd_sc_hd__clkbuf_4
Xfanout131 net138 VGND VGND VPWR VPWR net131 sky130_fd_sc_hd__clkbuf_4
Xfanout142 net143 VGND VGND VPWR VPWR net142 sky130_fd_sc_hd__clkbuf_4
XFILLER_63_43 VGND VPWR VPWR VGND sky130_ef_sc_hd__decap_12
XFILLER_42_298 VGND VGND VPWR VPWR sky130_fd_sc_hd__decap_8
Xclkbuf_leaf_22_clk clknet_2_2__leaf_clk VGND VGND VPWR VPWR clknet_leaf_22_clk sky130_fd_sc_hd__clkbuf_8
X_1200_ u_jt49.u_envdiv.count\[11\] u_jt49.u_envdiv.count\[10\] u_jt49.u_envdiv.count\[9\]
+ net76 VGND VGND VPWR VPWR _0779_ sky130_fd_sc_hd__and4_1
XFILLER_33_7 VGND VPWR VPWR VGND sky130_ef_sc_hd__decap_12
XFILLER_2_350 VGND VPWR VPWR VGND sky130_ef_sc_hd__decap_12
X_1131_ _0724_ _0726_ _0727_ _0723_ _0722_ VGND VGND VPWR VPWR _0728_ sky130_fd_sc_hd__o32a_1
X_1062_ _0659_ _0672_ _0673_ VGND VGND VPWR VPWR _0030_ sky130_fd_sc_hd__and3_1
XFILLER_18_273 VGND VGND VPWR VPWR sky130_fd_sc_hd__decap_8
Xclkbuf_leaf_13_clk clknet_2_3__leaf_clk VGND VGND VPWR VPWR clknet_leaf_13_clk sky130_fd_sc_hd__clkbuf_8
X_0915_ u_jt49.regarray\[8\]\[2\] _0529_ _0530_ u_jt49.regarray\[9\]\[2\] _0556_ VGND
+ VGND VPWR VPWR _0557_ sky130_fd_sc_hd__a221o_1
X_0846_ u_jt49.bitA VGND VGND VPWR VPWR _0497_ sky130_fd_sc_hd__inv_2
XFILLER_56_357 VGND VGND VPWR VPWR sky130_fd_sc_hd__decap_6
XFILLER_56_302 VGND VGND VPWR VPWR sky130_fd_sc_hd__decap_6
X_1329_ u_jt49.u_chA.count\[11\] u_jt49.periodA\[11\] VGND VGND VPWR VPWR _0354_ sky130_fd_sc_hd__and2b_1
XFILLER_24_232 VGND VGND VPWR VPWR sky130_fd_sc_hd__decap_8
XFILLER_59_151 VGND VPWR VPWR VGND sky130_ef_sc_hd__decap_12
XFILLER_3_169 VGND VGND VPWR VPWR sky130_fd_sc_hd__decap_6
XFILLER_3_136 VGND VGND VPWR VPWR sky130_fd_sc_hd__decap_4
Xhold9 net33 VGND VGND VPWR VPWR net154 sky130_fd_sc_hd__dlygate4sd3_1
X_1680_ clknet_leaf_1_clk _0101_ net117 VGND VGND VPWR VPWR u_jt49.u_chA.count\[0\]
+ sky130_fd_sc_hd__dfstp_1
X_1114_ u_jt49.eg_period\[15\] _0472_ u_jt49.u_envdiv.count\[14\] _0449_ VGND VGND
+ VPWR VPWR _0711_ sky130_fd_sc_hd__a2bb2o_1
XFILLER_38_335 VGND VGND VPWR VPWR sky130_fd_sc_hd__decap_3
Xclkbuf_leaf_2_clk clknet_2_0__leaf_clk VGND VGND VPWR VPWR clknet_leaf_2_clk sky130_fd_sc_hd__clkbuf_8
XFILLER_24_3 VGND VPWR VPWR VGND sky130_ef_sc_hd__decap_12
XFILLER_53_349 VGND VPWR VPWR VGND sky130_ef_sc_hd__decap_12
X_1045_ net88 u_jt49.u_chC.count\[0\] u_jt49.u_chC.count\[1\] VGND VGND VPWR VPWR
+ _0662_ sky130_fd_sc_hd__a21o_1
X_0829_ u_jt49.u_envdiv.count\[4\] VGND VGND VPWR VPWR _0480_ sky130_fd_sc_hd__inv_2
XFILLER_44_23 VGND VGND VPWR VPWR sky130_fd_sc_hd__decap_4
XFILLER_12_246 VGND VGND VPWR VPWR sky130_fd_sc_hd__decap_6
XFILLER_12_279 VGND VPWR VPWR VGND sky130_ef_sc_hd__decap_12
XFILLER_35_305 VGND VGND VPWR VPWR sky130_fd_sc_hd__decap_3
XPHY_EDGE_ROW_8_Left_73 VGND VGND VPWR VPWR sky130_fd_sc_hd__decap_3
XFILLER_47_198 VGND VPWR VPWR VGND sky130_ef_sc_hd__decap_12
XFILLER_47_176 VGND VGND VPWR VPWR sky130_fd_sc_hd__decap_4
XFILLER_35_327 VGND VGND VPWR VPWR sky130_fd_sc_hd__decap_8
X_1801_ clknet_leaf_11_clk _0220_ net128 VGND VGND VPWR VPWR u_jt49.periodB\[5\] sky130_fd_sc_hd__dfrtp_1
X_1732_ clknet_leaf_25_clk _0151_ net132 VGND VGND VPWR VPWR u_jt49.regarray\[9\]\[0\]
+ sky130_fd_sc_hd__dfrtp_1
X_1663_ clknet_leaf_1_clk _0086_ net117 VGND VGND VPWR VPWR u_jt49.u_ng.noise_en sky130_fd_sc_hd__dfrtp_1
X_1594_ clknet_leaf_8_clk _0017_ VGND VGND VPWR VPWR addr\[0\] sky130_fd_sc_hd__dfxtp_1
XPHY_EDGE_ROW_7_Right_7 VGND VGND VPWR VPWR sky130_fd_sc_hd__decap_3
XFILLER_26_316 VGND VGND VPWR VPWR sky130_fd_sc_hd__decap_4
X_1028_ _0469_ u_jt49.periodC\[3\] _0470_ u_jt49.periodC\[2\] VGND VGND VPWR VPWR
+ _0646_ sky130_fd_sc_hd__o22a_1
XPHY_EDGE_ROW_34_Left_99 VGND VGND VPWR VPWR sky130_fd_sc_hd__decap_3
XFILLER_4_253 VGND VGND VPWR VPWR sky130_fd_sc_hd__decap_8
X_1715_ clknet_leaf_15_clk _0134_ net145 VGND VGND VPWR VPWR net54 sky130_fd_sc_hd__dfrtp_1
X_1646_ clknet_leaf_8_clk net226 net125 VGND VGND VPWR VPWR u_jt49.u_ng.poly17\[1\]
+ sky130_fd_sc_hd__dfrtp_1
X_1577_ net114 net163 _0436_ _0439_ VGND VGND VPWR VPWR _0263_ sky130_fd_sc_hd__a22o_1
XFILLER_2_29 VGND VPWR VPWR VGND sky130_ef_sc_hd__decap_12
XFILLER_17_113 VGND VGND VPWR VPWR sky130_fd_sc_hd__decap_4
XFILLER_13_352 VGND VPWR VPWR VGND sky130_ef_sc_hd__decap_12
XFILLER_63_7 VGND VPWR VPWR VGND sky130_ef_sc_hd__decap_12
X_1500_ u_jt49.periodB\[10\] net107 _0416_ VGND VGND VPWR VPWR _0209_ sky130_fd_sc_hd__mux2_1
X_1293_ _0323_ VGND VGND VPWR VPWR _0324_ sky130_fd_sc_hd__inv_2
X_1362_ _0381_ VGND VGND VPWR VPWR _0382_ sky130_fd_sc_hd__inv_2
X_1431_ net243 net101 _0408_ VGND VGND VPWR VPWR _0148_ sky130_fd_sc_hd__mux2_1
X_1629_ clknet_leaf_16_clk _0052_ net143 VGND VGND VPWR VPWR u_jt49.u_envdiv.count\[0\]
+ sky130_fd_sc_hd__dfstp_1
XFILLER_52_23 VGND VGND VPWR VPWR sky130_fd_sc_hd__decap_4
XFILLER_52_67 VGND VGND VPWR VPWR sky130_fd_sc_hd__decap_6
XFILLER_10_377 VGND VGND VPWR VPWR sky130_fd_sc_hd__decap_4
XFILLER_60_277 VGND VPWR VPWR VGND sky130_ef_sc_hd__decap_12
XFILLER_60_233 VGND VPWR VPWR VGND sky130_ef_sc_hd__decap_12
X_0862_ net129 _0505_ _0508_ VGND VGND VPWR VPWR _0509_ sky130_fd_sc_hd__and3_1
X_0931_ u_jt49.regarray\[7\]\[4\] _0519_ net77 u_jt49.regarray\[1\]\[4\] VGND VGND
+ VPWR VPWR _0571_ sky130_fd_sc_hd__a22o_1
XFILLER_54_3 VGND VPWR VPWR VGND sky130_ef_sc_hd__decap_12
XPHY_EDGE_ROW_21_Left_86 VGND VGND VPWR VPWR sky130_fd_sc_hd__decap_3
X_0793_ u_jt49.eg_period\[0\] VGND VGND VPWR VPWR _0444_ sky130_fd_sc_hd__inv_2
X_1276_ u_jt49.u_chB.count\[1\] u_jt49.u_chB.count\[0\] net88 u_jt49.u_chB.count\[2\]
+ VGND VGND VPWR VPWR _0312_ sky130_fd_sc_hd__a31o_1
X_1414_ net100 net176 _0406_ VGND VGND VPWR VPWR _0133_ sky130_fd_sc_hd__mux2_1
X_1345_ _0363_ _0366_ net83 VGND VGND VPWR VPWR _0369_ sky130_fd_sc_hd__a21o_2
Xfanout143 net144 VGND VGND VPWR VPWR net143 sky130_fd_sc_hd__buf_2
Xfanout110 din_latch\[1\] VGND VGND VPWR VPWR net110 sky130_fd_sc_hd__buf_2
Xfanout121 net122 VGND VGND VPWR VPWR net121 sky130_fd_sc_hd__clkbuf_2
Xfanout132 net138 VGND VGND VPWR VPWR net132 sky130_fd_sc_hd__clkbuf_2
XFILLER_10_141 VGND VGND VPWR VPWR sky130_fd_sc_hd__decap_6
X_1130_ u_jt49.eg_period\[9\] _0475_ _0476_ u_jt49.eg_period\[8\] VGND VGND VPWR VPWR
+ _0727_ sky130_fd_sc_hd__o22a_1
X_1061_ u_jt49.u_chC.count\[5\] _0667_ u_jt49.u_chC.count\[6\] VGND VGND VPWR VPWR
+ _0673_ sky130_fd_sc_hd__a21o_1
XFILLER_18_230 VGND VGND VPWR VPWR sky130_fd_sc_hd__decap_6
X_0845_ u_jt49.bitB VGND VGND VPWR VPWR _0496_ sky130_fd_sc_hd__inv_2
X_0914_ u_jt49.regarray\[7\]\[2\] _0519_ _0526_ u_jt49.eg_period\[10\] VGND VGND VPWR
+ VPWR _0556_ sky130_fd_sc_hd__a22o_1
X_1259_ _0294_ _0295_ _0296_ VGND VGND VPWR VPWR _0297_ sky130_fd_sc_hd__a21o_1
X_1328_ _0486_ u_jt49.periodA\[9\] VGND VGND VPWR VPWR _0353_ sky130_fd_sc_hd__and2_1
XFILLER_33_36 VGND VPWR VPWR VGND sky130_ef_sc_hd__decap_12
XFILLER_59_163 VGND VGND VPWR VPWR sky130_fd_sc_hd__decap_4
XFILLER_15_277 VGND VGND VPWR VPWR sky130_fd_sc_hd__decap_3
X_1044_ _0660_ VGND VGND VPWR VPWR _0661_ sky130_fd_sc_hd__inv_2
XFILLER_0_40 VGND VGND VPWR VPWR sky130_fd_sc_hd__decap_8
X_1113_ _0693_ _0697_ _0701_ _0710_ net271 VGND VGND VPWR VPWR _0044_ sky130_fd_sc_hd__a32o_1
XFILLER_61_361 VGND VGND VPWR VPWR sky130_fd_sc_hd__decap_8
XFILLER_21_225 VGND VGND VPWR VPWR sky130_fd_sc_hd__decap_8
X_0828_ u_jt49.u_envdiv.count\[5\] VGND VGND VPWR VPWR _0479_ sky130_fd_sc_hd__inv_2
XFILLER_5_18 VGND VPWR VPWR VGND sky130_ef_sc_hd__decap_12
XFILLER_50_309 VGND VPWR VPWR VGND sky130_ef_sc_hd__decap_12
X_1800_ clknet_leaf_10_clk _0219_ net128 VGND VGND VPWR VPWR u_jt49.periodB\[4\] sky130_fd_sc_hd__dfrtp_2
XFILLER_34_90 VGND VGND VPWR VPWR sky130_fd_sc_hd__decap_8
X_1662_ clknet_leaf_8_clk _0085_ VGND VGND VPWR VPWR u_jt49.noise sky130_fd_sc_hd__dfxtp_1
X_1731_ clknet_leaf_17_clk _0150_ net141 VGND VGND VPWR VPWR u_jt49.regarray\[10\]\[7\]
+ sky130_fd_sc_hd__dfrtp_1
X_1593_ clknet_leaf_1_clk _0016_ net117 VGND VGND VPWR VPWR u_jt49.u_ng.u_div.count\[4\]
+ sky130_fd_sc_hd__dfrtp_1
X_1027_ u_jt49.periodC\[0\] _0471_ _0642_ _0643_ _0644_ VGND VGND VPWR VPWR _0645_
+ sky130_fd_sc_hd__a311o_1
XFILLER_14_49 VGND VGND VPWR VPWR sky130_fd_sc_hd__decap_3
XFILLER_29_122 VGND VGND VPWR VPWR sky130_fd_sc_hd__decap_8
XFILLER_52_180 VGND VPWR VPWR VGND sky130_ef_sc_hd__decap_12
XFILLER_44_147 VGND VPWR VPWR VGND sky130_ef_sc_hd__decap_12
XFILLER_4_243 VGND VGND VPWR VPWR sky130_fd_sc_hd__decap_8
Xhold90 _0072_ VGND VGND VPWR VPWR net235 sky130_fd_sc_hd__dlygate4sd3_1
XFILLER_31_364 VGND VPWR VPWR VGND sky130_ef_sc_hd__decap_12
X_1645_ clknet_leaf_8_clk _0068_ net125 VGND VGND VPWR VPWR u_jt49.u_ng.poly17\[0\]
+ sky130_fd_sc_hd__dfrtp_1
X_1714_ clknet_leaf_15_clk _0133_ net144 VGND VGND VPWR VPWR net53 sky130_fd_sc_hd__dfrtp_1
X_1576_ u_jt49.regarray\[10\]\[2\] u_jt49.envelope\[3\] u_jt49.regarray\[10\]\[4\]
+ VGND VGND VPWR VPWR _0439_ sky130_fd_sc_hd__mux2_1
XFILLER_41_106 VGND VGND VPWR VPWR sky130_fd_sc_hd__decap_6
XFILLER_26_158 VGND VGND VPWR VPWR sky130_fd_sc_hd__decap_3
XFILLER_41_47 VGND VGND VPWR VPWR sky130_fd_sc_hd__decap_8
XFILLER_49_206 VGND VGND VPWR VPWR sky130_fd_sc_hd__decap_8
XFILLER_40_161 VGND VPWR VPWR VGND sky130_ef_sc_hd__decap_12
XFILLER_13_364 VGND VPWR VPWR VGND sky130_ef_sc_hd__decap_12
XFILLER_15_81 VGND VGND VPWR VPWR sky130_fd_sc_hd__decap_8
X_1430_ u_jt49.regarray\[10\]\[4\] net103 _0408_ VGND VGND VPWR VPWR _0147_ sky130_fd_sc_hd__mux2_1
X_1292_ u_jt49.u_chB.count\[7\] u_jt49.u_chB.count\[6\] _0318_ VGND VGND VPWR VPWR
+ _0323_ sky130_fd_sc_hd__and3_1
X_1361_ u_jt49.u_chA.count\[5\] u_jt49.u_chA.count\[4\] _0375_ VGND VGND VPWR VPWR
+ _0381_ sky130_fd_sc_hd__and3_1
X_1628_ clknet_leaf_6_clk _0051_ VGND VGND VPWR VPWR u_jt49.u_ng.last_en sky130_fd_sc_hd__dfxtp_1
X_1559_ u_jt49.Bmix net20 VGND VGND VPWR VPWR _0430_ sky130_fd_sc_hd__and2_1
XFILLER_54_253 VGND VPWR VPWR VGND sky130_ef_sc_hd__decap_12
XFILLER_54_220 VGND VPWR VPWR VGND sky130_ef_sc_hd__decap_12
XFILLER_60_245 VGND VGND VPWR VPWR sky130_fd_sc_hd__decap_6
XFILLER_60_289 VGND VPWR VPWR VGND sky130_ef_sc_hd__decap_12
X_0861_ net129 _0508_ VGND VGND VPWR VPWR _0018_ sky130_fd_sc_hd__and2_1
X_0930_ u_jt49.periodC\[4\] net80 _0523_ u_jt49.regarray\[6\]\[4\] VGND VGND VPWR
+ VPWR _0570_ sky130_fd_sc_hd__a22o_1
X_0792_ u_jt49.eg_period\[1\] VGND VGND VPWR VPWR _0443_ sky130_fd_sc_hd__inv_2
XFILLER_47_3 VGND VGND VPWR VPWR sky130_fd_sc_hd__decap_6
X_1413_ net101 net191 _0406_ VGND VGND VPWR VPWR _0132_ sky130_fd_sc_hd__mux2_1
X_1275_ _0310_ VGND VGND VPWR VPWR _0311_ sky130_fd_sc_hd__inv_2
X_1344_ _0367_ _0368_ _0337_ VGND VGND VPWR VPWR _0101_ sky130_fd_sc_hd__a21oi_1
XFILLER_51_212 VGND VGND VPWR VPWR sky130_fd_sc_hd__decap_4
XFILLER_22_49 VGND VGND VPWR VPWR sky130_fd_sc_hd__decap_4
Xfanout111 din_latch\[0\] VGND VGND VPWR VPWR net111 sky130_fd_sc_hd__clkbuf_4
Xfanout144 net145 VGND VGND VPWR VPWR net144 sky130_fd_sc_hd__clkbuf_4
Xfanout100 din_latch\[6\] VGND VGND VPWR VPWR net100 sky130_fd_sc_hd__clkbuf_4
Xfanout133 net138 VGND VGND VPWR VPWR net133 sky130_fd_sc_hd__clkbuf_4
Xfanout122 net29 VGND VGND VPWR VPWR net122 sky130_fd_sc_hd__buf_2
XFILLER_47_68 VGND VGND VPWR VPWR sky130_fd_sc_hd__decap_4
XPHY_EDGE_ROW_29_Right_29 VGND VGND VPWR VPWR sky130_fd_sc_hd__decap_3
XFILLER_27_275 VGND VGND VPWR VPWR sky130_fd_sc_hd__decap_4
XPHY_EDGE_ROW_38_Right_38 VGND VGND VPWR VPWR sky130_fd_sc_hd__decap_3
XPHY_EDGE_ROW_47_Right_47 VGND VGND VPWR VPWR sky130_fd_sc_hd__decap_3
X_1060_ u_jt49.u_chC.count\[6\] u_jt49.u_chC.count\[5\] _0667_ VGND VGND VPWR VPWR
+ _0672_ sky130_fd_sc_hd__nand3_1
XPHY_EDGE_ROW_56_Right_56 VGND VGND VPWR VPWR sky130_fd_sc_hd__decap_3
XFILLER_37_90 VGND VPWR VPWR VGND sky130_ef_sc_hd__decap_12
XFILLER_33_212 VGND VPWR VPWR VGND sky130_ef_sc_hd__decap_12
X_0844_ u_jt49.bitC VGND VGND VPWR VPWR _0495_ sky130_fd_sc_hd__inv_2
X_0913_ u_jt49.periodB\[10\] _0522_ _0524_ u_jt49.regarray\[13\]\[2\] _0553_ VGND
+ VGND VPWR VPWR _0555_ sky130_fd_sc_hd__a221o_1
XFILLER_56_337 VGND VGND VPWR VPWR sky130_fd_sc_hd__decap_4
X_1258_ _0460_ u_jt49.periodB\[4\] _0461_ u_jt49.periodB\[3\] VGND VGND VPWR VPWR
+ _0296_ sky130_fd_sc_hd__a22o_1
X_1327_ u_jt49.periodA\[11\] u_jt49.u_chA.count\[11\] VGND VGND VPWR VPWR _0352_ sky130_fd_sc_hd__nand2b_1
X_1189_ _0477_ _0478_ _0767_ VGND VGND VPWR VPWR _0772_ sky130_fd_sc_hd__or3_1
XPHY_EDGE_ROW_49_Left_114 VGND VGND VPWR VPWR sky130_fd_sc_hd__decap_3
XFILLER_33_48 VGND VGND VPWR VPWR sky130_fd_sc_hd__decap_8
XPHY_EDGE_ROW_58_Left_123 VGND VGND VPWR VPWR sky130_fd_sc_hd__decap_3
XFILLER_55_370 VGND VPWR VPWR VGND sky130_ef_sc_hd__decap_12
XFILLER_53_329 VGND VGND VPWR VPWR sky130_fd_sc_hd__decap_6
X_1043_ net88 u_jt49.u_chC.count\[1\] u_jt49.u_chC.count\[0\] VGND VGND VPWR VPWR
+ _0660_ sky130_fd_sc_hd__and3_1
X_1112_ _0696_ _0693_ VGND VGND VPWR VPWR _0710_ sky130_fd_sc_hd__nand2b_1
X_0827_ u_jt49.u_envdiv.count\[6\] VGND VGND VPWR VPWR _0478_ sky130_fd_sc_hd__inv_2
XFILLER_8_208 VGND VPWR VPWR VGND sky130_ef_sc_hd__decap_12
XFILLER_20_281 VGND VPWR VPWR VGND sky130_ef_sc_hd__decap_12
X_1661_ clknet_leaf_7_clk _0084_ net126 VGND VGND VPWR VPWR u_jt49.u_ng.poly17\[16\]
+ sky130_fd_sc_hd__dfrtp_1
X_1730_ clknet_leaf_17_clk _0149_ net141 VGND VGND VPWR VPWR u_jt49.regarray\[10\]\[6\]
+ sky130_fd_sc_hd__dfrtp_1
XFILLER_11_281 VGND VPWR VPWR VGND sky130_ef_sc_hd__decap_12
X_1592_ clknet_leaf_0_clk _0015_ net117 VGND VGND VPWR VPWR u_jt49.u_ng.u_div.count\[3\]
+ sky130_fd_sc_hd__dfrtp_1
X_1026_ u_jt49.u_chC.count\[1\] u_jt49.periodC\[1\] VGND VGND VPWR VPWR _0644_ sky130_fd_sc_hd__and2b_1
XFILLER_61_181 VGND VPWR VPWR VGND sky130_ef_sc_hd__decap_12
XFILLER_55_57 VGND VGND VPWR VPWR sky130_fd_sc_hd__decap_4
XFILLER_40_365 VGND VGND VPWR VPWR sky130_fd_sc_hd__decap_4
Xhold91 u_jt49.u_cen.cencnt\[0\] VGND VGND VPWR VPWR net236 sky130_fd_sc_hd__dlygate4sd3_1
Xhold80 u_jt49.u_ng.poly17\[1\] VGND VGND VPWR VPWR net225 sky130_fd_sc_hd__dlygate4sd3_1
XFILLER_16_373 VGND VGND VPWR VPWR sky130_fd_sc_hd__decap_8
X_1713_ clknet_leaf_16_clk _0132_ net143 VGND VGND VPWR VPWR net52 sky130_fd_sc_hd__dfrtp_1
XFILLER_31_376 VGND VGND VPWR VPWR sky130_fd_sc_hd__decap_6
X_1644_ clknet_leaf_17_clk _0067_ net140 VGND VGND VPWR VPWR u_jt49.u_envdiv.count\[15\]
+ sky130_fd_sc_hd__dfrtp_1
X_1575_ net114 net166 _0436_ _0438_ VGND VGND VPWR VPWR _0262_ sky130_fd_sc_hd__a22o_1
XFILLER_34_181 VGND VGND VPWR VPWR sky130_fd_sc_hd__decap_8
X_1009_ net238 u_jt49.u_env.rst_latch net85 VGND VGND VPWR VPWR _0023_ sky130_fd_sc_hd__mux2_1
XFILLER_22_332 VGND VGND VPWR VPWR sky130_fd_sc_hd__decap_4
XFILLER_22_365 VGND VPWR VPWR VGND sky130_ef_sc_hd__decap_12
XFILLER_41_15 VGND VGND VPWR VPWR sky130_fd_sc_hd__decap_3
XFILLER_9_6 VGND VPWR VPWR VGND sky130_ef_sc_hd__decap_12
XFILLER_17_137 VGND VPWR VPWR VGND sky130_ef_sc_hd__decap_12
XFILLER_13_376 VGND VGND VPWR VPWR sky130_fd_sc_hd__decap_6
X_1360_ _0369_ _0379_ _0380_ VGND VGND VPWR VPWR _0105_ sky130_fd_sc_hd__and3_1
Xoutput70 net70 VGND VGND VPWR VPWR dout[6] sky130_fd_sc_hd__buf_2
X_1291_ net73 _0321_ _0322_ VGND VGND VPWR VPWR _0094_ sky130_fd_sc_hd__and3_1
X_1627_ clknet_leaf_22_clk _0050_ VGND VGND VPWR VPWR u_jt49.envelope\[4\] sky130_fd_sc_hd__dfxtp_1
X_1558_ u_jt49.regarray\[9\]\[3\] u_jt49.envelope\[0\] u_jt49.regarray\[9\]\[4\] VGND
+ VGND VPWR VPWR _0429_ sky130_fd_sc_hd__mux2_1
X_1489_ net273 net111 _0415_ VGND VGND VPWR VPWR _0199_ sky130_fd_sc_hd__mux2_1
XFILLER_54_265 VGND VPWR VPWR VGND sky130_ef_sc_hd__decap_12
XFILLER_54_232 VGND VGND VPWR VPWR sky130_fd_sc_hd__decap_6
XFILLER_7_3 VGND VPWR VPWR VGND sky130_ef_sc_hd__decap_12
XFILLER_45_210 VGND VGND VPWR VPWR sky130_fd_sc_hd__decap_8
Xclkbuf_leaf_25_clk clknet_2_2__leaf_clk VGND VGND VPWR VPWR clknet_leaf_25_clk sky130_fd_sc_hd__clkbuf_8
X_0860_ net129 _0505_ VGND VGND VPWR VPWR _0019_ sky130_fd_sc_hd__and2_1
X_0791_ u_jt49.u_env.last_step VGND VGND VPWR VPWR _0442_ sky130_fd_sc_hd__inv_2
X_1412_ net103 net178 _0406_ VGND VGND VPWR VPWR _0131_ sky130_fd_sc_hd__mux2_1
X_1343_ net83 _0493_ VGND VGND VPWR VPWR _0368_ sky130_fd_sc_hd__nor2_1
XFILLER_3_74 VGND VGND VPWR VPWR sky130_fd_sc_hd__decap_6
X_1274_ u_jt49.u_chB.count\[2\] u_jt49.u_chB.count\[1\] u_jt49.u_chB.count\[0\] net88
+ VGND VGND VPWR VPWR _0310_ sky130_fd_sc_hd__and4_1
Xclkbuf_leaf_16_clk clknet_2_3__leaf_clk VGND VGND VPWR VPWR clknet_leaf_16_clk sky130_fd_sc_hd__clkbuf_8
XFILLER_22_17 VGND VGND VPWR VPWR sky130_fd_sc_hd__decap_8
X_0989_ net86 u_jt49.u_ng.u_div.count\[0\] VGND VGND VPWR VPWR _0615_ sky130_fd_sc_hd__nand2_1
XFILLER_59_368 VGND VPWR VPWR VGND sky130_ef_sc_hd__decap_12
Xfanout101 net102 VGND VGND VPWR VPWR net101 sky130_fd_sc_hd__clkbuf_4
Xfanout145 net29 VGND VGND VPWR VPWR net145 sky130_fd_sc_hd__buf_2
Xfanout123 net126 VGND VGND VPWR VPWR net123 sky130_fd_sc_hd__clkbuf_4
Xfanout112 din_latch\[0\] VGND VGND VPWR VPWR net112 sky130_fd_sc_hd__buf_2
Xfanout134 net138 VGND VGND VPWR VPWR net134 sky130_fd_sc_hd__clkbuf_2
XFILLER_63_57 VGND VPWR VPWR VGND sky130_ef_sc_hd__decap_12
XFILLER_42_268 VGND VPWR VPWR VGND sky130_ef_sc_hd__decap_12
XFILLER_10_121 VGND VPWR VPWR VGND sky130_ef_sc_hd__decap_12
XFILLER_33_246 VGND VGND VPWR VPWR sky130_fd_sc_hd__decap_4
X_0912_ u_jt49.regarray\[10\]\[2\] _0520_ _0528_ u_jt49.periodB\[2\] _0552_ VGND VGND
+ VPWR VPWR _0554_ sky130_fd_sc_hd__a221o_1
X_0843_ u_jt49.u_env.inv VGND VGND VPWR VPWR _0494_ sky130_fd_sc_hd__inv_2
Xclkbuf_leaf_5_clk clknet_2_1__leaf_clk VGND VGND VPWR VPWR clknet_leaf_5_clk sky130_fd_sc_hd__clkbuf_8
X_1326_ _0491_ u_jt49.periodA\[2\] _0348_ _0349_ _0350_ VGND VGND VPWR VPWR _0351_
+ sky130_fd_sc_hd__o221a_1
X_1257_ _0461_ u_jt49.periodB\[3\] _0462_ u_jt49.periodB\[2\] VGND VGND VPWR VPWR
+ _0295_ sky130_fd_sc_hd__o22a_1
X_1188_ _0477_ _0769_ VGND VGND VPWR VPWR _0771_ sky130_fd_sc_hd__nand2_1
XFILLER_17_17 VGND VPWR VPWR VGND sky130_ef_sc_hd__decap_12
XFILLER_47_305 VGND VGND VPWR VPWR sky130_fd_sc_hd__decap_4
XFILLER_38_305 VGND VGND VPWR VPWR sky130_fd_sc_hd__decap_3
X_1111_ u_jt49.u_env.gain\[3\] u_jt49.u_env.gain\[2\] _0706_ _0709_ VGND VGND VPWR
+ VPWR _0043_ sky130_fd_sc_hd__o31ai_1
X_1042_ net84 _0657_ VGND VGND VPWR VPWR _0659_ sky130_fd_sc_hd__or2_2
XFILLER_9_73 VGND VGND VPWR VPWR sky130_fd_sc_hd__decap_4
X_0826_ u_jt49.u_envdiv.count\[7\] VGND VGND VPWR VPWR _0477_ sky130_fd_sc_hd__inv_2
X_1309_ u_jt49.periodB\[11\] u_jt49.periodB\[10\] u_jt49.periodB\[9\] u_jt49.periodB\[8\]
+ VGND VGND VPWR VPWR _0335_ sky130_fd_sc_hd__or4_1
XFILLER_28_38 VGND VGND VPWR VPWR sky130_fd_sc_hd__decap_8
XFILLER_60_25 VGND VGND VPWR VPWR sky130_fd_sc_hd__decap_3
XFILLER_20_293 VGND VPWR VPWR VGND sky130_ef_sc_hd__decap_12
XFILLER_11_293 VGND VPWR VPWR VGND sky130_ef_sc_hd__decap_12
X_1660_ clknet_leaf_7_clk net220 net126 VGND VGND VPWR VPWR u_jt49.u_ng.poly17\[15\]
+ sky130_fd_sc_hd__dfrtp_1
X_1591_ clknet_leaf_0_clk _0014_ net115 VGND VGND VPWR VPWR u_jt49.u_ng.u_div.count\[2\]
+ sky130_fd_sc_hd__dfrtp_1
XFILLER_22_3 VGND VGND VPWR VPWR sky130_fd_sc_hd__decap_8
XFILLER_61_193 VGND VPWR VPWR VGND sky130_ef_sc_hd__decap_12
XFILLER_53_138 VGND VPWR VPWR VGND sky130_ef_sc_hd__decap_12
XFILLER_53_116 VGND VPWR VPWR VGND sky130_ef_sc_hd__decap_12
X_1025_ u_jt49.u_chC.count\[2\] u_jt49.periodC\[2\] VGND VGND VPWR VPWR _0643_ sky130_fd_sc_hd__and2b_1
X_0809_ u_jt49.u_chB.count\[4\] VGND VGND VPWR VPWR _0460_ sky130_fd_sc_hd__inv_2
X_1789_ clknet_leaf_11_clk _0208_ net139 VGND VGND VPWR VPWR u_jt49.periodB\[9\] sky130_fd_sc_hd__dfrtp_1
XFILLER_29_113 VGND VGND VPWR VPWR sky130_fd_sc_hd__decap_4
XFILLER_52_171 VGND VGND VPWR VPWR sky130_fd_sc_hd__decap_6
Xhold70 _0075_ VGND VGND VPWR VPWR net215 sky130_fd_sc_hd__dlygate4sd3_1
Xhold92 u_jt49.u_ng.poly17\[2\] VGND VGND VPWR VPWR net237 sky130_fd_sc_hd__dlygate4sd3_1
Xhold81 _0069_ VGND VGND VPWR VPWR net226 sky130_fd_sc_hd__dlygate4sd3_1
XFILLER_29_81 VGND VGND VPWR VPWR sky130_fd_sc_hd__decap_3
XANTENNA_1 net72 VGND VGND VPWR VPWR sky130_fd_sc_hd__diode_2
X_1643_ clknet_leaf_12_clk _0066_ net143 VGND VGND VPWR VPWR u_jt49.u_envdiv.count\[14\]
+ sky130_fd_sc_hd__dfrtp_1
X_1712_ clknet_leaf_16_clk _0131_ net142 VGND VGND VPWR VPWR net51 sky130_fd_sc_hd__dfrtp_1
XFILLER_6_41 VGND VPWR VPWR VGND sky130_ef_sc_hd__decap_12
X_1574_ u_jt49.regarray\[10\]\[1\] u_jt49.envelope\[2\] u_jt49.regarray\[10\]\[4\]
+ VGND VGND VPWR VPWR _0438_ sky130_fd_sc_hd__mux2_1
XFILLER_6_85 VGND VGND VPWR VPWR sky130_fd_sc_hd__decap_8
XFILLER_34_160 VGND VPWR VPWR VGND sky130_ef_sc_hd__decap_12
X_1008_ u_jt49.u_env.rst_latch net85 VGND VGND VPWR VPWR _0627_ sky130_fd_sc_hd__and2_1
XFILLER_49_219 VGND VGND VPWR VPWR sky130_fd_sc_hd__decap_4
XFILLER_17_149 VGND VPWR VPWR VGND sky130_ef_sc_hd__decap_12
XFILLER_9_337 VGND VGND VPWR VPWR sky130_fd_sc_hd__decap_3
Xoutput60 net60 VGND VGND VPWR VPWR IOB_out[4] sky130_fd_sc_hd__buf_2
Xoutput71 net71 VGND VGND VPWR VPWR dout[7] sky130_fd_sc_hd__buf_2
X_1290_ u_jt49.u_chB.count\[6\] _0318_ VGND VGND VPWR VPWR _0322_ sky130_fd_sc_hd__or2_1
XFILLER_31_185 VGND VGND VPWR VPWR sky130_fd_sc_hd__decap_3
XFILLER_31_163 VGND VGND VPWR VPWR sky130_fd_sc_hd__decap_4
X_1626_ clknet_leaf_22_clk _0049_ VGND VGND VPWR VPWR u_jt49.envelope\[3\] sky130_fd_sc_hd__dfxtp_1
X_1557_ net113 net155 _0424_ _0428_ VGND VGND VPWR VPWR _0254_ sky130_fd_sc_hd__a22o_1
X_1488_ net81 net80 VGND VGND VPWR VPWR _0415_ sky130_fd_sc_hd__and2_2
XFILLER_54_277 VGND VPWR VPWR VGND sky130_ef_sc_hd__decap_12
XFILLER_45_244 VGND VGND VPWR VPWR sky130_fd_sc_hd__decap_6
XFILLER_61_7 VGND VGND VPWR VPWR sky130_fd_sc_hd__decap_8
X_0790_ u_jt49.u_env.rst_clr VGND VGND VPWR VPWR _0441_ sky130_fd_sc_hd__inv_2
X_1273_ net73 _0308_ _0309_ VGND VGND VPWR VPWR _0089_ sky130_fd_sc_hd__and3_1
X_1342_ _0363_ _0366_ VGND VGND VPWR VPWR _0367_ sky130_fd_sc_hd__and2_1
X_1411_ net106 net179 _0406_ VGND VGND VPWR VPWR _0130_ sky130_fd_sc_hd__mux2_1
XFILLER_3_53 VGND VGND VPWR VPWR sky130_fd_sc_hd__decap_3
X_0988_ _0485_ u_jt49.u_ng.u_div.count\[4\] _0612_ _0613_ VGND VGND VPWR VPWR _0614_
+ sky130_fd_sc_hd__a22o_1
Xfanout102 din_latch\[5\] VGND VGND VPWR VPWR net102 sky130_fd_sc_hd__clkbuf_4
Xfanout113 _0501_ VGND VGND VPWR VPWR net113 sky130_fd_sc_hd__buf_2
X_1609_ clknet_leaf_29_clk _0032_ net116 VGND VGND VPWR VPWR u_jt49.u_chC.count\[8\]
+ sky130_fd_sc_hd__dfrtp_1
Xfanout124 net125 VGND VGND VPWR VPWR net124 sky130_fd_sc_hd__clkbuf_4
Xfanout135 net137 VGND VGND VPWR VPWR net135 sky130_fd_sc_hd__clkbuf_4
XFILLER_63_69 VGND VPWR VPWR VGND sky130_ef_sc_hd__decap_12
XFILLER_10_133 VGND VGND VPWR VPWR sky130_fd_sc_hd__decap_6
XFILLER_10_177 VGND VGND VPWR VPWR sky130_fd_sc_hd__decap_3
XFILLER_2_365 VGND VPWR VPWR VGND sky130_ef_sc_hd__decap_12
XFILLER_33_269 VGND VGND VPWR VPWR sky130_fd_sc_hd__decap_8
X_0842_ u_jt49.u_chA.count\[0\] VGND VGND VPWR VPWR _0493_ sky130_fd_sc_hd__inv_2
X_0911_ u_jt49.regarray\[6\]\[2\] _0523_ _0525_ u_jt49.periodC\[10\] VGND VGND VPWR
+ VPWR _0553_ sky130_fd_sc_hd__a22o_1
X_1256_ _0463_ u_jt49.periodB\[0\] _0291_ _0292_ _0293_ VGND VGND VPWR VPWR _0294_
+ sky130_fd_sc_hd__a311o_1
X_1325_ _0490_ u_jt49.periodA\[3\] VGND VGND VPWR VPWR _0350_ sky130_fd_sc_hd__or2_1
XFILLER_17_29 VGND VGND VPWR VPWR sky130_fd_sc_hd__decap_3
XFILLER_64_361 VGND VGND VPWR VPWR sky130_fd_sc_hd__decap_3
X_1187_ net74 _0769_ _0770_ VGND VGND VPWR VPWR _0058_ sky130_fd_sc_hd__and3_1
XFILLER_58_58 VGND VGND VPWR VPWR sky130_fd_sc_hd__decap_4
XFILLER_62_309 VGND VPWR VPWR VGND sky130_ef_sc_hd__decap_12
XFILLER_15_225 VGND VGND VPWR VPWR sky130_fd_sc_hd__decap_4
X_1110_ _0627_ _0708_ VGND VGND VPWR VPWR _0709_ sky130_fd_sc_hd__nor2_1
XFILLER_17_6 VGND VGND VPWR VPWR sky130_fd_sc_hd__decap_6
XFILLER_9_30 VGND VPWR VPWR VGND sky130_ef_sc_hd__decap_12
X_1041_ net84 _0471_ _0658_ VGND VGND VPWR VPWR _0024_ sky130_fd_sc_hd__a21oi_1
X_0825_ u_jt49.u_envdiv.count\[8\] VGND VGND VPWR VPWR _0476_ sky130_fd_sc_hd__inv_2
XFILLER_9_85 VGND VGND VPWR VPWR sky130_fd_sc_hd__decap_8
XFILLER_56_169 VGND VGND VPWR VPWR sky130_fd_sc_hd__decap_4
XFILLER_52_320 VGND VPWR VPWR VGND sky130_ef_sc_hd__decap_12
X_1308_ u_jt49.periodB\[7\] u_jt49.periodB\[6\] u_jt49.periodB\[5\] u_jt49.periodB\[4\]
+ VGND VGND VPWR VPWR _0334_ sky130_fd_sc_hd__or4_1
X_1239_ _0498_ u_jt49.noise net83 VGND VGND VPWR VPWR _0085_ sky130_fd_sc_hd__mux2_1
XFILLER_64_191 VGND VGND VPWR VPWR sky130_fd_sc_hd__decap_4
XFILLER_50_81 VGND VGND VPWR VPWR sky130_fd_sc_hd__decap_3
X_1590_ clknet_leaf_0_clk _0013_ net115 VGND VGND VPWR VPWR u_jt49.u_ng.u_div.count\[1\]
+ sky130_fd_sc_hd__dfrtp_1
XFILLER_53_128 VGND VGND VPWR VPWR sky130_fd_sc_hd__decap_4
XFILLER_38_103 VGND VGND VPWR VPWR sky130_fd_sc_hd__decap_8
X_1024_ u_jt49.periodC\[1\] u_jt49.u_chC.count\[1\] VGND VGND VPWR VPWR _0642_ sky130_fd_sc_hd__nand2b_1
XFILLER_15_3 VGND VGND VPWR VPWR sky130_fd_sc_hd__decap_8
XFILLER_61_161 VGND VGND VPWR VPWR sky130_fd_sc_hd__decap_6
XPHY_EDGE_ROW_28_Left_93 VGND VGND VPWR VPWR sky130_fd_sc_hd__decap_3
X_0808_ u_jt49.u_chB.count\[5\] VGND VGND VPWR VPWR _0459_ sky130_fd_sc_hd__inv_2
X_1788_ clknet_leaf_11_clk _0207_ net139 VGND VGND VPWR VPWR u_jt49.periodB\[8\] sky130_fd_sc_hd__dfrtp_1
XPHY_EDGE_ROW_12_Left_77 VGND VGND VPWR VPWR sky130_fd_sc_hd__decap_3
Xhold82 u_jt49.u_ng.poly17\[11\] VGND VGND VPWR VPWR net227 sky130_fd_sc_hd__dlygate4sd3_1
Xhold71 u_jt49.u_ng.poly17\[9\] VGND VGND VPWR VPWR net216 sky130_fd_sc_hd__dlygate4sd3_1
XFILLER_29_93 VGND VPWR VPWR VGND sky130_ef_sc_hd__decap_12
Xhold93 u_jt49.u_env.rst_clr VGND VGND VPWR VPWR net238 sky130_fd_sc_hd__dlygate4sd3_1
Xhold60 u_jt49.regarray\[9\]\[5\] VGND VGND VPWR VPWR net205 sky130_fd_sc_hd__dlygate4sd3_1
XANTENNA_2 net100 VGND VGND VPWR VPWR sky130_fd_sc_hd__diode_2
X_1642_ clknet_leaf_14_clk _0065_ net144 VGND VGND VPWR VPWR u_jt49.u_envdiv.count\[13\]
+ sky130_fd_sc_hd__dfrtp_2
X_1711_ clknet_leaf_16_clk _0130_ net142 VGND VGND VPWR VPWR net50 sky130_fd_sc_hd__dfrtp_1
XFILLER_6_53 VGND VGND VPWR VPWR sky130_fd_sc_hd__decap_8
XFILLER_58_209 VGND VPWR VPWR VGND sky130_ef_sc_hd__decap_12
XFILLER_3_290 VGND VPWR VPWR VGND sky130_ef_sc_hd__decap_12
X_1573_ net114 net161 _0436_ _0437_ VGND VGND VPWR VPWR _0261_ sky130_fd_sc_hd__a22o_1
X_1007_ net146 net144 net18 _0502_ VGND VGND VPWR VPWR _0022_ sky130_fd_sc_hd__nand4_1
Xoutput61 net61 VGND VGND VPWR VPWR IOB_out[5] sky130_fd_sc_hd__buf_2
Xoutput50 net50 VGND VGND VPWR VPWR IOA_out[3] sky130_fd_sc_hd__buf_2
Xoutput72 net72 VGND VGND VPWR VPWR sample sky130_fd_sc_hd__buf_2
XFILLER_48_253 VGND VPWR VPWR VGND sky130_ef_sc_hd__decap_12
X_1625_ clknet_leaf_22_clk _0048_ VGND VGND VPWR VPWR u_jt49.envelope\[2\] sky130_fd_sc_hd__dfxtp_1
X_1556_ u_jt49.regarray\[8\]\[3\] u_jt49.envelope\[4\] u_jt49.regarray\[8\]\[4\] VGND
+ VGND VPWR VPWR _0428_ sky130_fd_sc_hd__mux2_1
X_1487_ net171 net97 _0414_ VGND VGND VPWR VPWR _0198_ sky130_fd_sc_hd__mux2_1
XFILLER_54_289 VGND VPWR VPWR VGND sky130_ef_sc_hd__decap_12
XFILLER_14_109 VGND VPWR VPWR VGND sky130_ef_sc_hd__decap_12
XFILLER_6_319 VGND VGND VPWR VPWR sky130_fd_sc_hd__decap_6
XFILLER_22_175 VGND VGND VPWR VPWR sky130_fd_sc_hd__decap_3
XFILLER_22_197 VGND VGND VPWR VPWR sky130_fd_sc_hd__decap_8
XPHY_EDGE_ROW_15_Left_80 VGND VGND VPWR VPWR sky130_fd_sc_hd__decap_3
XFILLER_9_102 VGND VGND VPWR VPWR sky130_fd_sc_hd__decap_8
XFILLER_9_113 VGND VPWR VPWR VGND sky130_ef_sc_hd__decap_12
X_1410_ net108 net177 _0406_ VGND VGND VPWR VPWR _0129_ sky130_fd_sc_hd__mux2_1
X_1272_ u_jt49.u_chB.count\[1\] u_jt49.u_chB.count\[0\] net88 VGND VGND VPWR VPWR
+ _0309_ sky130_fd_sc_hd__nand3_1
X_1341_ _0356_ _0361_ _0365_ VGND VGND VPWR VPWR _0366_ sky130_fd_sc_hd__or3_1
X_0987_ _0485_ u_jt49.u_ng.u_div.count\[4\] u_jt49.u_ng.u_div.count\[3\] _0483_ VGND
+ VGND VPWR VPWR _0613_ sky130_fd_sc_hd__o22a_1
XFILLER_59_337 VGND VGND VPWR VPWR sky130_fd_sc_hd__decap_8
Xfanout125 net126 VGND VGND VPWR VPWR net125 sky130_fd_sc_hd__clkbuf_4
Xfanout103 net104 VGND VGND VPWR VPWR net103 sky130_fd_sc_hd__clkbuf_4
Xfanout136 net137 VGND VGND VPWR VPWR net136 sky130_fd_sc_hd__clkbuf_4
Xfanout114 _0501_ VGND VGND VPWR VPWR net114 sky130_fd_sc_hd__clkbuf_2
X_1608_ clknet_leaf_29_clk _0031_ net116 VGND VGND VPWR VPWR u_jt49.u_chC.count\[7\]
+ sky130_fd_sc_hd__dfrtp_1
X_1539_ u_jt49.periodA\[5\] net102 _0420_ VGND VGND VPWR VPWR _0244_ sky130_fd_sc_hd__mux2_1
XFILLER_42_248 VGND VGND VPWR VPWR sky130_fd_sc_hd__decap_4
XFILLER_2_300 VGND VGND VPWR VPWR sky130_fd_sc_hd__decap_4
XFILLER_10_189 VGND VGND VPWR VPWR sky130_fd_sc_hd__decap_6
XFILLER_2_377 VGND VGND VPWR VPWR sky130_fd_sc_hd__decap_4
XPHY_EDGE_ROW_0_Left_65 VGND VGND VPWR VPWR sky130_fd_sc_hd__decap_3
XFILLER_37_60 VGND VPWR VPWR VGND sky130_ef_sc_hd__decap_12
XPHY_EDGE_ROW_16_Right_16 VGND VGND VPWR VPWR sky130_fd_sc_hd__decap_3
X_0841_ u_jt49.u_chA.count\[1\] VGND VGND VPWR VPWR _0492_ sky130_fd_sc_hd__inv_2
XPHY_EDGE_ROW_25_Right_25 VGND VGND VPWR VPWR sky130_fd_sc_hd__decap_3
X_0910_ u_jt49.eg_period\[2\] _0521_ net77 u_jt49.periodA\[10\] VGND VGND VPWR VPWR
+ _0552_ sky130_fd_sc_hd__a22o_1
X_1255_ u_jt49.u_chB.count\[1\] u_jt49.periodB\[1\] VGND VGND VPWR VPWR _0293_ sky130_fd_sc_hd__and2b_1
XPHY_EDGE_ROW_34_Right_34 VGND VGND VPWR VPWR sky130_fd_sc_hd__decap_3
X_1186_ _0478_ _0767_ VGND VGND VPWR VPWR _0770_ sky130_fd_sc_hd__nand2_1
X_1324_ _0491_ u_jt49.periodA\[2\] _0492_ u_jt49.periodA\[1\] VGND VGND VPWR VPWR
+ _0349_ sky130_fd_sc_hd__a22o_1
XPHY_EDGE_ROW_43_Right_43 VGND VGND VPWR VPWR sky130_fd_sc_hd__decap_3
XPHY_EDGE_ROW_52_Right_52 VGND VGND VPWR VPWR sky130_fd_sc_hd__decap_3
XPHY_EDGE_ROW_61_Right_61 VGND VGND VPWR VPWR sky130_fd_sc_hd__decap_3
XPHY_EDGE_ROW_36_Left_101 VGND VGND VPWR VPWR sky130_fd_sc_hd__decap_3
XPHY_EDGE_ROW_45_Left_110 VGND VGND VPWR VPWR sky130_fd_sc_hd__decap_3
XFILLER_0_33 VGND VGND VPWR VPWR sky130_fd_sc_hd__decap_3
X_1040_ net86 u_jt49.u_chC.count\[0\] _0657_ VGND VGND VPWR VPWR _0658_ sky130_fd_sc_hd__and3_1
XFILLER_64_80 VGND VGND VPWR VPWR sky130_fd_sc_hd__decap_4
XFILLER_9_42 VGND VPWR VPWR VGND sky130_ef_sc_hd__decap_12
X_0824_ u_jt49.u_envdiv.count\[9\] VGND VGND VPWR VPWR _0475_ sky130_fd_sc_hd__inv_2
XFILLER_28_18 VGND VGND VPWR VPWR sky130_fd_sc_hd__decap_4
XFILLER_52_332 VGND VPWR VPWR VGND sky130_ef_sc_hd__decap_12
X_1238_ net228 _0279_ net79 VGND VGND VPWR VPWR _0084_ sky130_fd_sc_hd__mux2_1
X_1307_ u_jt49.periodB\[3\] u_jt49.periodB\[2\] u_jt49.periodB\[1\] u_jt49.periodB\[0\]
+ VGND VGND VPWR VPWR _0333_ sky130_fd_sc_hd__or4_1
X_1169_ net74 _0756_ _0757_ VGND VGND VPWR VPWR _0053_ sky130_fd_sc_hd__and3_1
XFILLER_52_365 VGND VPWR VPWR VGND sky130_ef_sc_hd__decap_12
XFILLER_20_240 VGND VGND VPWR VPWR sky130_fd_sc_hd__decap_3
XFILLER_43_343 VGND VGND VPWR VPWR sky130_fd_sc_hd__decap_4
XFILLER_46_192 VGND VGND VPWR VPWR sky130_fd_sc_hd__decap_4
X_1023_ u_jt49.u_chC.count\[4\] u_jt49.periodC\[4\] VGND VGND VPWR VPWR _0641_ sky130_fd_sc_hd__and2b_1
XFILLER_34_365 VGND VGND VPWR VPWR sky130_fd_sc_hd__decap_4
X_0807_ u_jt49.u_chB.count\[6\] VGND VGND VPWR VPWR _0458_ sky130_fd_sc_hd__inv_2
X_1787_ clknet_leaf_2_clk _0206_ net121 VGND VGND VPWR VPWR u_jt49.periodC\[7\] sky130_fd_sc_hd__dfrtp_2
XPHY_EDGE_ROW_2_Right_2 VGND VGND VPWR VPWR sky130_fd_sc_hd__decap_3
XFILLER_55_27 VGND VGND VPWR VPWR sky130_fd_sc_hd__decap_4
XFILLER_20_41 VGND VPWR VPWR VGND sky130_ef_sc_hd__decap_12
XFILLER_20_85 VGND VGND VPWR VPWR sky130_fd_sc_hd__decap_4
Xhold72 u_jt49.u_ng.poly17\[12\] VGND VGND VPWR VPWR net217 sky130_fd_sc_hd__dlygate4sd3_1
Xhold61 net63 VGND VGND VPWR VPWR net206 sky130_fd_sc_hd__dlygate4sd3_1
Xhold83 u_jt49.u_ng.poly17\[16\] VGND VGND VPWR VPWR net228 sky130_fd_sc_hd__dlygate4sd3_1
Xhold50 net60 VGND VGND VPWR VPWR net195 sky130_fd_sc_hd__dlygate4sd3_1
XFILLER_16_321 VGND VPWR VPWR VGND sky130_ef_sc_hd__decap_12
Xhold94 u_jt49.regarray\[13\]\[4\] VGND VGND VPWR VPWR net239 sky130_fd_sc_hd__dlygate4sd3_1
XFILLER_43_195 VGND VPWR VPWR VGND sky130_ef_sc_hd__decap_12
XFILLER_61_81 VGND VPWR VPWR VGND sky130_ef_sc_hd__decap_12
XANTENNA_3 net100 VGND VGND VPWR VPWR sky130_fd_sc_hd__diode_2
X_1641_ clknet_leaf_15_clk _0064_ net143 VGND VGND VPWR VPWR u_jt49.u_envdiv.count\[12\]
+ sky130_fd_sc_hd__dfrtp_1
X_1710_ clknet_leaf_16_clk _0129_ net142 VGND VGND VPWR VPWR net49 sky130_fd_sc_hd__dfrtp_1
X_1572_ u_jt49.regarray\[10\]\[0\] u_jt49.envelope\[1\] u_jt49.regarray\[10\]\[4\]
+ VGND VGND VPWR VPWR _0437_ sky130_fd_sc_hd__mux2_1
X_1006_ net146 _0504_ _0626_ VGND VGND VPWR VPWR _0021_ sky130_fd_sc_hd__a21o_1
XFILLER_26_107 VGND VGND VPWR VPWR sky130_fd_sc_hd__decap_4
X_1839_ clknet_leaf_24_clk _0257_ VGND VGND VPWR VPWR net38 sky130_fd_sc_hd__dfxtp_1
XFILLER_22_357 VGND VGND VPWR VPWR sky130_fd_sc_hd__decap_6
XFILLER_57_221 VGND VGND VPWR VPWR sky130_fd_sc_hd__decap_3
XFILLER_25_151 VGND VGND VPWR VPWR sky130_fd_sc_hd__decap_6
XFILLER_15_52 VGND VGND VPWR VPWR sky130_fd_sc_hd__decap_4
Xoutput62 net62 VGND VGND VPWR VPWR IOB_out[6] sky130_fd_sc_hd__buf_2
Xoutput51 net51 VGND VGND VPWR VPWR IOA_out[4] sky130_fd_sc_hd__buf_2
Xoutput40 net40 VGND VGND VPWR VPWR B[4] sky130_fd_sc_hd__buf_2
XFILLER_48_265 VGND VPWR VPWR VGND sky130_ef_sc_hd__decap_12
Xclkbuf_leaf_28_clk clknet_2_0__leaf_clk VGND VGND VPWR VPWR clknet_leaf_28_clk sky130_fd_sc_hd__clkbuf_8
X_1555_ net113 net158 _0424_ _0427_ VGND VGND VPWR VPWR _0253_ sky130_fd_sc_hd__a22o_1
X_1624_ clknet_leaf_22_clk _0047_ VGND VGND VPWR VPWR u_jt49.envelope\[1\] sky130_fd_sc_hd__dfxtp_1
X_1486_ net198 net99 _0414_ VGND VGND VPWR VPWR _0197_ sky130_fd_sc_hd__mux2_1
Xclkbuf_leaf_19_clk clknet_2_2__leaf_clk VGND VGND VPWR VPWR clknet_leaf_19_clk sky130_fd_sc_hd__clkbuf_8
XFILLER_26_95 VGND VPWR VPWR VGND sky130_ef_sc_hd__decap_12
XFILLER_9_125 VGND VPWR VPWR VGND sky130_ef_sc_hd__decap_12
XFILLER_9_169 VGND VGND VPWR VPWR sky130_fd_sc_hd__decap_6
XFILLER_13_165 VGND VGND VPWR VPWR sky130_fd_sc_hd__decap_3
X_1340_ _0338_ _0364_ VGND VGND VPWR VPWR _0365_ sky130_fd_sc_hd__nand2_1
XFILLER_5_331 VGND VGND VPWR VPWR sky130_fd_sc_hd__decap_4
X_1271_ u_jt49.u_chB.count\[0\] net88 u_jt49.u_chB.count\[1\] VGND VGND VPWR VPWR
+ _0308_ sky130_fd_sc_hd__a21o_1
XFILLER_3_33 VGND VPWR VPWR VGND sky130_ef_sc_hd__decap_12
Xclkbuf_leaf_8_clk clknet_2_1__leaf_clk VGND VGND VPWR VPWR clknet_leaf_8_clk sky130_fd_sc_hd__clkbuf_8
X_0986_ _0483_ u_jt49.u_ng.u_div.count\[3\] u_jt49.u_ng.u_div.count\[2\] _0484_ _0611_
+ VGND VGND VPWR VPWR _0612_ sky130_fd_sc_hd__a221o_1
XFILLER_59_305 VGND VPWR VPWR VGND sky130_ef_sc_hd__decap_12
Xfanout126 net130 VGND VGND VPWR VPWR net126 sky130_fd_sc_hd__clkbuf_4
Xfanout104 din_latch\[4\] VGND VGND VPWR VPWR net104 sky130_fd_sc_hd__clkbuf_4
X_1469_ net173 net97 _0412_ VGND VGND VPWR VPWR _0182_ sky130_fd_sc_hd__mux2_1
Xfanout137 net138 VGND VGND VPWR VPWR net137 sky130_fd_sc_hd__clkbuf_4
X_1538_ u_jt49.periodA\[4\] net104 _0420_ VGND VGND VPWR VPWR _0243_ sky130_fd_sc_hd__mux2_1
X_1607_ clknet_leaf_29_clk _0030_ net115 VGND VGND VPWR VPWR u_jt49.u_chC.count\[6\]
+ sky130_fd_sc_hd__dfrtp_1
Xfanout115 net122 VGND VGND VPWR VPWR net115 sky130_fd_sc_hd__clkbuf_4
XFILLER_37_72 VGND VGND VPWR VPWR sky130_fd_sc_hd__decap_4
XFILLER_18_246 VGND VGND VPWR VPWR sky130_fd_sc_hd__decap_6
X_0840_ u_jt49.u_chA.count\[2\] VGND VGND VPWR VPWR _0491_ sky130_fd_sc_hd__inv_2
XFILLER_38_3 VGND VGND VPWR VPWR sky130_fd_sc_hd__decap_8
X_1323_ _0492_ u_jt49.periodA\[1\] u_jt49.periodA\[0\] _0493_ VGND VGND VPWR VPWR
+ _0348_ sky130_fd_sc_hd__o211a_1
XFILLER_5_150 VGND VGND VPWR VPWR sky130_fd_sc_hd__decap_4
X_1254_ u_jt49.u_chB.count\[2\] u_jt49.periodB\[2\] VGND VGND VPWR VPWR _0292_ sky130_fd_sc_hd__and2b_1
X_1185_ _0478_ _0767_ VGND VGND VPWR VPWR _0769_ sky130_fd_sc_hd__or2_1
XFILLER_33_19 VGND VGND VPWR VPWR sky130_fd_sc_hd__decap_8
XFILLER_24_249 VGND VGND VPWR VPWR sky130_fd_sc_hd__decap_3
X_0969_ u_jt49.periodA\[7\] _0518_ _0539_ _0605_ u_jt49.read_mask\[5\] VGND VGND VPWR
+ VPWR _0606_ sky130_fd_sc_hd__o2111a_1
XFILLER_3_109 VGND VGND VPWR VPWR sky130_fd_sc_hd__decap_3
XFILLER_59_113 VGND VPWR VPWR VGND sky130_ef_sc_hd__decap_12
XFILLER_30_219 VGND VPWR VPWR VGND sky130_ef_sc_hd__decap_12
XFILLER_23_52 VGND VGND VPWR VPWR sky130_fd_sc_hd__decap_4
XFILLER_2_153 VGND VGND VPWR VPWR sky130_fd_sc_hd__decap_8
XFILLER_0_89 VGND VGND VPWR VPWR sky130_fd_sc_hd__decap_6
XFILLER_14_282 VGND VGND VPWR VPWR sky130_fd_sc_hd__decap_8
XFILLER_21_219 VGND VGND VPWR VPWR sky130_fd_sc_hd__decap_4
X_0823_ u_jt49.u_envdiv.count\[13\] VGND VGND VPWR VPWR _0474_ sky130_fd_sc_hd__inv_2
XFILLER_56_105 VGND VPWR VPWR VGND sky130_ef_sc_hd__decap_12
X_1306_ _0452_ _0332_ _0307_ VGND VGND VPWR VPWR _0099_ sky130_fd_sc_hd__a21boi_1
XFILLER_52_377 VGND VGND VPWR VPWR sky130_fd_sc_hd__decap_4
XFILLER_52_344 VGND VPWR VPWR VGND sky130_ef_sc_hd__decap_12
X_1237_ u_jt49.u_ng.poly17\[0\] u_jt49.u_ng.poly17\[3\] _0278_ VGND VGND VPWR VPWR
+ _0279_ sky130_fd_sc_hd__a21oi_1
X_1168_ net85 u_jt49.u_envdiv.count\[0\] u_jt49.u_envdiv.count\[1\] VGND VGND VPWR
+ VPWR _0757_ sky130_fd_sc_hd__a21o_1
X_1099_ _0701_ VGND VGND VPWR VPWR _0702_ sky130_fd_sc_hd__inv_2
XFILLER_18_85 VGND VPWR VPWR VGND sky130_ef_sc_hd__decap_12
XFILLER_50_94 VGND VGND VPWR VPWR sky130_fd_sc_hd__decap_3
XFILLER_34_355 VGND VGND VPWR VPWR sky130_fd_sc_hd__decap_8
X_1022_ u_jt49.u_chC.count\[5\] _0468_ _0639_ VGND VGND VPWR VPWR _0640_ sky130_fd_sc_hd__a21oi_1
X_1855_ clknet_leaf_14_clk _0265_ VGND VGND VPWR VPWR u_jt49.wr_n sky130_fd_sc_hd__dfxtp_1
X_0806_ u_jt49.u_chB.count\[7\] VGND VGND VPWR VPWR _0457_ sky130_fd_sc_hd__inv_2
X_1786_ clknet_leaf_2_clk _0205_ net120 VGND VGND VPWR VPWR u_jt49.periodC\[6\] sky130_fd_sc_hd__dfrtp_2
XFILLER_44_119 VGND VPWR VPWR VGND sky130_ef_sc_hd__decap_12
XFILLER_44_108 VGND VGND VPWR VPWR sky130_fd_sc_hd__decap_4
XFILLER_29_105 VGND VGND VPWR VPWR sky130_fd_sc_hd__decap_6
XPHY_EDGE_ROW_64_Left_129 VGND VGND VPWR VPWR sky130_fd_sc_hd__decap_3
XFILLER_52_141 VGND VGND VPWR VPWR sky130_fd_sc_hd__decap_8
XFILLER_40_336 VGND VGND VPWR VPWR sky130_fd_sc_hd__decap_8
Xhold40 u_jt49.regarray\[9\]\[6\] VGND VGND VPWR VPWR net185 sky130_fd_sc_hd__dlygate4sd3_1
XFILLER_20_53 VGND VGND VPWR VPWR sky130_fd_sc_hd__decap_4
Xhold73 _0080_ VGND VGND VPWR VPWR net218 sky130_fd_sc_hd__dlygate4sd3_1
Xhold84 u_jt49.u_ng.poly17\[10\] VGND VGND VPWR VPWR net229 sky130_fd_sc_hd__dlygate4sd3_1
Xhold95 u_jt49.u_ng.poly17\[5\] VGND VGND VPWR VPWR net240 sky130_fd_sc_hd__dlygate4sd3_1
Xhold51 net48 VGND VGND VPWR VPWR net196 sky130_fd_sc_hd__dlygate4sd3_1
XFILLER_16_333 VGND VGND VPWR VPWR sky130_fd_sc_hd__decap_8
Xhold62 u_jt49.regarray\[6\]\[5\] VGND VGND VPWR VPWR net207 sky130_fd_sc_hd__dlygate4sd3_1
XFILLER_61_93 VGND VPWR VPWR VGND sky130_ef_sc_hd__decap_12
X_1640_ clknet_leaf_15_clk _0063_ net142 VGND VGND VPWR VPWR u_jt49.u_envdiv.count\[11\]
+ sky130_fd_sc_hd__dfrtp_1
X_1571_ net114 net164 _0435_ _0436_ VGND VGND VPWR VPWR _0260_ sky130_fd_sc_hd__a22o_1
XANTENNA_4 net102 VGND VGND VPWR VPWR sky130_fd_sc_hd__diode_2
X_1005_ _0504_ _0625_ net144 VGND VGND VPWR VPWR _0626_ sky130_fd_sc_hd__o21ai_1
XFILLER_34_141 VGND VGND VPWR VPWR sky130_fd_sc_hd__decap_4
X_1838_ clknet_leaf_24_clk _0256_ VGND VGND VPWR VPWR net37 sky130_fd_sc_hd__dfxtp_1
X_1769_ clknet_leaf_19_clk _0188_ net134 VGND VGND VPWR VPWR u_jt49.regarray\[13\]\[5\]
+ sky130_fd_sc_hd__dfrtp_1
Xoutput52 net52 VGND VGND VPWR VPWR IOA_out[5] sky130_fd_sc_hd__buf_2
Xoutput41 net41 VGND VGND VPWR VPWR C[0] sky130_fd_sc_hd__buf_2
Xoutput63 net63 VGND VGND VPWR VPWR IOB_out[7] sky130_fd_sc_hd__buf_2
XFILLER_48_277 VGND VPWR VPWR VGND sky130_ef_sc_hd__decap_12
XFILLER_63_225 VGND VPWR VPWR VGND sky130_ef_sc_hd__decap_12
XFILLER_56_93 VGND VPWR VPWR VGND sky130_ef_sc_hd__decap_12
XFILLER_16_130 VGND VGND VPWR VPWR sky130_fd_sc_hd__decap_8
X_1623_ clknet_leaf_22_clk _0046_ VGND VGND VPWR VPWR u_jt49.envelope\[0\] sky130_fd_sc_hd__dfxtp_1
X_1554_ u_jt49.regarray\[8\]\[2\] u_jt49.envelope\[3\] u_jt49.regarray\[8\]\[4\] VGND
+ VGND VPWR VPWR _0427_ sky130_fd_sc_hd__mux2_1
X_1485_ net193 net101 _0414_ VGND VGND VPWR VPWR _0196_ sky130_fd_sc_hd__mux2_1
C0 net130 VPWR 7.28222f
C1 VPWR _0521_ 3.47587f
C2 clknet_2_0__leaf_clk VPWR 4.31481f
C3 net102 _0559_ 3.30604f
C4 clknet_2_3__leaf_clk net102 2.95017f
C5 din_latch\[2\] VPWR 2.91862f
C6 net104 u_jt49.read_mask\[5\] 2.51829f
C7 net82 VPWR 5.07745f
C8 u_jt49.noise VPWR 2.85656f
C9 VPWR din_latch\[0\] 4.38388f
C10 clknet_leaf_9_clk VPWR 2.37111f
C11 net102 VPWR 15.11519f
C12 u_jt49.eg_period\[5\] VPWR 3.39639f
C13 VPWR _0589_ 3.25497f
C14 VPWR _0440_ 2.35453f
C15 din_latch\[7\] net101 2.04651f
C16 u_jt49.regarray\[6\]\[0\] VPWR 3.89208f
C17 clknet_leaf_28_clk VPWR 4.95037f
C18 clknet_leaf_11_clk VPWR 4.3098f
C19 net104 net20 2.64409f
C20 u_jt49.write VPWR 4.47376f
C21 VPWR net75 3.8029f
C22 net97 _0411_ 2.54038f
C23 u_jt49.periodB\[9\] VPWR 2.14099f
C24 u_jt49.periodB\[7\] net128 2.03685f
C25 net109 clknet_2_1__leaf_clk 2.69416f
C26 net87 VPWR 2.36382f
C27 _0659_ VPWR 3.32624f
C28 u_jt49.periodB\[0\] addr\[1\] 2.02913f
C29 VPWR clknet_leaf_8_clk 4.05161f
C30 VPWR _0417_ 2.43415f
C31 net85 VPWR 2.79092f
C32 u_jt49.regarray\[13\]\[3\] VPWR 2.2917f
C33 net7 u_jt49.eg_period\[11\] 3.16317f
C34 net6 VPWR 5.34542f
C35 clknet_leaf_20_clk net136 2.05872f
C36 _0525_ VPWR 2.81668f
C37 net55 net127 2.70575f
C38 VPWR u_jt49.envelope\[3\] 2.87851f
C39 VPWR u_jt49.eg_period\[4\] 3.44047f
C40 _0414_ VPWR 2.73307f
C41 net5 VPWR 7.10764f
C42 VPWR net8 4.73571f
C43 net98 VPWR 4.85152f
C44 VPWR net73 3.72309f
C45 VPWR u_jt49.regarray\[10\]\[4\] 2.17028f
C46 net128 VPWR 3.40805f
C47 VPWR net115 3.25685f
C48 _0586_ clknet_2_0__leaf_clk 2.02062f
C49 VPWR net13 5.48025f
C50 VPWR u_jt49.envelope\[4\] 4.18556f
C51 VPWR net144 3.18434f
C52 _0269_ VPWR 3.62814f
C53 net139 VPWR 2.30146f
C54 VPWR u_jt49.periodA\[10\] 4.0435f
C55 clknet_leaf_10_clk VPWR 2.34471f
C56 net2 u_jt49.envelope\[0\] 3.26391f
C57 VPWR clknet_2_2__leaf_clk 6.72528f
C58 clknet_2_3__leaf_clk VPWR 4.14569f
C59 net122 VPWR 11.06031f
C60 din_latch\[3\] VPWR 3.9626f
C61 _0412_ VPWR 5.54164f
C62 VPWR clknet_leaf_19_clk 4.32619f
C63 u_jt49.eg_period\[13\] _0589_ 2.2174f
C64 VPWR clknet_leaf_2_clk 2.03298f
C65 u_jt49.regarray\[13\]\[1\] _0524_ 2.01327f
C66 VPWR u_jt49.regarray\[10\]\[3\] 3.61908f
C67 u_jt49.envelope\[1\] VPWR 2.73932f
C68 VPWR net129 2.53816f
C69 VPWR u_jt49.u_ng.noise_en 2.47589f
C70 net111 VPWR 9.60058f
C71 net14 VPWR 2.21829f
C72 _0519_ VPWR 11.8333f
C73 VPWR net103 9.07386f
C74 VPWR net112 5.09349f
C75 u_jt49.periodB\[1\] VPWR 2.6683f
C76 clknet_leaf_29_clk VPWR 2.98117f
C77 u_jt49.eg_period\[15\] VPWR 2.50959f
C78 net143 VPWR 4.0999f
C79 u_jt49.periodC\[6\] VPWR 5.20164f
C80 net105 u_jt49.periodA\[10\] 2.82424f
C81 clk VPWR 4.13242f
C82 VPWR net133 2.21125f
C83 VPWR net16 2.46092f
C84 u_jt49.periodA\[11\] VPWR 3.14855f
C85 clknet_leaf_7_clk VPWR 5.61984f
C86 net100 net144 3.2228f
C87 net9 net115 2.06834f
C88 u_jt49.regarray\[8\]\[1\] u_jt49.regarray\[10\]\[2\] 3.94442f
C89 net145 _0504_ 4.46925f
C90 clknet_leaf_12_clk VPWR 3.37124f
C91 VPWR _0506_ 2.60245f
C92 net1 VPWR 9.61213f
C93 VPWR clknet_leaf_6_clk 3.03996f
C94 _0542_ _0577_ 4.90096f
C95 net105 VPWR 11.36059f
C96 VPWR _0413_ 5.28052f
C97 net83 VPWR 4.09814f
C98 net126 VPWR 8.54066f
C99 VPWR net81 7.10417f
C100 u_jt49.periodC\[11\] VPWR 3.23193f
C101 net88 _0659_ 2.47761f
C102 VPWR _0523_ 3.11889f
C103 net113 VPWR 4.09246f
C104 VPWR _0411_ 7.56422f
C105 u_jt49.read_mask\[5\] VPWR 2.02435f
C106 VPWR u_jt49.u_chC.count\[8\] 2.01304f
C107 _0405_ net98 2.20199f
C108 _0530_ VPWR 3.38658f
C109 net111 _0411_ 2.26449f
C110 VPWR net106 4.89125f
C111 net100 VPWR 9.3476f
C112 net84 VPWR 5.11193f
C113 u_jt49.write _0406_ 2.65769f
C114 clknet_leaf_13_clk VPWR 2.44609f
C115 VPWR _0367_ 3.18957f
C116 u_jt49.periodC\[10\] VPWR 4.80642f
C117 _0410_ VPWR 3.32148f
C118 net20 VPWR 18.01105f
C119 u_jt49.eg_period\[11\] VPWR 3.90475f
C120 VPWR u_jt49.eg_period\[10\] 4.36703f
C121 VPWR _0478_ 2.74736f
C122 VPWR net3 4.74758f
C123 u_jt49.periodA\[0\] VPWR 3.33876f
C124 VPWR din_latch\[1\] 2.23811f
C125 VPWR _0407_ 2.39414f
C126 net116 VPWR 2.42361f
C127 _0537_ u_jt49.periodB\[4\] 2.53828f
C128 net4 VPWR 4.55277f
C129 _0408_ u_jt49.regarray\[10\]\[4\] 3.10634f
C130 net102 _0419_ 2.87384f
C131 _0405_ VPWR 3.55908f
C132 net135 clknet_leaf_19_clk 2.25006f
C133 VPWR u_jt49.periodA\[5\] 2.05935f
C134 VPWR clknet_leaf_4_clk 2.51313f
C135 VPWR u_jt49.u_env.gain\[1\] 2.1692f
C136 VPWR net46 4.90701f
C137 _0418_ clknet_leaf_3_clk 2.02475f
C138 u_jt49.eg_period\[13\] VPWR 6.94122f
C139 u_jt49.periodB\[11\] VPWR 2.09228f
C140 _0541_ _0596_ 2.21424f
C141 clknet_leaf_0_clk VPWR 4.59837f
C142 clknet_leaf_21_clk VPWR 2.86604f
C143 u_jt49.periodB\[1\] u_jt49.periodB\[4\] 2.43562f
C144 net105 net120 2.08479f
C145 VPWR u_jt49.regarray\[6\]\[3\] 4.93844f
C146 _0420_ VPWR 2.89065f
C147 din_latch\[7\] VPWR 4.23384f
C148 _0518_ VPWR 3.64176f
C149 _0566_ net8 4.34614f
C150 VPWR u_jt49.regarray\[7\]\[3\] 2.95072f
C151 VPWR _0416_ 2.18982f
C152 net86 VPWR 2.44968f
C153 VPWR u_jt49.regarray\[10\]\[1\] 9.58261f
C154 _0408_ VPWR 2.35016f
C155 clknet_leaf_20_clk VPWR 4.0899f
C156 net88 VPWR 7.1294f
C157 clknet_leaf_5_clk VPWR 2.5168f
C158 _0524_ VPWR 5.46057f
C159 u_jt49.eg_period\[8\] VPWR 2.55139f
C160 _0517_ VPWR 3.54535f
C161 VPWR clknet_leaf_1_clk 4.85229f
C162 net109 VPWR 14.37013f
C163 net55 VPWR 7.75589f
C164 u_jt49.regarray\[13\]\[2\] VPWR 2.03134f
C165 _0406_ VPWR 2.08677f
C166 u_jt49.periodC\[7\] VPWR 3.26766f
C167 _0412_ clknet_0_clk 4.3458f
C168 VPWR net11 2.79315f
C169 _0616_ VPWR 2.29284f
C170 u_jt49.periodA\[2\] VPWR 2.19862f
C171 _0272_ _0271_ 3.34747f
C172 u_jt49.u_env.rst_latch VPWR 4.50579f
C173 clknet_0_clk VPWR 7.95589f
C174 VPWR net99 2.67445f
C175 VPWR u_jt49.regarray\[9\]\[3\] 3.41289f
C176 _0665_ VPWR 2.65616f
C177 clknet_2_1__leaf_clk VPWR 5.21274f
C178 _0270_ VPWR 2.77187f
C179 net2 VPWR 5.64302f
C180 net101 VPWR 5.27013f
C181 net108 VPWR 6.87141f
C182 VPWR _0369_ 2.94775f
C183 _0540_ _0273_ 3.85246f
C184 u_jt49.regarray\[8\]\[0\] u_jt49.regarray\[9\]\[2\] 2.45344f
C185 u_jt49.eg_period\[9\] net98 2.38998f
C186 VPWR net110 9.32094f
C187 net25 VPWR 2.04927f
C188 net137 VPWR 3.104f
C189 VPWR _0266_ 2.61149f
C190 _0529_ VPWR 2.01537f
C191 _0520_ VPWR 5.32163f
C192 _0542_ VPWR 5.1316f
C193 net145 VPWR 14.18486f
C194 VPWR net141 3.31528f
C195 _0272_ net116 2.73245f
C196 VPWR net74 3.38136f
C197 _0608_ VPWR 7.92386f
C198 net107 VPWR 9.97651f
C199 u_jt49.periodB\[3\] VPWR 3.15995f
C200 u_jt49.regarray\[10\]\[5\] VPWR 2.85871f
C201 VPWR clknet_leaf_25_clk 4.1325f
C202 VPWR _0419_ 4.65928f
C203 u_jt49.envelope\[0\] VPWR 3.27198f
C204 _0410_ u_jt49.regarray\[8\]\[4\] 2.83497f
C205 net78 VPWR 3.36877f
C206 clknet_leaf_27_clk VPWR 2.60283f
C207 net140 VPWR 2.54638f
C208 net79 VPWR 2.71711f
C209 u_jt49.eg_period\[9\] VPWR 7.0033f
C210 VPWR u_jt49.periodA\[7\] 4.7656f
C211 VPWR u_jt49.regarray\[10\]\[2\] 5.91999f
C212 net104 VPWR 11.42552f
C213 _0551_ net116 2.2906f
C214 u_jt49.periodC\[9\] VPWR 3.48752f
C215 u_jt49.periodC\[8\] VPWR 3.35861f
C216 _0268_ net11 2.93461f
C217 VPWR u_jt49.eg_period\[0\] 4.01081f
C218 clknet_leaf_3_clk VPWR 2.4207f
C219 u_jt49.periodB\[3\] u_jt49.periodB\[2\] 2.35636f
C220 VPWR clknet_leaf_14_clk 3.12015f
C221 VPWR u_jt49.regarray\[10\]\[0\] 2.66277f
C222 net104 net103 2.11477f
C223 u_jt49.regarray\[6\]\[2\] VPWR 2.58534f
C224 VPWR net125 3.4846f
C225 u_jt49.regarray\[8\]\[0\] u_jt49.bitB 2.70883f
C226 VPWR _0504_ 3.31287f
C227 VPWR net72 6.90443f
C228 VPWR clknet_leaf_15_clk 3.50644f
C229 net10 VPWR 2.33314f
C230 _0528_ VPWR 3.15139f
C231 u_jt49.envelope\[2\] VPWR 4.18267f
C232 net7 VPWR 4.10396f
C233 VPWR clknet_leaf_17_clk 3.24494f
C234 VPWR _0522_ 5.05753f
C235 _0307_ VPWR 5.34526f
C236 VPWR _0439_ 2.30426f
C237 net77 VPWR 2.7712f
C238 VPWR _0501_ 9.30724f
C239 u_jt49.u_env.cen VPWR 3.30163f
C240 addr\[1\] VPWR 2.11014f
C241 VPWR net97 7.94165f
C242 _0415_ VPWR 2.25385f
C243 u_jt49.regarray\[13\]\[1\] VPWR 3.56221f
C244 VPWR u_jt49.eg_period\[14\] 4.4794f
C245 _0541_ VPWR 3.8655f
C246 VPWR net29 6.33755f
C247 _0418_ VPWR 5.56016f
C248 clknet_leaf_19_clk VGND 3.57013f
C249 clknet_leaf_24_clk VGND 4.30043f
C250 clknet_leaf_15_clk VGND 6.09641f
C251 u_jt49.u_ng.poly17\[0\] VGND 2.7614f
C252 u_jt49.periodA\[4\] VGND 2.06898f
C253 net99 VGND 7.81141f
C254 u_jt49.periodA\[10\] VGND 2.42507f
C255 _0501_ VGND 5.49692f
C256 u_jt49.u_chB.count\[1\] VGND 2.42616f
C257 net72 VGND 15.50523f
C258 net18 VGND 3.0502f
C259 _0436_ VGND 4.09013f
C260 clknet_leaf_14_clk VGND 4.99279f
C261 _0523_ VGND 8.7032f
C262 net73 VGND 7.14933f
C263 u_jt49.regarray\[10\]\[1\] VGND 3.58935f
C264 din_latch\[0\] VGND 6.54118f
C265 u_jt49.u_ng.u_div.count\[0\] VGND 2.11212f
C266 u_jt49.regarray\[9\]\[3\] VGND 5.10917f
C267 u_jt49.regarray\[9\]\[4\] VGND 4.05226f
C268 _0438_ VGND 2.00044f
C269 net117 VGND 7.36762f
C270 u_jt49.u_chC.count\[0\] VGND 2.76654f
C271 _0522_ VGND 3.69063f
C272 u_jt49.periodB\[10\] VGND 3.98621f
C273 net29 VGND 6.29932f
C274 clknet_leaf_1_clk VGND 5.90089f
C275 net141 VGND 6.82126f
C276 u_jt49.eg_period\[10\] VGND 4.00373f
C277 u_jt49.u_chC.count\[5\] VGND 2.7791f
C278 din_latch\[1\] VGND 4.3647f
C279 net144 VGND 6.06221f
C280 clknet_leaf_8_clk VGND 4.34258f
C281 u_jt49.periodC\[2\] VGND 3.33111f
C282 clknet_leaf_25_clk VGND 6.38772f
C283 clknet_2_2__leaf_clk VGND 7.19117f
C284 net138 VGND 5.24032f
C285 net21 VGND 2.82013f
C286 _0504_ VGND 5.24096f
C287 u_jt49.regarray\[10\]\[3\] VGND 3.59267f
C288 u_jt49.regarray\[10\]\[4\] VGND 4.26642f
C289 u_jt49.periodC\[5\] VGND 3.41514f
C290 _0407_ VGND 3.79619f
C291 u_jt49.eg_period\[12\] VGND 3.09936f
C292 u_jt49.eg_period\[4\] VGND 2.81804f
C293 net125 VGND 5.88368f
C294 u_jt49.periodA\[1\] VGND 3.65789f
C295 _0477_ VGND 3.37901f
C296 _0369_ VGND 5.15153f
C297 u_jt49.periodB\[4\] VGND 2.98397f
C298 net112 VGND 10.4406f
C299 net46 VGND 7.9565f
C300 net81 VGND 5.11418f
C301 net11 VGND 2.4549f
C302 net3 VGND 11.35373f
C303 u_jt49.eg_period\[1\] VGND 4.48136f
C304 u_jt49.eg_period\[2\] VGND 7.0963f
C305 u_jt49.u_env.gain\[0\] VGND 3.44877f
C306 net110 VGND 8.50623f
C307 _0409_ VGND 2.9675f
C308 _0416_ VGND 3.5173f
C309 net16 VGND 2.1017f
C310 net8 VGND 3.85315f
C311 net133 VGND 5.71064f
C312 net129 VGND 3.84894f
C313 _0674_ VGND 2.5414f
C314 u_jt49.u_envdiv.count\[0\] VGND 2.68082f
C315 u_jt49.u_ng.poly17\[7\] VGND 2.08659f
C316 _0755_ VGND 2.00649f
C317 clknet_leaf_17_clk VGND 3.84059f
C318 _0413_ VGND 4.08768f
C319 clknet_leaf_23_clk VGND 2.9889f
C320 u_jt49.read_mask\[4\] VGND 2.36541f
C321 net106 VGND 9.5511f
C322 _0417_ VGND 3.22454f
C323 u_jt49.eg_period\[6\] VGND 2.97579f
C324 _0411_ VGND 5.50237f
C325 _0419_ VGND 5.34436f
C326 _0500_ VGND 2.31494f
C327 net97 VGND 15.43029f
C328 net120 VGND 4.21339f
C329 clknet_leaf_2_clk VGND 7.31674f
C330 net103 VGND 15.06197f
C331 u_jt49.eg_period\[14\] VGND 2.82166f
C332 u_jt49.regarray\[6\]\[1\] VGND 4.21907f
C333 u_jt49.bitA VGND 2.08294f
C334 net118 VGND 5.13745f
C335 net115 VGND 6.36321f
C336 _0267_ VGND 2.00048f
C337 clknet_leaf_30_clk VGND 3.35324f
C338 _0532_ VGND 3.91525f
C339 _0521_ VGND 5.31366f
C340 net74 VGND 6.9628f
C341 u_jt49.u_ng.noise_en VGND 2.6138f
C342 net17 VGND 2.15096f
C343 net9 VGND 4.08562f
C344 net75 VGND 4.394f
C345 clknet_leaf_6_clk VGND 3.50358f
C346 _0268_ VGND 4.7601f
C347 VPWR VGND 2.80223p
C348 u_jt49.periodC\[11\] VGND 2.76316f
C349 _0692_ VGND 3.70574f
C350 net87 VGND 9.59291f
C351 net101 VGND 11.73956f
C352 net82 VGND 5.31351f
C353 net86 VGND 6.35772f
C354 _0596_ VGND 2.82582f
C355 u_jt49.bitB VGND 2.30673f
C356 _0415_ VGND 3.49873f
C357 net114 VGND 4.86651f
C358 net140 VGND 3.96793f
C359 u_jt49.periodC\[6\] VGND 2.50445f
C360 net102 VGND 9.42926f
C361 clknet_leaf_29_clk VGND 4.88868f
C362 _0763_ VGND 2.05661f
C363 u_jt49.periodB\[9\] VGND 2.19692f
C364 net5 VGND 5.38553f
C365 net98 VGND 8.84118f
C366 u_jt49.envelope\[0\] VGND 4.20968f
C367 u_jt49.regarray\[8\]\[4\] VGND 2.82404f
C368 net100 VGND 27.37725f
C369 clknet_leaf_3_clk VGND 2.65771f
C370 clknet_leaf_10_clk VGND 4.83861f
C371 u_jt49.bitC VGND 2.70136f
C372 u_jt49.periodA\[9\] VGND 4.11814f
C373 net25 VGND 4.05239f
C374 net4 VGND 6.14847f
C375 net20 VGND 12.97932f
C376 u_jt49.regarray\[9\]\[2\] VGND 3.01319f
C377 net142 VGND 4.54482f
C378 clknet_leaf_16_clk VGND 3.95091f
C379 clknet_leaf_12_clk VGND 4.29693f
C380 net119 VGND 6.57125f
C381 u_jt49.u_env.rst_latch VGND 2.56692f
C382 u_jt49.regarray\[6\]\[4\] VGND 6.228f
C383 _0519_ VGND 5.22146f
C384 _0525_ VGND 3.88969f
C385 _0526_ VGND 8.28131f
C386 u_jt49.eg_period\[11\] VGND 3.48069f
C387 net113 VGND 6.12956f
C388 _0424_ VGND 2.38572f
C389 net79 VGND 2.97335f
C390 _0524_ VGND 3.00611f
C391 _0530_ VGND 6.18658f
C392 _0529_ VGND 3.41701f
C393 net78 VGND 3.97741f
C394 u_jt49.periodC\[7\] VGND 2.90467f
C395 clknet_leaf_9_clk VGND 3.8132f
C396 net84 VGND 10.5802f
C397 _0657_ VGND 4.86166f
C398 net1 VGND 6.48761f
C399 _0517_ VGND 3.62839f
C400 u_jt49.periodB\[1\] VGND 3.19365f
C401 _0659_ VGND 4.25288f
C402 _0318_ VGND 2.04438f
C403 net92 VGND 2.73505f
C404 _0406_ VGND 4.475f
C405 u_jt49.periodB\[11\] VGND 4.96454f
C406 u_jt49.periodA\[11\] VGND 2.74235f
C407 din_latch\[7\] VGND 3.00159f
C408 _0693_ VGND 3.44854f
C409 _0701_ VGND 2.89192f
C410 net131 VGND 5.7575f
C411 net88 VGND 6.1038f
C412 net24 VGND 3.54031f
C413 net77 VGND 3.92285f
C414 u_jt49.u_env.cen VGND 4.36838f
C415 _0746_ VGND 2.00863f
C416 addr\[0\] VGND 3.06147f
C417 clknet_0_clk VGND 3.74564f
C418 net132 VGND 2.08651f
C419 net123 VGND 6.50936f
C420 clknet_leaf_5_clk VGND 3.7842f
C421 net2 VGND 7.05982f
C422 _0528_ VGND 2.03234f
C423 u_jt49.periodB\[3\] VGND 2.53146f
C424 net89 VGND 3.82197f
C425 net91 VGND 3.06426f
C426 net93 VGND 2.55122f
C427 u_jt49.periodA\[8\] VGND 3.55853f
C428 net15 VGND 3.45971f
C429 net7 VGND 3.97641f
C430 clknet_leaf_0_clk VGND 5.30836f
C431 clk VGND 4.55945f
C432 B[2] VGND 2.77534f
C433 net126 VGND 5.8486f
C434 _0520_ VGND 3.42871f
C435 net83 VGND 6.97768f
C436 net111 VGND 13.02454f
C437 clknet_2_1__leaf_clk VGND 12.29102f
C438 u_jt49.periodB\[8\] VGND 2.69993f
C439 net107 VGND 13.9186f
C440 _0408_ VGND 3.12348f
C441 u_jt49.eg_period\[13\] VGND 3.58812f
C442 net85 VGND 5.10081f
C443 u_jt49.write VGND 5.08014f
C444 net109 VGND 10.7213f
C445 _0410_ VGND 3.85019f
C446 net136 VGND 4.38215f
C447 clknet_leaf_20_clk VGND 3.7564f
C448 net139 VGND 3.50464f
C449 clknet_leaf_11_clk VGND 2.8814f
C450 clknet_leaf_13_clk VGND 2.885f
C451 net127 VGND 4.86991f
C452 clknet_leaf_28_clk VGND 4.72668f
C453 net12 VGND 2.05146f
C454 net121 VGND 3.8268f
C455 clknet_leaf_26_clk VGND 2.7192f
C456 net124 VGND 4.69767f
C457 net108 VGND 8.98302f
C458 _0418_ VGND 4.97477f
C459 clknet_leaf_27_clk VGND 3.14191f
C460 net26 VGND 4.57383f
C461 _0608_ VGND 6.82405f
C462 net128 VGND 5.11551f
C463 net134 VGND 2.02634f
C464 clknet_2_3__leaf_clk VGND 11.55973f
C465 u_jt49.regarray\[13\]\[2\] VGND 4.2598f
C466 net105 VGND 9.30778f
C467 u_jt49.eg_period\[15\] VGND 4.21706f
C468 clknet_2_0__leaf_clk VGND 10.03208f
C469 _0412_ VGND 3.97612f
C470 net27 VGND 2.04655f
C471 clknet_leaf_7_clk VGND 4.91936f
C472 net135 VGND 3.5601f
C473 u_jt49.read_mask\[5\] VGND 2.41965f
C474 addr\[3\] VGND 3.21807f
C475 net104 VGND 9.99931f
C476 _0539_ VGND 5.75136f
C477 u_jt49.periodA\[0\] VGND 2.28998f
C478 u_jt49.noise VGND 4.80392f
C479 net122 VGND 9.5646f
C480 din_latch\[2\] VGND 3.90977f
C481 _0414_ VGND 4.94314f
C482 net137 VGND 8.87368f
C483 clknet_leaf_21_clk VGND 2.79509f
C484 net14 VGND 2.52577f
C485 net6 VGND 6.1854f
C486 net55 VGND 4.58729f
C487 u_jt49.envelope\[2\] VGND 2.68971f
C488 clknet_leaf_22_clk VGND 3.94211f
C489 net95 VGND 4.07903f
C490 net130 VGND 6.38f
C491 u_jt49.periodA\[2\] VGND 3.90832f
C492 _0420_ VGND 3.12142f
C493 net143 VGND 4.28585f
C494 clknet_leaf_18_clk VGND 2.23172f
C495 net28 VGND 2.48778f
C496 u_jt49.periodC\[4\] VGND 2.95438f
C497 _0541_ VGND 3.81517f
C498 _0542_ VGND 9.16401f
C499 _0604_ VGND 2.31254f
C500 u_jt49.periodA\[3\] VGND 4.16608f
C501 net145 VGND 4.71026f
C502 u_jt49.eg_period\[8\] VGND 2.82218f
C503 _0405_ VGND 2.82057f
.ends
